* PEX produced on Wed Aug 19 17:35:31 CEST 2026 using scripts/sak-pex.sh with m=3 and s=1 (extresist threshold=10000 mOhm, minres=1000 mOhm, mindelay=1 ps)
* NGSPICE file created from counter_pex.ext - technology: ihp-sg13cmos5l

.subckt counter_pex VPWR VGND clk_i rst_ni enable_i count_o[0] count_o[1]
+ count_o[2] count_o[3] count_o[4] count_o[5] count_o[6] count_o[7]
X0 VPWR VGND.t484 VPWR VPWR sg13_lv_pmos ad=0.34p pd=2.68u as=1.15641n ps=4.6671m w=1u l=1u
X1 VPWR a_5135_11065# a_5392_10946# VPWR sg13_lv_pmos ad=1.38282p pd=8.655u as=79.8f ps=0.8u w=0.42u l=0.13u
X2 VGND.t676 VPWR VGND.t676 VGND.t86 sg13_lv_nmos ad=0.1428p pd=1.52u as=0 ps=0 w=0.42u l=1u
X3 a_4858_13692# sg13cmos5l_dfrbpq_1_2.Q VPWR VPWR sg13_lv_pmos ad=0.1428p pd=1.52u as=0.1523p ps=1.38u w=0.42u l=0.13u
X4 VGND.t410 VPWR VGND.t410 VGND.t459 sg13_lv_nmos ad=0.1428p pd=1.52u as=0 ps=0 w=0.42u l=1u
X5 VGND.t419 VPWR VGND.t419 VGND.t420 sg13_lv_nmos ad=79.8f pd=0.8u as=0 ps=0 w=0.42u l=1u
X6 VPWR VGND.t778 VPWR VPWR sg13_lv_pmos ad=0.34p pd=2.68u as=0 ps=0 w=1u l=1u
X7 VGND.t59 a_6185_14066# a_6106_13969# VGND.t980 sg13_lv_nmos ad=3.51557p pd=23.16u as=0.27427p ps=2.28u w=0.795u l=0.13u
X8 VPWR VGND.t484 VPWR VPWR sg13_lv_pmos ad=0.34p pd=2.68u as=0 ps=0 w=1u l=1u
X9 VGND.t572 VPWR VGND.t572 VGND.t574 sg13_lv_nmos ad=79.8f pd=0.8u as=0 ps=0 w=0.42u l=1u
X10 sg13cmos5l_xor2_1_2.B a_4085_14482# VPWR VPWR sg13_lv_pmos ad=0.2128p pd=1.5u as=0.203p ps=1.5u w=1.12u l=0.13u
X11 VPWR VGND.t190 VPWR VPWR sg13_lv_pmos ad=0.19p pd=1.38u as=0 ps=0 w=1u l=1u
X12 VPWR VGND.t228 VPWR VPWR sg13_lv_pmos ad=0.19p pd=1.38u as=0 ps=0 w=1u l=1u
X13 VGND.t31 a_9189_12945# a_9291_13088# VGND.t65 sg13_lv_nmos ad=4.58315p pd=29.2u as=0.2516p ps=2.16u w=0.74u l=0.13u
X14 VGND.t696 VPWR VGND.t696 VGND.t86 sg13_lv_nmos ad=0.1428p pd=1.52u as=0 ps=0 w=0.42u l=1u
X15 VPWR VGND.t696 VPWR VPWR sg13_lv_pmos ad=0.34p pd=2.68u as=0 ps=0 w=1u l=1u
X16 VPWR VGND.t521 VPWR VPWR sg13_lv_pmos ad=0.34p pd=2.68u as=0 ps=0 w=1u l=1u
X17 sg13cmos5l_inv_1_1.A a_11574_13034# VGND.t18 VGND.t17 sg13_lv_nmos ad=0.2516p pd=2.16u as=0.1426p ps=1.16u w=0.74u l=0.13u
X18 VPWR VGND.t237 VPWR VPWR sg13_lv_pmos ad=0.34p pd=2.68u as=0 ps=0 w=1u l=1u
X19 a_10112_10117# a_10231_9906# VPWR VPWR sg13_lv_pmos ad=0.3864p pd=2.93u as=0.2128p ps=1.5u w=1.12u l=0.13u
X20 VPWR a_9274_10668# a_8993_10970# VPWR sg13_lv_pmos ad=0.1523p pd=1.38u as=0.34p ps=2.68u w=1u l=0.5u
X21 VPWR VGND.t613 VPWR VPWR sg13_lv_pmos ad=0.19p pd=1.38u as=0 ps=0 w=1u l=1u
X22 a_3642_13691# sg13cmos5l_nand4_1_0.Y VGND.t200 VGND.t960 sg13_lv_nmos ad=0.17462p pd=1.185u as=0.15245p ps=1.17u w=0.55u l=0.13u
X23 VPWR VGND.t676 VPWR VPWR sg13_lv_pmos ad=0.34p pd=2.68u as=0 ps=0 w=1u l=1u
X24 VPWR VGND.t684 VPWR VPWR sg13_lv_pmos ad=0.34p pd=2.68u as=0 ps=0 w=1u l=1u
X25 VGND.t405 VPWR VGND.t405 VGND.t453 sg13_lv_nmos ad=0.1428p pd=1.52u as=0 ps=0 w=0.42u l=1u
X26 VPWR a_12250_14446# a_11969_14668# VPWR sg13_lv_pmos ad=0.1523p pd=1.38u as=0.34p ps=2.68u w=1u l=0.5u
X27 VGND.t16 sg13cmos5l_nor3_2_0.C sg13cmos5l_mux2_1_0.S VGND.t15 sg13_lv_nmos ad=0.2516p pd=2.16u as=0.1406p ps=1.12u w=0.74u l=0.13u
X28 a_12120_13284# sg13cmos5l_xor2_1_2.B VPWR VPWR sg13_lv_pmos ad=0.2128p pd=1.5u as=0.3808p ps=2.92u w=1.12u l=0.15u
X29 a_9189_12945# sg13cmos5l_dfrbpq_1_7.CLK VPWR VPWR sg13_lv_pmos ad=0.4088p pd=2.97u as=1.7455p ps=10.885u w=1.12u l=0.13u
X30 VPWR VGND.t752 VPWR VPWR sg13_lv_pmos ad=0.34p pd=2.68u as=0 ps=0 w=1u l=1u
X31 VPWR VGND.t688 VPWR VPWR sg13_lv_pmos ad=0.19p pd=1.38u as=0 ps=0 w=1u l=1u
X32 VPWR VGND.t572 VPWR VPWR sg13_lv_pmos ad=0.19p pd=1.38u as=0 ps=0 w=1u l=1u
X33 VGND.t329 VPWR VGND.t331 VGND.t330 sg13_lv_nmos ad=79.8f pd=0.8u as=0 ps=0 w=0.42u l=1u
X34 a_2162_12582# sg13cmos5l_xnor2_1_0.B VGND.t124 VGND.t140 sg13_lv_nmos ad=0.1406p pd=1.12u as=0.2516p ps=2.16u w=0.74u l=0.13u
X35 VGND.t392 VPWR VGND.t392 VGND.t442 sg13_lv_nmos ad=79.8f pd=0.8u as=0 ps=0 w=0.42u l=1u
X36 a_10791_10160# a_10943_10212# VGND.t23 VGND.t945 sg13_lv_nmos ad=0.2516p pd=2.16u as=2.99005p ps=19.165u w=0.74u l=0.13u
X37 VGND.t672 VPWR VGND.t672 VGND.t86 sg13_lv_nmos ad=0.1428p pd=1.52u as=0 ps=0 w=0.42u l=1u
X38 a_5290_13189# a_5733_12945# a_5030_12966# VGND.t174 sg13_lv_nmos ad=79.8f pd=0.8u as=0.1296p ps=1.52u w=0.42u l=0.13u
X39 VPWR VGND.t672 VPWR VPWR sg13_lv_pmos ad=0.34p pd=2.68u as=0 ps=0 w=1u l=1u
X40 VPWR VGND.t676 VPWR VPWR sg13_lv_pmos ad=0.34p pd=2.68u as=0 ps=0 w=1u l=1u
X41 VGND.t410 VPWR VGND.t410 VGND.t413 sg13_lv_nmos ad=79.8f pd=0.8u as=0 ps=0 w=0.42u l=1u
X42 a_8073_10333# a_7716_10260# VPWR VPWR sg13_lv_pmos ad=63f pd=0.72u as=0.1563p ps=1.22u w=0.42u l=0.13u
X43 VPWR VGND.t590 VPWR VPWR sg13_lv_pmos ad=0.19p pd=1.38u as=0 ps=0 w=1u l=1u
X44 a_11632_9562# sg13cmos5l_mux2_1_0.A0 a_11518_9562# VGND.t183 sg13_lv_nmos ad=0.3367p pd=1.65u as=0.1628p ps=1.18u w=0.74u l=0.13u
X45 VGND.t745 VPWR VGND.t745 VGND.t744 sg13_lv_nmos ad=0.1428p pd=1.52u as=0 ps=0 w=0.42u l=1u
X46 VGND.t747 VPWR VGND.t747 VGND.t776 sg13_lv_nmos ad=0.1428p pd=1.52u as=0 ps=0 w=0.42u l=1u
X47 VPWR sg13cmos5l_dfrbpq_1_0.RESET_B a_4906_10165# VPWR sg13_lv_pmos ad=0.1563p pd=1.22u as=0.147p ps=1.54u w=0.42u l=0.13u
X48 VGND.t63 VPWR VGND.t270 VGND.t135 sg13_lv_nmos ad=79.8f pd=0.8u as=0 ps=0 w=0.42u l=1u
X49 VPWR sg13cmos5l_nand4_1_1.A sg13cmos5l_o21ai_1_2.Y VPWR sg13_lv_pmos ad=0.3808p pd=2.92u as=0.2128p ps=1.5u w=1.12u l=0.15u
X50 VPWR VGND.t688 VPWR VPWR sg13_lv_pmos ad=0.34p pd=2.68u as=0 ps=0 w=1u l=1u
X51 VPWR VGND.t696 VPWR VPWR sg13_lv_pmos ad=0.34p pd=2.68u as=0 ps=0 w=1u l=1u
X52 VGND.t253 VPWR VGND.t255 VGND.t254 sg13_lv_nmos ad=79.8f pd=0.8u as=0 ps=0 w=0.42u l=1u
X53 VGND.t676 VPWR VGND.t676 VGND.t86 sg13_lv_nmos ad=0.1428p pd=1.52u as=0 ps=0 w=0.42u l=1u
X54 VGND.t226 VPWR VGND.t224 VGND.t225 sg13_lv_nmos ad=0.1428p pd=1.52u as=0 ps=0 w=0.42u l=1u
X55 VGND.t127 a_4858_13692# a_4577_13994# VGND.t962 sg13_lv_nmos ad=79.8f pd=0.8u as=0.1428p ps=1.52u w=0.42u l=0.5u
X56 VGND.t912 VPWR VGND.t914 VGND.t913 sg13_lv_nmos ad=79.8f pd=0.8u as=0 ps=0 w=0.42u l=1u
X57 VGND.t747 VPWR VGND.t747 VGND.t775 sg13_lv_nmos ad=79.8f pd=0.8u as=0 ps=0 w=0.42u l=1u
X58 VGND.t10 a_10288_13186# a_9937_13043# VGND.t46 sg13_lv_nmos ad=79.8f pd=0.8u as=0.1428p ps=1.52u w=0.42u l=0.13u
X59 VGND.t395 VPWR VGND.t395 VGND.t447 sg13_lv_nmos ad=0.1428p pd=1.52u as=0 ps=0 w=0.42u l=1u
X60 VGND.t405 VPWR VGND.t405 VGND.t406 sg13_lv_nmos ad=79.8f pd=0.8u as=0 ps=0 w=0.42u l=1u
X61 a_7355_9192# sg13cmos5l_a21oi_1_0.A2 VPWR VPWR sg13_lv_pmos ad=0.3808p pd=2.92u as=0.2128p ps=1.5u w=1.12u l=0.13u
X62 VPWR sg13cmos5l_dfrbpq_1_5.D a_11639_10333# VPWR sg13_lv_pmos ad=0.1428p pd=1.52u as=79.8f ps=0.8u w=0.42u l=0.13u
X63 VPWR VGND.t747 VPWR VPWR sg13_lv_pmos ad=0.34p pd=2.68u as=0 ps=0 w=1u l=1u
X64 VPWR VGND.t270 VPWR VPWR sg13_lv_pmos ad=0.19p pd=1.38u as=0 ps=0 w=1u l=1u
X65 a_5722_13692# sg13cmos5l_xor2_1_1.X VGND.t202 VGND.t1095 sg13_lv_nmos ad=0.1428p pd=1.52u as=79.8f ps=0.8u w=0.42u l=0.13u
X66 VGND.t696 VPWR VGND.t696 VGND.t86 sg13_lv_nmos ad=0.1428p pd=1.52u as=0 ps=0 w=0.42u l=1u
X67 count_o[1] a_2920_14516# VPWR VPWR sg13_lv_pmos ad=0.42p pd=2.99u as=0.2114p ps=1.54u w=1.12u l=0.13u
X68 VPWR VGND.t696 VPWR VPWR sg13_lv_pmos ad=0.34p pd=2.68u as=0 ps=0 w=1u l=1u
X69 VPWR VGND.t484 VPWR VPWR sg13_lv_pmos ad=0.34p pd=2.68u as=0 ps=0 w=1u l=1u
X70 VGND.t2 a_13673_11042# a_13594_10945# VGND.t2 sg13_lv_nmos ad=4.55085p pd=29.865u as=0.27427p ps=2.28u w=0.795u l=0.13u
X71 a_8486_12966# a_9291_13088# a_8746_13189# VPWR sg13_lv_pmos ad=0.1428p pd=1.52u as=79.8f ps=0.8u w=0.42u l=0.13u
X72 VGND.t295 VPWR VGND.t295 VGND.t294 sg13_lv_nmos ad=0.1428p pd=1.52u as=0 ps=0 w=0.42u l=1u
X73 VPWR VGND.t208 VPWR VPWR sg13_lv_pmos ad=0.19p pd=1.38u as=0 ps=0 w=1u l=1u
X74 VPWR a_7918_10971# sg13cmos5l_a21oi_1_0.A1 VPWR sg13_lv_pmos ad=0.2254p pd=1.53u as=0.4256p ps=3u w=1.12u l=0.13u
X75 VPWR sg13cmos5l_dfrbpq_1_2.RESET_B a_3850_12184# VPWR sg13_lv_pmos ad=0.1563p pd=1.22u as=0.147p ps=1.54u w=0.42u l=0.13u
X76 VPWR VGND.t672 VPWR VPWR sg13_lv_pmos ad=0.34p pd=2.68u as=0 ps=0 w=1u l=1u
X77 VGND.t360 VPWR VGND.t362 VGND.t361 sg13_lv_nmos ad=79.8f pd=0.8u as=0 ps=0 w=0.42u l=1u
X78 VPWR VGND.t747 VPWR VPWR sg13_lv_pmos ad=0.34p pd=2.68u as=0 ps=0 w=1u l=1u
X79 VPWR VGND.t139 VPWR VPWR sg13_lv_pmos ad=0.19p pd=1.38u as=0 ps=0 w=1u l=1u
X80 VPWR sg13cmos5l_dfrbpq_1_2.Q a_2920_14516# VPWR sg13_lv_pmos ad=0.2114p pd=1.54u as=0.2856p ps=2.36u w=0.84u l=0.13u
X81 sg13cmos5l_buf_1_1.X a_808_8468# VGND.t392 VGND.t950 sg13_lv_nmos ad=0.2886p pd=2.26u as=0.14875p ps=1.16u w=0.74u l=0.13u
X82 VGND.t424 VPWR VGND.t424 VGND.t471 sg13_lv_nmos ad=0.1428p pd=1.52u as=0 ps=0 w=0.42u l=1u
X83 VGND.t676 VPWR VGND.t676 VGND.t86 sg13_lv_nmos ad=0.1428p pd=1.52u as=0 ps=0 w=0.42u l=1u
X84 VPWR a_2039_10023# a_2039_10257# VPWR sg13_lv_pmos ad=1.38282p pd=8.655u as=0.2442p ps=2.06u w=0.66u l=0.13u
X85 VGND.t765 VPWR VGND.t747 VGND.t769 sg13_lv_nmos ad=79.8f pd=0.8u as=0 ps=0 w=0.42u l=1u
X86 VGND.t613 VPWR VGND.t613 VGND.t572 sg13_lv_nmos ad=79.8f pd=0.8u as=0 ps=0 w=0.42u l=1u
X87 VPWR VGND.t484 VPWR VPWR sg13_lv_pmos ad=0.34p pd=2.68u as=0 ps=0 w=1u l=1u
X88 VGND.t395 VPWR VGND.t395 VGND.t398 sg13_lv_nmos ad=79.8f pd=0.8u as=0 ps=0 w=0.42u l=1u
X89 VPWR VGND.t844 VPWR VPWR sg13_lv_pmos ad=0.19p pd=1.38u as=0 ps=0 w=1u l=1u
X90 sg13cmos5l_dfrbpq_1_0.Q a_6858_10240# VGND.t6 VGND.t949 sg13_lv_nmos ad=0.2516p pd=2.16u as=0.1406p ps=1.12u w=0.74u l=0.13u
X91 a_6682_10668# sg13cmos5l_dfrbpq_1_0.Q VGND.t7 VGND.t2 sg13_lv_nmos ad=0.1428p pd=1.52u as=79.8f ps=0.8u w=0.42u l=0.13u
X92 VPWR a_1388_14442# count_o[0] VPWR sg13_lv_pmos ad=0.2114p pd=1.54u as=0.42p ps=2.99u w=1.12u l=0.13u
X93 VPWR VGND.t745 VPWR VPWR sg13_lv_pmos ad=0.34p pd=2.68u as=0 ps=0 w=1u l=1u
X94 a_7800_13708# sg13cmos5l_xor2_1_2.B VPWR VPWR sg13_lv_pmos ad=0.2128p pd=1.5u as=0.3808p ps=2.92u w=1.12u l=0.15u
X95 VPWR VGND.t688 VPWR VPWR sg13_lv_pmos ad=0.34p pd=2.68u as=0 ps=0 w=1u l=1u
X96 VPWR VGND.t308 VPWR VPWR sg13_lv_pmos ad=0.34p pd=2.68u as=0 ps=0 w=1u l=1u
X97 VPWR VGND.t696 VPWR VPWR sg13_lv_pmos ad=0.34p pd=2.68u as=0 ps=0 w=1u l=1u
X98 VPWR VGND.t613 VPWR VPWR sg13_lv_pmos ad=0.19p pd=1.38u as=0 ps=0 w=1u l=1u
X99 VPWR sg13cmos5l_dfrbpq_1_2.RESET_B a_3590_12654# VPWR sg13_lv_pmos ad=0.36237p pd=2.605u as=79.8f ps=0.8u w=0.42u l=0.13u
X100 a_14828_14442# sg13cmos5l_dfrbpq_1_5.Q VGND.t247 VGND.t1063 sg13_lv_nmos ad=0.187p pd=1.78u as=0.14875p ps=1.16u w=0.55u l=0.13u
X101 VGND.t400 VPWR VGND.t400 VGND.t449 sg13_lv_nmos ad=0.1428p pd=1.52u as=0 ps=0 w=0.42u l=1u
X102 VGND.t405 VPWR VGND.t405 VGND.t408 sg13_lv_nmos ad=79.8f pd=0.8u as=0 ps=0 w=0.42u l=1u
X103 VPWR a_8975_10019# a_9232_10162# VPWR sg13_lv_pmos ad=1.38282p pd=8.655u as=79.8f ps=0.8u w=0.42u l=0.13u
X104 VGND.t590 VPWR VGND.t590 VGND.t592 sg13_lv_nmos ad=79.8f pd=0.8u as=0 ps=0 w=0.42u l=1u
X105 VPWR VGND.t747 VPWR VPWR sg13_lv_pmos ad=0.34p pd=2.68u as=0 ps=0 w=1u l=1u
X106 VGND.t700 VPWR VGND.t700 VGND.t86 sg13_lv_nmos ad=0.1428p pd=1.52u as=0 ps=0 w=0.42u l=1u
X107 VPWR sg13cmos5l_nand4_1_0.Y a_3668_13728# VPWR sg13_lv_pmos ad=0.2128p pd=1.5u as=0.2128p ps=1.5u w=1.12u l=0.13u
X108 VGND.t333 VPWR VGND.t51 VGND.t334 sg13_lv_nmos ad=79.8f pd=0.8u as=0 ps=0 w=0.42u l=1u
X109 VGND.t424 VPWR VGND.t424 VGND.t427 sg13_lv_nmos ad=79.8f pd=0.8u as=0 ps=0 w=0.42u l=1u
X110 VPWR VGND.t676 VPWR VPWR sg13_lv_pmos ad=0.34p pd=2.68u as=0 ps=0 w=1u l=1u
X111 sg13cmos5l_dfrbpq_1_7.CLK a_11355_11458# VGND.t303 VGND.t15 sg13_lv_nmos ad=0.1406p pd=1.12u as=0.1406p ps=1.12u w=0.74u l=0.13u
X112 VGND.t484 VPWR VGND.t484 VGND.t487 sg13_lv_nmos ad=79.8f pd=0.8u as=0 ps=0 w=0.42u l=1u
X113 VGND.t59 a_9178_13692# a_8897_13994# VGND.t942 sg13_lv_nmos ad=79.8f pd=0.8u as=0.1428p ps=1.52u w=0.42u l=0.5u
X114 VPWR VGND.t688 VPWR VPWR sg13_lv_pmos ad=0.34p pd=2.68u as=0 ps=0 w=1u l=1u
X115 VGND.t424 VPWR VGND.t424 VGND.t473 sg13_lv_nmos ad=0.1428p pd=1.52u as=0 ps=0 w=0.42u l=1u
X116 VPWR a_7148_14442# count_o[3] VPWR sg13_lv_pmos ad=0.2114p pd=1.54u as=0.42p ps=2.99u w=1.12u l=0.13u
X117 VPWR a_7822_9459# sg13cmos5l_dlygate4sd3_1_15.X VPWR sg13_lv_pmos ad=0.2254p pd=1.53u as=0.4256p ps=3u w=1.12u l=0.13u
X118 VGND.t1 a_11733_10100# a_10812_9906# VGND.t0 sg13_lv_nmos ad=0.1626p pd=1.415u as=0.2516p ps=2.16u w=0.74u l=0.13u
X119 VGND.t747 VPWR VGND.t747 VGND.t771 sg13_lv_nmos ad=79.8f pd=0.8u as=0 ps=0 w=0.42u l=1u
X120 VGND.t400 VPWR VGND.t400 VGND.t401 sg13_lv_nmos ad=79.8f pd=0.8u as=0 ps=0 w=0.42u l=1u
X121 VPWR VGND.t747 VPWR VPWR sg13_lv_pmos ad=0.19p pd=1.38u as=0 ps=0 w=1u l=1u
X122 a_8590_14667# a_8705_14668# VPWR VPWR sg13_lv_pmos ad=0.34p pd=2.68u as=0.2254p ps=1.53u w=1u l=0.5u
X123 VPWR a_6682_10668# a_6401_10970# VPWR sg13_lv_pmos ad=0.1523p pd=1.38u as=0.34p ps=2.68u w=1u l=0.5u
X124 sg13cmos5l_dfrbpq_1_3.Q a_5802_10704# VGND.t28 VGND.t2 sg13_lv_nmos ad=0.2516p pd=2.16u as=0.1406p ps=1.12u w=0.74u l=0.13u
X125 sg13cmos5l_o21ai_1_0.Y sg13cmos5l_o21ai_1_0.B1 a_7318_11450# VGND.t15 sg13_lv_nmos ad=0.2516p pd=2.16u as=0.1406p ps=1.12u w=0.74u l=0.15u
X126 VGND.t2 sg13cmos5l_xor2_1_2.B a_3761_11508# VGND.t1075 sg13_lv_nmos ad=0.15245p pd=1.17u as=0.17462p ps=1.185u w=0.55u l=0.13u
X127 VGND.t71 a_10988_14442# count_o[5] VGND.t1041 sg13_lv_nmos ad=0.14875p pd=1.16u as=0.2886p ps=2.26u w=0.74u l=0.13u
X128 VPWR VGND.t688 VPWR VPWR sg13_lv_pmos ad=0.34p pd=2.68u as=0 ps=0 w=1u l=1u
X129 VPWR VGND.t700 VPWR VPWR sg13_lv_pmos ad=0.34p pd=2.68u as=0 ps=0 w=1u l=1u
X130 VGND.t788 VPWR VGND.t788 VGND.t790 sg13_lv_nmos ad=79.8f pd=0.8u as=0 ps=0 w=0.42u l=1u
X131 VPWR VGND.t260 VPWR VPWR sg13_lv_pmos ad=0.34p pd=2.68u as=0 ps=0 w=1u l=1u
X132 VPWR a_5516_14442# count_o[2] VPWR sg13_lv_pmos ad=0.2114p pd=1.54u as=0.42p ps=2.99u w=1.12u l=0.13u
X133 VPWR VGND.t342 VPWR VPWR sg13_lv_pmos ad=0.19p pd=1.38u as=0 ps=0 w=1u l=1u
X134 VGND.t400 VPWR VGND.t400 VGND.t451 sg13_lv_nmos ad=0.1428p pd=1.52u as=0 ps=0 w=0.42u l=1u
X135 VPWR a_9189_12945# a_9291_13088# VPWR sg13_lv_pmos ad=1.7455p pd=10.885u as=0.3864p ps=2.93u w=1.12u l=0.13u
X136 VGND.t897 VPWR VGND.t896 VGND.t895 sg13_lv_nmos ad=0.1428p pd=1.52u as=0 ps=0 w=0.42u l=1u
X137 VPWR VGND.t613 VPWR VPWR sg13_lv_pmos ad=0.19p pd=1.38u as=0 ps=0 w=1u l=1u
X138 VPWR a_12038_13728# a_12150_13752# VPWR sg13_lv_pmos ad=0.2254p pd=1.53u as=0.34p ps=2.68u w=1u l=0.5u
X139 VGND.t688 VPWR VGND.t688 VGND.t86 sg13_lv_nmos ad=0.1428p pd=1.52u as=0 ps=0 w=0.42u l=1u
X140 VGND.t87 VPWR VGND.t87 VGND.t86 sg13_lv_nmos ad=79.8f pd=0.8u as=0 ps=0 w=0.42u l=1u
X141 VPWR VGND.t333 VPWR VPWR sg13_lv_pmos ad=0.19p pd=1.38u as=0 ps=0 w=1u l=1u
X142 a_10231_12180# a_10791_12303# a_10702_12339# VPWR sg13_lv_pmos ad=0.2048p pd=1.63u as=93.45f ps=0.865u w=0.42u l=0.13u
X143 VGND.t51 VPWR VGND.t51 VGND.t336 sg13_lv_nmos ad=79.8f pd=0.8u as=0 ps=0 w=0.42u l=1u
X144 VPWR VGND.t148 VPWR VPWR sg13_lv_pmos ad=0.19p pd=1.38u as=0 ps=0 w=1u l=1u
X145 VGND.t778 VPWR VGND.t783 VGND.t782 sg13_lv_nmos ad=79.8f pd=0.8u as=0 ps=0 w=0.42u l=1u
X146 VGND.t424 VPWR VGND.t424 VGND.t429 sg13_lv_nmos ad=79.8f pd=0.8u as=0 ps=0 w=0.42u l=1u
X147 VPWR VGND.t193 VPWR VPWR sg13_lv_pmos ad=0.19p pd=1.38u as=0 ps=0 w=1u l=1u
X148 VPWR a_8133_9921# a_8235_10064# VPWR sg13_lv_pmos ad=1.38282p pd=8.655u as=0.3864p ps=2.93u w=1.12u l=0.13u
X149 VGND.t892 VPWR VGND.t891 VGND.t890 sg13_lv_nmos ad=0.1428p pd=1.52u as=0 ps=0 w=0.42u l=1u
X150 VPWR VGND.t590 VPWR VPWR sg13_lv_pmos ad=0.19p pd=1.38u as=0 ps=0 w=1u l=1u
X151 VGND.t365 VPWR VGND.t364 VGND.t363 sg13_lv_nmos ad=0.1428p pd=1.52u as=0 ps=0 w=0.42u l=1u
X152 a_10715_13728# sg13cmos5l_a21oi_1_1.A2 VPWR VPWR sg13_lv_pmos ad=0.3808p pd=2.92u as=0.2128p ps=1.5u w=1.12u l=0.13u
X153 VPWR VGND.t392 VPWR VPWR sg13_lv_pmos ad=0.19p pd=1.38u as=0 ps=0 w=1u l=1u
X154 a_8133_9921# sg13cmos5l_dfrbpq_1_7.CLK VGND.t23 VGND.t22 sg13_lv_nmos ad=0.2516p pd=2.16u as=2.69105p ps=17.245u w=0.74u l=0.13u
X155 VPWR VGND.t484 VPWR VPWR sg13_lv_pmos ad=0.19p pd=1.38u as=0 ps=0 w=1u l=1u
X156 VGND.t747 VPWR VGND.t747 VGND.t773 sg13_lv_nmos ad=79.8f pd=0.8u as=0 ps=0 w=0.42u l=1u
X157 VPWR VGND.t1 VPWR VPWR sg13_lv_pmos ad=0.19p pd=1.38u as=0 ps=0 w=1u l=1u
X158 VGND.t310 VPWR VGND.t308 VGND.t2 sg13_lv_nmos ad=0.1428p pd=1.52u as=0 ps=0 w=0.42u l=1u
X159 VGND.t395 VPWR VGND.t395 VGND.t445 sg13_lv_nmos ad=0.1428p pd=1.52u as=0 ps=0 w=0.42u l=1u
X160 VGND.t400 VPWR VGND.t400 VGND.t403 sg13_lv_nmos ad=79.8f pd=0.8u as=0 ps=0 w=0.42u l=1u
X161 VPWR VGND.t747 VPWR VPWR sg13_lv_pmos ad=0.19p pd=1.38u as=0 ps=0 w=1u l=1u
X162 VGND.t7 sg13cmos5l_xor2_1_2.B a_7318_11450# VGND.t15 sg13_lv_nmos ad=0.1406p pd=1.12u as=0.2516p ps=2.16u w=0.74u l=0.15u
X163 sg13cmos5l_nand3_1_0.Y sg13cmos5l_nand4_1_0.C VPWR VPWR sg13_lv_pmos ad=0.2128p pd=1.5u as=0.2128p ps=1.5u w=1.12u l=0.13u
X164 VPWR VGND.t306 VPWR VPWR sg13_lv_pmos ad=0.34p pd=2.68u as=0 ps=0 w=1u l=1u
X165 a_10812_12577# a_10943_12187# a_10231_12180# VPWR sg13_lv_pmos ad=0.34p pd=2.68u as=0.2048p ps=1.63u w=1u l=0.13u
X166 VGND.t1 VPWR VGND.t340 VGND.t339 sg13_lv_nmos ad=79.8f pd=0.8u as=0 ps=0 w=0.42u l=1u
X167 a_5705_11400# a_5829_11497# VPWR VPWR sg13_lv_pmos ad=0.2442p pd=2.06u as=2.16757p ps=13.96u w=0.66u l=0.13u
X168 VGND.t195 VPWR VGND.t234 VGND.t233 sg13_lv_nmos ad=79.8f pd=0.8u as=0 ps=0 w=0.42u l=1u
X169 VPWR a_5722_13692# a_5441_13994# VPWR sg13_lv_pmos ad=0.1523p pd=1.38u as=0.34p ps=2.68u w=1u l=0.5u
X170 VPWR VGND.t572 VPWR VPWR sg13_lv_pmos ad=0.34p pd=2.68u as=0 ps=0 w=1u l=1u
X171 VPWR VGND.t688 VPWR VPWR sg13_lv_pmos ad=0.34p pd=2.68u as=0 ps=0 w=1u l=1u
X172 VGND.t188 VPWR VGND.t190 VGND.t230 sg13_lv_nmos ad=79.8f pd=0.8u as=0 ps=0 w=0.42u l=1u
X173 VGND.t226 VPWR VGND.t228 VGND.t227 sg13_lv_nmos ad=79.8f pd=0.8u as=0 ps=0 w=0.42u l=1u
X174 VGND.t484 VPWR VGND.t484 VGND.t487 sg13_lv_nmos ad=79.8f pd=0.8u as=0 ps=0 w=0.42u l=1u
X175 VPWR VGND.t788 VPWR VPWR sg13_lv_pmos ad=0.19p pd=1.38u as=0 ps=0 w=1u l=1u
X176 a_6382_12483# a_6497_12482# VPWR VPWR sg13_lv_pmos ad=0.34p pd=2.68u as=0.2254p ps=1.53u w=1u l=0.5u
X177 VGND.t395 VPWR VGND.t395 VGND.t396 sg13_lv_nmos ad=79.8f pd=0.8u as=0 ps=0 w=0.42u l=1u
X178 a_11990_9955# a_10812_9906# a_11594_10100# VGND.t85 sg13_lv_nmos ad=37.8f pd=0.6u as=0.1428p ps=1.52u w=0.42u l=0.13u
X179 VGND.t410 VPWR VGND.t410 VGND.t409 sg13_lv_nmos ad=0.1428p pd=1.52u as=0 ps=0 w=0.42u l=1u
X180 VPWR sg13cmos5l_buf_1_0.X a_1740_10970# VPWR sg13_lv_pmos ad=0.4536p pd=2.76u as=0.1596p ps=1.22u w=0.84u l=0.13u
X181 VPWR sg13cmos5l_buf_1_0.X sg13cmos5l_nand4_1_0.Y VPWR sg13_lv_pmos ad=0.3808p pd=2.92u as=0.2128p ps=1.5u w=1.12u l=0.13u
X182 VGND.t783 VPWR VGND.t783 VGND.t785 sg13_lv_nmos ad=79.8f pd=0.8u as=0 ps=0 w=0.42u l=1u
X183 VPWR VGND.t783 VPWR VPWR sg13_lv_pmos ad=0.19p pd=1.38u as=0 ps=0 w=1u l=1u
X184 VPWR VGND.t765 VPWR VPWR sg13_lv_pmos ad=0.19p pd=1.38u as=0 ps=0 w=1u l=1u
X185 a_11854_14667# a_11969_14668# VPWR VPWR sg13_lv_pmos ad=0.34p pd=2.68u as=0.2254p ps=1.53u w=1u l=0.5u
X186 sg13cmos5l_o21ai_1_1.Y sg13cmos5l_inv_1_1.A a_12022_12962# VGND.t72 sg13_lv_nmos ad=0.2516p pd=2.16u as=0.1406p ps=1.12u w=0.74u l=0.15u
X187 a_11639_10333# sg13cmos5l_dfrbpq_1_5.D a_12386_9942# VGND.t157 sg13_lv_nmos ad=0.1428p pd=1.52u as=60.89999f ps=0.71u w=0.42u l=0.13u
X188 a_11835_12263# a_10943_12187# a_11733_12263# VPWR sg13_lv_pmos ad=63f pd=0.72u as=79.8f ps=0.8u w=0.42u l=0.13u
X189 VGND.t6 VPWR VGND.t6 VGND.t367 sg13_lv_nmos ad=0.1428p pd=1.52u as=0 ps=0 w=0.42u l=1u
X190 a_8120_12582# sg13cmos5l_nand2_1_1.A a_8018_12582# VGND.t135 sg13_lv_nmos ad=0.1406p pd=1.12u as=0.1406p ps=1.12u w=0.74u l=0.13u
X191 VPWR VGND.t745 VPWR VPWR sg13_lv_pmos ad=0.34p pd=2.68u as=0 ps=0 w=1u l=1u
X192 VGND.t572 VPWR VGND.t572 VGND.t573 sg13_lv_nmos ad=0.1428p pd=1.52u as=0 ps=0 w=0.42u l=1u
X193 a_4426_11422# sg13cmos5l_buf_8_0.A VGND.t28 VGND.t15 sg13_lv_nmos ad=0.1406p pd=1.12u as=0.1406p ps=1.12u w=0.74u l=0.13u
X194 a_1940_13264# sg13cmos5l_nand4_1_0.C VPWR VPWR sg13_lv_pmos ad=0.3808p pd=2.92u as=0.2128p ps=1.5u w=1.12u l=0.13u
X195 VPWR VGND.t340 VPWR VPWR sg13_lv_pmos ad=0.19p pd=1.38u as=0 ps=0 w=1u l=1u
X196 VGND.t668 VPWR VGND.t668 VGND.t86 sg13_lv_nmos ad=0.1428p pd=1.52u as=0 ps=0 w=0.42u l=1u
X197 VGND.t747 VPWR VGND.t747 VGND.t760 sg13_lv_nmos ad=79.8f pd=0.8u as=0 ps=0 w=0.42u l=1u
X198 VPWR VGND.t260 VPWR VPWR sg13_lv_pmos ad=0.34p pd=2.68u as=0 ps=0 w=1u l=1u
X199 VPWR VGND.t747 VPWR VPWR sg13_lv_pmos ad=0.19p pd=1.38u as=0 ps=0 w=1u l=1u
X200 VPWR VGND.t613 VPWR VPWR sg13_lv_pmos ad=0.19p pd=1.38u as=0 ps=0 w=1u l=1u
X201 VPWR a_9370_14699# sg13cmos5l_dfrbpq_1_4.RESET_B VPWR sg13_lv_pmos ad=11.27927p pd=73.965u as=0.3927p ps=2.99u w=1.155u l=0.13u
X202 a_5316_13284# a_5290_13189# VGND.t75 VGND.t74 sg13_lv_nmos ad=0.2516p pd=2.16u as=0.1626p ps=1.415u w=0.74u l=0.13u
X203 VGND.t747 VPWR VGND.t747 VGND.t772 sg13_lv_nmos ad=0.1428p pd=1.52u as=0 ps=0 w=0.42u l=1u
X204 VPWR VGND.t215 VPWR VPWR sg13_lv_pmos ad=0.19p pd=1.38u as=0 ps=0 w=1u l=1u
X205 VPWR VGND.t124 VPWR VPWR sg13_lv_pmos ad=0.34p pd=2.68u as=0 ps=0 w=1u l=1u
X206 VPWR a_10812_12577# a_11835_12263# VPWR sg13_lv_pmos ad=0.1563p pd=1.22u as=63f ps=0.72u w=0.42u l=0.13u
X207 VGND.t747 VPWR VGND.t778 VGND.t777 sg13_lv_nmos ad=79.8f pd=0.8u as=0 ps=0 w=0.42u l=1u
X208 VPWR VGND.t305 VPWR VPWR sg13_lv_pmos ad=0.19p pd=1.38u as=0 ps=0 w=1u l=1u
X209 sg13cmos5l_o21ai_1_0.Y sg13cmos5l_nand2_1_1.Y a_7416_11772# VPWR sg13_lv_pmos ad=0.2128p pd=1.5u as=0.2128p ps=1.5u w=1.12u l=0.15u
X210 VGND.t18 VPWR VGND.t18 VGND.t277 sg13_lv_nmos ad=0.1428p pd=1.52u as=0 ps=0 w=0.42u l=1u
X211 VGND.t206 VPWR VGND.t208 VGND.t239 sg13_lv_nmos ad=79.8f pd=0.8u as=0 ps=0 w=0.42u l=1u
X212 VPWR VGND.t190 VPWR VPWR sg13_lv_pmos ad=0.34p pd=2.68u as=0 ps=0 w=1u l=1u
X213 VPWR VGND.t246 VPWR VPWR sg13_lv_pmos ad=0.34p pd=2.68u as=0 ps=0 w=1u l=1u
X214 a_11518_9562# sg13cmos5l_mux2_1_0.A0 a_11421_9216# VPWR sg13_lv_pmos ad=0.2225p pd=1.445u as=0.3325p ps=1.665u w=1u l=0.13u
X215 sg13cmos5l_o21ai_1_1.Y sg13cmos5l_nor3_2_0.C a_12120_13284# VPWR sg13_lv_pmos ad=0.2128p pd=1.5u as=0.2128p ps=1.5u w=1.12u l=0.15u
X216 sg13cmos5l_dfrbpq_1_7.CLK a_11355_11458# VPWR VPWR sg13_lv_pmos ad=0.2128p pd=1.5u as=0.2128p ps=1.5u w=1.12u l=0.13u
X217 VGND.t410 VPWR VGND.t410 VGND.t412 sg13_lv_nmos ad=0.1428p pd=1.52u as=0 ps=0 w=0.42u l=1u
X218 VGND.t783 VPWR VGND.t788 VGND.t787 sg13_lv_nmos ad=79.8f pd=0.8u as=0 ps=0 w=0.42u l=1u
X219 VPWR VGND.t783 VPWR VPWR sg13_lv_pmos ad=0.19p pd=1.38u as=0 ps=0 w=1u l=1u
X220 VGND.t2 a_3761_11508# sg13cmos5l_nor2_1_3.B VGND.t998 sg13_lv_nmos ad=0.3108p pd=2.32u as=0.1628p ps=1.18u w=0.74u l=0.13u
X221 VGND.t663 VPWR VGND.t663 VGND.t86 sg13_lv_nmos ad=0.1428p pd=1.52u as=0 ps=0 w=0.42u l=1u
X222 a_13678_10131# a_13793_10132# VPWR VPWR sg13_lv_pmos ad=0.34p pd=2.68u as=0.2254p ps=1.53u w=1u l=0.5u
X223 sg13cmos5l_o21ai_1_2.Y sg13cmos5l_nand4_1_1.A a_7702_14106# VGND.t963 sg13_lv_nmos ad=0.2516p pd=2.16u as=0.1406p ps=1.12u w=0.74u l=0.15u
X224 VPWR VGND.t747 VPWR VPWR sg13_lv_pmos ad=0.19p pd=1.38u as=0 ps=0 w=1u l=1u
X225 VPWR VGND.t608 VPWR VPWR sg13_lv_pmos ad=0.34p pd=2.68u as=0 ps=0 w=1u l=1u
X226 a_7918_10971# a_8033_10970# VGND.t7 VGND.t2 sg13_lv_nmos ad=0.1428p pd=1.52u as=0.1426p ps=1.16u w=0.42u l=0.5u
X227 VPWR VGND.t302 VPWR VPWR sg13_lv_pmos ad=0.19p pd=1.38u as=0 ps=0 w=1u l=1u
X228 sg13cmos5l_nor2_1_0.B a_1740_10970# VPWR VPWR sg13_lv_pmos ad=0.2408p pd=1.55u as=0.3808p ps=2.92u w=1.12u l=0.13u
X229 VPWR a_6832_13186# a_6777_13281# VPWR sg13_lv_pmos ad=1.7455p pd=10.885u as=93.45f ps=0.865u w=0.42u l=0.13u
X230 VPWR VGND.t684 VPWR VPWR sg13_lv_pmos ad=0.19p pd=1.38u as=0 ps=0 w=1u l=1u
X231 VGND.t134 a_6286_10971# sg13cmos5l_xor2_1_2.A VGND.t2 sg13_lv_nmos ad=0.1426p pd=1.16u as=0.2516p ps=2.16u w=0.74u l=0.13u
X232 VPWR VGND.t747 VPWR VPWR sg13_lv_pmos ad=0.19p pd=1.38u as=0 ps=0 w=1u l=1u
X233 VGND.t847 VPWR VGND.t846 VGND.t845 sg13_lv_nmos ad=0.1428p pd=1.52u as=0 ps=0 w=0.42u l=1u
X234 VPWR VGND.t395 VPWR VPWR sg13_lv_pmos ad=0.34p pd=2.68u as=0 ps=0 w=1u l=1u
X235 VGND.t747 VPWR VGND.t747 VGND.t774 sg13_lv_nmos ad=0.1428p pd=1.52u as=0 ps=0 w=0.42u l=1u
X236 VGND.t788 VPWR VGND.t788 VGND.t747 sg13_lv_nmos ad=79.8f pd=0.8u as=0 ps=0 w=0.42u l=1u
X237 VGND.t405 VPWR VGND.t405 VGND.t404 sg13_lv_nmos ad=0.1428p pd=1.52u as=0 ps=0 w=0.42u l=1u
X238 VPWR VGND.t747 VPWR VPWR sg13_lv_pmos ad=0.34p pd=2.68u as=0 ps=0 w=1u l=1u
X239 a_6286_10971# a_6401_10970# VGND.t134 VGND.t2 sg13_lv_nmos ad=0.1428p pd=1.52u as=0.1426p ps=1.16u w=0.42u l=0.5u
X240 a_1388_14442# sg13cmos5l_dfrbpq_1_3.Q VGND.t190 VGND.t1048 sg13_lv_nmos ad=0.187p pd=1.78u as=0.14875p ps=1.16u w=0.55u l=0.13u
X241 VGND.t260 VPWR VGND.t260 VGND.t261 sg13_lv_nmos ad=0.1428p pd=1.52u as=0 ps=0 w=0.42u l=1u
X242 a_8600_12582# sg13cmos5l_dlygate4sd3_1_1.X a_8498_12582# VGND.t135 sg13_lv_nmos ad=0.1406p pd=1.12u as=0.1406p ps=1.12u w=0.74u l=0.13u
X243 VGND.t7 sg13cmos5l_o21ai_1_0.B1 a_7177_10728# VGND.t2 sg13_lv_nmos ad=0.13395p pd=1.12u as=0.198p ps=1.27u w=0.55u l=0.13u
X244 VGND.t778 VPWR VGND.t778 VGND.t780 sg13_lv_nmos ad=79.8f pd=0.8u as=0 ps=0 w=0.42u l=1u
X245 VPWR VGND.t484 VPWR VPWR sg13_lv_pmos ad=0.19p pd=1.38u as=0 ps=0 w=1u l=1u
X246 VPWR VGND.t778 VPWR VPWR sg13_lv_pmos ad=0.19p pd=1.38u as=0 ps=0 w=1u l=1u
X247 a_11786_10704# sg13cmos5l_dlygate4sd3_1_12.X sg13cmos5l_mux2_1_0.A1 VPWR sg13_lv_pmos ad=0.1176p pd=1.33u as=0.3808p ps=2.92u w=1.12u l=0.13u
X248 a_10604_11752# sg13cmos5l_xor2_1_2.B a_10816_11752# VPWR sg13_lv_pmos ad=0.2128p pd=1.5u as=0.3808p ps=2.92u w=1.12u l=0.13u
X249 a_10791_12303# a_10943_12187# VGND.t31 VGND.t1042 sg13_lv_nmos ad=0.2516p pd=2.16u as=4.58315p ps=29.2u w=0.74u l=0.13u
X250 VGND.t191 VPWR VGND.t193 VGND.t192 sg13_lv_nmos ad=79.8f pd=0.8u as=0 ps=0 w=0.42u l=1u
X251 a_4164_11129# a_4395_10715# a_3850_10672# VGND.t948 sg13_lv_nmos ad=0.2373p pd=1.97u as=79.8f ps=0.8u w=0.42u l=0.13u
X252 a_3590_11142# sg13cmos5l_nor2_1_0.Y VPWR VPWR sg13_lv_pmos ad=79.8f pd=0.8u as=0.1428p ps=1.52u w=0.42u l=0.13u
X253 VGND.t71 sg13cmos5l_a21oi_1_1.Y a_11768_13769# VGND.t967 sg13_lv_nmos ad=79.8f pd=0.8u as=0.1428p ps=1.52u w=0.42u l=0.13u
X254 VPWR VGND.t36 VPWR VPWR sg13_lv_pmos ad=0.19p pd=1.38u as=0 ps=0 w=1u l=1u
X255 VGND.t329 VPWR VGND.t328 VGND.t327 sg13_lv_nmos ad=0.1428p pd=1.52u as=0 ps=0 w=0.42u l=1u
X256 VGND.t765 VPWR VGND.t765 VGND.t768 sg13_lv_nmos ad=0.1428p pd=1.52u as=0 ps=0 w=0.42u l=1u
X257 VGND.t392 VPWR VGND.t392 VGND.t441 sg13_lv_nmos ad=0.1428p pd=1.52u as=0 ps=0 w=0.42u l=1u
X258 VGND.t395 VPWR VGND.t395 VGND.t397 sg13_lv_nmos ad=0.1428p pd=1.52u as=0 ps=0 w=0.42u l=1u
X259 VPWR sg13cmos5l_dfrbpq_1_5.Q a_10808_10745# VPWR sg13_lv_pmos ad=0.1523p pd=1.38u as=0.1428p ps=1.52u w=0.42u l=0.13u
X260 VGND.t36 sg13cmos5l_dfrbpq_1_5.RESET_B a_10538_9942# VGND.t35 sg13_lv_nmos ad=79.8f pd=0.8u as=37.8f ps=0.6u w=0.42u l=0.13u
X261 a_8975_10019# a_8133_9921# a_8881_10019# VGND.t24 sg13_lv_nmos ad=0.12665p pd=1.145u as=0.1428p ps=1.52u w=0.42u l=0.13u
X262 VPWR VGND.t521 VPWR VPWR sg13_lv_pmos ad=0.19p pd=1.38u as=0 ps=0 w=1u l=1u
X263 VGND.t765 VPWR VGND.t765 VGND.t767 sg13_lv_nmos ad=79.8f pd=0.8u as=0 ps=0 w=0.42u l=1u
X264 VPWR VGND.t148 VPWR VPWR sg13_lv_pmos ad=0.34p pd=2.68u as=0 ps=0 w=1u l=1u
X265 VPWR a_1943_14033# a_1943_13803# VPWR sg13_lv_pmos ad=1.7455p pd=10.885u as=0.2442p ps=2.06u w=0.66u l=0.13u
X266 a_9178_13692# sg13cmos5l_dlygate4sd3_1_8.A VPWR VPWR sg13_lv_pmos ad=0.1428p pd=1.52u as=0.1523p ps=1.38u w=0.42u l=0.13u
X267 VPWR VGND.t688 VPWR VPWR sg13_lv_pmos ad=0.19p pd=1.38u as=0 ps=0 w=1u l=1u
X268 VGND.t419 VPWR VGND.t424 VGND.t468 sg13_lv_nmos ad=79.8f pd=0.8u as=0 ps=0 w=0.42u l=1u
X269 VPWR VGND.t752 VPWR VPWR sg13_lv_pmos ad=0.19p pd=1.38u as=0 ps=0 w=1u l=1u
X270 VGND.t917 VPWR VGND.t916 VGND.t915 sg13_lv_nmos ad=0.1428p pd=1.52u as=0 ps=0 w=0.42u l=1u
X271 VGND.t783 VPWR VGND.t783 VGND.t786 sg13_lv_nmos ad=0.1428p pd=1.52u as=0 ps=0 w=0.42u l=1u
X272 VGND.t273 VPWR VGND.t272 VGND.t271 sg13_lv_nmos ad=0.1428p pd=1.52u as=0 ps=0 w=0.42u l=1u
X273 VGND.t59 sg13cmos5l_xor2_1_2.B a_7702_14106# VGND.t1071 sg13_lv_nmos ad=0.1406p pd=1.12u as=0.2516p ps=2.16u w=0.74u l=0.15u
X274 VPWR VGND.t747 VPWR VPWR sg13_lv_pmos ad=0.19p pd=1.38u as=0 ps=0 w=1u l=1u
X275 VGND.t290 VPWR VGND.t139 VGND.t291 sg13_lv_nmos ad=79.8f pd=0.8u as=0 ps=0 w=0.42u l=1u
X276 a_11421_9216# sg13cmos5l_mux2_1_0.S VPWR VPWR sg13_lv_pmos ad=0.3325p pd=1.665u as=0.253p ps=1.53u w=1u l=0.13u
X277 sg13cmos5l_nor2_1_0.Y sg13cmos5l_a21oi_1_0.B1 VGND.t288 VGND.t1027 sg13_lv_nmos ad=0.1406p pd=1.12u as=0.2516p ps=2.16u w=0.74u l=0.13u
X278 sg13cmos5l_nand2_1_1.Y sg13cmos5l_nand2_1_1.A a_7066_11458# VGND.t15 sg13_lv_nmos ad=0.2516p pd=2.16u as=0.1406p ps=1.12u w=0.74u l=0.13u
X279 VGND.t6 a_6448_10162# a_6097_10019# VGND.t89 sg13_lv_nmos ad=79.8f pd=0.8u as=0.1428p ps=1.52u w=0.42u l=0.13u
X280 sg13cmos5l_dfrbpq_1_2.Q a_5802_12216# VGND.t49 VGND.t48 sg13_lv_nmos ad=0.2516p pd=2.16u as=0.1406p ps=1.12u w=0.74u l=0.13u
X281 VPWR VGND.t572 VPWR VPWR sg13_lv_pmos ad=0.34p pd=2.68u as=0 ps=0 w=1u l=1u
X282 a_10702_12339# a_10444_12654# VPWR VPWR sg13_lv_pmos ad=93.45f pd=0.865u as=2.16757p ps=13.96u w=0.42u l=0.13u
X283 sg13cmos5l_o21ai_1_2.Y sg13cmos5l_nand3_1_1.Y a_7800_13708# VPWR sg13_lv_pmos ad=0.2128p pd=1.5u as=0.2128p ps=1.5u w=1.12u l=0.15u
X284 VGND.t310 VPWR VGND.t311 VGND.t2 sg13_lv_nmos ad=79.8f pd=0.8u as=0 ps=0 w=0.42u l=1u
X285 VGND.t125 sg13cmos5l_nand4_1_1.A a_7849_12970# VGND.t43 sg13_lv_nmos ad=0.13395p pd=1.12u as=0.198p ps=1.27u w=0.55u l=0.13u
X286 VPWR VGND.t484 VPWR VPWR sg13_lv_pmos ad=0.19p pd=1.38u as=0 ps=0 w=1u l=1u
X287 a_12386_12654# sg13cmos5l_dfrbpq_1_6.RESET_B VGND.t18 VGND.t151 sg13_lv_nmos ad=60.89999f pd=0.71u as=0.1626p ps=1.415u w=0.42u l=0.13u
X288 a_7148_14442# sg13cmos5l_nand2_1_1.A VGND.t208 VGND.t1050 sg13_lv_nmos ad=0.187p pd=1.78u as=0.14875p ps=1.16u w=0.55u l=0.13u
X289 VPWR a_4174_13155# sg13cmos5l_xnor2_1_0.B VPWR sg13_lv_pmos ad=0.2254p pd=1.53u as=0.4256p ps=3u w=1.12u l=0.13u
X290 VPWR VGND.t788 VPWR VPWR sg13_lv_pmos ad=0.19p pd=1.38u as=0 ps=0 w=1u l=1u
X291 a_8772_13284# a_9291_13088# a_10031_13043# VGND.t46 sg13_lv_nmos ad=0.3473p pd=2.71u as=0.12665p ps=1.145u w=0.74u l=0.13u
X292 VGND.t424 VPWR VGND.t424 VGND.t426 sg13_lv_nmos ad=0.1428p pd=1.52u as=0 ps=0 w=0.42u l=1u
X293 VGND.t333 VPWR VGND.t333 VGND.t332 sg13_lv_nmos ad=0.1428p pd=1.52u as=0 ps=0 w=0.42u l=1u
X294 VGND.t127 a_5326_13995# sg13cmos5l_dlygate4sd3_1_2.X VGND.t126 sg13_lv_nmos ad=0.1426p pd=1.16u as=0.2516p ps=2.16u w=0.74u l=0.13u
X295 sg13cmos5l_buf_1_1.X a_808_8468# VPWR VPWR sg13_lv_pmos ad=0.42p pd=2.99u as=0.2114p ps=1.54u w=1.12u l=0.13u
X296 VPWR VGND.t410 VPWR VPWR sg13_lv_pmos ad=0.19p pd=1.38u as=0 ps=0 w=1u l=1u
X297 VPWR VGND.t27 VPWR VPWR sg13_lv_pmos ad=0.34p pd=2.68u as=0 ps=0 w=1u l=1u
X298 VGND.t747 VPWR VGND.t747 VGND.t761 sg13_lv_nmos ad=0.1428p pd=1.52u as=0 ps=0 w=0.42u l=1u
X299 VGND.t608 VPWR VGND.t608 VGND.t609 sg13_lv_nmos ad=0.1428p pd=1.52u as=0 ps=0 w=0.42u l=1u
X300 VPWR a_5626_11675# sg13cmos5l_dfrbpq_1_0.RESET_B VPWR sg13_lv_pmos ad=2.16757p pd=13.96u as=0.3927p ps=2.99u w=1.155u l=0.13u
X301 VPWR VGND.t747 VPWR VPWR sg13_lv_pmos ad=0.34p pd=2.68u as=0 ps=0 w=1u l=1u
X302 a_10231_9906# a_10791_10160# a_10702_10257# VPWR sg13_lv_pmos ad=0.2048p pd=1.63u as=93.45f ps=0.865u w=0.42u l=0.13u
X303 VPWR VGND.t249 VPWR VPWR sg13_lv_pmos ad=0.34p pd=2.68u as=0 ps=0 w=1u l=1u
X304 VPWR VGND.t778 VPWR VPWR sg13_lv_pmos ad=0.19p pd=1.38u as=0 ps=0 w=1u l=1u
X305 VGND.t484 VPWR VGND.t484 VGND.t486 sg13_lv_nmos ad=0.1428p pd=1.52u as=0 ps=0 w=0.42u l=1u
X306 a_8004_9955# a_8235_10064# a_7690_10165# VGND.t21 sg13_lv_nmos ad=0.2373p pd=1.97u as=79.8f ps=0.8u w=0.42u l=0.13u
X307 VPWR VGND.t783 VPWR VPWR sg13_lv_pmos ad=0.19p pd=1.38u as=0 ps=0 w=1u l=1u
X308 VGND.t410 VPWR VGND.t410 VGND.t462 sg13_lv_nmos ad=79.8f pd=0.8u as=0 ps=0 w=0.42u l=1u
X309 a_5516_14442# sg13cmos5l_dfrbpq_1_0.Q VGND.t1055 VGND.t1054 sg13_lv_nmos ad=0.187p pd=1.78u as=0.14875p ps=1.16u w=0.55u l=0.13u
X310 VGND.t71 sg13cmos5l_dfrbpq_1_6.Q a_11368_14516# VGND.t1088 sg13_lv_nmos ad=0.14875p pd=1.16u as=0.187p ps=1.78u w=0.55u l=0.13u
X311 VPWR VGND.t260 VPWR VPWR sg13_lv_pmos ad=0.19p pd=1.38u as=0 ps=0 w=1u l=1u
X312 sg13cmos5l_buf_8_0.A a_8091_11458# VGND.t3 VGND.t15 sg13_lv_nmos ad=0.1406p pd=1.12u as=0.1406p ps=1.12u w=0.74u l=0.13u
X313 VPWR sg13cmos5l_nand4_1_1.A sg13cmos5l_nor3_2_0.C VPWR sg13_lv_pmos ad=0.3808p pd=2.92u as=0.2128p ps=1.5u w=1.12u l=0.13u
X314 VPWR VGND.t765 VPWR VPWR sg13_lv_pmos ad=0.19p pd=1.38u as=0 ps=0 w=1u l=1u
X315 VGND.t747 VPWR VGND.t747 VGND.t770 sg13_lv_nmos ad=0.1428p pd=1.52u as=0 ps=0 w=0.42u l=1u
X316 VGND.t400 VPWR VGND.t400 VGND.t399 sg13_lv_nmos ad=0.1428p pd=1.52u as=0 ps=0 w=0.42u l=1u
X317 VPWR VGND.t71 VPWR VPWR sg13_lv_pmos ad=0.34p pd=2.68u as=0 ps=0 w=1u l=1u
X318 VPWR VGND.t765 VPWR VPWR sg13_lv_pmos ad=0.34p pd=2.68u as=0 ps=0 w=1u l=1u
X319 VGND.t59 a_8986_14446# a_8705_14668# VGND.t1019 sg13_lv_nmos ad=79.8f pd=0.8u as=0.1428p ps=1.52u w=0.42u l=0.5u
X320 VGND.t882 VPWR VGND.t884 VGND.t883 sg13_lv_nmos ad=79.8f pd=0.8u as=0 ps=0 w=0.42u l=1u
X321 a_4426_11422# sg13cmos5l_buf_8_0.A VPWR VPWR sg13_lv_pmos ad=0.2128p pd=1.5u as=0.2128p ps=1.5u w=1.12u l=0.13u
X322 sg13cmos5l_dfrbpq_1_7.Q a_9642_10240# VPWR VPWR sg13_lv_pmos ad=0.3808p pd=2.92u as=0.2128p ps=1.5u w=1.12u l=0.13u
X323 a_5673_13357# a_5316_13284# VPWR VPWR sg13_lv_pmos ad=63f pd=0.72u as=0.1563p ps=1.22u w=0.42u l=0.13u
X324 a_10288_13186# sg13cmos5l_dfrbpq_1_4.RESET_B VPWR VPWR sg13_lv_pmos ad=79.8f pd=0.8u as=1.7455p ps=10.885u w=0.42u l=0.13u
X325 a_4932_10260# a_4906_10165# VGND.t57 VGND.t56 sg13_lv_nmos ad=0.2516p pd=2.16u as=0.1626p ps=1.415u w=0.74u l=0.13u
X326 VGND.t788 VPWR VGND.t788 VGND.t789 sg13_lv_nmos ad=0.1428p pd=1.52u as=0 ps=0 w=0.42u l=1u
X327 a_14828_14442# sg13cmos5l_dfrbpq_1_5.Q VPWR VPWR sg13_lv_pmos ad=0.2856p pd=2.36u as=0.2114p ps=1.54u w=0.84u l=0.13u
X328 VPWR VGND.t783 VPWR VPWR sg13_lv_pmos ad=0.34p pd=2.68u as=0 ps=0 w=1u l=1u
X329 VPWR VGND.t747 VPWR VPWR sg13_lv_pmos ad=0.19p pd=1.38u as=0 ps=0 w=1u l=1u
X330 sg13cmos5l_buf_8_0.A a_8091_11458# VGND.t7 VGND.t15 sg13_lv_nmos ad=0.1406p pd=1.12u as=0.1406p ps=1.12u w=0.74u l=0.13u
X331 VPWR VGND.t400 VPWR VPWR sg13_lv_pmos ad=0.19p pd=1.38u as=0 ps=0 w=1u l=1u
X332 VPWR VGND.t285 VPWR VPWR sg13_lv_pmos ad=0.34p pd=2.68u as=0 ps=0 w=1u l=1u
X333 VPWR VGND.t196 VPWR VPWR sg13_lv_pmos ad=0.34p pd=2.68u as=0 ps=0 w=1u l=1u
X334 VGND.t213 VPWR VGND.t215 VGND.t214 sg13_lv_nmos ad=79.8f pd=0.8u as=0 ps=0 w=0.42u l=1u
X335 sg13cmos5l_dfrbpq_1_7.CLK a_11355_11458# VGND.t16 VGND.t15 sg13_lv_nmos ad=0.1406p pd=1.12u as=0.1406p ps=1.12u w=0.74u l=0.13u
X336 a_4396_10240# sg13cmos5l_nor2_1_3.B sg13cmos5l_nor2_1_3.Y VPWR sg13_lv_pmos ad=0.1176p pd=1.33u as=0.3808p ps=2.92u w=1.12u l=0.13u
X337 a_3729_11776# sg13cmos5l_xor2_1_2.A VPWR VPWR sg13_lv_pmos ad=0.1225p pd=1.245u as=0.36p ps=2.72u w=1u l=0.13u
X338 a_10231_12180# a_10791_12303# a_10812_12577# VGND.t105 sg13_lv_nmos ad=0.12665p pd=1.145u as=0.3473p ps=2.71u w=0.74u l=0.13u
X339 sg13cmos5l_dfrbpq_1_1.D sg13cmos5l_a21oi_1_0.B1 VGND.t127 VGND.t1032 sg13_lv_nmos ad=0.1406p pd=1.12u as=0.2516p ps=2.16u w=0.74u l=0.13u
X340 VGND.t124 sg13cmos5l_nand4_1_0.C a_1914_13162# VGND.t976 sg13_lv_nmos ad=0.374p pd=2.46u as=0.17462p ps=1.185u w=0.55u l=0.13u
X341 VGND.t260 VPWR VGND.t260 VGND.t263 sg13_lv_nmos ad=0.1428p pd=1.52u as=0 ps=0 w=0.42u l=1u
X342 a_5158_9955# sg13cmos5l_dfrbpq_1_0.RESET_B VGND.t57 VGND.t1002 sg13_lv_nmos ad=37.8f pd=0.6u as=0.1701p ps=1.65u w=0.42u l=0.13u
X343 sg13cmos5l_dfrbpq_1_1.D sg13cmos5l_dlygate4sd3_1_2.X a_5162_14776# VPWR sg13_lv_pmos ad=0.3808p pd=2.92u as=0.1176p ps=1.33u w=1.12u l=0.13u
X344 VGND.t12 sg13cmos5l_nor2_1_1.B sg13cmos5l_nor2_1_1.Y VGND.t995 sg13_lv_nmos ad=0.2516p pd=2.16u as=0.1406p ps=1.12u w=0.74u l=0.13u
X345 VGND.t208 VPWR VGND.t208 VGND.t240 sg13_lv_nmos ad=0.1428p pd=1.52u as=0 ps=0 w=0.42u l=1u
X346 VPWR VGND.t96 VPWR VPWR sg13_lv_pmos ad=0.34p pd=2.68u as=0 ps=0 w=1u l=1u
X347 VGND.t747 VPWR VGND.t747 VGND.t763 sg13_lv_nmos ad=0.1428p pd=1.52u as=0 ps=0 w=0.42u l=1u
X348 VGND.t392 VPWR VGND.t392 VGND.t391 sg13_lv_nmos ad=0.1428p pd=1.52u as=0 ps=0 w=0.42u l=1u
X349 VPWR sg13cmos5l_tiehi_0.L_HI a_3850_10672# VPWR sg13_lv_pmos ad=0.1563p pd=1.22u as=0.147p ps=1.54u w=0.42u l=0.13u
X350 a_11355_11458# sg13cmos5l_buf_8_0.A VGND.t16 VGND.t15 sg13_lv_nmos ad=0.1406p pd=1.12u as=0.1406p ps=1.12u w=0.74u l=0.13u
X351 VPWR VGND.t747 VPWR VPWR sg13_lv_pmos ad=0.34p pd=2.68u as=0 ps=0 w=1u l=1u
X352 VPWR VGND.t521 VPWR VPWR sg13_lv_pmos ad=0.19p pd=1.38u as=0 ps=0 w=1u l=1u
X353 VGND.t3 a_8878_10971# sg13cmos5l_o21ai_1_0.B1 VGND.t2 sg13_lv_nmos ad=0.1426p pd=1.16u as=0.2516p ps=2.16u w=0.74u l=0.13u
X354 a_9394_9942# sg13cmos5l_tiehi_5.L_HI VGND.t62 VGND.t954 sg13_lv_nmos ad=37.8f pd=0.6u as=79.8f ps=0.8u w=0.42u l=0.13u
X355 VGND.t23 a_2039_10023# a_2039_10023# VGND.t97 sg13_lv_nmos ad=2.99005p pd=19.165u as=0.111p ps=1.34u w=0.3u l=0.13u
X356 VPWR a_11078_10704# a_11190_10728# VPWR sg13_lv_pmos ad=0.2254p pd=1.53u as=0.34p ps=2.68u w=1u l=0.5u
X357 a_12250_14446# sg13cmos5l_o21ai_1_1.Y VGND.t71 VGND.t1067 sg13_lv_nmos ad=0.1428p pd=1.52u as=79.8f ps=0.8u w=0.42u l=0.13u
X358 VPWR VGND.t783 VPWR VPWR sg13_lv_pmos ad=0.19p pd=1.38u as=0 ps=0 w=1u l=1u
X359 VGND.t410 VPWR VGND.t419 VGND.t464 sg13_lv_nmos ad=79.8f pd=0.8u as=0 ps=0 w=0.42u l=1u
X360 a_4740_9942# sg13cmos5l_nor2_1_3.Y a_4646_9942# VGND.t185 sg13_lv_nmos ad=60.89999f pd=0.71u as=0.1428p ps=1.52u w=0.42u l=0.13u
X361 VGND.t10 a_10031_13043# a_10698_13264# VGND.t46 sg13_lv_nmos ad=0.1406p pd=1.12u as=0.2516p ps=2.16u w=0.74u l=0.13u
X362 VPWR VGND.t224 VPWR VPWR sg13_lv_pmos ad=0.19p pd=1.38u as=0 ps=0 w=1u l=1u
X363 VPWR VGND.t1 VPWR VPWR sg13_lv_pmos ad=0.34p pd=2.68u as=0 ps=0 w=1u l=1u
X364 VPWR VGND.t18 VPWR VPWR sg13_lv_pmos ad=0.34p pd=2.68u as=0 ps=0 w=1u l=1u
X365 VGND.t700 VPWR VGND.t700 VGND.t86 sg13_lv_nmos ad=79.8f pd=0.8u as=0 ps=0 w=0.42u l=1u
X366 VPWR VGND.t608 VPWR VPWR sg13_lv_pmos ad=0.34p pd=2.68u as=0 ps=0 w=1u l=1u
X367 VPWR VGND.t700 VPWR VPWR sg13_lv_pmos ad=0.19p pd=1.38u as=0 ps=0 w=1u l=1u
X368 VGND.t148 VPWR VGND.t148 VGND.t293 sg13_lv_nmos ad=79.8f pd=0.8u as=0 ps=0 w=0.42u l=1u
X369 VGND.t433 VPWR VGND.t438 VGND.t480 sg13_lv_nmos ad=79.8f pd=0.8u as=0 ps=0 w=0.42u l=1u
X370 VGND.t1 VPWR VGND.t1 VGND.t338 sg13_lv_nmos ad=0.1428p pd=1.52u as=0 ps=0 w=0.42u l=1u
X371 VPWR VGND.t59 VPWR VPWR sg13_lv_pmos ad=0.34p pd=2.68u as=0 ps=0 w=1u l=1u
X372 a_1914_10704# sg13cmos5l_xnor2_1_0.B sg13cmos5l_nor2_1_0.B VPWR sg13_lv_pmos ad=0.1428p pd=1.375u as=0.2408p ps=1.55u w=1.12u l=0.13u
X373 VGND.t788 VPWR VGND.t788 VGND.t791 sg13_lv_nmos ad=0.1428p pd=1.52u as=0 ps=0 w=0.42u l=1u
X374 VGND.t484 VPWR VGND.t484 VGND.t486 sg13_lv_nmos ad=0.1428p pd=1.52u as=0 ps=0 w=0.42u l=1u
X375 VPWR VGND.t788 VPWR VPWR sg13_lv_pmos ad=0.34p pd=2.68u as=0 ps=0 w=1u l=1u
X376 VPWR VGND.t747 VPWR VPWR sg13_lv_pmos ad=0.19p pd=1.38u as=0 ps=0 w=1u l=1u
X377 VPWR VGND.t405 VPWR VPWR sg13_lv_pmos ad=0.19p pd=1.38u as=0 ps=0 w=1u l=1u
X378 VGND.t313 VPWR VGND.t312 VGND.t15 sg13_lv_nmos ad=0.1428p pd=1.52u as=0 ps=0 w=0.42u l=1u
X379 VGND.t887 VPWR VGND.t889 VGND.t888 sg13_lv_nmos ad=79.8f pd=0.8u as=0 ps=0 w=0.42u l=1u
X380 VPWR sg13cmos5l_tiehi_0.L_HI a_3590_11142# VPWR sg13_lv_pmos ad=0.36237p pd=2.605u as=79.8f ps=0.8u w=0.42u l=0.13u
X381 a_8307_14076# sg13cmos5l_or3_1_2.X VGND.t59 VGND.t136 sg13_lv_nmos ad=0.1406p pd=1.12u as=0.2516p ps=2.16u w=0.74u l=0.13u
X382 VPWR VGND.t747 VPWR VPWR sg13_lv_pmos ad=0.34p pd=2.68u as=0 ps=0 w=1u l=1u
X383 VGND.t424 VPWR VGND.t424 VGND.t474 sg13_lv_nmos ad=79.8f pd=0.8u as=0 ps=0 w=0.42u l=1u
X384 VGND.t31 sg13cmos5l_dfrbpq_1_7.CLK a_10943_12187# VGND.t66 sg13_lv_nmos ad=3.92842p pd=25.025u as=0.2516p ps=2.16u w=0.74u l=0.13u
X385 VGND.t676 VPWR VGND.t676 VGND.t86 sg13_lv_nmos ad=79.8f pd=0.8u as=0 ps=0 w=0.42u l=1u
X386 VGND.t75 a_5392_12458# a_5041_12577# VGND.t131 sg13_lv_nmos ad=79.8f pd=0.8u as=0.1428p ps=1.52u w=0.42u l=0.13u
X387 VPWR VGND.t204 VPWR VPWR sg13_lv_pmos ad=0.34p pd=2.68u as=0 ps=0 w=1u l=1u
X388 VGND.t212 a_10138_13692# a_9857_13994# VGND.t989 sg13_lv_nmos ad=79.8f pd=0.8u as=0.1428p ps=1.52u w=0.42u l=0.5u
X389 a_1418_10704# sg13cmos5l_a21oi_1_0.B1 VPWR VPWR sg13_lv_pmos ad=0.1176p pd=1.33u as=0.4032p ps=2.96u w=1.12u l=0.13u
X390 VPWR VGND.t778 VPWR VPWR sg13_lv_pmos ad=0.19p pd=1.38u as=0 ps=0 w=1u l=1u
X391 VPWR VGND.t295 VPWR VPWR sg13_lv_pmos ad=0.19p pd=1.38u as=0 ps=0 w=1u l=1u
X392 a_11828_10668# sg13cmos5l_buf_1_1.X VPWR VPWR sg13_lv_pmos ad=0.2856p pd=2.36u as=0.2618p ps=1.63u w=0.84u l=0.13u
X393 VGND.t307 VPWR VGND.t306 VGND.t15 sg13_lv_nmos ad=0.1428p pd=1.52u as=0 ps=0 w=0.42u l=1u
X394 a_5392_12458# a_5135_12577# a_5554_12654# VGND.t971 sg13_lv_nmos ad=0.1428p pd=1.52u as=37.8f ps=0.6u w=0.42u l=0.13u
X395 VPWR VGND.t12 VPWR VPWR sg13_lv_pmos ad=0.19p pd=1.38u as=0 ps=0 w=1u l=1u
X396 VPWR VGND.t395 VPWR VPWR sg13_lv_pmos ad=0.19p pd=1.38u as=0 ps=0 w=1u l=1u
X397 VPWR VGND.t260 VPWR VPWR sg13_lv_pmos ad=0.19p pd=1.38u as=0 ps=0 w=1u l=1u
X398 VGND.t27 VPWR VGND.t387 VGND.t386 sg13_lv_nmos ad=79.8f pd=0.8u as=0 ps=0 w=0.42u l=1u
X399 VPWR VGND.t747 VPWR VPWR sg13_lv_pmos ad=0.34p pd=2.68u as=0 ps=0 w=1u l=1u
X400 a_4906_10165# a_5349_9921# a_5289_10333# VPWR sg13_lv_pmos ad=79.8f pd=0.8u as=63f ps=0.72u w=0.42u l=0.13u
X401 sg13cmos5l_nor2_1_1.Y sg13cmos5l_nor2_1_1.B a_1802_12216# VPWR sg13_lv_pmos ad=0.3808p pd=2.92u as=0.1176p ps=1.33u w=1.12u l=0.13u
X402 a_4233_12263# a_3876_12220# VPWR VPWR sg13_lv_pmos ad=63f pd=0.72u as=0.1563p ps=1.22u w=0.42u l=0.13u
X403 VPWR VGND.t208 VPWR VPWR sg13_lv_pmos ad=0.34p pd=2.68u as=0 ps=0 w=1u l=1u
X404 VPWR VGND.t700 VPWR VPWR sg13_lv_pmos ad=0.19p pd=1.38u as=0 ps=0 w=1u l=1u
X405 VPWR VGND.t688 VPWR VPWR sg13_lv_pmos ad=0.19p pd=1.38u as=0 ps=0 w=1u l=1u
X406 VGND.t419 VPWR VGND.t419 VGND.t466 sg13_lv_nmos ad=79.8f pd=0.8u as=0 ps=0 w=0.42u l=1u
X407 a_7716_10260# a_7690_10165# VGND.t6 VGND.t21 sg13_lv_nmos ad=0.2516p pd=2.16u as=0.1626p ps=1.415u w=0.74u l=0.13u
X408 VPWR VGND.t778 VPWR VPWR sg13_lv_pmos ad=0.34p pd=2.68u as=0 ps=0 w=1u l=1u
X409 VPWR VGND.t752 VPWR VPWR sg13_lv_pmos ad=0.19p pd=1.38u as=0 ps=0 w=1u l=1u
X410 sg13cmos5l_or3_1_2.X a_7849_12970# VGND.t125 VGND.t43 sg13_lv_nmos ad=0.2516p pd=2.16u as=0.13395p ps=1.12u w=0.74u l=0.13u
X411 VPWR sg13cmos5l_nand4_1_1.A a_8045_13264# VPWR sg13_lv_pmos ad=0.3822p pd=1.84u as=0.1575p ps=1.315u w=1u l=0.13u
X412 sg13cmos5l_buf_1_0.X a_808_3144# VPWR VPWR sg13_lv_pmos ad=0.42p pd=2.99u as=0.2114p ps=1.54u w=1.12u l=0.13u
X413 VPWR VGND.t308 VPWR VPWR sg13_lv_pmos ad=0.34p pd=2.68u as=0 ps=0 w=1u l=1u
X414 VGND.t937 VPWR VGND.t936 VGND.t935 sg13_lv_nmos ad=0.1428p pd=1.52u as=0 ps=0 w=0.42u l=1u
X415 VPWR sg13cmos5l_nand2_1_1.A sg13cmos5l_nand2_1_1.Y VPWR sg13_lv_pmos ad=0.3808p pd=2.92u as=0.2128p ps=1.5u w=1.12u l=0.13u
X416 VPWR VGND.t202 VPWR VPWR sg13_lv_pmos ad=0.34p pd=2.68u as=0 ps=0 w=1u l=1u
X417 sg13cmos5l_nand2_1_1.A a_7242_13264# VPWR VPWR sg13_lv_pmos ad=0.3808p pd=2.92u as=0.2128p ps=1.5u w=1.12u l=0.13u
X418 a_10031_13043# a_9189_12945# a_9937_13043# VGND.t46 sg13_lv_nmos ad=0.12665p pd=1.145u as=0.1428p ps=1.52u w=0.42u l=0.13u
X419 VPWR a_9836_14442# count_o[4] VPWR sg13_lv_pmos ad=0.2114p pd=1.54u as=0.42p ps=2.99u w=1.12u l=0.13u
X420 a_3850_12184# a_4293_12227# a_4233_12263# VPWR sg13_lv_pmos ad=79.8f pd=0.8u as=63f ps=0.72u w=0.42u l=0.13u
X421 a_8486_12966# sg13cmos5l_dfrbpq_1_4.D VPWR VPWR sg13_lv_pmos ad=79.8f pd=0.8u as=0.1428p ps=1.52u w=0.42u l=0.13u
X422 VPWR VGND.t676 VPWR VPWR sg13_lv_pmos ad=0.19p pd=1.38u as=0 ps=0 w=1u l=1u
X423 a_12235_11052# sg13cmos5l_dlygate4sd3_1_12.X a_12141_11052# VGND.t2 sg13_lv_nmos ad=0.1216p pd=1.02u as=0.2176p ps=1.96u w=0.64u l=0.13u
X424 a_2070_12982# sg13cmos5l_nand2_1_0.Y sg13cmos5l_nor2_1_1.B VGND.t122 sg13_lv_nmos ad=88.8f pd=0.98u as=0.1628p ps=1.18u w=0.74u l=0.13u
X425 VGND.t747 VPWR VGND.t747 VGND.t776 sg13_lv_nmos ad=0.1428p pd=1.52u as=0 ps=0 w=0.42u l=1u
X426 sg13cmos5l_mux2_1_0.X a_11518_9562# VGND.t1 VGND.t91 sg13_lv_nmos ad=0.4033p pd=2.57u as=0.148p ps=1.14u w=0.74u l=0.13u
X427 a_7271_10728# sg13cmos5l_nand2_1_1.Y a_7177_10728# VPWR sg13_lv_pmos ad=0.19p pd=1.38u as=0.34p ps=2.68u w=1u l=0.13u
X428 VGND.t18 a_11462_12970# a_11574_13034# VGND.t943 sg13_lv_nmos ad=0.1426p pd=1.16u as=0.1428p ps=1.52u w=0.42u l=0.5u
X429 VPWR VGND.t788 VPWR VPWR sg13_lv_pmos ad=0.34p pd=2.68u as=0 ps=0 w=1u l=1u
X430 VGND.t226 VPWR VGND.t224 VGND.t225 sg13_lv_nmos ad=0.1428p pd=1.52u as=0 ps=0 w=0.42u l=1u
X431 VPWR VGND.t747 VPWR VPWR sg13_lv_pmos ad=0.34p pd=2.68u as=0 ps=0 w=1u l=1u
X432 VGND.t572 VPWR VGND.t572 VGND.t587 sg13_lv_nmos ad=79.8f pd=0.8u as=0 ps=0 w=0.42u l=1u
X433 VGND.t424 VPWR VGND.t433 VGND.t476 sg13_lv_nmos ad=79.8f pd=0.8u as=0 ps=0 w=0.42u l=1u
X434 a_7524_9942# sg13cmos5l_dlygate4sd3_1_15.X a_7430_9942# VGND.t111 sg13_lv_nmos ad=60.89999f pd=0.71u as=0.1428p ps=1.52u w=0.42u l=0.13u
X435 sg13cmos5l_dfrbpq_1_0.CLK a_4426_11422# VGND.t2 VGND.t1122 sg13_lv_nmos ad=0.1406p pd=1.12u as=0.1406p ps=1.12u w=0.74u l=0.13u
X436 VPWR VGND.t778 VPWR VPWR sg13_lv_pmos ad=0.19p pd=1.38u as=0 ps=0 w=1u l=1u
X437 a_11380_13752# sg13cmos5l_inv_1_1.A VPWR VPWR sg13_lv_pmos ad=0.1575p pd=1.315u as=0.3822p ps=1.84u w=1u l=0.13u
X438 VPWR VGND.t572 VPWR VPWR sg13_lv_pmos ad=0.19p pd=1.38u as=0 ps=0 w=1u l=1u
X439 VGND.t3 a_9274_10668# a_8993_10970# VGND.t2 sg13_lv_nmos ad=79.8f pd=0.8u as=0.1428p ps=1.52u w=0.42u l=0.5u
X440 VPWR VGND.t51 VPWR VPWR sg13_lv_pmos ad=0.19p pd=1.38u as=0 ps=0 w=1u l=1u
X441 VPWR sg13cmos5l_o21ai_1_0.B1 sg13cmos5l_o21ai_1_0.Y VPWR sg13_lv_pmos ad=0.3808p pd=2.92u as=0.2128p ps=1.5u w=1.12u l=0.15u
X442 VGND.t250 VPWR VGND.t249 VGND.t248 sg13_lv_nmos ad=0.1428p pd=1.52u as=0 ps=0 w=0.42u l=1u
X443 VPWR VGND.t484 VPWR VPWR sg13_lv_pmos ad=0.34p pd=2.68u as=0 ps=0 w=1u l=1u
X444 sg13cmos5l_buf_8_0.A a_8091_11458# VPWR VPWR sg13_lv_pmos ad=0.2128p pd=1.5u as=0.2128p ps=1.5u w=1.12u l=0.13u
X445 a_4462_13995# a_4577_13994# VGND.t200 VGND.t961 sg13_lv_nmos ad=0.1428p pd=1.52u as=0.1426p ps=1.16u w=0.42u l=0.5u
X446 sg13cmos5l_buf_1_0.X a_808_3144# VGND.t87 VGND.t86 sg13_lv_nmos ad=0.2886p pd=2.26u as=0.14875p ps=1.16u w=0.74u l=0.13u
X447 VGND.t867 VPWR VGND.t866 VGND.t865 sg13_lv_nmos ad=0.1428p pd=1.52u as=0 ps=0 w=0.42u l=1u
X448 VPWR VGND.t228 VPWR VPWR sg13_lv_pmos ad=0.19p pd=1.38u as=0 ps=0 w=1u l=1u
X449 VPWR VGND.t765 VPWR VPWR sg13_lv_pmos ad=0.34p pd=2.68u as=0 ps=0 w=1u l=1u
X450 sg13cmos5l_xor2_1_2.B a_4085_14482# VGND.t200 VGND.t1015 sg13_lv_nmos ad=0.1406p pd=1.12u as=0.3293p ps=1.63u w=0.74u l=0.13u
X451 VPWR VGND.t260 VPWR VPWR sg13_lv_pmos ad=0.19p pd=1.38u as=0 ps=0 w=1u l=1u
X452 VPWR VGND.t410 VPWR VPWR sg13_lv_pmos ad=0.34p pd=2.68u as=0 ps=0 w=1u l=1u
X453 VGND.t304 VPWR VGND.t305 VGND.t15 sg13_lv_nmos ad=79.8f pd=0.8u as=0 ps=0 w=0.42u l=1u
X454 sg13cmos5l_nor3_2_0.C sg13cmos5l_dfrbpq_1_0.Q VPWR VPWR sg13_lv_pmos ad=0.2128p pd=1.5u as=0.3808p ps=2.92u w=1.12u l=0.13u
X455 VGND.t405 VPWR VGND.t405 VGND.t454 sg13_lv_nmos ad=79.8f pd=0.8u as=0 ps=0 w=0.42u l=1u
X456 sg13cmos5l_dfrbpq_1_0.CLK a_4426_11422# VGND.t2 VGND.t1118 sg13_lv_nmos ad=0.1406p pd=1.12u as=0.2516p ps=2.16u w=0.74u l=0.13u
X457 a_6778_12180# sg13cmos5l_nand2_1_1.A VGND.t44 VGND.t135 sg13_lv_nmos ad=0.1428p pd=1.52u as=79.8f ps=0.8u w=0.42u l=0.13u
X458 VPWR a_13594_13969# sg13cmos5l_dfrbpq_1_6.RESET_B VPWR sg13_lv_pmos ad=1.7455p pd=10.885u as=0.3927p ps=2.99u w=1.155u l=0.13u
X459 a_8218_9156# sg13cmos5l_a21oi_1_0.Y VPWR VPWR sg13_lv_pmos ad=0.1428p pd=1.52u as=0.1523p ps=1.38u w=0.42u l=0.13u
X460 a_5829_11497# a_5829_11497# VGND.t2 VGND.t15 sg13_lv_nmos ad=0.111p pd=1.34u as=4.55085p ps=29.865u w=0.3u l=0.13u
X461 sg13cmos5l_buf_8_0.A a_8091_11458# VPWR VPWR sg13_lv_pmos ad=0.2128p pd=1.5u as=0.2128p ps=1.5u w=1.12u l=0.13u
X462 VGND.t419 VPWR VGND.t419 VGND.t465 sg13_lv_nmos ad=0.1428p pd=1.52u as=0 ps=0 w=0.42u l=1u
X463 VPWR VGND.t783 VPWR VPWR sg13_lv_pmos ad=0.34p pd=2.68u as=0 ps=0 w=1u l=1u
X464 sg13cmos5l_dfrbpq_1_7.CLK a_11355_11458# VPWR VPWR sg13_lv_pmos ad=0.2128p pd=1.5u as=0.2128p ps=1.5u w=1.12u l=0.13u
X465 VGND.t907 VPWR VGND.t909 VGND.t908 sg13_lv_nmos ad=79.8f pd=0.8u as=0 ps=0 w=0.42u l=1u
X466 a_10702_10257# a_10444_9942# VPWR VPWR sg13_lv_pmos ad=93.45f pd=0.865u as=1.38282p ps=8.655u w=0.42u l=0.13u
X467 VGND.t577 VPWR VGND.t572 VGND.t581 sg13_lv_nmos ad=79.8f pd=0.8u as=0 ps=0 w=0.42u l=1u
X468 VGND.t424 VPWR VGND.t424 VGND.t470 sg13_lv_nmos ad=79.8f pd=0.8u as=0 ps=0 w=0.42u l=1u
X469 VGND.t7 clk_i a_8091_11458# VGND.t15 sg13_lv_nmos ad=0.1406p pd=1.12u as=0.2553p ps=2.17u w=0.74u l=0.13u
X470 VGND.t198 VPWR VGND.t200 VGND.t199 sg13_lv_nmos ad=79.8f pd=0.8u as=0 ps=0 w=0.42u l=1u
X471 a_11462_12970# a_11192_12970# VPWR VPWR sg13_lv_pmos ad=0.34p pd=2.68u as=0.1523p ps=1.38u w=1u l=0.5u
X472 VPWR VGND.t747 VPWR VPWR sg13_lv_pmos ad=0.34p pd=2.68u as=0 ps=0 w=1u l=1u
X473 a_11733_12263# a_10791_12303# a_11594_12496# VGND.t106 sg13_lv_nmos ad=79.8f pd=0.8u as=0.2373p ps=1.97u w=0.42u l=0.13u
X474 VPWR VGND.t392 VPWR VPWR sg13_lv_pmos ad=0.19p pd=1.38u as=0 ps=0 w=1u l=1u
X475 sg13cmos5l_dlygate4sd3_1_12.X a_11190_10728# VGND.t16 VGND.t2 sg13_lv_nmos ad=0.2516p pd=2.16u as=0.1426p ps=1.16u w=0.74u l=0.13u
X476 a_11355_11458# sg13cmos5l_buf_8_0.A VPWR VPWR sg13_lv_pmos ad=0.2128p pd=1.5u as=0.2128p ps=1.5u w=1.12u l=0.13u
X477 VPWR VGND.t696 VPWR VPWR sg13_lv_pmos ad=0.19p pd=1.38u as=0 ps=0 w=1u l=1u
X478 VGND.t572 VPWR VGND.t590 VGND.t589 sg13_lv_nmos ad=79.8f pd=0.8u as=0 ps=0 w=0.42u l=1u
X479 VGND.t433 VPWR VGND.t433 VGND.t478 sg13_lv_nmos ad=79.8f pd=0.8u as=0 ps=0 w=0.42u l=1u
X480 VPWR VGND.t747 VPWR VPWR sg13_lv_pmos ad=0.34p pd=2.68u as=0 ps=0 w=1u l=1u
X481 VPWR VGND.t405 VPWR VPWR sg13_lv_pmos ad=0.34p pd=2.68u as=0 ps=0 w=1u l=1u
X482 VGND.t684 VPWR VGND.t684 VGND.t86 sg13_lv_nmos ad=79.8f pd=0.8u as=0 ps=0 w=0.42u l=1u
X483 a_13797_10741# a_13797_10741# VGND.t2 VGND.t2 sg13_lv_nmos ad=0.111p pd=1.34u as=4.55085p ps=29.865u w=0.3u l=0.13u
X484 a_7416_11772# sg13cmos5l_xor2_1_2.B VPWR VPWR sg13_lv_pmos ad=0.2128p pd=1.5u as=0.3808p ps=2.92u w=1.12u l=0.15u
X485 VGND.t222 VPWR VGND.t224 VGND.t223 sg13_lv_nmos ad=79.8f pd=0.8u as=0 ps=0 w=0.42u l=1u
X486 a_6191_10019# a_5349_9921# a_4932_10260# VPWR sg13_lv_pmos ad=0.2048p pd=1.63u as=0.34p ps=2.68u w=1u l=0.13u
X487 a_2142_13666# a_1943_13803# VGND.t59 VGND.t1092 sg13_lv_nmos ad=0.27427p pd=2.28u as=3.51557p ps=23.16u w=0.795u l=0.13u
X488 a_3932_11752# sg13cmos5l_xor2_1_2.B VPWR VPWR sg13_lv_pmos ad=0.2128p pd=1.5u as=0.2128p ps=1.5u w=1.12u l=0.13u
X489 VGND.t217 VPWR VGND.t71 VGND.t216 sg13_lv_nmos ad=0.1428p pd=1.52u as=0 ps=0 w=0.42u l=1u
X490 VGND.t16 sg13cmos5l_dfrbpq_1_5.Q a_10808_10745# VGND.t2 sg13_lv_nmos ad=79.8f pd=0.8u as=0.1428p ps=1.52u w=0.42u l=0.13u
X491 VPWR VGND.t395 VPWR VPWR sg13_lv_pmos ad=0.34p pd=2.68u as=0 ps=0 w=1u l=1u
X492 VGND.t783 VPWR VGND.t783 VGND.t784 sg13_lv_nmos ad=0.1428p pd=1.52u as=0 ps=0 w=0.42u l=1u
X493 VGND.t148 VPWR VGND.t295 VGND.t316 sg13_lv_nmos ad=79.8f pd=0.8u as=0 ps=0 w=0.42u l=1u
X494 VGND.t572 VPWR VGND.t572 VGND.t574 sg13_lv_nmos ad=79.8f pd=0.8u as=0 ps=0 w=0.42u l=1u
X495 VPWR a_6778_12180# a_6497_12482# VPWR sg13_lv_pmos ad=0.1523p pd=1.38u as=0.34p ps=2.68u w=1u l=0.5u
X496 VGND.t419 VPWR VGND.t419 VGND.t467 sg13_lv_nmos ad=0.1428p pd=1.52u as=0 ps=0 w=0.42u l=1u
X497 a_7702_14106# sg13cmos5l_nand3_1_1.Y VGND.t59 VGND.t941 sg13_lv_nmos ad=0.1406p pd=1.12u as=0.1406p ps=1.12u w=0.74u l=0.15u
X498 VPWR VGND.t788 VPWR VPWR sg13_lv_pmos ad=0.34p pd=2.68u as=0 ps=0 w=1u l=1u
X499 VGND.t837 VPWR VGND.t839 VGND.t838 sg13_lv_nmos ad=79.8f pd=0.8u as=0 ps=0 w=0.42u l=1u
X500 VPWR VGND.t874 VPWR VPWR sg13_lv_pmos ad=0.19p pd=1.38u as=0 ps=0 w=1u l=1u
X501 sg13cmos5l_mux2_1_0.A1 sg13cmos5l_dlygate4sd3_1_12.X VGND.t16 VGND.t2 sg13_lv_nmos ad=0.1406p pd=1.12u as=0.2516p ps=2.16u w=0.74u l=0.13u
X502 a_3708_12974# sg13cmos5l_buf_1_0.X sg13cmos5l_nand3_1_0.Y VGND.t144 sg13_lv_nmos ad=0.1406p pd=1.12u as=0.2516p ps=2.16u w=0.74u l=0.13u
X503 VGND.t572 VPWR VGND.t572 VGND.t583 sg13_lv_nmos ad=79.8f pd=0.8u as=0 ps=0 w=0.42u l=1u
X504 VGND.t424 VPWR VGND.t424 VGND.t472 sg13_lv_nmos ad=79.8f pd=0.8u as=0 ps=0 w=0.42u l=1u
X505 a_1388_14442# sg13cmos5l_dfrbpq_1_3.Q VPWR VPWR sg13_lv_pmos ad=0.2856p pd=2.36u as=0.2114p ps=1.54u w=0.84u l=0.13u
X506 a_3761_11508# sg13cmos5l_xor2_1_2.A VGND.t2 VGND.t182 sg13_lv_nmos ad=0.17462p pd=1.185u as=0.374p ps=2.46u w=0.55u l=0.13u
X507 VGND.t676 VPWR VGND.t676 VGND.t86 sg13_lv_nmos ad=79.8f pd=0.8u as=0 ps=0 w=0.42u l=1u
X508 a_4646_9942# a_5451_10064# a_4906_10165# VPWR sg13_lv_pmos ad=0.1428p pd=1.52u as=79.8f ps=0.8u w=0.42u l=0.13u
X509 VPWR VGND.t484 VPWR VPWR sg13_lv_pmos ad=0.34p pd=2.68u as=0 ps=0 w=1u l=1u
X510 VPWR a_6448_10162# a_6393_10257# VPWR sg13_lv_pmos ad=1.38282p pd=8.655u as=93.45f ps=0.865u w=0.42u l=0.13u
X511 VGND.t410 VPWR VGND.t410 VGND.t461 sg13_lv_nmos ad=0.1428p pd=1.52u as=0 ps=0 w=0.42u l=1u
X512 VGND.t59 VPWR VGND.t208 VGND.t207 sg13_lv_nmos ad=0.1428p pd=1.52u as=0 ps=0 w=0.42u l=1u
X513 a_7355_9192# sg13cmos5l_a21oi_1_0.B1 sg13cmos5l_a21oi_1_0.Y VPWR sg13_lv_pmos ad=0.2128p pd=1.5u as=0.3808p ps=2.92u w=1.12u l=0.13u
X514 VPWR VGND.t424 VPWR VPWR sg13_lv_pmos ad=0.34p pd=2.68u as=0 ps=0 w=1u l=1u
X515 VPWR VGND.t747 VPWR VPWR sg13_lv_pmos ad=0.34p pd=2.68u as=0 ps=0 w=1u l=1u
X516 VGND.t572 VPWR VGND.t577 VGND.t576 sg13_lv_nmos ad=79.8f pd=0.8u as=0 ps=0 w=0.42u l=1u
X517 a_7822_9459# a_7937_9458# VPWR VPWR sg13_lv_pmos ad=0.34p pd=2.68u as=0.2254p ps=1.53u w=1u l=0.5u
X518 a_10288_13186# a_10031_13043# a_10450_12966# VGND.t46 sg13_lv_nmos ad=0.1428p pd=1.52u as=37.8f ps=0.6u w=0.42u l=0.13u
X519 VGND.t672 VPWR VGND.t672 VGND.t86 sg13_lv_nmos ad=79.8f pd=0.8u as=0 ps=0 w=0.42u l=1u
X520 VGND.t16 sg13cmos5l_inv_1_1.A sg13cmos5l_nor3_2_0.A VGND.t15 sg13_lv_nmos ad=0.2516p pd=2.16u as=0.2516p ps=2.16u w=0.74u l=0.13u
X521 sg13cmos5l_xor2_1_1.X a_3642_13691# VGND.t198 VGND.t973 sg13_lv_nmos ad=0.1628p pd=1.18u as=0.3108p ps=2.32u w=0.74u l=0.13u
X522 VGND.t433 VPWR VGND.t433 VGND.t477 sg13_lv_nmos ad=0.1428p pd=1.52u as=0 ps=0 w=0.42u l=1u
X523 VPWR VGND.t410 VPWR VPWR sg13_lv_pmos ad=0.19p pd=1.38u as=0 ps=0 w=1u l=1u
X524 VGND.t837 VPWR VGND.t836 VGND.t835 sg13_lv_nmos ad=0.1428p pd=1.52u as=0 ps=0 w=0.42u l=1u
X525 a_8805_9229# a_8805_9229# VGND.t23 VGND.t47 sg13_lv_nmos ad=0.111p pd=1.34u as=2.99005p ps=19.165u w=0.3u l=0.13u
X526 a_11639_10333# a_10943_10212# a_11733_10100# VGND.t946 sg13_lv_nmos ad=0.1296p pd=1.52u as=79.8f ps=0.8u w=0.42u l=0.13u
X527 VGND.t303 sg13cmos5l_buf_1_1.X a_12235_11052# VGND.t2 sg13_lv_nmos ad=0.1331p pd=1.12u as=0.1216p ps=1.02u w=0.64u l=0.13u
X528 VGND.t7 sg13cmos5l_nand2_1_1.Y a_7177_10728# VGND.t2 sg13_lv_nmos ad=0.1045p pd=0.93u as=0.187p ps=1.78u w=0.55u l=0.13u
X529 VPWR VGND.t778 VPWR VPWR sg13_lv_pmos ad=0.34p pd=2.68u as=0 ps=0 w=1u l=1u
X530 VPWR VGND.t859 VPWR VPWR sg13_lv_pmos ad=0.19p pd=1.38u as=0 ps=0 w=1u l=1u
X531 VGND.t59 a_1943_14033# a_1943_14033# VGND.t1060 sg13_lv_nmos ad=3.51557p pd=23.16u as=0.111p ps=1.34u w=0.3u l=0.13u
X532 VGND.t164 a_6382_12483# sg13cmos5l_dlygate4sd3_1_1.X VGND.t135 sg13_lv_nmos ad=0.1426p pd=1.16u as=0.2516p ps=2.16u w=0.74u l=0.13u
X533 VGND.t484 VPWR VGND.t484 VGND.t499 sg13_lv_nmos ad=79.8f pd=0.8u as=0 ps=0 w=0.42u l=1u
X534 VPWR VGND.t400 VPWR VPWR sg13_lv_pmos ad=0.34p pd=2.68u as=0 ps=0 w=1u l=1u
X535 VPWR sg13cmos5l_tiehi_5.L_HI a_7690_10165# VPWR sg13_lv_pmos ad=0.1563p pd=1.22u as=0.147p ps=1.54u w=0.42u l=0.13u
X536 VPWR VGND.t405 VPWR VPWR sg13_lv_pmos ad=0.19p pd=1.38u as=0 ps=0 w=1u l=1u
X537 a_7148_14442# sg13cmos5l_nand2_1_1.A VPWR VPWR sg13_lv_pmos ad=0.2856p pd=2.36u as=0.2114p ps=1.54u w=0.84u l=0.13u
X538 a_10791_12303# a_10943_12187# VPWR VPWR sg13_lv_pmos ad=0.3864p pd=2.93u as=2.16757p ps=13.96u w=1.12u l=0.13u
X539 VGND.t410 VPWR VGND.t410 VGND.t415 sg13_lv_nmos ad=79.8f pd=0.8u as=0 ps=0 w=0.42u l=1u
X540 VGND.t7 a_6682_10668# a_6401_10970# VGND.t2 sg13_lv_nmos ad=79.8f pd=0.8u as=0.1428p ps=1.52u w=0.42u l=0.5u
X541 VPWR VGND.t788 VPWR VPWR sg13_lv_pmos ad=0.34p pd=2.68u as=0 ps=0 w=1u l=1u
X542 VGND.t405 VPWR VGND.t405 VGND.t455 sg13_lv_nmos ad=0.1428p pd=1.52u as=0 ps=0 w=0.42u l=1u
X543 VPWR VGND.t124 VPWR VPWR sg13_lv_pmos ad=0.34p pd=2.68u as=0 ps=0 w=1u l=1u
X544 VPWR a_5135_12577# a_5802_12216# VPWR sg13_lv_pmos ad=0.2128p pd=1.5u as=0.3864p ps=2.93u w=1.12u l=0.13u
X545 VGND.t59 a_8590_14667# sg13cmos5l_a21oi_1_2.A1 VGND.t1023 sg13_lv_nmos ad=0.1426p pd=1.16u as=0.2516p ps=2.16u w=0.74u l=0.13u
X546 a_11639_12263# sg13cmos5l_dfrbpq_1_6.RESET_B VPWR VPWR sg13_lv_pmos ad=79.8f pd=0.8u as=0.36237p ps=2.605u w=0.42u l=0.13u
X547 a_4293_12227# sg13cmos5l_dfrbpq_1_0.CLK VGND.t31 VGND.t176 sg13_lv_nmos ad=0.2516p pd=2.16u as=3.92842p ps=25.025u w=0.74u l=0.13u
X548 VGND.t383 VPWR VGND.t1 VGND.t382 sg13_lv_nmos ad=0.1428p pd=1.52u as=0 ps=0 w=0.42u l=1u
X549 VGND.t44 a_6832_13186# a_6481_13043# VGND.t43 sg13_lv_nmos ad=79.8f pd=0.8u as=0.1428p ps=1.52u w=0.42u l=0.13u
X550 VGND.t663 VPWR VGND.t667 VGND.t86 sg13_lv_nmos ad=79.8f pd=0.8u as=0 ps=0 w=0.42u l=1u
X551 sg13cmos5l_dfrbpq_1_0.CLK a_4426_11422# VPWR VPWR sg13_lv_pmos ad=0.2128p pd=1.5u as=0.2128p ps=1.5u w=1.12u l=0.13u
X552 a_10138_13692# sg13cmos5l_dfrbpq_1_4.Q VPWR VPWR sg13_lv_pmos ad=0.1428p pd=1.52u as=0.1523p ps=1.38u w=0.42u l=0.13u
X553 VGND.t433 VPWR VGND.t433 VGND.t434 sg13_lv_nmos ad=79.8f pd=0.8u as=0 ps=0 w=0.42u l=1u
X554 VGND.t842 VPWR VGND.t844 VGND.t843 sg13_lv_nmos ad=79.8f pd=0.8u as=0 ps=0 w=0.42u l=1u
X555 VPWR VGND.t572 VPWR VPWR sg13_lv_pmos ad=0.19p pd=1.38u as=0 ps=0 w=1u l=1u
X556 a_5516_14442# sg13cmos5l_dfrbpq_1_0.Q VPWR VPWR sg13_lv_pmos ad=0.2856p pd=2.36u as=0.2114p ps=1.54u w=0.84u l=0.13u
X557 a_5349_9921# sg13cmos5l_dfrbpq_1_0.CLK VGND.t23 VGND.t170 sg13_lv_nmos ad=0.2516p pd=2.16u as=2.99005p ps=19.165u w=0.74u l=0.13u
X558 VPWR sg13cmos5l_dfrbpq_1_6.Q a_11368_14516# VPWR sg13_lv_pmos ad=0.2114p pd=1.54u as=0.2856p ps=2.36u w=0.84u l=0.13u
X559 VPWR VGND.t676 VPWR VPWR sg13_lv_pmos ad=0.34p pd=2.68u as=0 ps=0 w=1u l=1u
X560 VGND.t410 VPWR VGND.t410 VGND.t463 sg13_lv_nmos ad=0.1428p pd=1.52u as=0 ps=0 w=0.42u l=1u
X561 VGND.t226 VPWR VGND.t228 VGND.t227 sg13_lv_nmos ad=79.8f pd=0.8u as=0 ps=0 w=0.42u l=1u
X562 a_11695_9216# sg13cmos5l_mux2_1_0.A1 a_11518_9562# VPWR sg13_lv_pmos ad=0.2975p pd=1.595u as=0.2225p ps=1.445u w=1u l=0.13u
X563 a_5337_12339# a_4395_12227# a_5135_12577# VPWR sg13_lv_pmos ad=93.45f pd=0.865u as=0.2048p ps=1.63u w=0.42u l=0.13u
X564 VGND.t577 VPWR VGND.t577 VGND.t579 sg13_lv_nmos ad=79.8f pd=0.8u as=0 ps=0 w=0.42u l=1u
X565 VGND.t484 VPWR VGND.t484 VGND.t493 sg13_lv_nmos ad=79.8f pd=0.8u as=0 ps=0 w=0.42u l=1u
X566 VPWR VGND.t392 VPWR VPWR sg13_lv_pmos ad=0.34p pd=2.68u as=0 ps=0 w=1u l=1u
X567 VGND.t672 VPWR VGND.t672 VGND.t86 sg13_lv_nmos ad=79.8f pd=0.8u as=0 ps=0 w=0.42u l=1u
X568 VGND.t887 VPWR VGND.t886 VGND.t885 sg13_lv_nmos ad=0.1428p pd=1.52u as=0 ps=0 w=0.42u l=1u
X569 VPWR VGND.t6 VPWR VPWR sg13_lv_pmos ad=0.19p pd=1.38u as=0 ps=0 w=1u l=1u
X570 a_8218_9156# sg13cmos5l_a21oi_1_0.Y VGND.t53 VGND.t47 sg13_lv_nmos ad=0.1428p pd=1.52u as=79.8f ps=0.8u w=0.42u l=0.13u
X571 sg13cmos5l_dfrbpq_1_0.CLK a_4426_11422# VPWR VPWR sg13_lv_pmos ad=0.2128p pd=1.5u as=0.3864p ps=2.93u w=1.12u l=0.13u
X572 VGND.t590 VPWR VGND.t590 VGND.t591 sg13_lv_nmos ad=0.1428p pd=1.52u as=0 ps=0 w=0.42u l=1u
X573 VGND.t433 VPWR VGND.t433 VGND.t479 sg13_lv_nmos ad=0.1428p pd=1.52u as=0 ps=0 w=0.42u l=1u
X574 VPWR VGND.t395 VPWR VPWR sg13_lv_pmos ad=0.19p pd=1.38u as=0 ps=0 w=1u l=1u
X575 VGND.t18 VPWR VGND.t260 VGND.t259 sg13_lv_nmos ad=79.8f pd=0.8u as=0 ps=0 w=0.42u l=1u
X576 VPWR VGND.t747 VPWR VPWR sg13_lv_pmos ad=0.19p pd=1.38u as=0 ps=0 w=1u l=1u
X577 VPWR VGND.t864 VPWR VPWR sg13_lv_pmos ad=0.19p pd=1.38u as=0 ps=0 w=1u l=1u
X578 VGND.t688 VPWR VGND.t688 VGND.t86 sg13_lv_nmos ad=79.8f pd=0.8u as=0 ps=0 w=0.42u l=1u
X579 VGND.t484 VPWR VGND.t484 VGND.t501 sg13_lv_nmos ad=79.8f pd=0.8u as=0 ps=0 w=0.42u l=1u
X580 VPWR VGND.t400 VPWR VPWR sg13_lv_pmos ad=0.34p pd=2.68u as=0 ps=0 w=1u l=1u
X581 a_11421_9562# sg13cmos5l_mux2_1_0.S VGND.t36 VGND.t1117 sg13_lv_nmos ad=0.13135p pd=1.095u as=0.18945p ps=1.27u w=0.74u l=0.13u
X582 a_12250_14446# sg13cmos5l_o21ai_1_1.Y VPWR VPWR sg13_lv_pmos ad=0.1428p pd=1.52u as=0.1523p ps=1.38u w=0.42u l=0.13u
X583 VPWR clk_i a_8091_11458# VPWR sg13_lv_pmos ad=0.2128p pd=1.5u as=0.3808p ps=2.92u w=1.12u l=0.13u
X584 VPWR VGND.t93 VPWR VPWR sg13_lv_pmos ad=0.19p pd=1.38u as=0 ps=0 w=1u l=1u
X585 VPWR VGND.t700 VPWR VPWR sg13_lv_pmos ad=0.34p pd=2.68u as=0 ps=0 w=1u l=1u
X586 VGND.t572 VPWR VGND.t572 VGND.t584 sg13_lv_nmos ad=0.1428p pd=1.52u as=0 ps=0 w=0.42u l=1u
X587 VGND.t410 VPWR VGND.t410 VGND.t417 sg13_lv_nmos ad=79.8f pd=0.8u as=0 ps=0 w=0.42u l=1u
X588 VPWR a_4085_14482# sg13cmos5l_xor2_1_2.B VPWR sg13_lv_pmos ad=0.2128p pd=1.5u as=0.2128p ps=1.5u w=1.12u l=0.13u
X589 VPWR VGND.t747 VPWR VPWR sg13_lv_pmos ad=0.34p pd=2.68u as=0 ps=0 w=1u l=1u
X590 VGND.t410 VPWR VGND.t410 VGND.t457 sg13_lv_nmos ad=0.1428p pd=1.52u as=0 ps=0 w=0.42u l=1u
X591 VPWR VGND.t849 VPWR VPWR sg13_lv_pmos ad=0.19p pd=1.38u as=0 ps=0 w=1u l=1u
X592 VGND.t570 VPWR VGND.t572 VGND.t571 sg13_lv_nmos ad=79.8f pd=0.8u as=0 ps=0 w=0.42u l=1u
X593 VGND.t27 VPWR VGND.t27 VGND.t385 sg13_lv_nmos ad=0.1428p pd=1.52u as=0 ps=0 w=0.42u l=1u
X594 VPWR VGND.t424 VPWR VPWR sg13_lv_pmos ad=0.19p pd=1.38u as=0 ps=0 w=1u l=1u
X595 a_9836_14442# sg13cmos5l_dfrbpq_1_7.Q VGND.t130 VGND.t1045 sg13_lv_nmos ad=0.187p pd=1.78u as=0.14875p ps=1.16u w=0.55u l=0.13u
X596 VGND.t688 VPWR VGND.t688 VGND.t86 sg13_lv_nmos ad=0.1428p pd=1.52u as=0 ps=0 w=0.42u l=1u
X597 VGND.t668 VPWR VGND.t668 VGND.t86 sg13_lv_nmos ad=79.8f pd=0.8u as=0 ps=0 w=0.42u l=1u
X598 sg13cmos5l_nand3_1_1.Y sg13cmos5l_dfrbpq_1_0.Q VPWR VPWR sg13_lv_pmos ad=0.2128p pd=1.5u as=0.3808p ps=2.92u w=1.12u l=0.13u
X599 VPWR VGND.t51 VPWR VPWR sg13_lv_pmos ad=0.19p pd=1.38u as=0 ps=0 w=1u l=1u
X600 a_10231_9906# a_10791_10160# a_10812_9906# VGND.t166 sg13_lv_nmos ad=0.12665p pd=1.145u as=0.3473p ps=2.71u w=0.74u l=0.13u
X601 VPWR VGND.t285 VPWR VPWR sg13_lv_pmos ad=0.34p pd=2.68u as=0 ps=0 w=1u l=1u
X602 VPWR sg13cmos5l_or3_1_2.X a_8213_13728# VPWR sg13_lv_pmos ad=0.2128p pd=1.5u as=0.3808p ps=2.92u w=1.12u l=0.13u
X603 VGND.t484 VPWR VGND.t484 VGND.t499 sg13_lv_nmos ad=79.8f pd=0.8u as=0 ps=0 w=0.42u l=1u
X604 VGND.t433 VPWR VGND.t433 VGND.t436 sg13_lv_nmos ad=79.8f pd=0.8u as=0 ps=0 w=0.42u l=1u
X605 VGND.t51 VPWR VGND.t51 VGND.t337 sg13_lv_nmos ad=0.1428p pd=1.52u as=0 ps=0 w=0.42u l=1u
X606 a_2264_12582# sg13cmos5l_nand4_1_0.C a_2162_12582# VGND.t979 sg13_lv_nmos ad=0.1406p pd=1.12u as=0.1406p ps=1.12u w=0.74u l=0.13u
X607 VPWR sg13cmos5l_inv_1_1.A sg13cmos5l_o21ai_1_1.Y VPWR sg13_lv_pmos ad=0.3808p pd=2.92u as=0.2128p ps=1.5u w=1.12u l=0.15u
X608 VPWR VGND.t340 VPWR VPWR sg13_lv_pmos ad=0.19p pd=1.38u as=0 ps=0 w=1u l=1u
X609 VGND.t304 VPWR VGND.t303 VGND.t2 sg13_lv_nmos ad=0.1428p pd=1.52u as=0 ps=0 w=0.42u l=1u
X610 VGND.t484 VPWR VGND.t484 VGND.t495 sg13_lv_nmos ad=79.8f pd=0.8u as=0 ps=0 w=0.42u l=1u
X611 VPWR VGND.t395 VPWR VPWR sg13_lv_pmos ad=0.34p pd=2.68u as=0 ps=0 w=1u l=1u
X612 VGND.t424 VPWR VGND.t424 VGND.t423 sg13_lv_nmos ad=0.1428p pd=1.52u as=0 ps=0 w=0.42u l=1u
X613 a_5604_12979# a_5835_13088# a_5290_13189# VGND.t154 sg13_lv_nmos ad=0.2373p pd=1.97u as=79.8f ps=0.8u w=0.42u l=0.13u
X614 a_8004_9955# a_7716_10260# a_7942_9955# VGND.t21 sg13_lv_nmos ad=0.1428p pd=1.52u as=37.8f ps=0.6u w=0.42u l=0.13u
X615 VPWR VGND.t260 VPWR VPWR sg13_lv_pmos ad=0.34p pd=2.68u as=0 ps=0 w=1u l=1u
X616 a_4462_13995# a_4577_13994# VPWR VPWR sg13_lv_pmos ad=0.34p pd=2.68u as=0.2254p ps=1.53u w=1u l=0.5u
X617 VGND.t577 VPWR VGND.t577 VGND.t578 sg13_lv_nmos ad=0.1428p pd=1.52u as=0 ps=0 w=0.42u l=1u
X618 VGND.t438 VPWR VGND.t438 VGND.t481 sg13_lv_nmos ad=0.1428p pd=1.52u as=0 ps=0 w=0.42u l=1u
X619 VPWR VGND.t400 VPWR VPWR sg13_lv_pmos ad=0.19p pd=1.38u as=0 ps=0 w=1u l=1u
X620 VGND.t410 VPWR VGND.t410 VGND.t411 sg13_lv_nmos ad=79.8f pd=0.8u as=0 ps=0 w=0.42u l=1u
X621 VPWR VGND.t16 VPWR VPWR sg13_lv_pmos ad=0.34p pd=2.68u as=0 ps=0 w=1u l=1u
X622 VPWR sg13cmos5l_dfrbpq_1_1.RESET_B a_5290_13189# VPWR sg13_lv_pmos ad=0.1563p pd=1.22u as=0.147p ps=1.54u w=0.42u l=0.13u
X623 VGND.t688 VPWR VGND.t688 VGND.t86 sg13_lv_nmos ad=79.8f pd=0.8u as=0 ps=0 w=0.42u l=1u
X624 VGND.t484 VPWR VGND.t484 VGND.t489 sg13_lv_nmos ad=79.8f pd=0.8u as=0 ps=0 w=0.42u l=1u
X625 a_2196_11052# sg13cmos5l_xnor2_1_0.B a_1740_10970# VGND.t142 sg13_lv_nmos ad=78.39999f pd=0.885u as=0.2176p ps=1.96u w=0.64u l=0.13u
X626 a_10450_12966# sg13cmos5l_dfrbpq_1_4.RESET_B VGND.t10 VGND.t46 sg13_lv_nmos ad=37.8f pd=0.6u as=79.8f ps=0.8u w=0.42u l=0.13u
X627 a_9742_13995# a_9857_13994# VGND.t130 VGND.t129 sg13_lv_nmos ad=0.1428p pd=1.52u as=0.1426p ps=1.16u w=0.42u l=0.5u
X628 VPWR VGND.t688 VPWR VPWR sg13_lv_pmos ad=0.34p pd=2.68u as=0 ps=0 w=1u l=1u
X629 VGND.t484 VPWR VGND.t484 VGND.t493 sg13_lv_nmos ad=79.8f pd=0.8u as=0 ps=0 w=0.42u l=1u
X630 VGND.t93 a_10112_10117# sg13cmos5l_dfrbpq_1_5.Q VGND.t92 sg13_lv_nmos ad=0.1406p pd=1.12u as=0.2516p ps=2.16u w=0.74u l=0.13u
X631 a_2366_13288# sg13cmos5l_nand2_1_0.Y a_1914_13162# VPWR sg13_lv_pmos ad=0.1225p pd=1.245u as=0.34p ps=2.68u w=1u l=0.13u
X632 a_12141_11052# sg13cmos5l_dlygate4sd3_1_12.X VPWR VPWR sg13_lv_pmos ad=0.1596p pd=1.22u as=0.2856p ps=2.36u w=0.84u l=0.13u
X633 VGND.t932 VPWR VGND.t934 VGND.t933 sg13_lv_nmos ad=79.8f pd=0.8u as=0 ps=0 w=0.42u l=1u
X634 VGND.t603 VPWR VGND.t603 VGND.t604 sg13_lv_nmos ad=0.1428p pd=1.52u as=0 ps=0 w=0.42u l=1u
X635 VGND.t410 VPWR VGND.t410 VGND.t416 sg13_lv_nmos ad=0.1428p pd=1.52u as=0 ps=0 w=0.42u l=1u
X636 VPWR VGND.t424 VPWR VPWR sg13_lv_pmos ad=0.19p pd=1.38u as=0 ps=0 w=1u l=1u
X637 VPWR VGND.t881 VPWR VPWR sg13_lv_pmos ad=0.34p pd=2.68u as=0 ps=0 w=1u l=1u
X638 VGND.t668 VPWR VGND.t668 VGND.t86 sg13_lv_nmos ad=79.8f pd=0.8u as=0 ps=0 w=0.42u l=1u
X639 VGND.t907 VPWR VGND.t906 VGND.t905 sg13_lv_nmos ad=0.1428p pd=1.52u as=0 ps=0 w=0.42u l=1u
X640 VPWR VGND.t357 VPWR VPWR sg13_lv_pmos ad=0.19p pd=1.38u as=0 ps=0 w=1u l=1u
X641 VGND.t788 VPWR VGND.t788 VGND.t747 sg13_lv_nmos ad=79.8f pd=0.8u as=0 ps=0 w=0.42u l=1u
X642 a_3876_12220# a_4395_12227# a_5135_12577# VGND.t1113 sg13_lv_nmos ad=0.3473p pd=2.71u as=0.12665p ps=1.145u w=0.74u l=0.13u
X643 VGND.t484 VPWR VGND.t484 VGND.t501 sg13_lv_nmos ad=79.8f pd=0.8u as=0 ps=0 w=0.42u l=1u
X644 a_11078_10704# a_10808_10745# VPWR VPWR sg13_lv_pmos ad=0.34p pd=2.68u as=0.1523p ps=1.38u w=1u l=0.5u
X645 VGND.t260 VPWR VGND.t260 VGND.t262 sg13_lv_nmos ad=79.8f pd=0.8u as=0 ps=0 w=0.42u l=1u
X646 VGND.t663 VPWR VGND.t663 VGND.t86 sg13_lv_nmos ad=79.8f pd=0.8u as=0 ps=0 w=0.42u l=1u
X647 VGND.t927 VPWR VGND.t929 VGND.t928 sg13_lv_nmos ad=79.8f pd=0.8u as=0 ps=0 w=0.42u l=1u
X648 VPWR VGND.t333 VPWR VPWR sg13_lv_pmos ad=0.19p pd=1.38u as=0 ps=0 w=1u l=1u
X649 VGND.t577 VPWR VGND.t577 VGND.t580 sg13_lv_nmos ad=0.1428p pd=1.52u as=0 ps=0 w=0.42u l=1u
X650 VGND.t424 VPWR VGND.t424 VGND.t469 sg13_lv_nmos ad=0.1428p pd=1.52u as=0 ps=0 w=0.42u l=1u
X651 VGND.t424 VPWR VGND.t424 VGND.t431 sg13_lv_nmos ad=79.8f pd=0.8u as=0 ps=0 w=0.42u l=1u
X652 VPWR VGND.t400 VPWR VPWR sg13_lv_pmos ad=0.19p pd=1.38u as=0 ps=0 w=1u l=1u
X653 VPWR sg13cmos5l_dfrbpq_1_7.CLK a_10943_12187# VPWR sg13_lv_pmos ad=2.16757p pd=13.96u as=0.4088p ps=2.97u w=1.12u l=0.13u
X654 VGND.t765 VPWR VGND.t765 VGND.t767 sg13_lv_nmos ad=79.8f pd=0.8u as=0 ps=0 w=0.42u l=1u
X655 VGND.t676 VPWR VGND.t676 VGND.t86 sg13_lv_nmos ad=0.1428p pd=1.52u as=0 ps=0 w=0.42u l=1u
X656 a_6393_10257# a_5451_10064# a_6191_10019# VPWR sg13_lv_pmos ad=93.45f pd=0.865u as=0.2048p ps=1.63u w=0.42u l=0.13u
X657 VGND.t31 a_4293_12227# a_4395_12227# VGND.t30 sg13_lv_nmos ad=4.58315p pd=29.2u as=0.2516p ps=2.16u w=0.74u l=0.13u
X658 VPWR VGND.t839 VPWR VPWR sg13_lv_pmos ad=0.19p pd=1.38u as=0 ps=0 w=1u l=1u
X659 a_11828_10668# sg13cmos5l_buf_1_1.X VGND.t16 VGND.t2 sg13_lv_nmos ad=0.187p pd=1.78u as=0.17255p ps=1.25u w=0.55u l=0.13u
X660 VGND.t484 VPWR VGND.t484 VGND.t491 sg13_lv_nmos ad=79.8f pd=0.8u as=0 ps=0 w=0.42u l=1u
X661 VGND.t96 a_14074_9910# a_13793_10132# VGND.t95 sg13_lv_nmos ad=79.8f pd=0.8u as=0.1428p ps=1.52u w=0.42u l=0.5u
X662 a_8133_9921# sg13cmos5l_dfrbpq_1_7.CLK VPWR VPWR sg13_lv_pmos ad=0.4088p pd=2.97u as=1.3227p ps=8.28u w=1.12u l=0.13u
X663 a_11639_12263# sg13cmos5l_dfrbpq_1_6.D a_12386_12654# VGND.t55 sg13_lv_nmos ad=0.1428p pd=1.52u as=60.89999f ps=0.71u w=0.42u l=0.13u
X664 VGND.t31 a_5733_12945# a_5835_13088# VGND.t175 sg13_lv_nmos ad=4.58315p pd=29.2u as=0.2516p ps=2.16u w=0.74u l=0.13u
X665 VPWR VGND.t866 VPWR VPWR sg13_lv_pmos ad=0.34p pd=2.68u as=0 ps=0 w=1u l=1u
X666 sg13cmos5l_a21oi_1_0.B1 sg13cmos5l_buf_1_1.X VGND.t333 VGND.t1009 sg13_lv_nmos ad=0.2516p pd=2.16u as=0.2516p ps=2.16u w=0.74u l=0.13u
X667 VGND.t253 VPWR VGND.t124 VGND.t252 sg13_lv_nmos ad=0.1428p pd=1.52u as=0 ps=0 w=0.42u l=1u
X668 VGND.t484 VPWR VGND.t484 VGND.t495 sg13_lv_nmos ad=79.8f pd=0.8u as=0 ps=0 w=0.42u l=1u
X669 VGND.t484 VPWR VGND.t484 VGND.t502 sg13_lv_nmos ad=0.1428p pd=1.52u as=0 ps=0 w=0.42u l=1u
X670 VPWR sg13cmos5l_inv_1_1.A sg13cmos5l_nor3_2_0.A VPWR sg13_lv_pmos ad=0.3808p pd=2.92u as=0.3808p ps=2.92u w=1.12u l=0.13u
X671 a_3668_13728# sg13cmos5l_dlygate4sd3_1_1.X VPWR VPWR sg13_lv_pmos ad=0.3808p pd=2.92u as=0.2128p ps=1.5u w=1.12u l=0.13u
X672 a_8580_12966# sg13cmos5l_dfrbpq_1_4.D a_8486_12966# VGND.t43 sg13_lv_nmos ad=60.89999f pd=0.71u as=0.1428p ps=1.52u w=0.42u l=0.13u
X673 VPWR VGND.t410 VPWR VPWR sg13_lv_pmos ad=0.34p pd=2.68u as=0 ps=0 w=1u l=1u
X674 VGND.t747 VPWR VGND.t747 VGND.t749 sg13_lv_nmos ad=79.8f pd=0.8u as=0 ps=0 w=0.42u l=1u
X675 a_7690_10165# a_8133_9921# a_8073_10333# VPWR sg13_lv_pmos ad=79.8f pd=0.8u as=63f ps=0.72u w=0.42u l=0.13u
X676 VGND.t862 VPWR VGND.t864 VGND.t863 sg13_lv_nmos ad=79.8f pd=0.8u as=0 ps=0 w=0.42u l=1u
X677 VGND.t603 VPWR VGND.t603 VGND.t606 sg13_lv_nmos ad=0.1428p pd=1.52u as=0 ps=0 w=0.42u l=1u
X678 VGND.t419 VPWR VGND.t419 VGND.t418 sg13_lv_nmos ad=0.1428p pd=1.52u as=0 ps=0 w=0.42u l=1u
X679 VPWR VGND.t311 VPWR VPWR sg13_lv_pmos ad=0.19p pd=1.38u as=0 ps=0 w=1u l=1u
X680 VPWR VGND.t851 VPWR VPWR sg13_lv_pmos ad=0.34p pd=2.68u as=0 ps=0 w=1u l=1u
X681 VPWR VGND.t260 VPWR VPWR sg13_lv_pmos ad=0.19p pd=1.38u as=0 ps=0 w=1u l=1u
X682 VPWR VGND.t484 VPWR VPWR sg13_lv_pmos ad=0.19p pd=1.38u as=0 ps=0 w=1u l=1u
X683 VGND.t303 a_11355_11458# sg13cmos5l_dfrbpq_1_7.CLK VGND.t15 sg13_lv_nmos ad=0.2516p pd=2.16u as=0.1406p ps=1.12u w=0.74u l=0.13u
X684 VGND.t484 VPWR VGND.t484 VGND.t489 sg13_lv_nmos ad=79.8f pd=0.8u as=0 ps=0 w=0.42u l=1u
X685 VGND.t424 VPWR VGND.t424 VGND.t425 sg13_lv_nmos ad=79.8f pd=0.8u as=0 ps=0 w=0.42u l=1u
X686 VPWR VGND.t395 VPWR VPWR sg13_lv_pmos ad=0.19p pd=1.38u as=0 ps=0 w=1u l=1u
X687 a_4233_10751# a_3876_10708# VPWR VPWR sg13_lv_pmos ad=63f pd=0.72u as=0.1563p ps=1.22u w=0.42u l=0.13u
X688 VPWR VGND.t188 VPWR VPWR sg13_lv_pmos ad=0.34p pd=2.68u as=0 ps=0 w=1u l=1u
X689 VPWR VGND.t788 VPWR VPWR sg13_lv_pmos ad=0.19p pd=1.38u as=0 ps=0 w=1u l=1u
X690 VGND.t484 VPWR VGND.t484 VGND.t496 sg13_lv_nmos ad=0.1428p pd=1.52u as=0 ps=0 w=0.42u l=1u
X691 VPWR VGND.t204 VPWR VPWR sg13_lv_pmos ad=0.34p pd=2.68u as=0 ps=0 w=1u l=1u
X692 VGND.t285 VPWR VGND.t286 VGND.t314 sg13_lv_nmos ad=0.1428p pd=1.52u as=0 ps=0 w=0.42u l=1u
X693 VGND.t572 VPWR VGND.t572 VGND.t573 sg13_lv_nmos ad=0.1428p pd=1.52u as=0 ps=0 w=0.42u l=1u
X694 a_7457_9540# sg13cmos5l_a21oi_1_0.A1 sg13cmos5l_a21oi_1_0.Y VGND.t13 sg13_lv_nmos ad=0.1406p pd=1.12u as=0.1406p ps=1.12u w=0.74u l=0.13u
X695 VPWR VGND.t747 VPWR VPWR sg13_lv_pmos ad=0.19p pd=1.38u as=0 ps=0 w=1u l=1u
X696 VGND.t912 VPWR VGND.t911 VGND.t910 sg13_lv_nmos ad=0.1428p pd=1.52u as=0 ps=0 w=0.42u l=1u
X697 VPWR VGND.t484 VPWR VPWR sg13_lv_pmos ad=0.19p pd=1.38u as=0 ps=0 w=1u l=1u
X698 VGND.t484 VPWR VGND.t484 VGND.t485 sg13_lv_nmos ad=79.8f pd=0.8u as=0 ps=0 w=0.42u l=1u
X699 VGND.t392 rst_ni a_808_8468# VGND.t1034 sg13_lv_nmos ad=0.14875p pd=1.16u as=0.187p ps=1.78u w=0.55u l=0.13u
X700 VPWR VGND.t20 VPWR VPWR sg13_lv_pmos ad=0.34p pd=2.68u as=0 ps=0 w=1u l=1u
X701 sg13cmos5l_xor2_1_2.B a_4085_14482# VPWR VPWR sg13_lv_pmos ad=0.2128p pd=1.5u as=0.2128p ps=1.5u w=1.12u l=0.13u
X702 VGND.t10 sg13cmos5l_dfrbpq_1_6.Q a_11192_12970# VGND.t1087 sg13_lv_nmos ad=79.8f pd=0.8u as=0.1428p ps=1.52u w=0.42u l=0.13u
X703 VPWR VGND.t62 VPWR VPWR sg13_lv_pmos ad=0.19p pd=1.38u as=0 ps=0 w=1u l=1u
X704 VGND.t572 VPWR VGND.t572 VGND.t582 sg13_lv_nmos ad=0.1428p pd=1.52u as=0 ps=0 w=0.42u l=1u
X705 VGND.t1106 a_11355_11458# sg13cmos5l_dfrbpq_1_7.CLK VGND.t15 sg13_lv_nmos ad=0.1406p pd=1.12u as=0.1406p ps=1.12u w=0.74u l=0.13u
X706 VPWR VGND.t18 VPWR VPWR sg13_lv_pmos ad=0.34p pd=2.68u as=0 ps=0 w=1u l=1u
X707 a_3850_10672# a_4293_10715# a_4233_10751# VPWR sg13_lv_pmos ad=79.8f pd=0.8u as=63f ps=0.72u w=0.42u l=0.13u
X708 VGND.t676 VPWR VGND.t676 VGND.t86 sg13_lv_nmos ad=0.1428p pd=1.52u as=0 ps=0 w=0.42u l=1u
X709 VPWR VGND.t765 VPWR VPWR sg13_lv_pmos ad=0.19p pd=1.38u as=0 ps=0 w=1u l=1u
X710 VPWR VGND.t400 VPWR VPWR sg13_lv_pmos ad=0.34p pd=2.68u as=0 ps=0 w=1u l=1u
X711 VPWR VGND.t911 VPWR VPWR sg13_lv_pmos ad=0.34p pd=2.68u as=0 ps=0 w=1u l=1u
X712 VPWR a_4570_12934# a_4289_13156# VPWR sg13_lv_pmos ad=0.1523p pd=1.38u as=0.34p ps=2.68u w=1u l=0.5u
X713 a_2366_12582# sg13cmos5l_dfrbpq_1_0.Q a_2264_12582# VGND.t1056 sg13_lv_nmos ad=0.1406p pd=1.12u as=0.1406p ps=1.12u w=0.74u l=0.13u
X714 a_4085_14482# sg13cmos5l_nand3_1_0.Y VPWR VPWR sg13_lv_pmos ad=0.1596p pd=1.22u as=0.2856p ps=2.36u w=0.84u l=0.13u
X715 VPWR VGND.t484 VPWR VPWR sg13_lv_pmos ad=0.19p pd=1.38u as=0 ps=0 w=1u l=1u
X716 VPWR VGND.t392 VPWR VPWR sg13_lv_pmos ad=0.34p pd=2.68u as=0 ps=0 w=1u l=1u
X717 VPWR VGND.t12 VPWR VPWR sg13_lv_pmos ad=0.19p pd=1.38u as=0 ps=0 w=1u l=1u
X718 a_1914_13162# sg13cmos5l_nand2_1_0.Y VGND.t124 VGND.t123 sg13_lv_nmos ad=0.17462p pd=1.185u as=0.15245p ps=1.17u w=0.55u l=0.13u
X719 VGND.t484 VPWR VGND.t484 VGND.t490 sg13_lv_nmos ad=0.1428p pd=1.52u as=0 ps=0 w=0.42u l=1u
X720 a_8782_13995# a_8897_13994# VGND.t59 VGND.t987 sg13_lv_nmos ad=0.1428p pd=1.52u as=0.1426p ps=1.16u w=0.42u l=0.5u
X721 VPWR VGND.t410 VPWR VPWR sg13_lv_pmos ad=0.34p pd=2.68u as=0 ps=0 w=1u l=1u
X722 VGND.t10 a_10112_12503# sg13cmos5l_dfrbpq_1_6.Q VGND.t105 sg13_lv_nmos ad=0.1406p pd=1.12u as=0.2516p ps=2.16u w=0.74u l=0.13u
X723 VGND.t419 VPWR VGND.t419 VGND.t421 sg13_lv_nmos ad=0.1428p pd=1.52u as=0 ps=0 w=0.42u l=1u
X724 VPWR VGND.t856 VPWR VPWR sg13_lv_pmos ad=0.34p pd=2.68u as=0 ps=0 w=1u l=1u
X725 VPWR VGND.t331 VPWR VPWR sg13_lv_pmos ad=0.19p pd=1.38u as=0 ps=0 w=1u l=1u
X726 VPWR a_6575_13043# a_6832_13186# VPWR sg13_lv_pmos ad=1.7455p pd=10.885u as=79.8f ps=0.8u w=0.42u l=0.13u
X727 VGND.t572 VPWR VGND.t572 VGND.t575 sg13_lv_nmos ad=0.1428p pd=1.52u as=0 ps=0 w=0.42u l=1u
X728 VGND.t484 VPWR VGND.t484 VGND.t491 sg13_lv_nmos ad=79.8f pd=0.8u as=0 ps=0 w=0.42u l=1u
X729 a_10702_9942# a_10444_9942# VGND.t36 VGND.t1111 sg13_lv_nmos ad=0.1428p pd=1.52u as=79.8f ps=0.8u w=0.42u l=0.13u
X730 VGND.t672 VPWR VGND.t672 VGND.t86 sg13_lv_nmos ad=0.1428p pd=1.52u as=0 ps=0 w=0.42u l=1u
X731 VGND.t16 a_11078_10704# a_11190_10728# VGND.t2 sg13_lv_nmos ad=0.1426p pd=1.16u as=0.1428p ps=1.52u w=0.42u l=0.5u
X732 VPWR VGND.t57 VPWR VPWR sg13_lv_pmos ad=0.34p pd=2.68u as=0 ps=0 w=1u l=1u
X733 VPWR a_8314_10668# a_8033_10970# VPWR sg13_lv_pmos ad=0.1523p pd=1.38u as=0.34p ps=2.68u w=1u l=0.5u
X734 VGND.t484 VPWR VGND.t484 VGND.t502 sg13_lv_nmos ad=0.1428p pd=1.52u as=0 ps=0 w=0.42u l=1u
X735 VGND.t842 VPWR VGND.t841 VGND.t840 sg13_lv_nmos ad=0.1428p pd=1.52u as=0 ps=0 w=0.42u l=1u
X736 VGND.t23 a_8681_9530# a_8602_9433# VGND.t47 sg13_lv_nmos ad=2.99005p pd=19.165u as=0.27427p ps=2.28u w=0.795u l=0.13u
X737 VGND.t410 VPWR VGND.t410 VGND.t414 sg13_lv_nmos ad=0.1428p pd=1.52u as=0 ps=0 w=0.42u l=1u
X738 VGND.t484 VPWR VGND.t484 VGND.t514 sg13_lv_nmos ad=0.1428p pd=1.52u as=0 ps=0 w=0.42u l=1u
X739 VPWR sg13cmos5l_buf_1_1.X a_12141_11052# VPWR sg13_lv_pmos ad=0.1918p pd=1.5u as=0.1596p ps=1.22u w=0.84u l=0.13u
X740 VPWR sg13cmos5l_xnor2_1_0.B sg13cmos5l_nand3_1_0.Y VPWR sg13_lv_pmos ad=0.3808p pd=2.92u as=0.2128p ps=1.5u w=1.12u l=0.13u
X741 a_6610_9942# sg13cmos5l_dfrbpq_1_0.RESET_B VGND.t6 VGND.t1001 sg13_lv_nmos ad=37.8f pd=0.6u as=79.8f ps=0.8u w=0.42u l=0.13u
X742 VGND.t663 VPWR VGND.t663 VGND.t86 sg13_lv_nmos ad=0.1428p pd=1.52u as=0 ps=0 w=0.42u l=1u
X743 VPWR VGND.t51 VPWR VPWR sg13_lv_pmos ad=0.34p pd=2.68u as=0 ps=0 w=1u l=1u
X744 count_o[6] a_11368_14516# VPWR VPWR sg13_lv_pmos ad=0.42p pd=2.99u as=0.2114p ps=1.54u w=1.12u l=0.13u
X745 VPWR VGND.t71 VPWR VPWR sg13_lv_pmos ad=0.34p pd=2.68u as=0 ps=0 w=1u l=1u
X746 VGND.t484 VPWR VGND.t484 VGND.t496 sg13_lv_nmos ad=0.1428p pd=1.52u as=0 ps=0 w=0.42u l=1u
X747 VGND.t433 VPWR VGND.t433 VGND.t432 sg13_lv_nmos ad=0.1428p pd=1.52u as=0 ps=0 w=0.42u l=1u
X748 VPWR VGND.t405 VPWR VPWR sg13_lv_pmos ad=0.34p pd=2.68u as=0 ps=0 w=1u l=1u
X749 VPWR VGND.t410 VPWR VPWR sg13_lv_pmos ad=0.19p pd=1.38u as=0 ps=0 w=1u l=1u
X750 VPWR VGND.t841 VPWR VPWR sg13_lv_pmos ad=0.34p pd=2.68u as=0 ps=0 w=1u l=1u
X751 VPWR VGND.t484 VPWR VPWR sg13_lv_pmos ad=0.19p pd=1.38u as=0 ps=0 w=1u l=1u
X752 VGND.t344 VPWR VGND.t344 VGND.t390 sg13_lv_nmos ad=0.1428p pd=1.52u as=0 ps=0 w=0.42u l=1u
X753 VGND.t484 VPWR VGND.t484 VGND.t485 sg13_lv_nmos ad=79.8f pd=0.8u as=0 ps=0 w=0.42u l=1u
X754 VPWR VGND.t788 VPWR VPWR sg13_lv_pmos ad=0.19p pd=1.38u as=0 ps=0 w=1u l=1u
X755 VGND.t484 VPWR VGND.t484 VGND.t492 sg13_lv_nmos ad=0.1428p pd=1.52u as=0 ps=0 w=0.42u l=1u
X756 a_4858_13692# sg13cmos5l_dfrbpq_1_2.Q VGND.t127 VGND.t1021 sg13_lv_nmos ad=0.1428p pd=1.52u as=79.8f ps=0.8u w=0.42u l=0.13u
X757 VPWR VGND.t272 VPWR VPWR sg13_lv_pmos ad=0.34p pd=2.68u as=0 ps=0 w=1u l=1u
X758 VPWR VGND.t395 VPWR VPWR sg13_lv_pmos ad=0.34p pd=2.68u as=0 ps=0 w=1u l=1u
X759 sg13cmos5l_nor2_1_3.Y sg13cmos5l_nor2_1_3.B VGND.t51 VGND.t50 sg13_lv_nmos ad=0.1406p pd=1.12u as=0.2516p ps=2.16u w=0.74u l=0.13u
X760 VGND.t28 a_5392_10946# a_5041_11065# VGND.t2 sg13_lv_nmos ad=79.8f pd=0.8u as=0.1428p ps=1.52u w=0.42u l=0.13u
X761 VGND.t405 VPWR VGND.t405 VGND.t407 sg13_lv_nmos ad=0.1428p pd=1.52u as=0 ps=0 w=0.42u l=1u
X762 VPWR VGND.t861 VPWR VPWR sg13_lv_pmos ad=0.34p pd=2.68u as=0 ps=0 w=1u l=1u
X763 a_5392_10946# a_5135_11065# a_5554_11142# VGND.t2 sg13_lv_nmos ad=0.1428p pd=1.52u as=37.8f ps=0.6u w=0.42u l=0.13u
X764 VGND.t688 VPWR VGND.t688 VGND.t86 sg13_lv_nmos ad=0.1428p pd=1.52u as=0 ps=0 w=0.42u l=1u
X765 VPWR VGND.t484 VPWR VPWR sg13_lv_pmos ad=0.19p pd=1.38u as=0 ps=0 w=1u l=1u
X766 VPWR VGND.t3 VPWR VPWR sg13_lv_pmos ad=0.34p pd=2.68u as=0 ps=0 w=1u l=1u
X767 sg13cmos5l_nand3_1_1.Y sg13cmos5l_dfrbpq_1_7.Q a_8120_12582# VGND.t135 sg13_lv_nmos ad=0.2516p pd=2.16u as=0.1406p ps=1.12u w=0.74u l=0.13u
X768 sg13cmos5l_nand4_1_0.Y sg13cmos5l_xnor2_1_0.B VPWR VPWR sg13_lv_pmos ad=0.2128p pd=1.5u as=0.3808p ps=2.92u w=1.12u l=0.13u
X769 VGND.t484 VPWR VGND.t484 VGND.t490 sg13_lv_nmos ad=0.1428p pd=1.52u as=0 ps=0 w=0.42u l=1u
X770 VGND.t28 sg13cmos5l_buf_8_0.A a_4426_11422# VGND.t15 sg13_lv_nmos ad=0.1406p pd=1.12u as=0.1406p ps=1.12u w=0.74u l=0.13u
X771 VGND.t87 VPWR VGND.t663 VGND.t86 sg13_lv_nmos ad=79.8f pd=0.8u as=0 ps=0 w=0.42u l=1u
X772 sg13cmos5l_inv_1_1.A a_11574_13034# VPWR VPWR sg13_lv_pmos ad=0.4256p pd=3u as=0.2254p ps=1.53u w=1.12u l=0.13u
X773 VPWR VGND.t87 VPWR VPWR sg13_lv_pmos ad=0.19p pd=1.38u as=0 ps=0 w=1u l=1u
X774 VGND.t484 VPWR VGND.t484 VGND.t516 sg13_lv_nmos ad=0.1428p pd=1.52u as=0 ps=0 w=0.42u l=1u
X775 a_4174_13155# a_4289_13156# VPWR VPWR sg13_lv_pmos ad=0.34p pd=2.68u as=0.2254p ps=1.53u w=1u l=0.5u
X776 VPWR a_5733_12945# a_5835_13088# VPWR sg13_lv_pmos ad=1.7455p pd=10.885u as=0.3864p ps=2.93u w=1.12u l=0.13u
X777 VPWR VGND.t62 VPWR VPWR sg13_lv_pmos ad=0.34p pd=2.68u as=0 ps=0 w=1u l=1u
X778 VGND.t59 a_13673_14066# a_13594_13969# VGND.t58 sg13_lv_nmos ad=3.51557p pd=23.16u as=0.27427p ps=2.28u w=0.795u l=0.13u
X779 sg13cmos5l_or3_1_2.X a_7849_12970# VPWR VPWR sg13_lv_pmos ad=0.3808p pd=2.92u as=0.3822p ps=1.84u w=1.12u l=0.13u
X780 VGND.t668 VPWR VGND.t668 VGND.t86 sg13_lv_nmos ad=0.1428p pd=1.52u as=0 ps=0 w=0.42u l=1u
X781 VPWR VGND.t51 VPWR VPWR sg13_lv_pmos ad=0.34p pd=2.68u as=0 ps=0 w=1u l=1u
X782 VGND.t433 VPWR VGND.t433 VGND.t435 sg13_lv_nmos ad=0.1428p pd=1.52u as=0 ps=0 w=0.42u l=1u
X783 VPWR VGND.t419 VPWR VPWR sg13_lv_pmos ad=0.19p pd=1.38u as=0 ps=0 w=1u l=1u
X784 a_9742_13995# a_9857_13994# VPWR VPWR sg13_lv_pmos ad=0.34p pd=2.68u as=0.2254p ps=1.53u w=1u l=0.5u
X785 a_5316_13284# a_5835_13088# a_6575_13043# VGND.t43 sg13_lv_nmos ad=0.3473p pd=2.71u as=0.12665p ps=1.145u w=0.74u l=0.13u
X786 VPWR VGND.t846 VPWR VPWR sg13_lv_pmos ad=0.34p pd=2.68u as=0 ps=0 w=1u l=1u
X787 a_7822_9459# a_7937_9458# VGND.t6 VGND.t47 sg13_lv_nmos ad=0.1428p pd=1.52u as=0.1426p ps=1.16u w=0.42u l=0.5u
X788 a_6185_14066# a_6309_13765# VPWR VPWR sg13_lv_pmos ad=0.2442p pd=2.06u as=1.7455p ps=10.885u w=0.66u l=0.13u
X789 VGND.t484 VPWR VGND.t484 VGND.t494 sg13_lv_nmos ad=0.1428p pd=1.52u as=0 ps=0 w=0.42u l=1u
X790 VPWR a_11355_11458# sg13cmos5l_dfrbpq_1_7.CLK VPWR sg13_lv_pmos ad=0.3864p pd=2.93u as=0.2128p ps=1.5u w=1.12u l=0.13u
X791 VGND.t484 VPWR VGND.t484 VGND.t514 sg13_lv_nmos ad=0.1428p pd=1.52u as=0 ps=0 w=0.42u l=1u
X792 VPWR VGND.t788 VPWR VPWR sg13_lv_pmos ad=0.19p pd=1.38u as=0 ps=0 w=1u l=1u
X793 VPWR VGND.t438 VPWR VPWR sg13_lv_pmos ad=0.19p pd=1.38u as=0 ps=0 w=1u l=1u
X794 VPWR VGND.t400 VPWR VPWR sg13_lv_pmos ad=0.34p pd=2.68u as=0 ps=0 w=1u l=1u
X795 a_8975_10019# a_8133_9921# a_7716_10260# VPWR sg13_lv_pmos ad=0.2048p pd=1.63u as=0.34p ps=2.68u w=1u l=0.13u
X796 VGND.t63 a_6575_13043# a_7242_13264# VGND.t43 sg13_lv_nmos ad=0.1406p pd=1.12u as=0.2516p ps=2.16u w=0.74u l=0.13u
X797 VPWR VGND.t663 VPWR VPWR sg13_lv_pmos ad=0.19p pd=1.38u as=0 ps=0 w=1u l=1u
X798 VGND.t71 a_12250_14446# a_11969_14668# VGND.t1094 sg13_lv_nmos ad=79.8f pd=0.8u as=0.1428p ps=1.52u w=0.42u l=0.5u
X799 VGND.t286 VPWR VGND.t285 VGND.t284 sg13_lv_nmos ad=0.1428p pd=1.52u as=0 ps=0 w=0.42u l=1u
X800 sg13cmos5l_mux2_1_0.S sg13cmos5l_xor2_1_2.B VGND.t16 VGND.t15 sg13_lv_nmos ad=0.1406p pd=1.12u as=0.3293p ps=1.63u w=0.74u l=0.13u
X801 VGND.t932 VPWR VGND.t931 VGND.t930 sg13_lv_nmos ad=0.1428p pd=1.52u as=0 ps=0 w=0.42u l=1u
X802 a_4293_12227# sg13cmos5l_dfrbpq_1_0.CLK VPWR VPWR sg13_lv_pmos ad=0.4088p pd=2.97u as=2.16757p ps=13.96u w=1.12u l=0.13u
X803 a_7716_10260# a_8235_10064# a_8975_10019# VGND.t957 sg13_lv_nmos ad=0.3473p pd=2.71u as=0.12665p ps=1.145u w=0.74u l=0.13u
X804 a_1775_11074# sg13cmos5l_buf_1_0.X VGND.t139 VGND.t146 sg13_lv_nmos ad=0.2516p pd=2.16u as=0.1898p ps=1.36u w=0.74u l=0.13u
X805 VPWR a_11355_11458# sg13cmos5l_dfrbpq_1_7.CLK VPWR sg13_lv_pmos ad=0.2128p pd=1.5u as=0.2128p ps=1.5u w=1.12u l=0.13u
X806 VGND.t87 VPWR VGND.t87 VGND.t86 sg13_lv_nmos ad=0.1428p pd=1.52u as=0 ps=0 w=0.42u l=1u
X807 VPWR VGND.t424 VPWR VPWR sg13_lv_pmos ad=0.19p pd=1.38u as=0 ps=0 w=1u l=1u
X808 VGND.t71 sg13cmos5l_xor2_1_2.B a_11171_13997# VGND.t1073 sg13_lv_nmos ad=0.1045p pd=0.93u as=0.198p ps=1.27u w=0.55u l=0.13u
X809 VPWR VGND.t348 VPWR VPWR sg13_lv_pmos ad=0.34p pd=2.68u as=0 ps=0 w=1u l=1u
X810 sg13cmos5l_nor2_1_0.Y sg13cmos5l_nor2_1_0.B a_1418_10704# VPWR sg13_lv_pmos ad=0.3808p pd=2.92u as=0.1176p ps=1.33u w=1.12u l=0.13u
X811 VPWR VGND.t484 VPWR VPWR sg13_lv_pmos ad=0.34p pd=2.68u as=0 ps=0 w=1u l=1u
X812 VGND.t424 VPWR VGND.t424 VGND.t428 sg13_lv_nmos ad=0.1428p pd=1.52u as=0 ps=0 w=0.42u l=1u
X813 VGND.t51 VPWR VGND.t51 VGND.t335 sg13_lv_nmos ad=0.1428p pd=1.52u as=0 ps=0 w=0.42u l=1u
X814 VGND.t484 VPWR VGND.t484 VGND.t492 sg13_lv_nmos ad=0.1428p pd=1.52u as=0 ps=0 w=0.42u l=1u
X815 VPWR VGND.t765 VPWR VPWR sg13_lv_pmos ad=0.19p pd=1.38u as=0 ps=0 w=1u l=1u
X816 a_6832_13186# sg13cmos5l_dfrbpq_1_1.RESET_B VPWR VPWR sg13_lv_pmos ad=79.8f pd=0.8u as=1.7455p ps=10.885u w=0.42u l=0.13u
X817 VPWR VGND.t410 VPWR VPWR sg13_lv_pmos ad=0.19p pd=1.38u as=0 ps=0 w=1u l=1u
X818 VPWR a_5135_11065# a_5802_10704# VPWR sg13_lv_pmos ad=0.2128p pd=1.5u as=0.3864p ps=2.93u w=1.12u l=0.13u
X819 a_10112_12503# a_10231_12180# VGND.t10 VGND.t105 sg13_lv_nmos ad=0.2516p pd=2.16u as=0.1406p ps=1.12u w=0.74u l=0.13u
X820 VGND.t484 VPWR VGND.t484 VGND.t488 sg13_lv_nmos ad=0.1428p pd=1.52u as=0 ps=0 w=0.42u l=1u
X821 a_9836_14442# sg13cmos5l_dfrbpq_1_7.Q VPWR VPWR sg13_lv_pmos ad=0.2856p pd=2.36u as=0.2114p ps=1.54u w=0.84u l=0.13u
X822 a_8702_12582# sg13cmos5l_o21ai_1_0.B1 a_8600_12582# VGND.t1011 sg13_lv_nmos ad=0.1406p pd=1.12u as=0.1406p ps=1.12u w=0.74u l=0.13u
X823 VPWR VGND.t51 VPWR VPWR sg13_lv_pmos ad=0.34p pd=2.68u as=0 ps=0 w=1u l=1u
X824 VGND.t570 VPWR VGND.t570 VGND.t569 sg13_lv_nmos ad=0.1428p pd=1.52u as=0 ps=0 w=0.42u l=1u
X825 VGND.t438 VPWR VGND.t438 VGND.t437 sg13_lv_nmos ad=0.1428p pd=1.52u as=0 ps=0 w=0.42u l=1u
X826 VPWR VGND.t392 VPWR VPWR sg13_lv_pmos ad=0.34p pd=2.68u as=0 ps=0 w=1u l=1u
X827 a_10816_11752# sg13cmos5l_xor2_1_2.B a_10604_11752# VPWR sg13_lv_pmos ad=0.2128p pd=1.5u as=0.2128p ps=1.5u w=1.12u l=0.13u
X828 VPWR VGND.t419 VPWR VPWR sg13_lv_pmos ad=0.19p pd=1.38u as=0 ps=0 w=1u l=1u
X829 VGND.t23 sg13cmos5l_dfrbpq_1_7.CLK a_10943_10212# VGND.t67 sg13_lv_nmos ad=2.69105p pd=17.245u as=0.2516p ps=2.16u w=0.74u l=0.13u
X830 VPWR VGND.t747 VPWR VPWR sg13_lv_pmos ad=0.34p pd=2.68u as=0 ps=0 w=1u l=1u
X831 VGND.t250 VPWR VGND.t12 VGND.t251 sg13_lv_nmos ad=79.8f pd=0.8u as=0 ps=0 w=0.42u l=1u
X832 a_10538_9942# a_10231_9906# a_10444_9942# VGND.t118 sg13_lv_nmos ad=37.8f pd=0.6u as=0.1428p ps=1.52u w=0.42u l=0.13u
X833 VPWR VGND.t212 VPWR VPWR sg13_lv_pmos ad=0.34p pd=2.68u as=0 ps=0 w=1u l=1u
X834 VGND.t572 VPWR VGND.t572 VGND.t600 sg13_lv_nmos ad=79.8f pd=0.8u as=0 ps=0 w=0.42u l=1u
X835 a_12038_13728# a_11768_13769# VGND.t71 VGND.t993 sg13_lv_nmos ad=0.1428p pd=1.52u as=79.8f ps=0.8u w=0.42u l=0.5u
X836 VPWR VGND.t484 VPWR VPWR sg13_lv_pmos ad=0.19p pd=1.38u as=0 ps=0 w=1u l=1u
X837 VPWR VGND.t96 VPWR VPWR sg13_lv_pmos ad=0.34p pd=2.68u as=0 ps=0 w=1u l=1u
X838 a_5337_10827# a_4395_10715# a_5135_11065# VPWR sg13_lv_pmos ad=93.45f pd=0.865u as=0.2048p ps=1.63u w=0.42u l=0.13u
X839 VGND.t6 a_6191_10019# a_6858_10240# VGND.t109 sg13_lv_nmos ad=0.1406p pd=1.12u as=0.2516p ps=2.16u w=0.74u l=0.13u
X840 VGND.t484 VPWR VGND.t484 VGND.t516 sg13_lv_nmos ad=0.1428p pd=1.52u as=0 ps=0 w=0.42u l=1u
X841 VGND.t206 VPWR VGND.t204 VGND.t238 sg13_lv_nmos ad=0.1428p pd=1.52u as=0 ps=0 w=0.42u l=1u
X842 VPWR VGND.t572 VPWR VPWR sg13_lv_pmos ad=0.19p pd=1.38u as=0 ps=0 w=1u l=1u
X843 a_5604_12979# a_5316_13284# a_5542_12979# VGND.t152 sg13_lv_nmos ad=0.1428p pd=1.52u as=37.8f ps=0.6u w=0.42u l=0.13u
X844 VPWR VGND.t484 VPWR VPWR sg13_lv_pmos ad=0.34p pd=2.68u as=0 ps=0 w=1u l=1u
X845 a_10604_11752# sg13cmos5l_nor3_2_0.A VPWR VPWR sg13_lv_pmos ad=0.2128p pd=1.5u as=0.3864p ps=2.93u w=1.12u l=0.13u
X846 a_8746_13189# a_9189_12945# a_8486_12966# VGND.t155 sg13_lv_nmos ad=79.8f pd=0.8u as=0.1296p ps=1.52u w=0.42u l=0.13u
X847 VPWR a_8590_14667# sg13cmos5l_a21oi_1_2.A1 VPWR sg13_lv_pmos ad=0.2254p pd=1.53u as=0.4256p ps=3u w=1.12u l=0.13u
X848 VGND.t862 VPWR VGND.t861 VGND.t860 sg13_lv_nmos ad=0.1428p pd=1.52u as=0 ps=0 w=0.42u l=1u
X849 a_4646_9942# sg13cmos5l_nor2_1_3.Y VPWR VPWR sg13_lv_pmos ad=79.8f pd=0.8u as=0.1428p ps=1.52u w=0.42u l=0.13u
X850 VGND.t217 VPWR VGND.t71 VGND.t216 sg13_lv_nmos ad=0.1428p pd=1.52u as=0 ps=0 w=0.42u l=1u
X851 VGND.t20 sg13cmos5l_nor2_1_0.B sg13cmos5l_nor2_1_0.Y VGND.t19 sg13_lv_nmos ad=0.2516p pd=2.16u as=0.1406p ps=1.12u w=0.74u l=0.13u
X852 VPWR VGND.t433 VPWR VPWR sg13_lv_pmos ad=0.19p pd=1.38u as=0 ps=0 w=1u l=1u
X853 VPWR VGND.t333 VPWR VPWR sg13_lv_pmos ad=0.34p pd=2.68u as=0 ps=0 w=1u l=1u
X854 VGND.t783 VPWR VGND.t783 VGND.t784 sg13_lv_nmos ad=0.1428p pd=1.52u as=0 ps=0 w=0.42u l=1u
X855 VPWR VGND.t484 VPWR VPWR sg13_lv_pmos ad=0.34p pd=2.68u as=0 ps=0 w=1u l=1u
X856 VGND.t424 VPWR VGND.t424 VGND.t430 sg13_lv_nmos ad=0.1428p pd=1.52u as=0 ps=0 w=0.42u l=1u
X857 VGND.t484 VPWR VGND.t484 VGND.t494 sg13_lv_nmos ad=0.1428p pd=1.52u as=0 ps=0 w=0.42u l=1u
X858 VGND.t260 VPWR VGND.t260 VGND.t283 sg13_lv_nmos ad=0.1428p pd=1.52u as=0 ps=0 w=0.42u l=1u
X859 VPWR a_5392_12458# a_5337_12339# VPWR sg13_lv_pmos ad=2.16757p pd=13.96u as=93.45f ps=0.865u w=0.42u l=0.13u
X860 VPWR VGND.t295 VPWR VPWR sg13_lv_pmos ad=0.19p pd=1.38u as=0 ps=0 w=1u l=1u
X861 VGND.t747 VPWR VGND.t747 VGND.t748 sg13_lv_nmos ad=0.1428p pd=1.52u as=0 ps=0 w=0.42u l=1u
X862 VGND.t590 VPWR VGND.t572 VGND.t594 sg13_lv_nmos ad=79.8f pd=0.8u as=0 ps=0 w=0.42u l=1u
X863 VGND.t438 VPWR VGND.t438 VGND.t482 sg13_lv_nmos ad=79.8f pd=0.8u as=0 ps=0 w=0.42u l=1u
X864 VPWR VGND.t663 VPWR VPWR sg13_lv_pmos ad=0.34p pd=2.68u as=0 ps=0 w=1u l=1u
X865 sg13cmos5l_dfrbpq_1_2.RESET_B a_2142_13666# VPWR VPWR sg13_lv_pmos ad=0.3927p pd=2.99u as=1.7455p ps=10.885u w=1.155u l=0.13u
X866 VPWR VGND.t788 VPWR VPWR sg13_lv_pmos ad=0.19p pd=1.38u as=0 ps=0 w=1u l=1u
X867 VPWR VGND.t295 VPWR VPWR sg13_lv_pmos ad=0.34p pd=2.68u as=0 ps=0 w=1u l=1u
X868 VPWR VGND.t572 VPWR VPWR sg13_lv_pmos ad=0.19p pd=1.38u as=0 ps=0 w=1u l=1u
X869 a_10988_14442# sg13cmos5l_dfrbpq_1_4.Q VGND.t71 VGND.t1085 sg13_lv_nmos ad=0.187p pd=1.78u as=0.14875p ps=1.16u w=0.55u l=0.13u
X870 VGND.t148 sg13cmos5l_buf_1_0.X a_2196_11052# VGND.t147 sg13_lv_nmos ad=0.2272p pd=1.99u as=78.39999f ps=0.885u w=0.64u l=0.13u
X871 VPWR VGND.t405 VPWR VPWR sg13_lv_pmos ad=0.19p pd=1.38u as=0 ps=0 w=1u l=1u
X872 VPWR sg13cmos5l_nand4_1_0.C a_2366_13288# VPWR sg13_lv_pmos ad=0.36p pd=2.72u as=0.1225p ps=1.245u w=1u l=0.13u
X873 a_8782_13995# a_8897_13994# VPWR VPWR sg13_lv_pmos ad=0.34p pd=2.68u as=0.2254p ps=1.53u w=1u l=0.5u
X874 a_11733_10100# a_10791_10160# a_11639_10333# VPWR sg13_lv_pmos ad=79.8f pd=0.8u as=0.1428p ps=1.52u w=0.42u l=0.13u
X875 VGND.t3 a_8091_11458# sg13cmos5l_buf_8_0.A VGND.t15 sg13_lv_nmos ad=0.1406p pd=1.12u as=0.1406p ps=1.12u w=0.74u l=0.13u
X876 VPWR VGND.t419 VPWR VPWR sg13_lv_pmos ad=0.34p pd=2.68u as=0 ps=0 w=1u l=1u
X877 VPWR VGND.t484 VPWR VPWR sg13_lv_pmos ad=0.34p pd=2.68u as=0 ps=0 w=1u l=1u
X878 VGND.t410 VPWR VGND.t410 VGND.t460 sg13_lv_nmos ad=79.8f pd=0.8u as=0 ps=0 w=0.42u l=1u
X879 VPWR VGND.t371 VPWR VPWR sg13_lv_pmos ad=0.34p pd=2.68u as=0 ps=0 w=1u l=1u
X880 VPWR VGND.t312 VPWR VPWR sg13_lv_pmos ad=0.34p pd=2.68u as=0 ps=0 w=1u l=1u
X881 VPWR VGND.t424 VPWR VPWR sg13_lv_pmos ad=0.19p pd=1.38u as=0 ps=0 w=1u l=1u
X882 VGND.t484 VPWR VGND.t484 VGND.t488 sg13_lv_nmos ad=0.1428p pd=1.52u as=0 ps=0 w=0.42u l=1u
X883 VPWR sg13cmos5l_buf_8_0.A a_4426_11422# VPWR sg13_lv_pmos ad=0.2128p pd=1.5u as=0.2128p ps=1.5u w=1.12u l=0.13u
X884 VPWR a_10031_13043# a_10288_13186# VPWR sg13_lv_pmos ad=1.7455p pd=10.885u as=79.8f ps=0.8u w=0.42u l=0.13u
X885 VGND.t96 VPWR VGND.t342 VGND.t389 sg13_lv_nmos ad=79.8f pd=0.8u as=0 ps=0 w=0.42u l=1u
X886 sg13cmos5l_dfrbpq_1_6.D a_12150_13752# VPWR VPWR sg13_lv_pmos ad=0.4256p pd=3u as=0.2254p ps=1.53u w=1.12u l=0.13u
X887 VGND.t7 a_8091_11458# sg13cmos5l_buf_8_0.A VGND.t15 sg13_lv_nmos ad=0.1406p pd=1.12u as=0.1406p ps=1.12u w=0.74u l=0.13u
X888 VPWR VGND.t836 VPWR VPWR sg13_lv_pmos ad=0.34p pd=2.68u as=0 ps=0 w=1u l=1u
X889 VGND.t333 VPWR VGND.t333 VGND.t349 sg13_lv_nmos ad=79.8f pd=0.8u as=0 ps=0 w=0.42u l=1u
X890 VPWR a_10988_14442# count_o[5] VPWR sg13_lv_pmos ad=0.2114p pd=1.54u as=0.42p ps=2.99u w=1.12u l=0.13u
X891 VGND.t572 VPWR VGND.t572 VGND.t587 sg13_lv_nmos ad=79.8f pd=0.8u as=0 ps=0 w=0.42u l=1u
X892 VPWR VGND.t484 VPWR VPWR sg13_lv_pmos ad=0.34p pd=2.68u as=0 ps=0 w=1u l=1u
X893 a_6575_13043# a_5733_12945# a_6481_13043# VGND.t43 sg13_lv_nmos ad=0.12665p pd=1.145u as=0.1428p ps=1.52u w=0.42u l=0.13u
X894 VGND.t127 sg13cmos5l_dlygate4sd3_1_2.X sg13cmos5l_dfrbpq_1_1.D VGND.t1038 sg13_lv_nmos ad=0.2516p pd=2.16u as=0.1406p ps=1.12u w=0.74u l=0.13u
X895 VPWR VGND.t783 VPWR VPWR sg13_lv_pmos ad=0.34p pd=2.68u as=0 ps=0 w=1u l=1u
X896 VPWR sg13cmos5l_buf_1_0.X a_1914_10704# VPWR sg13_lv_pmos ad=0.2891p pd=1.695u as=0.1428p ps=1.375u w=1.12u l=0.13u
X897 VPWR VGND.t400 VPWR VPWR sg13_lv_pmos ad=0.19p pd=1.38u as=0 ps=0 w=1u l=1u
X898 a_14074_9910# sg13cmos5l_mux2_1_0.X VGND.t96 VGND.t969 sg13_lv_nmos ad=0.1428p pd=1.52u as=79.8f ps=0.8u w=0.42u l=0.13u
X899 VGND.t18 a_11733_12263# a_10812_12577# VGND.t128 sg13_lv_nmos ad=0.1626p pd=1.415u as=0.2516p ps=2.16u w=0.74u l=0.13u
X900 VGND.t572 VPWR VGND.t572 VGND.t596 sg13_lv_nmos ad=79.8f pd=0.8u as=0 ps=0 w=0.42u l=1u
X901 VGND.t237 VPWR VGND.t236 VGND.t235 sg13_lv_nmos ad=0.1428p pd=1.52u as=0 ps=0 w=0.42u l=1u
X902 VGND.t16 sg13cmos5l_buf_8_0.A a_11355_11458# VGND.t15 sg13_lv_nmos ad=0.1406p pd=1.12u as=0.1406p ps=1.12u w=0.74u l=0.13u
X903 a_3798_14086# sg13cmos5l_nand4_1_0.Y sg13cmos5l_xor2_1_1.X VGND.t959 sg13_lv_nmos ad=88.8f pd=0.98u as=0.1628p ps=1.18u w=0.74u l=0.13u
X904 VPWR VGND.t572 VPWR VPWR sg13_lv_pmos ad=0.19p pd=1.38u as=0 ps=0 w=1u l=1u
X905 a_4293_10715# sg13cmos5l_dfrbpq_1_0.CLK VGND.t2 VGND.t177 sg13_lv_nmos ad=0.2516p pd=2.16u as=4.55085p ps=29.865u w=0.74u l=0.13u
X906 VPWR a_4858_13692# a_4577_13994# VPWR sg13_lv_pmos ad=0.1523p pd=1.38u as=0.34p ps=2.68u w=1u l=0.5u
X907 VPWR VGND.t308 VPWR VPWR sg13_lv_pmos ad=0.19p pd=1.38u as=0 ps=0 w=1u l=1u
X908 VGND.t18 VPWR VGND.t18 VGND.t279 sg13_lv_nmos ad=0.1428p pd=1.52u as=0 ps=0 w=0.42u l=1u
X909 VGND.t613 VPWR VGND.t613 VGND.t615 sg13_lv_nmos ad=79.8f pd=0.8u as=0 ps=0 w=0.42u l=1u
X910 VGND.t1 VPWR VGND.t1 VGND.t381 sg13_lv_nmos ad=79.8f pd=0.8u as=0 ps=0 w=0.42u l=1u
X911 sg13cmos5l_dfrbpq_1_4.Q a_10698_13264# VGND.t10 VGND.t46 sg13_lv_nmos ad=0.2516p pd=2.16u as=0.1406p ps=1.12u w=0.74u l=0.13u
X912 VPWR a_4293_12227# a_4395_12227# VPWR sg13_lv_pmos ad=2.16757p pd=13.96u as=0.3864p ps=2.93u w=1.12u l=0.13u
X913 VPWR VGND.t419 VPWR VPWR sg13_lv_pmos ad=0.34p pd=2.68u as=0 ps=0 w=1u l=1u
X914 VPWR rst_ni a_808_8468# VPWR sg13_lv_pmos ad=0.2114p pd=1.54u as=0.2856p ps=2.36u w=0.84u l=0.13u
X915 VGND.t62 a_8975_10019# a_9642_10240# VGND.t61 sg13_lv_nmos ad=0.1406p pd=1.12u as=0.2516p ps=2.16u w=0.74u l=0.13u
X916 VPWR VGND.t344 VPWR VPWR sg13_lv_pmos ad=0.34p pd=2.68u as=0 ps=0 w=1u l=1u
X917 VPWR VGND.t577 VPWR VPWR sg13_lv_pmos ad=0.19p pd=1.38u as=0 ps=0 w=1u l=1u
X918 VPWR VGND.t424 VPWR VPWR sg13_lv_pmos ad=0.19p pd=1.38u as=0 ps=0 w=1u l=1u
X919 VGND.t577 VPWR VGND.t572 VGND.t581 sg13_lv_nmos ad=79.8f pd=0.8u as=0 ps=0 w=0.42u l=1u
X920 VPWR VGND.t484 VPWR VPWR sg13_lv_pmos ad=0.34p pd=2.68u as=0 ps=0 w=1u l=1u
X921 a_9177_10257# a_8235_10064# a_8975_10019# VPWR sg13_lv_pmos ad=93.45f pd=0.865u as=0.2048p ps=1.63u w=0.42u l=0.13u
X922 VGND.t484 VPWR VGND.t484 VGND.t483 sg13_lv_nmos ad=0.1428p pd=1.52u as=0 ps=0 w=0.42u l=1u
X923 VGND.t603 VPWR VGND.t608 VGND.t607 sg13_lv_nmos ad=79.8f pd=0.8u as=0 ps=0 w=0.42u l=1u
X924 VPWR VGND.t889 VPWR VPWR sg13_lv_pmos ad=0.19p pd=1.38u as=0 ps=0 w=1u l=1u
X925 a_10031_13043# a_9189_12945# a_8772_13284# VPWR sg13_lv_pmos ad=0.2048p pd=1.63u as=0.34p ps=2.68u w=1u l=0.13u
X926 VPWR VGND.t410 VPWR VPWR sg13_lv_pmos ad=0.34p pd=2.68u as=0 ps=0 w=1u l=1u
X927 VPWR VGND.t378 VPWR VPWR sg13_lv_pmos ad=0.34p pd=2.68u as=0 ps=0 w=1u l=1u
X928 VGND.t484 VPWR VGND.t484 VGND.t511 sg13_lv_nmos ad=79.8f pd=0.8u as=0 ps=0 w=0.42u l=1u
X929 VGND.t302 VPWR VGND.t301 VGND.t2 sg13_lv_nmos ad=0.1428p pd=1.52u as=0 ps=0 w=0.42u l=1u
X930 sg13cmos5l_dlygate4sd3_1_8.A sg13cmos5l_a21oi_1_2.A1 a_8307_14076# VGND.t1035 sg13_lv_nmos ad=0.1406p pd=1.12u as=0.1406p ps=1.12u w=0.74u l=0.13u
X931 a_3876_12220# a_3850_12184# VGND.t133 VGND.t132 sg13_lv_nmos ad=0.2516p pd=2.16u as=0.1626p ps=1.415u w=0.74u l=0.13u
X932 VGND.t572 VPWR VGND.t590 VGND.t589 sg13_lv_nmos ad=79.8f pd=0.8u as=0 ps=0 w=0.42u l=1u
X933 VPWR VGND.t484 VPWR VPWR sg13_lv_pmos ad=0.34p pd=2.68u as=0 ps=0 w=1u l=1u
X934 a_2238_10194# a_2039_10257# VGND.t23 VGND.t958 sg13_lv_nmos ad=0.27427p pd=2.28u as=2.99005p ps=19.165u w=0.795u l=0.13u
X935 a_5542_12979# sg13cmos5l_dfrbpq_1_1.RESET_B VGND.t75 VGND.t984 sg13_lv_nmos ad=37.8f pd=0.6u as=0.1701p ps=1.65u w=0.42u l=0.13u
X936 VGND.t18 VPWR VGND.t18 VGND.t256 sg13_lv_nmos ad=0.1428p pd=1.52u as=0 ps=0 w=0.42u l=1u
X937 a_5554_12654# sg13cmos5l_dfrbpq_1_2.RESET_B VGND.t75 VGND.t1101 sg13_lv_nmos ad=37.8f pd=0.6u as=79.8f ps=0.8u w=0.42u l=0.13u
X938 VPWR sg13cmos5l_nand2_1_1.A sg13cmos5l_nand3_1_1.Y VPWR sg13_lv_pmos ad=0.2128p pd=1.5u as=0.2128p ps=1.5u w=1.12u l=0.13u
X939 VPWR VGND.t433 VPWR VPWR sg13_lv_pmos ad=0.34p pd=2.68u as=0 ps=0 w=1u l=1u
X940 a_13673_14066# a_13797_13765# VPWR VPWR sg13_lv_pmos ad=0.2442p pd=2.06u as=1.7455p ps=10.885u w=0.66u l=0.13u
X941 VGND.t253 VPWR VGND.t255 VGND.t254 sg13_lv_nmos ad=79.8f pd=0.8u as=0 ps=0 w=0.42u l=1u
X942 VPWR VGND.t747 VPWR VPWR sg13_lv_pmos ad=0.34p pd=2.68u as=0 ps=0 w=1u l=1u
X943 VGND.t572 VPWR VGND.t572 VGND.t598 sg13_lv_nmos ad=79.8f pd=0.8u as=0 ps=0 w=0.42u l=1u
X944 VPWR sg13cmos5l_nor3_2_0.A a_10604_11752# VPWR sg13_lv_pmos ad=0.3808p pd=2.92u as=0.2128p ps=1.5u w=1.12u l=0.13u
X945 a_9060_12979# a_9291_13088# a_8746_13189# VGND.t180 sg13_lv_nmos ad=0.2373p pd=1.97u as=79.8f ps=0.8u w=0.42u l=0.13u
X946 VPWR VGND.t260 VPWR VPWR sg13_lv_pmos ad=0.19p pd=1.38u as=0 ps=0 w=1u l=1u
X947 VPWR VGND.t198 VPWR VPWR sg13_lv_pmos ad=0.34p pd=2.68u as=0 ps=0 w=1u l=1u
X948 a_5290_13189# a_5733_12945# a_5673_13357# VPWR sg13_lv_pmos ad=79.8f pd=0.8u as=63f ps=0.72u w=0.42u l=0.13u
X949 a_6832_13186# a_6575_13043# a_6994_12966# VGND.t43 sg13_lv_nmos ad=0.1428p pd=1.52u as=37.8f ps=0.6u w=0.42u l=0.13u
X950 VPWR VGND.t419 VPWR VPWR sg13_lv_pmos ad=0.19p pd=1.38u as=0 ps=0 w=1u l=1u
X951 VPWR VGND.t572 VPWR VPWR sg13_lv_pmos ad=0.19p pd=1.38u as=0 ps=0 w=1u l=1u
X952 VGND.t16 VPWR VGND.t16 VGND.t2 sg13_lv_nmos ad=0.1428p pd=1.52u as=0 ps=0 w=0.42u l=1u
X953 VGND.t383 VPWR VGND.t340 VGND.t384 sg13_lv_nmos ad=79.8f pd=0.8u as=0 ps=0 w=0.42u l=1u
X954 VPWR VGND.t328 VPWR VPWR sg13_lv_pmos ad=0.34p pd=2.68u as=0 ps=0 w=1u l=1u
X955 VPWR VGND.t328 VPWR VPWR sg13_lv_pmos ad=0.34p pd=2.68u as=0 ps=0 w=1u l=1u
X956 VGND.t247 a_14828_14442# count_o[7] VGND.t1098 sg13_lv_nmos ad=0.14875p pd=1.16u as=0.2886p ps=2.26u w=0.74u l=0.13u
X957 VGND.t87 VPWR VGND.t87 VGND.t86 sg13_lv_nmos ad=0.1428p pd=1.52u as=0 ps=0 w=0.42u l=1u
X958 VGND.t484 VPWR VGND.t484 VGND.t505 sg13_lv_nmos ad=79.8f pd=0.8u as=0 ps=0 w=0.42u l=1u
X959 VPWR VGND.t405 VPWR VPWR sg13_lv_pmos ad=0.34p pd=2.68u as=0 ps=0 w=1u l=1u
X960 VGND.t18 VPWR VGND.t18 VGND.t278 sg13_lv_nmos ad=79.8f pd=0.8u as=0 ps=0 w=0.42u l=1u
X961 a_7430_9942# sg13cmos5l_dlygate4sd3_1_15.X VPWR VPWR sg13_lv_pmos ad=79.8f pd=0.8u as=0.1428p ps=1.52u w=0.42u l=0.13u
X962 VPWR VGND.t333 VPWR VPWR sg13_lv_pmos ad=0.34p pd=2.68u as=0 ps=0 w=1u l=1u
X963 VGND.t572 VPWR VGND.t572 VGND.t583 sg13_lv_nmos ad=79.8f pd=0.8u as=0 ps=0 w=0.42u l=1u
X964 VPWR VGND.t484 VPWR VPWR sg13_lv_pmos ad=0.34p pd=2.68u as=0 ps=0 w=1u l=1u
X965 VPWR VGND.t190 VPWR VPWR sg13_lv_pmos ad=0.34p pd=2.68u as=0 ps=0 w=1u l=1u
X966 VGND.t902 VPWR VGND.t904 VGND.t903 sg13_lv_nmos ad=79.8f pd=0.8u as=0 ps=0 w=0.42u l=1u
X967 a_3590_12654# a_4395_12227# a_3850_12184# VPWR sg13_lv_pmos ad=0.1428p pd=1.52u as=79.8f ps=0.8u w=0.42u l=0.13u
X968 VPWR sg13cmos5l_dfrbpq_1_4.RESET_B a_8486_12966# VPWR sg13_lv_pmos ad=0.36237p pd=2.605u as=79.8f ps=0.8u w=0.42u l=0.13u
X969 VGND.t419 VPWR VGND.t419 VGND.t422 sg13_lv_nmos ad=79.8f pd=0.8u as=0 ps=0 w=0.42u l=1u
X970 VPWR VGND.t303 VPWR VPWR sg13_lv_pmos ad=0.34p pd=2.68u as=0 ps=0 w=1u l=1u
X971 VGND.t202 VPWR VGND.t202 VGND.t201 sg13_lv_nmos ad=0.1428p pd=1.52u as=0 ps=0 w=0.42u l=1u
X972 VGND.t608 VPWR VGND.t608 VGND.t610 sg13_lv_nmos ad=79.8f pd=0.8u as=0 ps=0 w=0.42u l=1u
X973 VPWR VGND.t590 VPWR VPWR sg13_lv_pmos ad=0.34p pd=2.68u as=0 ps=0 w=1u l=1u
X974 VPWR VGND.t894 VPWR VPWR sg13_lv_pmos ad=0.19p pd=1.38u as=0 ps=0 w=1u l=1u
X975 a_7373_10728# sg13cmos5l_xor2_1_2.B a_7271_10728# VPWR sg13_lv_pmos ad=0.1575p pd=1.315u as=0.19p ps=1.38u w=1u l=0.13u
X976 VGND.t301 VPWR VGND.t3 VGND.t15 sg13_lv_nmos ad=0.1428p pd=1.52u as=0 ps=0 w=0.42u l=1u
X977 a_10444_12654# a_10231_12180# VPWR VPWR sg13_lv_pmos ad=79.8f pd=0.8u as=2.16757p ps=13.96u w=0.42u l=0.13u
X978 VPWR VGND.t134 VPWR VPWR sg13_lv_pmos ad=0.19p pd=1.38u as=0 ps=0 w=1u l=1u
X979 VPWR a_6382_12483# sg13cmos5l_dlygate4sd3_1_1.X VPWR sg13_lv_pmos ad=0.2254p pd=1.53u as=0.4256p ps=3u w=1.12u l=0.13u
X980 VPWR a_9178_13692# a_8897_13994# VPWR sg13_lv_pmos ad=0.1523p pd=1.38u as=0.34p ps=2.68u w=1u l=0.5u
X981 VGND.t572 VPWR VGND.t577 VGND.t576 sg13_lv_nmos ad=79.8f pd=0.8u as=0 ps=0 w=0.42u l=1u
X982 VPWR VGND.t934 VPWR VPWR sg13_lv_pmos ad=0.19p pd=1.38u as=0 ps=0 w=1u l=1u
X983 VPWR VGND.t572 VPWR VPWR sg13_lv_pmos ad=0.19p pd=1.38u as=0 ps=0 w=1u l=1u
X984 VPWR VGND.t311 VPWR VPWR sg13_lv_pmos ad=0.19p pd=1.38u as=0 ps=0 w=1u l=1u
X985 VGND.t2 a_4426_11422# sg13cmos5l_dfrbpq_1_0.CLK VGND.t1123 sg13_lv_nmos ad=0.1406p pd=1.12u as=0.1406p ps=1.12u w=0.74u l=0.13u
X986 VPWR VGND.t288 VPWR VPWR sg13_lv_pmos ad=0.19p pd=1.38u as=0 ps=0 w=1u l=1u
X987 VPWR VGND.t433 VPWR VPWR sg13_lv_pmos ad=0.34p pd=2.68u as=0 ps=0 w=1u l=1u
X988 VGND.t484 VPWR VGND.t484 VGND.t483 sg13_lv_nmos ad=0.1428p pd=1.52u as=0 ps=0 w=0.42u l=1u
X989 VPWR sg13cmos5l_dfrbpq_1_6.Q a_11192_12970# VPWR sg13_lv_pmos ad=0.1523p pd=1.38u as=0.1428p ps=1.52u w=0.42u l=0.13u
X990 VGND.t572 VPWR VGND.t572 VGND.t585 sg13_lv_nmos ad=79.8f pd=0.8u as=0 ps=0 w=0.42u l=1u
X991 VPWR a_8091_11458# sg13cmos5l_buf_8_0.A VPWR sg13_lv_pmos ad=0.2128p pd=1.5u as=0.2128p ps=1.5u w=1.12u l=0.13u
X992 VGND.t676 VPWR VGND.t676 VGND.t86 sg13_lv_nmos ad=79.8f pd=0.8u as=0 ps=0 w=0.42u l=1u
X993 VGND.t572 VPWR VGND.t572 VGND.t597 sg13_lv_nmos ad=0.1428p pd=1.52u as=0 ps=0 w=0.42u l=1u
X994 VPWR VGND.t572 VPWR VPWR sg13_lv_pmos ad=0.19p pd=1.38u as=0 ps=0 w=1u l=1u
X995 VGND.t484 VPWR VGND.t484 VGND.t511 sg13_lv_nmos ad=79.8f pd=0.8u as=0 ps=0 w=0.42u l=1u
X996 sg13cmos5l_buf_8_0.A a_8091_11458# VGND.t7 VGND.t15 sg13_lv_nmos ad=0.1406p pd=1.12u as=0.1406p ps=1.12u w=0.74u l=0.13u
X997 VGND.t200 a_4085_14482# sg13cmos5l_xor2_1_2.B VGND.t1016 sg13_lv_nmos ad=0.1406p pd=1.12u as=0.1406p ps=1.12u w=0.74u l=0.13u
X998 VPWR VGND.t919 VPWR VPWR sg13_lv_pmos ad=0.19p pd=1.38u as=0 ps=0 w=1u l=1u
X999 VPWR sg13cmos5l_dlygate4sd3_1_1.X sg13cmos5l_nor3_2_0.C VPWR sg13_lv_pmos ad=0.2128p pd=1.5u as=0.2128p ps=1.5u w=1.12u l=0.13u
X1000 VGND.t2 a_4426_11422# sg13cmos5l_dfrbpq_1_0.CLK VGND.t1119 sg13_lv_nmos ad=0.1406p pd=1.12u as=0.1406p ps=1.12u w=0.74u l=0.13u
X1001 VGND.t572 VPWR VGND.t603 VGND.t602 sg13_lv_nmos ad=79.8f pd=0.8u as=0 ps=0 w=0.42u l=1u
X1002 VPWR VGND.t572 VPWR VPWR sg13_lv_pmos ad=0.34p pd=2.68u as=0 ps=0 w=1u l=1u
X1003 a_3876_10708# a_4395_10715# a_5135_11065# VGND.t2 sg13_lv_nmos ad=0.3473p pd=2.71u as=0.12665p ps=1.145u w=0.74u l=0.13u
X1004 VPWR VGND.t879 VPWR VPWR sg13_lv_pmos ad=0.19p pd=1.38u as=0 ps=0 w=1u l=1u
X1005 VGND.t696 VPWR VGND.t696 VGND.t86 sg13_lv_nmos ad=79.8f pd=0.8u as=0 ps=0 w=0.42u l=1u
X1006 VGND.t484 VPWR VGND.t484 VGND.t507 sg13_lv_nmos ad=79.8f pd=0.8u as=0 ps=0 w=0.42u l=1u
X1007 VPWR VGND.t410 VPWR VPWR sg13_lv_pmos ad=0.34p pd=2.68u as=0 ps=0 w=1u l=1u
X1008 VPWR a_8091_11458# sg13cmos5l_buf_8_0.A VPWR sg13_lv_pmos ad=0.2128p pd=1.5u as=0.2128p ps=1.5u w=1.12u l=0.13u
X1009 sg13cmos5l_nand2_1_0.Y sg13cmos5l_buf_1_0.X VPWR VPWR sg13_lv_pmos ad=0.2128p pd=1.5u as=0.3808p ps=2.92u w=1.12u l=0.13u
X1010 a_4026_11470# sg13cmos5l_xor2_1_2.A VGND.t2 VGND.t181 sg13_lv_nmos ad=88.8f pd=0.98u as=0.15245p ps=1.17u w=0.74u l=0.13u
X1011 VPWR VGND.t410 VPWR VPWR sg13_lv_pmos ad=0.19p pd=1.38u as=0 ps=0 w=1u l=1u
X1012 a_8091_11458# clk_i VGND.t7 VGND.t15 sg13_lv_nmos ad=0.1406p pd=1.12u as=0.1406p ps=1.12u w=0.74u l=0.13u
X1013 sg13cmos5l_dfrbpq_1_7.CLK a_11355_11458# VGND.t16 VGND.t15 sg13_lv_nmos ad=0.1406p pd=1.12u as=0.1406p ps=1.12u w=0.74u l=0.13u
X1014 VPWR VGND.t783 VPWR VPWR sg13_lv_pmos ad=0.34p pd=2.68u as=0 ps=0 w=1u l=1u
X1015 VGND.t608 VPWR VGND.t613 VGND.t612 sg13_lv_nmos ad=79.8f pd=0.8u as=0 ps=0 w=0.42u l=1u
X1016 VPWR VGND.t899 VPWR VPWR sg13_lv_pmos ad=0.19p pd=1.38u as=0 ps=0 w=1u l=1u
X1017 VPWR VGND.t577 VPWR VPWR sg13_lv_pmos ad=0.34p pd=2.68u as=0 ps=0 w=1u l=1u
X1018 VGND.t521 VPWR VGND.t521 VGND.t524 sg13_lv_nmos ad=79.8f pd=0.8u as=0 ps=0 w=0.42u l=1u
X1019 VPWR VGND.t424 VPWR VPWR sg13_lv_pmos ad=0.34p pd=2.68u as=0 ps=0 w=1u l=1u
X1020 a_8986_14446# sg13cmos5l_o21ai_1_2.Y VGND.t59 VGND.t1083 sg13_lv_nmos ad=0.1428p pd=1.52u as=79.8f ps=0.8u w=0.42u l=0.13u
X1021 VGND.t36 VPWR VGND.t36 VGND.t379 sg13_lv_nmos ad=79.8f pd=0.8u as=0 ps=0 w=0.42u l=1u
X1022 a_11639_12263# a_10943_12187# a_11733_12263# VGND.t1043 sg13_lv_nmos ad=0.1296p pd=1.52u as=79.8f ps=0.8u w=0.42u l=0.13u
X1023 VPWR VGND.t433 VPWR VPWR sg13_lv_pmos ad=0.19p pd=1.38u as=0 ps=0 w=1u l=1u
X1024 VGND.t1006 sg13cmos5l_dfrbpq_1_4.RESET_B a_8580_12966# VGND.t1080 sg13_lv_nmos ad=0.1626p pd=1.415u as=60.89999f ps=0.71u w=0.42u l=0.13u
X1025 VGND.t2 a_4293_10715# a_4395_10715# VGND.t39 sg13_lv_nmos ad=4.55085p pd=29.865u as=0.2516p ps=2.16u w=0.74u l=0.13u
X1026 a_9178_13692# sg13cmos5l_dlygate4sd3_1_8.A VGND.t59 VGND.t966 sg13_lv_nmos ad=0.1428p pd=1.52u as=79.8f ps=0.8u w=0.42u l=0.13u
X1027 VPWR sg13cmos5l_buf_8_0.A a_11355_11458# VPWR sg13_lv_pmos ad=0.2128p pd=1.5u as=0.2128p ps=1.5u w=1.12u l=0.13u
X1028 VGND.t273 VPWR VGND.t275 VGND.t274 sg13_lv_nmos ad=79.8f pd=0.8u as=0 ps=0 w=0.42u l=1u
X1029 VPWR a_11733_10100# a_10812_9906# VPWR sg13_lv_pmos ad=0.36237p pd=2.605u as=0.34p ps=2.68u w=1u l=0.13u
X1030 VGND.t577 VPWR VGND.t577 VGND.t579 sg13_lv_nmos ad=79.8f pd=0.8u as=0 ps=0 w=0.42u l=1u
X1031 VGND.t484 VPWR VGND.t484 VGND.t505 sg13_lv_nmos ad=79.8f pd=0.8u as=0 ps=0 w=0.42u l=1u
X1032 VPWR VGND.t572 VPWR VPWR sg13_lv_pmos ad=0.19p pd=1.38u as=0 ps=0 w=1u l=1u
X1033 VPWR sg13cmos5l_mux2_1_0.S a_11195_9248# VPWR sg13_lv_pmos ad=0.253p pd=1.53u as=0.2856p ps=2.36u w=0.84u l=0.13u
X1034 a_6309_13765# a_6309_13765# VGND.t59 VGND.t168 sg13_lv_nmos ad=0.111p pd=1.34u as=3.51557p ps=23.16u w=0.3u l=0.13u
X1035 VGND.t484 VPWR VGND.t484 VGND.t517 sg13_lv_nmos ad=79.8f pd=0.8u as=0 ps=0 w=0.42u l=1u
X1036 VPWR VGND.t438 VPWR VPWR sg13_lv_pmos ad=0.34p pd=2.68u as=0 ps=0 w=1u l=1u
X1037 sg13cmos5l_mux2_1_0.X a_11518_9562# VPWR VPWR sg13_lv_pmos ad=0.6048p pd=3.32u as=0.2198p ps=1.52u w=1.12u l=0.13u
X1038 VGND.t590 VPWR VGND.t590 VGND.t591 sg13_lv_nmos ad=0.1428p pd=1.52u as=0 ps=0 w=0.42u l=1u
X1039 VGND.t200 a_4462_13995# sg13cmos5l_nand4_1_0.C VGND.t982 sg13_lv_nmos ad=0.1426p pd=1.16u as=0.2516p ps=2.16u w=0.74u l=0.13u
X1040 a_7943_13264# sg13cmos5l_nand3_1_1.Y a_7849_12970# VPWR sg13_lv_pmos ad=0.19p pd=1.38u as=0.34p ps=2.68u w=1u l=0.13u
X1041 VGND.t747 VPWR VGND.t747 VGND.t749 sg13_lv_nmos ad=79.8f pd=0.8u as=0 ps=0 w=0.42u l=1u
X1042 VGND.t676 VPWR VGND.t676 VGND.t86 sg13_lv_nmos ad=79.8f pd=0.8u as=0 ps=0 w=0.42u l=1u
X1043 sg13cmos5l_nor2_1_3.B a_3761_11508# a_3932_11752# VPWR sg13_lv_pmos ad=0.3808p pd=2.92u as=0.2128p ps=1.5u w=1.12u l=0.13u
X1044 VGND.t572 VPWR VGND.t572 VGND.t599 sg13_lv_nmos ad=0.1428p pd=1.52u as=0 ps=0 w=0.42u l=1u
X1045 a_4570_12934# sg13cmos5l_dfrbpq_1_3.Q VGND.t104 VGND.t1047 sg13_lv_nmos ad=0.1428p pd=1.52u as=79.8f ps=0.8u w=0.42u l=0.13u
X1046 VPWR VGND.t405 VPWR VPWR sg13_lv_pmos ad=0.19p pd=1.38u as=0 ps=0 w=1u l=1u
X1047 a_11078_10704# a_10808_10745# VGND.t16 VGND.t2 sg13_lv_nmos ad=0.1428p pd=1.52u as=79.8f ps=0.8u w=0.42u l=0.5u
X1048 VPWR VGND.t924 VPWR VPWR sg13_lv_pmos ad=0.19p pd=1.38u as=0 ps=0 w=1u l=1u
X1049 VPWR VGND.t577 VPWR VPWR sg13_lv_pmos ad=0.19p pd=1.38u as=0 ps=0 w=1u l=1u
X1050 VPWR VGND.t603 VPWR VPWR sg13_lv_pmos ad=0.34p pd=2.68u as=0 ps=0 w=1u l=1u
X1051 VPWR VGND.t51 VPWR VPWR sg13_lv_pmos ad=0.34p pd=2.68u as=0 ps=0 w=1u l=1u
X1052 VGND.t922 VPWR VGND.t924 VGND.t923 sg13_lv_nmos ad=79.8f pd=0.8u as=0 ps=0 w=0.42u l=1u
X1053 a_4102_11129# sg13cmos5l_tiehi_0.L_HI VGND.t2 VGND.t951 sg13_lv_nmos ad=37.8f pd=0.6u as=0.1701p ps=1.65u w=0.42u l=0.13u
X1054 VGND.t603 VPWR VGND.t603 VGND.t605 sg13_lv_nmos ad=79.8f pd=0.8u as=0 ps=0 w=0.42u l=1u
X1055 a_8590_14667# a_8705_14668# VGND.t59 VGND.t1040 sg13_lv_nmos ad=0.1428p pd=1.52u as=0.1426p ps=1.16u w=0.42u l=0.5u
X1056 VGND.t572 VPWR VGND.t572 VGND.t584 sg13_lv_nmos ad=0.1428p pd=1.52u as=0 ps=0 w=0.42u l=1u
X1057 a_5030_12966# sg13cmos5l_dfrbpq_1_1.D VPWR VPWR sg13_lv_pmos ad=79.8f pd=0.8u as=0.1428p ps=1.52u w=0.42u l=0.13u
X1058 VGND.t696 VPWR VGND.t696 VGND.t86 sg13_lv_nmos ad=79.8f pd=0.8u as=0 ps=0 w=0.42u l=1u
X1059 VPWR VGND.t18 VPWR VPWR sg13_lv_pmos ad=0.34p pd=2.68u as=0 ps=0 w=1u l=1u
X1060 VGND.t484 VPWR VGND.t484 VGND.t509 sg13_lv_nmos ad=79.8f pd=0.8u as=0 ps=0 w=0.42u l=1u
X1061 VGND.t16 a_11828_10668# sg13cmos5l_mux2_1_0.A1 VGND.t2 sg13_lv_nmos ad=0.17255p pd=1.25u as=0.1406p ps=1.12u w=0.74u l=0.13u
X1062 VGND.t7 a_7918_10971# sg13cmos5l_a21oi_1_0.A1 VGND.t2 sg13_lv_nmos ad=0.1426p pd=1.16u as=0.2516p ps=2.16u w=0.74u l=0.13u
X1063 VGND.t295 VPWR VGND.t295 VGND.t296 sg13_lv_nmos ad=79.8f pd=0.8u as=0 ps=0 w=0.42u l=1u
X1064 a_3810_12974# sg13cmos5l_nand4_1_0.C a_3708_12974# VGND.t978 sg13_lv_nmos ad=0.1406p pd=1.12u as=0.1406p ps=1.12u w=0.74u l=0.13u
X1065 VGND.t590 VPWR VGND.t590 VGND.t593 sg13_lv_nmos ad=0.1428p pd=1.52u as=0 ps=0 w=0.42u l=1u
X1066 VPWR VGND.t410 VPWR VPWR sg13_lv_pmos ad=0.19p pd=1.38u as=0 ps=0 w=1u l=1u
X1067 VGND.t570 VPWR VGND.t572 VGND.t571 sg13_lv_nmos ad=79.8f pd=0.8u as=0 ps=0 w=0.42u l=1u
X1068 VPWR VGND.t219 VPWR VPWR sg13_lv_pmos ad=0.19p pd=1.38u as=0 ps=0 w=1u l=1u
X1069 VGND.t688 VPWR VGND.t688 VGND.t86 sg13_lv_nmos ad=0.1428p pd=1.52u as=0 ps=0 w=0.42u l=1u
X1070 VGND.t10 sg13cmos5l_dfrbpq_1_6.RESET_B a_10538_12654# VGND.t105 sg13_lv_nmos ad=79.8f pd=0.8u as=37.8f ps=0.6u w=0.42u l=0.13u
X1071 VPWR VGND.t869 VPWR VPWR sg13_lv_pmos ad=0.19p pd=1.38u as=0 ps=0 w=1u l=1u
X1072 VPWR VGND.t577 VPWR VPWR sg13_lv_pmos ad=0.34p pd=2.68u as=0 ps=0 w=1u l=1u
X1073 a_6448_10162# sg13cmos5l_dfrbpq_1_0.RESET_B VPWR VPWR sg13_lv_pmos ad=79.8f pd=0.8u as=1.38282p ps=8.655u w=0.42u l=0.13u
X1074 VGND.t608 VPWR VGND.t608 VGND.t611 sg13_lv_nmos ad=0.1428p pd=1.52u as=0 ps=0 w=0.42u l=1u
X1075 VPWR VGND.t433 VPWR VPWR sg13_lv_pmos ad=0.19p pd=1.38u as=0 ps=0 w=1u l=1u
X1076 VGND.t198 VPWR VGND.t198 VGND.t197 sg13_lv_nmos ad=0.1428p pd=1.52u as=0 ps=0 w=0.42u l=1u
X1077 VPWR VGND.t896 VPWR VPWR sg13_lv_pmos ad=0.34p pd=2.68u as=0 ps=0 w=1u l=1u
X1078 VGND.t676 VPWR VGND.t676 VGND.t86 sg13_lv_nmos ad=79.8f pd=0.8u as=0 ps=0 w=0.42u l=1u
X1079 VGND.t857 VPWR VGND.t859 VGND.t858 sg13_lv_nmos ad=79.8f pd=0.8u as=0 ps=0 w=0.42u l=1u
X1080 VPWR VGND.t6 VPWR VPWR sg13_lv_pmos ad=0.19p pd=1.38u as=0 ps=0 w=1u l=1u
X1081 VPWR a_6286_10971# sg13cmos5l_xor2_1_2.A VPWR sg13_lv_pmos ad=0.2254p pd=1.53u as=0.4256p ps=3u w=1.12u l=0.13u
X1082 VGND.t484 VPWR VGND.t484 VGND.t507 sg13_lv_nmos ad=79.8f pd=0.8u as=0 ps=0 w=0.42u l=1u
X1083 VPWR VGND.t909 VPWR VPWR sg13_lv_pmos ad=0.19p pd=1.38u as=0 ps=0 w=1u l=1u
X1084 VPWR a_11195_9248# a_11695_9216# VPWR sg13_lv_pmos ad=0.2198p pd=1.52u as=0.2975p ps=1.595u w=1u l=0.13u
X1085 VGND.t484 VPWR VGND.t484 VGND.t519 sg13_lv_nmos ad=79.8f pd=0.8u as=0 ps=0 w=0.42u l=1u
X1086 VPWR VGND.t424 VPWR VPWR sg13_lv_pmos ad=0.34p pd=2.68u as=0 ps=0 w=1u l=1u
X1087 VGND.t310 VPWR VGND.t308 VGND.t15 sg13_lv_nmos ad=0.1428p pd=1.52u as=0 ps=0 w=0.42u l=1u
X1088 VPWR VGND.t484 VPWR VPWR sg13_lv_pmos ad=0.34p pd=2.68u as=0 ps=0 w=1u l=1u
X1089 VPWR VGND.t424 VPWR VPWR sg13_lv_pmos ad=0.34p pd=2.68u as=0 ps=0 w=1u l=1u
X1090 VGND.t747 VPWR VGND.t747 VGND.t762 sg13_lv_nmos ad=79.8f pd=0.8u as=0 ps=0 w=0.42u l=1u
X1091 VGND.t577 VPWR VGND.t577 VGND.t578 sg13_lv_nmos ad=0.1428p pd=1.52u as=0 ps=0 w=0.42u l=1u
X1092 VGND.t260 VPWR VGND.t260 VGND.t264 sg13_lv_nmos ad=79.8f pd=0.8u as=0 ps=0 w=0.42u l=1u
X1093 sg13cmos5l_mux2_1_0.A0 a_12141_11052# VGND.t303 VGND.t2 sg13_lv_nmos ad=0.2516p pd=2.16u as=0.1331p ps=1.12u w=0.74u l=0.13u
X1094 VGND.t521 VPWR VGND.t521 VGND.t524 sg13_lv_nmos ad=79.8f pd=0.8u as=0 ps=0 w=0.42u l=1u
X1095 a_7177_10728# sg13cmos5l_xor2_1_2.B VGND.t7 VGND.t2 sg13_lv_nmos ad=0.198p pd=1.27u as=0.1045p ps=0.93u w=0.55u l=0.13u
X1096 VGND.t191 VPWR VGND.t190 VGND.t189 sg13_lv_nmos ad=0.1428p pd=1.52u as=0 ps=0 w=0.42u l=1u
X1097 VPWR VGND.t747 VPWR VPWR sg13_lv_pmos ad=0.19p pd=1.38u as=0 ps=0 w=1u l=1u
X1098 VGND.t572 VPWR VGND.t572 VGND.t586 sg13_lv_nmos ad=0.1428p pd=1.52u as=0 ps=0 w=0.42u l=1u
X1099 VGND.t424 VPWR VGND.t424 VGND.t475 sg13_lv_nmos ad=0.1428p pd=1.52u as=0 ps=0 w=0.42u l=1u
X1100 VGND.t438 VPWR VGND.t438 VGND.t439 sg13_lv_nmos ad=79.8f pd=0.8u as=0 ps=0 w=0.42u l=1u
X1101 VPWR VGND.t410 VPWR VPWR sg13_lv_pmos ad=0.19p pd=1.38u as=0 ps=0 w=1u l=1u
X1102 VGND.t852 VPWR VGND.t854 VGND.t853 sg13_lv_nmos ad=79.8f pd=0.8u as=0 ps=0 w=0.42u l=1u
X1103 a_4293_10715# sg13cmos5l_dfrbpq_1_0.CLK VPWR VPWR sg13_lv_pmos ad=0.4088p pd=2.97u as=1.3227p ps=8.28u w=1.12u l=0.13u
X1104 sg13cmos5l_a21oi_1_1.Y sg13cmos5l_a21oi_1_0.B1 VGND.t215 VGND.t1033 sg13_lv_nmos ad=0.1406p pd=1.12u as=0.2516p ps=2.16u w=0.74u l=0.13u
X1105 VGND.t676 VPWR VGND.t676 VGND.t86 sg13_lv_nmos ad=0.1428p pd=1.52u as=0 ps=0 w=0.42u l=1u
X1106 sg13cmos5l_a21oi_1_0.A2 a_7177_10728# VGND.t7 VGND.t2 sg13_lv_nmos ad=0.2516p pd=2.16u as=0.13395p ps=1.12u w=0.74u l=0.13u
X1107 a_10812_9906# a_10943_10212# a_10231_9906# VPWR sg13_lv_pmos ad=0.34p pd=2.68u as=0.2048p ps=1.63u w=1u l=0.13u
X1108 VPWR VGND.t854 VPWR VPWR sg13_lv_pmos ad=0.19p pd=1.38u as=0 ps=0 w=1u l=1u
X1109 VPWR VGND.t572 VPWR VPWR sg13_lv_pmos ad=0.34p pd=2.68u as=0 ps=0 w=1u l=1u
X1110 VGND.t333 VPWR VGND.t348 VGND.t347 sg13_lv_nmos ad=0.1428p pd=1.52u as=0 ps=0 w=0.42u l=1u
X1111 VPWR VGND.t276 VPWR VPWR sg13_lv_pmos ad=0.34p pd=2.68u as=0 ps=0 w=1u l=1u
X1112 VPWR VGND.t590 VPWR VPWR sg13_lv_pmos ad=0.34p pd=2.68u as=0 ps=0 w=1u l=1u
X1113 VGND.t484 VPWR VGND.t484 VGND.t497 sg13_lv_nmos ad=79.8f pd=0.8u as=0 ps=0 w=0.42u l=1u
X1114 VPWR VGND.t484 VPWR VPWR sg13_lv_pmos ad=0.19p pd=1.38u as=0 ps=0 w=1u l=1u
X1115 VGND.t96 VPWR VGND.t96 VGND.t388 sg13_lv_nmos ad=0.1428p pd=1.52u as=0 ps=0 w=0.42u l=1u
X1116 a_1940_13264# a_1914_13162# sg13cmos5l_nor2_1_1.B VPWR sg13_lv_pmos ad=0.2128p pd=1.5u as=0.3808p ps=2.92u w=1.12u l=0.13u
X1117 VGND.t484 VPWR VGND.t484 VGND.t517 sg13_lv_nmos ad=79.8f pd=0.8u as=0 ps=0 w=0.42u l=1u
X1118 sg13cmos5l_dfrbpq_1_2.Q a_5802_12216# VPWR VPWR sg13_lv_pmos ad=0.3808p pd=2.92u as=0.2128p ps=1.5u w=1.12u l=0.13u
X1119 VGND.t572 VPWR VGND.t572 VGND.t595 sg13_lv_nmos ad=0.1428p pd=1.52u as=0 ps=0 w=0.42u l=1u
X1120 VPWR sg13cmos5l_dfrbpq_1_6.D a_11639_12263# VPWR sg13_lv_pmos ad=0.1428p pd=1.52u as=79.8f ps=0.8u w=0.42u l=0.13u
X1121 VGND.t484 VPWR VGND.t484 VGND.t508 sg13_lv_nmos ad=0.1428p pd=1.52u as=0 ps=0 w=0.42u l=1u
X1122 a_6994_12966# sg13cmos5l_dfrbpq_1_1.RESET_B VGND.t44 VGND.t43 sg13_lv_nmos ad=37.8f pd=0.6u as=79.8f ps=0.8u w=0.42u l=0.13u
X1123 VGND.t603 VPWR VGND.t603 VGND.t604 sg13_lv_nmos ad=0.1428p pd=1.52u as=0 ps=0 w=0.42u l=1u
X1124 count_o[1] a_2920_14516# VGND.t237 VGND.t1039 sg13_lv_nmos ad=0.2886p pd=2.26u as=0.14875p ps=1.16u w=0.74u l=0.13u
X1125 a_10988_14442# sg13cmos5l_dfrbpq_1_4.Q VPWR VPWR sg13_lv_pmos ad=0.2856p pd=2.36u as=0.2114p ps=1.54u w=0.84u l=0.13u
X1126 VPWR VGND.t572 VPWR VPWR sg13_lv_pmos ad=0.34p pd=2.68u as=0 ps=0 w=1u l=1u
X1127 VPWR a_4426_11422# sg13cmos5l_dfrbpq_1_0.CLK VPWR sg13_lv_pmos ad=0.2128p pd=1.5u as=0.2128p ps=1.5u w=1.12u l=0.13u
X1128 VGND.t484 VPWR VGND.t484 VGND.t513 sg13_lv_nmos ad=79.8f pd=0.8u as=0 ps=0 w=0.42u l=1u
X1129 VPWR VGND.t410 VPWR VPWR sg13_lv_pmos ad=0.34p pd=2.68u as=0 ps=0 w=1u l=1u
X1130 VGND.t752 VPWR VGND.t747 VGND.t756 sg13_lv_nmos ad=79.8f pd=0.8u as=0 ps=0 w=0.42u l=1u
X1131 sg13cmos5l_xor2_1_2.B a_4085_14482# VGND.t200 VGND.t1017 sg13_lv_nmos ad=0.1406p pd=1.12u as=0.1406p ps=1.12u w=0.74u l=0.13u
X1132 VGND.t688 VPWR VGND.t688 VGND.t86 sg13_lv_nmos ad=79.8f pd=0.8u as=0 ps=0 w=0.42u l=1u
X1133 VGND.t613 VPWR VGND.t613 VGND.t614 sg13_lv_nmos ad=0.1428p pd=1.52u as=0 ps=0 w=0.42u l=1u
X1134 VGND.t1 VPWR VGND.t1 VGND.t380 sg13_lv_nmos ad=0.1428p pd=1.52u as=0 ps=0 w=0.42u l=1u
X1135 sg13cmos5l_dfrbpq_1_0.CLK a_4426_11422# VGND.t2 VGND.t1120 sg13_lv_nmos ad=0.1406p pd=1.12u as=0.1406p ps=1.12u w=0.74u l=0.13u
X1136 VPWR VGND.t901 VPWR VPWR sg13_lv_pmos ad=0.34p pd=2.68u as=0 ps=0 w=1u l=1u
X1137 VGND.t190 VPWR VGND.t190 VGND.t231 sg13_lv_nmos ad=0.1428p pd=1.52u as=0 ps=0 w=0.42u l=1u
X1138 VGND.t247 VPWR VGND.t246 VGND.t245 sg13_lv_nmos ad=0.1428p pd=1.52u as=0 ps=0 w=0.42u l=1u
X1139 VPWR VGND.t484 VPWR VPWR sg13_lv_pmos ad=0.19p pd=1.38u as=0 ps=0 w=1u l=1u
X1140 VGND.t484 VPWR VGND.t484 VGND.t509 sg13_lv_nmos ad=79.8f pd=0.8u as=0 ps=0 w=0.42u l=1u
X1141 VPWR VGND.t914 VPWR VPWR sg13_lv_pmos ad=0.19p pd=1.38u as=0 ps=0 w=1u l=1u
X1142 a_5289_10333# a_4932_10260# VPWR VPWR sg13_lv_pmos ad=63f pd=0.72u as=0.1563p ps=1.22u w=0.42u l=0.13u
X1143 VPWR VGND.t572 VPWR VPWR sg13_lv_pmos ad=0.19p pd=1.38u as=0 ps=0 w=1u l=1u
X1144 sg13cmos5l_buf_8_0.A a_8091_11458# VPWR VPWR sg13_lv_pmos ad=0.2128p pd=1.5u as=0.2128p ps=1.5u w=1.12u l=0.13u
X1145 VPWR sg13cmos5l_xnor2_1_0.B sg13cmos5l_nand2_1_0.Y VPWR sg13_lv_pmos ad=0.3808p pd=2.92u as=0.2128p ps=1.5u w=1.12u l=0.13u
X1146 VGND.t59 a_9449_14424# a_9370_14699# VGND.t1079 sg13_lv_nmos ad=3.51557p pd=23.16u as=0.27427p ps=2.28u w=0.795u l=0.13u
X1147 VGND.t521 VPWR VGND.t521 VGND.t522 sg13_lv_nmos ad=79.8f pd=0.8u as=0 ps=0 w=0.42u l=1u
X1148 VPWR a_5326_13995# sg13cmos5l_dlygate4sd3_1_2.X VPWR sg13_lv_pmos ad=0.2254p pd=1.53u as=0.4256p ps=3u w=1.12u l=0.13u
X1149 VPWR a_4426_11422# sg13cmos5l_dfrbpq_1_0.CLK VPWR sg13_lv_pmos ad=0.2128p pd=1.5u as=0.2128p ps=1.5u w=1.12u l=0.13u
X1150 VGND.t747 VPWR VGND.t765 VGND.t764 sg13_lv_nmos ad=79.8f pd=0.8u as=0 ps=0 w=0.42u l=1u
X1151 VGND.t577 VPWR VGND.t577 VGND.t580 sg13_lv_nmos ad=0.1428p pd=1.52u as=0 ps=0 w=0.42u l=1u
X1152 VGND.t202 a_5722_13692# a_5441_13994# VGND.t981 sg13_lv_nmos ad=79.8f pd=0.8u as=0.1428p ps=1.52u w=0.42u l=0.5u
X1153 VPWR VGND.t438 VPWR VPWR sg13_lv_pmos ad=0.34p pd=2.68u as=0 ps=0 w=1u l=1u
X1154 VGND.t200 sg13cmos5l_nand3_1_0.Y a_4085_14482# VGND.t1036 sg13_lv_nmos ad=0.3293p pd=1.63u as=0.2516p ps=2.16u w=0.74u l=0.13u
X1155 a_11854_14667# a_11969_14668# VGND.t71 VGND.t1052 sg13_lv_nmos ad=0.1428p pd=1.52u as=0.1426p ps=1.16u w=0.42u l=0.5u
X1156 VPWR VGND.t572 VPWR VPWR sg13_lv_pmos ad=0.34p pd=2.68u as=0 ps=0 w=1u l=1u
X1157 VPWR VGND.t676 VPWR VPWR sg13_lv_pmos ad=0.19p pd=1.38u as=0 ps=0 w=1u l=1u
X1158 VPWR VGND.t484 VPWR VPWR sg13_lv_pmos ad=0.19p pd=1.38u as=0 ps=0 w=1u l=1u
X1159 a_5722_13692# sg13cmos5l_xor2_1_1.X VPWR VPWR sg13_lv_pmos ad=0.1428p pd=1.52u as=0.1523p ps=1.38u w=0.42u l=0.13u
X1160 VPWR VGND.t886 VPWR VPWR sg13_lv_pmos ad=0.34p pd=2.68u as=0 ps=0 w=1u l=1u
X1161 VGND.t6 sg13cmos5l_a21oi_1_0.A2 a_7457_9540# VGND.t5 sg13_lv_nmos ad=0.2516p pd=2.16u as=0.1406p ps=1.12u w=0.74u l=0.13u
X1162 a_11733_10100# sg13cmos5l_dfrbpq_1_5.RESET_B VPWR VPWR sg13_lv_pmos ad=0.147p pd=1.54u as=0.1563p ps=1.22u w=0.42u l=0.13u
X1163 VPWR VGND.t362 VPWR VPWR sg13_lv_pmos ad=0.19p pd=1.38u as=0 ps=0 w=1u l=1u
X1164 a_9274_10668# sg13cmos5l_dfrbpq_1_7.Q VPWR VPWR sg13_lv_pmos ad=0.1428p pd=1.52u as=0.1523p ps=1.38u w=0.42u l=0.13u
X1165 VGND.t307 VPWR VGND.t308 VGND.t15 sg13_lv_nmos ad=79.8f pd=0.8u as=0 ps=0 w=0.42u l=1u
X1166 VGND.t572 VPWR VGND.t572 VGND.t588 sg13_lv_nmos ad=0.1428p pd=1.52u as=0 ps=0 w=0.42u l=1u
X1167 VGND.t190 a_1388_14442# count_o[0] VGND.t1026 sg13_lv_nmos ad=0.14875p pd=1.16u as=0.2886p ps=2.26u w=0.74u l=0.13u
X1168 VGND.t7 a_8314_10668# a_8033_10970# VGND.t2 sg13_lv_nmos ad=79.8f pd=0.8u as=0.1428p ps=1.52u w=0.42u l=0.5u
X1169 a_8091_11458# clk_i VPWR VPWR sg13_lv_pmos ad=0.2128p pd=1.5u as=0.2128p ps=1.5u w=1.12u l=0.13u
X1170 VGND.t684 VPWR VGND.t684 VGND.t86 sg13_lv_nmos ad=0.1428p pd=1.52u as=0 ps=0 w=0.42u l=1u
X1171 sg13cmos5l_dfrbpq_1_7.CLK a_11355_11458# VPWR VPWR sg13_lv_pmos ad=0.2128p pd=1.5u as=0.2128p ps=1.5u w=1.12u l=0.13u
X1172 VPWR VGND.t572 VPWR VPWR sg13_lv_pmos ad=0.34p pd=2.68u as=0 ps=0 w=1u l=1u
X1173 a_10444_9942# a_10231_9906# VPWR VPWR sg13_lv_pmos ad=79.8f pd=0.8u as=1.38282p ps=8.655u w=0.42u l=0.13u
X1174 VPWR VGND.t926 VPWR VPWR sg13_lv_pmos ad=0.34p pd=2.68u as=0 ps=0 w=1u l=1u
X1175 VPWR VGND.t577 VPWR VPWR sg13_lv_pmos ad=0.34p pd=2.68u as=0 ps=0 w=1u l=1u
X1176 VGND.t688 VPWR VGND.t688 VGND.t86 sg13_lv_nmos ad=79.8f pd=0.8u as=0 ps=0 w=0.42u l=1u
X1177 VPWR VGND.t672 VPWR VPWR sg13_lv_pmos ad=0.19p pd=1.38u as=0 ps=0 w=1u l=1u
X1178 VGND.t484 VPWR VGND.t484 VGND.t519 sg13_lv_nmos ad=79.8f pd=0.8u as=0 ps=0 w=0.42u l=1u
X1179 VPWR a_5392_10946# a_5337_10827# VPWR sg13_lv_pmos ad=1.38282p pd=8.655u as=93.45f ps=0.865u w=0.42u l=0.13u
X1180 VGND.t484 VPWR VGND.t484 VGND.t510 sg13_lv_nmos ad=0.1428p pd=1.52u as=0 ps=0 w=0.42u l=1u
X1181 VGND.t603 VPWR VGND.t603 VGND.t606 sg13_lv_nmos ad=0.1428p pd=1.52u as=0 ps=0 w=0.42u l=1u
X1182 VPWR a_11828_10668# a_11786_10704# VPWR sg13_lv_pmos ad=0.2618p pd=1.63u as=0.1176p ps=1.33u w=1.12u l=0.13u
X1183 VPWR VGND.t700 VPWR VPWR sg13_lv_pmos ad=0.34p pd=2.68u as=0 ps=0 w=1u l=1u
X1184 VGND.t484 VPWR VGND.t484 VGND.t515 sg13_lv_nmos ad=79.8f pd=0.8u as=0 ps=0 w=0.42u l=1u
X1185 VPWR VGND.t419 VPWR VPWR sg13_lv_pmos ad=0.34p pd=2.68u as=0 ps=0 w=1u l=1u
X1186 a_8213_13728# sg13cmos5l_a21oi_1_2.A1 VPWR VPWR sg13_lv_pmos ad=0.2128p pd=1.5u as=0.2128p ps=1.5u w=1.12u l=0.13u
X1187 VGND.t747 VPWR VGND.t747 VGND.t758 sg13_lv_nmos ad=79.8f pd=0.8u as=0 ps=0 w=0.42u l=1u
X1188 a_6191_10019# a_5349_9921# a_6097_10019# VGND.t171 sg13_lv_nmos ad=0.12665p pd=1.145u as=0.1428p ps=1.52u w=0.42u l=0.13u
X1189 VGND.t922 VPWR VGND.t921 VGND.t920 sg13_lv_nmos ad=0.1428p pd=1.52u as=0 ps=0 w=0.42u l=1u
X1190 VGND.t613 VPWR VGND.t613 VGND.t616 sg13_lv_nmos ad=0.1428p pd=1.52u as=0 ps=0 w=0.42u l=1u
X1191 a_7942_9955# sg13cmos5l_tiehi_5.L_HI VGND.t6 VGND.t21 sg13_lv_nmos ad=37.8f pd=0.6u as=0.1701p ps=1.65u w=0.42u l=0.13u
X1192 a_5733_12945# sg13cmos5l_dfrbpq_1_0.CLK VGND.t31 VGND.t175 sg13_lv_nmos ad=0.2516p pd=2.16u as=3.92842p ps=25.025u w=0.74u l=0.13u
X1193 VPWR VGND.t871 VPWR VPWR sg13_lv_pmos ad=0.34p pd=2.68u as=0 ps=0 w=1u l=1u
X1194 VPWR VGND.t424 VPWR VPWR sg13_lv_pmos ad=0.19p pd=1.38u as=0 ps=0 w=1u l=1u
X1195 VPWR VGND.t51 VPWR VPWR sg13_lv_pmos ad=0.19p pd=1.38u as=0 ps=0 w=1u l=1u
X1196 VPWR VGND.t484 VPWR VPWR sg13_lv_pmos ad=0.19p pd=1.38u as=0 ps=0 w=1u l=1u
X1197 VGND.t484 VPWR VGND.t484 VGND.t497 sg13_lv_nmos ad=79.8f pd=0.8u as=0 ps=0 w=0.42u l=1u
X1198 VGND.t484 VPWR VGND.t484 VGND.t504 sg13_lv_nmos ad=0.1428p pd=1.52u as=0 ps=0 w=0.42u l=1u
X1199 a_3876_10708# a_3850_10672# VPWR VPWR sg13_lv_pmos ad=0.34p pd=2.68u as=0.36237p ps=2.605u w=1u l=0.13u
X1200 VPWR VGND.t603 VPWR VPWR sg13_lv_pmos ad=0.34p pd=2.68u as=0 ps=0 w=1u l=1u
X1201 a_13678_10131# a_13793_10132# VGND.t27 VGND.t26 sg13_lv_nmos ad=0.1428p pd=1.52u as=0.1426p ps=1.16u w=0.42u l=0.5u
X1202 a_10538_12654# a_10231_12180# a_10444_12654# VGND.t105 sg13_lv_nmos ad=37.8f pd=0.6u as=0.1428p ps=1.52u w=0.42u l=0.13u
X1203 VGND.t572 VPWR VGND.t572 VGND.t582 sg13_lv_nmos ad=0.1428p pd=1.52u as=0 ps=0 w=0.42u l=1u
X1204 VGND.t484 VPWR VGND.t484 VGND.t508 sg13_lv_nmos ad=0.1428p pd=1.52u as=0 ps=0 w=0.42u l=1u
X1205 VGND.t747 VPWR VGND.t752 VGND.t751 sg13_lv_nmos ad=79.8f pd=0.8u as=0 ps=0 w=0.42u l=1u
X1206 VGND.t208 a_7148_14442# count_o[3] VGND.t1020 sg13_lv_nmos ad=0.14875p pd=1.16u as=0.2886p ps=2.26u w=0.74u l=0.13u
X1207 VPWR VGND.t484 VPWR VPWR sg13_lv_pmos ad=0.19p pd=1.38u as=0 ps=0 w=1u l=1u
X1208 VPWR VGND.t667 VPWR VPWR sg13_lv_pmos ad=0.19p pd=1.38u as=0 ps=0 w=1u l=1u
X1209 VPWR VGND.t521 VPWR VPWR sg13_lv_pmos ad=0.19p pd=1.38u as=0 ps=0 w=1u l=1u
X1210 VGND.t484 VPWR VGND.t484 VGND.t513 sg13_lv_nmos ad=79.8f pd=0.8u as=0 ps=0 w=0.42u l=1u
X1211 VPWR a_8878_10971# sg13cmos5l_o21ai_1_0.B1 VPWR sg13_lv_pmos ad=0.2254p pd=1.53u as=0.4256p ps=3u w=1.12u l=0.13u
X1212 VGND.t196 VPWR VGND.t195 VGND.t194 sg13_lv_nmos ad=0.1428p pd=1.52u as=0 ps=0 w=0.42u l=1u
X1213 VGND.t521 VPWR VGND.t484 VGND.t520 sg13_lv_nmos ad=0.1428p pd=1.52u as=0 ps=0 w=0.42u l=1u
X1214 a_9573_14521# a_9573_14521# VGND.t59 VGND.t1025 sg13_lv_nmos ad=0.111p pd=1.34u as=3.51557p ps=23.16u w=0.3u l=0.13u
X1215 VPWR a_11171_13997# sg13cmos5l_a21oi_1_1.A2 VPWR sg13_lv_pmos ad=0.3822p pd=1.84u as=0.3808p ps=2.92u w=1.12u l=0.13u
X1216 VGND.t684 VPWR VGND.t684 VGND.t86 sg13_lv_nmos ad=0.1428p pd=1.52u as=0 ps=0 w=0.42u l=1u
X1217 VGND.t18 VPWR VGND.t18 VGND.t258 sg13_lv_nmos ad=0.1428p pd=1.52u as=0 ps=0 w=0.42u l=1u
X1218 VGND.t672 VPWR VGND.t676 VGND.t86 sg13_lv_nmos ad=79.8f pd=0.8u as=0 ps=0 w=0.42u l=1u
X1219 VPWR VGND.t931 VPWR VPWR sg13_lv_pmos ad=0.34p pd=2.68u as=0 ps=0 w=1u l=1u
X1220 VPWR VGND.t577 VPWR VPWR sg13_lv_pmos ad=0.34p pd=2.68u as=0 ps=0 w=1u l=1u
X1221 VGND.t1055 a_5516_14442# count_o[2] VGND.t1061 sg13_lv_nmos ad=0.14875p pd=1.16u as=0.2886p ps=2.26u w=0.74u l=0.13u
X1222 VPWR VGND.t484 VPWR VPWR sg13_lv_pmos ad=0.19p pd=1.38u as=0 ps=0 w=1u l=1u
X1223 VPWR VGND.t424 VPWR VPWR sg13_lv_pmos ad=0.19p pd=1.38u as=0 ps=0 w=1u l=1u
X1224 VPWR VGND.t484 VPWR VPWR sg13_lv_pmos ad=0.19p pd=1.38u as=0 ps=0 w=1u l=1u
X1225 VGND.t521 VPWR VGND.t521 VGND.t522 sg13_lv_nmos ad=79.8f pd=0.8u as=0 ps=0 w=0.42u l=1u
X1226 a_8878_10971# a_8993_10970# VPWR VPWR sg13_lv_pmos ad=0.34p pd=2.68u as=0.2254p ps=1.53u w=1u l=0.5u
X1227 sg13cmos5l_mux2_1_0.S sg13cmos5l_nor3_2_0.C a_10816_11752# VPWR sg13_lv_pmos ad=0.2128p pd=1.5u as=0.2128p ps=1.5u w=1.12u l=0.13u
X1228 VPWR VGND.t484 VPWR VPWR sg13_lv_pmos ad=0.19p pd=1.38u as=0 ps=0 w=1u l=1u
X1229 VGND.t484 VPWR VGND.t484 VGND.t498 sg13_lv_nmos ad=0.1428p pd=1.52u as=0 ps=0 w=0.42u l=1u
X1230 a_13797_13765# a_13797_13765# VGND.t59 VGND.t994 sg13_lv_nmos ad=0.111p pd=1.34u as=3.51557p ps=23.16u w=0.3u l=0.13u
X1231 a_4932_10260# a_5451_10064# a_6191_10019# VGND.t101 sg13_lv_nmos ad=0.3473p pd=2.71u as=0.12665p ps=1.145u w=0.74u l=0.13u
X1232 VGND.t676 VPWR VGND.t676 VGND.t86 sg13_lv_nmos ad=0.1428p pd=1.52u as=0 ps=0 w=0.42u l=1u
X1233 VPWR VGND.t688 VPWR VPWR sg13_lv_pmos ad=0.19p pd=1.38u as=0 ps=0 w=1u l=1u
X1234 VPWR VGND.t419 VPWR VPWR sg13_lv_pmos ad=0.34p pd=2.68u as=0 ps=0 w=1u l=1u
X1235 VGND.t572 VPWR VGND.t572 VGND.t575 sg13_lv_nmos ad=0.1428p pd=1.52u as=0 ps=0 w=0.42u l=1u
X1236 VGND.t298 VPWR VGND.t134 VGND.t15 sg13_lv_nmos ad=79.8f pd=0.8u as=0 ps=0 w=0.42u l=1u
X1237 sg13cmos5l_nor2_1_3.B sg13cmos5l_xor2_1_2.B a_4026_11470# VGND.t1076 sg13_lv_nmos ad=0.1628p pd=1.18u as=88.8f ps=0.98u w=0.74u l=0.13u
X1238 a_10817_14076# sg13cmos5l_a21oi_1_1.A1 sg13cmos5l_a21oi_1_1.Y VGND.t1086 sg13_lv_nmos ad=0.1406p pd=1.12u as=0.1406p ps=1.12u w=0.74u l=0.13u
X1239 VGND.t572 VPWR VGND.t572 VGND.t601 sg13_lv_nmos ad=0.1428p pd=1.52u as=0 ps=0 w=0.42u l=1u
X1240 VGND.t357 sg13cmos5l_a21oi_1_0.B1 sg13cmos5l_nor2_1_3.Y VGND.t1030 sg13_lv_nmos ad=0.2516p pd=2.16u as=0.1406p ps=1.12u w=0.74u l=0.13u
X1241 VPWR VGND.t876 VPWR VPWR sg13_lv_pmos ad=0.34p pd=2.68u as=0 ps=0 w=1u l=1u
X1242 VPWR VGND.t484 VPWR VPWR sg13_lv_pmos ad=0.19p pd=1.38u as=0 ps=0 w=1u l=1u
X1243 VGND.t696 VPWR VGND.t696 VGND.t86 sg13_lv_nmos ad=0.1428p pd=1.52u as=0 ps=0 w=0.42u l=1u
X1244 VPWR VGND.t747 VPWR VPWR sg13_lv_pmos ad=0.19p pd=1.38u as=0 ps=0 w=1u l=1u
X1245 VGND.t484 VPWR VGND.t484 VGND.t506 sg13_lv_nmos ad=0.1428p pd=1.52u as=0 ps=0 w=0.42u l=1u
X1246 VPWR a_4293_10715# a_4395_10715# VPWR sg13_lv_pmos ad=1.38282p pd=8.655u as=0.3864p ps=2.93u w=1.12u l=0.13u
X1247 VGND.t310 VPWR VGND.t311 VGND.t15 sg13_lv_nmos ad=79.8f pd=0.8u as=0 ps=0 w=0.42u l=1u
X1248 VGND.t286 VPWR VGND.t288 VGND.t287 sg13_lv_nmos ad=79.8f pd=0.8u as=0 ps=0 w=0.42u l=1u
X1249 VGND.t59 VPWR VGND.t59 VGND.t210 sg13_lv_nmos ad=0.1428p pd=1.52u as=0 ps=0 w=0.42u l=1u
X1250 VGND.t927 VPWR VGND.t926 VGND.t925 sg13_lv_nmos ad=0.1428p pd=1.52u as=0 ps=0 w=0.42u l=1u
X1251 VGND.t484 VPWR VGND.t484 VGND.t510 sg13_lv_nmos ad=0.1428p pd=1.52u as=0 ps=0 w=0.42u l=1u
X1252 VGND.t752 VPWR VGND.t752 VGND.t754 sg13_lv_nmos ad=79.8f pd=0.8u as=0 ps=0 w=0.42u l=1u
X1253 VGND.t2 a_5705_11400# a_5626_11675# VGND.t15 sg13_lv_nmos ad=4.55085p pd=29.865u as=0.27427p ps=2.28u w=0.795u l=0.13u
X1254 VGND.t75 sg13cmos5l_dfrbpq_1_1.RESET_B a_5124_12966# VGND.t985 sg13_lv_nmos ad=0.1626p pd=1.415u as=60.89999f ps=0.71u w=0.42u l=0.13u
X1255 VGND.t668 VPWR VGND.t668 VGND.t86 sg13_lv_nmos ad=79.8f pd=0.8u as=0 ps=0 w=0.42u l=1u
X1256 VPWR VGND.t916 VPWR VPWR sg13_lv_pmos ad=0.34p pd=2.68u as=0 ps=0 w=1u l=1u
X1257 VPWR VGND.t572 VPWR VPWR sg13_lv_pmos ad=0.34p pd=2.68u as=0 ps=0 w=1u l=1u
X1258 VPWR a_10031_13043# a_10698_13264# VPWR sg13_lv_pmos ad=0.2128p pd=1.5u as=0.3864p ps=2.93u w=1.12u l=0.13u
X1259 VPWR VGND.t668 VPWR VPWR sg13_lv_pmos ad=0.19p pd=1.38u as=0 ps=0 w=1u l=1u
X1260 VPWR VGND.t676 VPWR VPWR sg13_lv_pmos ad=0.19p pd=1.38u as=0 ps=0 w=1u l=1u
X1261 VGND.t6 VPWR VGND.t6 VGND.t369 sg13_lv_nmos ad=0.1428p pd=1.52u as=0 ps=0 w=0.42u l=1u
X1262 VGND.t124 sg13cmos5l_nand4_1_0.C a_2070_12982# VGND.t977 sg13_lv_nmos ad=0.15245p pd=1.17u as=88.8f ps=0.98u w=0.74u l=0.13u
X1263 a_4102_12641# sg13cmos5l_dfrbpq_1_2.RESET_B VGND.t133 VGND.t1099 sg13_lv_nmos ad=37.8f pd=0.6u as=0.1701p ps=1.65u w=0.42u l=0.13u
X1264 VGND.t484 VPWR VGND.t484 VGND.t515 sg13_lv_nmos ad=79.8f pd=0.8u as=0 ps=0 w=0.42u l=1u
X1265 VGND.t521 VPWR VGND.t521 VGND.t523 sg13_lv_nmos ad=0.1428p pd=1.52u as=0 ps=0 w=0.42u l=1u
X1266 VGND.t765 VPWR VGND.t765 VGND.t766 sg13_lv_nmos ad=0.1428p pd=1.52u as=0 ps=0 w=0.42u l=1u
X1267 VGND.t295 VPWR VGND.t318 VGND.t317 sg13_lv_nmos ad=0.1428p pd=1.52u as=0 ps=0 w=0.42u l=1u
X1268 VPWR VGND.t433 VPWR VPWR sg13_lv_pmos ad=0.34p pd=2.68u as=0 ps=0 w=1u l=1u
X1269 VPWR sg13cmos5l_a21oi_1_0.B1 a_4396_10240# VPWR sg13_lv_pmos ad=0.4032p pd=2.96u as=0.1176p ps=1.33u w=1.12u l=0.13u
X1270 a_8314_10668# sg13cmos5l_o21ai_1_0.Y VPWR VPWR sg13_lv_pmos ad=0.1428p pd=1.52u as=0.1523p ps=1.38u w=0.42u l=0.13u
X1271 VGND.t206 VPWR VGND.t204 VGND.t205 sg13_lv_nmos ad=0.1428p pd=1.52u as=0 ps=0 w=0.42u l=1u
X1272 VGND.t130 a_9742_13995# sg13cmos5l_nand4_1_1.A VGND.t990 sg13_lv_nmos ad=0.1426p pd=1.16u as=0.2516p ps=2.16u w=0.74u l=0.13u
X1273 VGND.t672 VPWR VGND.t672 VGND.t86 sg13_lv_nmos ad=0.1428p pd=1.52u as=0 ps=0 w=0.42u l=1u
X1274 VGND.t217 VPWR VGND.t219 VGND.t218 sg13_lv_nmos ad=79.8f pd=0.8u as=0 ps=0 w=0.42u l=1u
X1275 VPWR VGND.t364 VPWR VPWR sg13_lv_pmos ad=0.34p pd=2.68u as=0 ps=0 w=1u l=1u
X1276 VPWR VGND.t51 VPWR VPWR sg13_lv_pmos ad=0.34p pd=2.68u as=0 ps=0 w=1u l=1u
X1277 VGND.t484 VPWR VGND.t484 VGND.t504 sg13_lv_nmos ad=0.1428p pd=1.52u as=0 ps=0 w=0.42u l=1u
X1278 VPWR VGND.t410 VPWR VPWR sg13_lv_pmos ad=0.34p pd=2.68u as=0 ps=0 w=1u l=1u
X1279 VGND.t676 VPWR VGND.t676 VGND.t86 sg13_lv_nmos ad=79.8f pd=0.8u as=0 ps=0 w=0.42u l=1u
X1280 VPWR VGND.t936 VPWR VPWR sg13_lv_pmos ad=0.34p pd=2.68u as=0 ps=0 w=1u l=1u
X1281 VPWR VGND.t572 VPWR VPWR sg13_lv_pmos ad=0.34p pd=2.68u as=0 ps=0 w=1u l=1u
X1282 VGND.t71 a_11854_14667# sg13cmos5l_a21oi_1_1.A1 VGND.t1093 sg13_lv_nmos ad=0.1426p pd=1.16u as=0.2516p ps=2.16u w=0.74u l=0.13u
X1283 VPWR VGND.t484 VPWR VPWR sg13_lv_pmos ad=0.19p pd=1.38u as=0 ps=0 w=1u l=1u
X1284 sg13cmos5l_dfrbpq_1_0.CLK a_4426_11422# VPWR VPWR sg13_lv_pmos ad=0.2128p pd=1.5u as=0.2128p ps=1.5u w=1.12u l=0.13u
X1285 VGND.t747 VPWR VGND.t747 VGND.t759 sg13_lv_nmos ad=0.1428p pd=1.52u as=0 ps=0 w=0.42u l=1u
X1286 a_7430_9942# a_8235_10064# a_7690_10165# VPWR sg13_lv_pmos ad=0.1428p pd=1.52u as=79.8f ps=0.8u w=0.42u l=0.13u
X1287 VPWR VGND.t484 VPWR VPWR sg13_lv_pmos ad=0.34p pd=2.68u as=0 ps=0 w=1u l=1u
X1288 a_3850_12184# a_4293_12227# a_3590_12654# VGND.t29 sg13_lv_nmos ad=79.8f pd=0.8u as=0.1296p ps=1.52u w=0.42u l=0.13u
X1289 VGND.t484 VPWR VGND.t484 VGND.t500 sg13_lv_nmos ad=0.1428p pd=1.52u as=0 ps=0 w=0.42u l=1u
X1290 VGND.t313 VPWR VGND.t312 VGND.t2 sg13_lv_nmos ad=0.1428p pd=1.52u as=0 ps=0 w=0.42u l=1u
X1291 VGND.t747 VPWR VGND.t747 VGND.t748 sg13_lv_nmos ad=0.1428p pd=1.52u as=0 ps=0 w=0.42u l=1u
X1292 VGND.t521 VPWR VGND.t484 VGND.t520 sg13_lv_nmos ad=0.1428p pd=1.52u as=0 ps=0 w=0.42u l=1u
X1293 VPWR a_9232_10162# a_9177_10257# VPWR sg13_lv_pmos ad=1.38282p pd=8.655u as=93.45f ps=0.865u w=0.42u l=0.13u
X1294 VPWR a_5349_9921# a_5451_10064# VPWR sg13_lv_pmos ad=1.38282p pd=8.655u as=0.3864p ps=2.93u w=1.12u l=0.13u
X1295 sg13cmos5l_buf_8_0.A a_8091_11458# VGND.t3 VGND.t15 sg13_lv_nmos ad=0.1406p pd=1.12u as=0.1406p ps=1.12u w=0.74u l=0.13u
X1296 VPWR VGND.t688 VPWR VPWR sg13_lv_pmos ad=0.19p pd=1.38u as=0 ps=0 w=1u l=1u
X1297 a_8986_14446# sg13cmos5l_o21ai_1_2.Y VPWR VPWR sg13_lv_pmos ad=0.1428p pd=1.52u as=0.1523p ps=1.38u w=0.42u l=0.13u
X1298 VPWR VGND.t405 VPWR VPWR sg13_lv_pmos ad=0.34p pd=2.68u as=0 ps=0 w=1u l=1u
X1299 VGND.t745 VPWR VGND.t747 VGND.t746 sg13_lv_nmos ad=79.8f pd=0.8u as=0 ps=0 w=0.42u l=1u
X1300 VPWR VGND.t196 VPWR VPWR sg13_lv_pmos ad=0.34p pd=2.68u as=0 ps=0 w=1u l=1u
X1301 VPWR VGND.t668 VPWR VPWR sg13_lv_pmos ad=0.19p pd=1.38u as=0 ps=0 w=1u l=1u
X1302 VPWR VGND.t570 VPWR VPWR sg13_lv_pmos ad=0.34p pd=2.68u as=0 ps=0 w=1u l=1u
X1303 VPWR VGND.t224 VPWR VPWR sg13_lv_pmos ad=0.34p pd=2.68u as=0 ps=0 w=1u l=1u
X1304 VPWR VGND.t484 VPWR VPWR sg13_lv_pmos ad=0.19p pd=1.38u as=0 ps=0 w=1u l=1u
X1305 VPWR a_10138_13692# a_9857_13994# VPWR sg13_lv_pmos ad=0.1523p pd=1.38u as=0.34p ps=2.68u w=1u l=0.5u
X1306 a_11469_13752# sg13cmos5l_xor2_1_2.B a_11380_13752# VPWR sg13_lv_pmos ad=0.19p pd=1.38u as=0.1575p ps=1.315u w=1u l=0.13u
X1307 VGND.t696 VPWR VGND.t696 VGND.t86 sg13_lv_nmos ad=0.1428p pd=1.52u as=0 ps=0 w=0.42u l=1u
X1308 VPWR VGND.t424 VPWR VPWR sg13_lv_pmos ad=0.34p pd=2.68u as=0 ps=0 w=1u l=1u
X1309 VPWR a_4085_14482# sg13cmos5l_xor2_1_2.B VPWR sg13_lv_pmos ad=0.3808p pd=2.92u as=0.2128p ps=1.5u w=1.12u l=0.13u
X1310 a_8772_13284# a_8746_13189# VPWR VPWR sg13_lv_pmos ad=0.34p pd=2.68u as=0.36237p ps=2.605u w=1u l=0.13u
X1311 a_11462_12970# a_11192_12970# VGND.t10 VGND.t9 sg13_lv_nmos ad=0.1428p pd=1.52u as=79.8f ps=0.8u w=0.42u l=0.5u
X1312 VGND.t857 VPWR VGND.t856 VGND.t855 sg13_lv_nmos ad=0.1428p pd=1.52u as=0 ps=0 w=0.42u l=1u
X1313 VPWR VGND.t484 VPWR VPWR sg13_lv_pmos ad=0.34p pd=2.68u as=0 ps=0 w=1u l=1u
X1314 VGND.t484 VPWR VGND.t484 VGND.t498 sg13_lv_nmos ad=0.1428p pd=1.52u as=0 ps=0 w=0.42u l=1u
X1315 sg13cmos5l_dfrbpq_1_7.CLK a_11355_11458# VGND.t1106 VGND.t15 sg13_lv_nmos ad=0.1406p pd=1.12u as=0.1406p ps=1.12u w=0.74u l=0.13u
X1316 VGND.t668 VPWR VGND.t672 VGND.t86 sg13_lv_nmos ad=79.8f pd=0.8u as=0 ps=0 w=0.42u l=1u
X1317 VPWR VGND.t572 VPWR VPWR sg13_lv_pmos ad=0.34p pd=2.68u as=0 ps=0 w=1u l=1u
X1318 VGND.t133 sg13cmos5l_dfrbpq_1_2.RESET_B a_3684_12654# VGND.t1100 sg13_lv_nmos ad=0.1626p pd=1.415u as=60.89999f ps=0.71u w=0.42u l=0.13u
X1319 VPWR VGND.t668 VPWR VPWR sg13_lv_pmos ad=0.19p pd=1.38u as=0 ps=0 w=1u l=1u
X1320 VPWR VGND.t484 VPWR VPWR sg13_lv_pmos ad=0.19p pd=1.38u as=0 ps=0 w=1u l=1u
X1321 VPWR VGND.t484 VPWR VPWR sg13_lv_pmos ad=0.19p pd=1.38u as=0 ps=0 w=1u l=1u
X1322 a_3590_11142# a_4395_10715# a_3850_10672# VPWR sg13_lv_pmos ad=0.1428p pd=1.52u as=79.8f ps=0.8u w=0.42u l=0.13u
X1323 VGND.t521 VPWR VGND.t521 VGND.t525 sg13_lv_nmos ad=0.1428p pd=1.52u as=0 ps=0 w=0.42u l=1u
X1324 VGND.t752 VPWR VGND.t752 VGND.t753 sg13_lv_nmos ad=0.1428p pd=1.52u as=0 ps=0 w=0.42u l=1u
X1325 VGND.t27 a_13678_10131# sg13cmos5l_dfrbpq_1_5.D VGND.t107 sg13_lv_nmos ad=0.1426p pd=1.16u as=0.2516p ps=2.16u w=0.74u l=0.13u
X1326 VPWR VGND.t484 VPWR VPWR sg13_lv_pmos ad=0.34p pd=2.68u as=0 ps=0 w=1u l=1u
X1327 sg13cmos5l_nand4_1_0.Y sg13cmos5l_buf_1_0.X a_2366_12582# VGND.t145 sg13_lv_nmos ad=0.2516p pd=2.16u as=0.1406p ps=1.12u w=0.74u l=0.13u
X1328 VPWR VGND.t433 VPWR VPWR sg13_lv_pmos ad=0.34p pd=2.68u as=0 ps=0 w=1u l=1u
X1329 VPWR sg13cmos5l_nand3_1_0.Y a_4085_14482# VPWR sg13_lv_pmos ad=0.203p pd=1.5u as=0.1596p ps=1.22u w=0.84u l=0.13u
X1330 VGND.t877 VPWR VGND.t879 VGND.t878 sg13_lv_nmos ad=79.8f pd=0.8u as=0 ps=0 w=0.42u l=1u
X1331 VPWR VGND.t6 VPWR VPWR sg13_lv_pmos ad=0.34p pd=2.68u as=0 ps=0 w=1u l=1u
X1332 VGND.t484 VPWR VGND.t484 VGND.t506 sg13_lv_nmos ad=0.1428p pd=1.52u as=0 ps=0 w=0.42u l=1u
X1333 VPWR VGND.t208 VPWR VPWR sg13_lv_pmos ad=0.34p pd=2.68u as=0 ps=0 w=1u l=1u
X1334 a_5135_12577# a_4293_12227# a_3876_12220# VPWR sg13_lv_pmos ad=0.2048p pd=1.63u as=0.34p ps=2.68u w=1u l=0.13u
X1335 VGND.t663 VPWR VGND.t663 VGND.t86 sg13_lv_nmos ad=79.8f pd=0.8u as=0 ps=0 w=0.42u l=1u
X1336 VPWR VGND.t906 VPWR VPWR sg13_lv_pmos ad=0.34p pd=2.68u as=0 ps=0 w=1u l=1u
X1337 VGND.t392 VPWR VGND.t395 VGND.t444 sg13_lv_nmos ad=79.8f pd=0.8u as=0 ps=0 w=0.42u l=1u
X1338 VGND.t63 VPWR VGND.t269 VGND.t135 sg13_lv_nmos ad=0.1428p pd=1.52u as=0 ps=0 w=0.42u l=1u
X1339 VGND.t688 VPWR VGND.t688 VGND.t86 sg13_lv_nmos ad=0.1428p pd=1.52u as=0 ps=0 w=0.42u l=1u
X1340 VPWR VGND.t484 VPWR VPWR sg13_lv_pmos ad=0.19p pd=1.38u as=0 ps=0 w=1u l=1u
X1341 VPWR VGND.t676 VPWR VPWR sg13_lv_pmos ad=0.34p pd=2.68u as=0 ps=0 w=1u l=1u
X1342 VPWR VGND.t484 VPWR VPWR sg13_lv_pmos ad=0.34p pd=2.68u as=0 ps=0 w=1u l=1u
X1343 VGND.t521 VPWR VGND.t521 VGND.t523 sg13_lv_nmos ad=0.1428p pd=1.52u as=0 ps=0 w=0.42u l=1u
X1344 a_5733_12945# sg13cmos5l_dfrbpq_1_0.CLK VPWR VPWR sg13_lv_pmos ad=0.4088p pd=2.97u as=1.7455p ps=10.885u w=1.12u l=0.13u
X1345 VPWR VGND.t572 VPWR VPWR sg13_lv_pmos ad=0.19p pd=1.38u as=0 ps=0 w=1u l=1u
X1346 a_4906_10165# a_5349_9921# a_4646_9942# VGND.t169 sg13_lv_nmos ad=79.8f pd=0.8u as=0.1296p ps=1.52u w=0.42u l=0.13u
X1347 VGND.t778 VPWR VGND.t778 VGND.t779 sg13_lv_nmos ad=0.1428p pd=1.52u as=0 ps=0 w=0.42u l=1u
X1348 VPWR VGND.t663 VPWR VPWR sg13_lv_pmos ad=0.19p pd=1.38u as=0 ps=0 w=1u l=1u
X1349 VPWR VGND.t672 VPWR VPWR sg13_lv_pmos ad=0.19p pd=1.38u as=0 ps=0 w=1u l=1u
X1350 a_10138_13692# sg13cmos5l_dfrbpq_1_4.Q VGND.t212 VGND.t1084 sg13_lv_nmos ad=0.1428p pd=1.52u as=79.8f ps=0.8u w=0.42u l=0.13u
X1351 VGND.t700 VPWR VGND.t700 VGND.t86 sg13_lv_nmos ad=0.1428p pd=1.52u as=0 ps=0 w=0.42u l=1u
X1352 VPWR VGND.t303 VPWR VPWR sg13_lv_pmos ad=0.34p pd=2.68u as=0 ps=0 w=1u l=1u
X1353 a_9129_13357# a_8772_13284# VPWR VPWR sg13_lv_pmos ad=63f pd=0.72u as=0.1563p ps=1.22u w=0.42u l=0.13u
X1354 VPWR VGND.t424 VPWR VPWR sg13_lv_pmos ad=0.34p pd=2.68u as=0 ps=0 w=1u l=1u
X1355 VPWR VGND.t438 VPWR VPWR sg13_lv_pmos ad=0.19p pd=1.38u as=0 ps=0 w=1u l=1u
X1356 sg13cmos5l_mux2_1_0.A0 a_12141_11052# VPWR VPWR sg13_lv_pmos ad=0.3808p pd=2.92u as=0.1918p ps=1.5u w=1.12u l=0.13u
X1357 a_10816_11752# sg13cmos5l_nor3_2_0.C sg13cmos5l_mux2_1_0.S VPWR sg13_lv_pmos ad=0.3808p pd=2.92u as=0.2128p ps=1.5u w=1.12u l=0.13u
X1358 VPWR VGND.t484 VPWR VPWR sg13_lv_pmos ad=0.34p pd=2.68u as=0 ps=0 w=1u l=1u
X1359 VGND.t484 VPWR VGND.t484 VGND.t500 sg13_lv_nmos ad=0.1428p pd=1.52u as=0 ps=0 w=0.42u l=1u
X1360 VPWR a_6191_10019# a_6858_10240# VPWR sg13_lv_pmos ad=0.2128p pd=1.5u as=0.3864p ps=2.93u w=1.12u l=0.13u
X1361 VPWR VGND.t663 VPWR VPWR sg13_lv_pmos ad=0.19p pd=1.38u as=0 ps=0 w=1u l=1u
X1362 VPWR VGND.t484 VPWR VPWR sg13_lv_pmos ad=0.19p pd=1.38u as=0 ps=0 w=1u l=1u
X1363 VGND.t484 VPWR VGND.t484 VGND.t512 sg13_lv_nmos ad=0.1428p pd=1.52u as=0 ps=0 w=0.42u l=1u
X1364 VPWR VGND.t484 VPWR VPWR sg13_lv_pmos ad=0.34p pd=2.68u as=0 ps=0 w=1u l=1u
X1365 a_10715_13728# sg13cmos5l_a21oi_1_0.B1 sg13cmos5l_a21oi_1_1.Y VPWR sg13_lv_pmos ad=0.2128p pd=1.5u as=0.3808p ps=2.92u w=1.12u l=0.13u
X1366 VGND.t570 VPWR VGND.t570 VGND.t569 sg13_lv_nmos ad=0.1428p pd=1.52u as=0 ps=0 w=0.42u l=1u
X1367 VGND.t752 VPWR VGND.t752 VGND.t755 sg13_lv_nmos ad=0.1428p pd=1.52u as=0 ps=0 w=0.42u l=1u
X1368 a_11639_10333# sg13cmos5l_dfrbpq_1_5.RESET_B VPWR VPWR sg13_lv_pmos ad=79.8f pd=0.8u as=0.36237p ps=2.605u w=0.42u l=0.13u
X1369 VPWR a_11462_12970# a_11574_13034# VPWR sg13_lv_pmos ad=0.2254p pd=1.53u as=0.34p ps=2.68u w=1u l=0.5u
X1370 VPWR VGND.t668 VPWR VPWR sg13_lv_pmos ad=0.34p pd=2.68u as=0 ps=0 w=1u l=1u
X1371 a_5124_12966# sg13cmos5l_dfrbpq_1_1.D a_5030_12966# VGND.t1097 sg13_lv_nmos ad=60.89999f pd=0.71u as=0.1428p ps=1.52u w=0.42u l=0.13u
X1372 VGND.t365 VPWR VGND.t6 VGND.t363 sg13_lv_nmos ad=79.8f pd=0.8u as=0 ps=0 w=0.42u l=1u
X1373 VGND.t572 VPWR VGND.t572 VGND.t600 sg13_lv_nmos ad=79.8f pd=0.8u as=0 ps=0 w=0.42u l=1u
X1374 VPWR VGND.t484 VPWR VPWR sg13_lv_pmos ad=0.34p pd=2.68u as=0 ps=0 w=1u l=1u
X1375 VPWR a_11733_12263# a_10812_12577# VPWR sg13_lv_pmos ad=0.36237p pd=2.605u as=0.34p ps=2.68u w=1u l=0.13u
X1376 VGND.t667 VPWR VGND.t668 VGND.t86 sg13_lv_nmos ad=79.8f pd=0.8u as=0 ps=0 w=0.42u l=1u
X1377 VGND.t59 a_8782_13995# sg13cmos5l_dfrbpq_1_4.D VGND.t172 sg13_lv_nmos ad=0.1426p pd=1.16u as=0.2516p ps=2.16u w=0.74u l=0.13u
X1378 VPWR VGND.t410 VPWR VPWR sg13_lv_pmos ad=0.19p pd=1.38u as=0 ps=0 w=1u l=1u
X1379 a_3876_10708# a_3850_10672# VGND.t2 VGND.t1000 sg13_lv_nmos ad=0.2516p pd=2.16u as=0.1626p ps=1.415u w=0.74u l=0.13u
X1380 a_5554_11142# sg13cmos5l_tiehi_0.L_HI VGND.t28 VGND.t2 sg13_lv_nmos ad=37.8f pd=0.6u as=79.8f ps=0.8u w=0.42u l=0.13u
X1381 VGND.t676 VPWR VGND.t676 VGND.t86 sg13_lv_nmos ad=0.1428p pd=1.52u as=0 ps=0 w=0.42u l=1u
X1382 VGND.t688 VPWR VGND.t688 VGND.t86 sg13_lv_nmos ad=0.1428p pd=1.52u as=0 ps=0 w=0.42u l=1u
X1383 VPWR VGND.t676 VPWR VPWR sg13_lv_pmos ad=0.34p pd=2.68u as=0 ps=0 w=1u l=1u
X1384 VPWR VGND.t484 VPWR VPWR sg13_lv_pmos ad=0.34p pd=2.68u as=0 ps=0 w=1u l=1u
X1385 VPWR VGND.t484 VPWR VPWR sg13_lv_pmos ad=0.34p pd=2.68u as=0 ps=0 w=1u l=1u
X1386 VGND.t521 VPWR VGND.t521 VGND.t525 sg13_lv_nmos ad=0.1428p pd=1.52u as=0 ps=0 w=0.42u l=1u
X1387 VGND.t375 VPWR VGND.t93 VGND.t376 sg13_lv_nmos ad=79.8f pd=0.8u as=0 ps=0 w=0.42u l=1u
X1388 VPWR VGND.t572 VPWR VPWR sg13_lv_pmos ad=0.19p pd=1.38u as=0 ps=0 w=1u l=1u
X1389 a_11990_12641# a_10812_12577# a_11594_12496# VGND.t112 sg13_lv_nmos ad=37.8f pd=0.6u as=0.1428p ps=1.52u w=0.42u l=0.13u
X1390 VGND.t778 VPWR VGND.t778 VGND.t781 sg13_lv_nmos ad=0.1428p pd=1.52u as=0 ps=0 w=0.42u l=1u
X1391 VGND.t250 VPWR VGND.t249 VGND.t248 sg13_lv_nmos ad=0.1428p pd=1.52u as=0 ps=0 w=0.42u l=1u
X1392 VPWR sg13cmos5l_nand4_1_0.C sg13cmos5l_nand4_1_0.Y VPWR sg13_lv_pmos ad=0.2128p pd=1.5u as=0.2128p ps=1.5u w=1.12u l=0.13u
X1393 a_4426_11422# sg13cmos5l_buf_8_0.A VGND.t28 VGND.t15 sg13_lv_nmos ad=0.2553p pd=2.17u as=0.1406p ps=1.12u w=0.74u l=0.13u
X1394 VGND.t672 VPWR VGND.t672 VGND.t86 sg13_lv_nmos ad=0.1428p pd=1.52u as=0 ps=0 w=0.42u l=1u
X1395 VPWR VGND.t613 VPWR VPWR sg13_lv_pmos ad=0.19p pd=1.38u as=0 ps=0 w=1u l=1u
X1396 VGND.t71 a_11171_13997# sg13cmos5l_a21oi_1_1.A2 VGND.t991 sg13_lv_nmos ad=0.13395p pd=1.12u as=0.2516p ps=2.16u w=0.74u l=0.13u
X1397 VPWR VGND.t424 VPWR VPWR sg13_lv_pmos ad=0.34p pd=2.68u as=0 ps=0 w=1u l=1u
X1398 a_9274_10668# sg13cmos5l_dfrbpq_1_7.Q VGND.t3 VGND.t2 sg13_lv_nmos ad=0.1428p pd=1.52u as=79.8f ps=0.8u w=0.42u l=0.13u
X1399 VGND.t51 VPWR VGND.t51 VGND.t355 sg13_lv_nmos ad=79.8f pd=0.8u as=0 ps=0 w=0.42u l=1u
X1400 VPWR sg13cmos5l_a21oi_1_1.Y a_11768_13769# VPWR sg13_lv_pmos ad=0.1523p pd=1.38u as=0.1428p ps=1.52u w=0.42u l=0.13u
X1401 VGND.t590 VPWR VGND.t572 VGND.t594 sg13_lv_nmos ad=79.8f pd=0.8u as=0 ps=0 w=0.42u l=1u
X1402 VPWR VGND.t484 VPWR VPWR sg13_lv_pmos ad=0.34p pd=2.68u as=0 ps=0 w=1u l=1u
X1403 VGND.t304 VPWR VGND.t305 VGND.t2 sg13_lv_nmos ad=79.8f pd=0.8u as=0 ps=0 w=0.42u l=1u
X1404 VGND.t87 VPWR VGND.t87 VGND.t86 sg13_lv_nmos ad=79.8f pd=0.8u as=0 ps=0 w=0.42u l=1u
X1405 a_1594_12970# sg13cmos5l_buf_1_0.X sg13cmos5l_nand2_1_0.Y VGND.t143 sg13_lv_nmos ad=0.1406p pd=1.12u as=0.2516p ps=2.16u w=0.74u l=0.13u
X1406 VGND.t3 a_8091_11458# sg13cmos5l_buf_8_0.A VGND.t15 sg13_lv_nmos ad=0.2516p pd=2.16u as=0.1406p ps=1.12u w=0.74u l=0.13u
X1407 VPWR VGND.t302 VPWR VPWR sg13_lv_pmos ad=0.19p pd=1.38u as=0 ps=0 w=1u l=1u
X1408 VGND.t747 VPWR VGND.t747 VGND.t757 sg13_lv_nmos ad=0.1428p pd=1.52u as=0 ps=0 w=0.42u l=1u
X1409 sg13cmos5l_dfrbpq_1_0.CLK a_4426_11422# VGND.t2 VGND.t15 sg13_lv_nmos ad=0.1406p pd=1.12u as=0.1406p ps=1.12u w=0.74u l=0.13u
X1410 VGND.t44 a_6778_12180# a_6497_12482# VGND.t135 sg13_lv_nmos ad=79.8f pd=0.8u as=0.1428p ps=1.52u w=0.42u l=0.5u
X1411 VPWR VGND.t608 VPWR VPWR sg13_lv_pmos ad=0.19p pd=1.38u as=0 ps=0 w=1u l=1u
X1412 VPWR VGND.t672 VPWR VPWR sg13_lv_pmos ad=0.34p pd=2.68u as=0 ps=0 w=1u l=1u
X1413 VPWR VGND.t676 VPWR VPWR sg13_lv_pmos ad=0.34p pd=2.68u as=0 ps=0 w=1u l=1u
X1414 VPWR VGND.t484 VPWR VPWR sg13_lv_pmos ad=0.34p pd=2.68u as=0 ps=0 w=1u l=1u
X1415 a_4570_12934# sg13cmos5l_dfrbpq_1_3.Q VPWR VPWR sg13_lv_pmos ad=0.1428p pd=1.52u as=0.1523p ps=1.38u w=0.42u l=0.13u
X1416 VPWR a_8986_14446# a_8705_14668# VPWR sg13_lv_pmos ad=0.1523p pd=1.38u as=0.34p ps=2.68u w=1u l=0.5u
X1417 a_3668_13728# a_3642_13691# sg13cmos5l_xor2_1_1.X VPWR sg13_lv_pmos ad=0.2128p pd=1.5u as=0.3808p ps=2.92u w=1.12u l=0.13u
X1418 a_3684_12654# sg13cmos5l_nor2_1_1.Y a_3590_12654# VGND.t41 sg13_lv_nmos ad=60.89999f pd=0.71u as=0.1428p ps=1.52u w=0.42u l=0.13u
X1419 a_7716_10260# a_7690_10165# VPWR VPWR sg13_lv_pmos ad=0.34p pd=2.68u as=0.36237p ps=2.605u w=1u l=0.13u
X1420 VGND.t276 VPWR VGND.t276 VGND.t105 sg13_lv_nmos ad=0.1428p pd=1.52u as=0 ps=0 w=0.42u l=1u
X1421 VPWR VGND.t590 VPWR VPWR sg13_lv_pmos ad=0.19p pd=1.38u as=0 ps=0 w=1u l=1u
X1422 VGND.t6 VPWR VGND.t6 VGND.t368 sg13_lv_nmos ad=79.8f pd=0.8u as=0 ps=0 w=0.42u l=1u
X1423 sg13cmos5l_buf_8_0.A a_8091_11458# VPWR VPWR sg13_lv_pmos ad=0.2128p pd=1.5u as=0.2128p ps=1.5u w=1.12u l=0.13u
X1424 VGND.t1 a_11195_9248# a_11632_9562# VGND.t54 sg13_lv_nmos ad=0.148p pd=1.14u as=0.3367p ps=1.65u w=0.74u l=0.13u
X1425 VGND.t290 VPWR VGND.t20 VGND.t289 sg13_lv_nmos ad=0.1428p pd=1.52u as=0 ps=0 w=0.42u l=1u
X1426 a_10702_12654# a_10943_12187# a_10231_12180# VGND.t105 sg13_lv_nmos ad=0.1428p pd=1.52u as=0.12665p ps=1.145u w=0.42u l=0.13u
X1427 VPWR VGND.t570 VPWR VPWR sg13_lv_pmos ad=0.34p pd=2.68u as=0 ps=0 w=1u l=1u
X1428 VGND.t303 a_11355_11458# sg13cmos5l_dfrbpq_1_7.CLK VGND.t15 sg13_lv_nmos ad=0.1406p pd=1.12u as=0.1406p ps=1.12u w=0.74u l=0.13u
X1429 VGND.t667 VPWR VGND.t663 VGND.t86 sg13_lv_nmos ad=0.1428p pd=1.52u as=0 ps=0 w=0.42u l=1u
X1430 a_10791_10160# a_10943_10212# VPWR VPWR sg13_lv_pmos ad=0.3864p pd=2.93u as=1.38282p ps=8.655u w=1.12u l=0.13u
X1431 VPWR VGND.t331 VPWR VPWR sg13_lv_pmos ad=0.19p pd=1.38u as=0 ps=0 w=1u l=1u
X1432 sg13cmos5l_nand2_1_1.A a_7242_13264# VGND.t63 VGND.t43 sg13_lv_nmos ad=0.2516p pd=2.16u as=0.1406p ps=1.12u w=0.74u l=0.13u
X1433 VPWR VGND.t663 VPWR VPWR sg13_lv_pmos ad=0.34p pd=2.68u as=0 ps=0 w=1u l=1u
X1434 VPWR VGND.t484 VPWR VPWR sg13_lv_pmos ad=0.34p pd=2.68u as=0 ps=0 w=1u l=1u
X1435 VPWR VGND.t521 VPWR VPWR sg13_lv_pmos ad=0.34p pd=2.68u as=0 ps=0 w=1u l=1u
X1436 VGND.t484 VPWR VGND.t484 VGND.t512 sg13_lv_nmos ad=0.1428p pd=1.52u as=0 ps=0 w=0.42u l=1u
X1437 VPWR VGND.t572 VPWR VPWR sg13_lv_pmos ad=0.19p pd=1.38u as=0 ps=0 w=1u l=1u
X1438 VPWR VGND.t433 VPWR VPWR sg13_lv_pmos ad=0.19p pd=1.38u as=0 ps=0 w=1u l=1u
X1439 sg13cmos5l_dfrbpq_1_7.Q a_9642_10240# VGND.t62 VGND.t76 sg13_lv_nmos ad=0.2516p pd=2.16u as=0.1406p ps=1.12u w=0.74u l=0.13u
X1440 VGND.t16 sg13cmos5l_xor2_1_2.B sg13cmos5l_mux2_1_0.S VGND.t15 sg13_lv_nmos ad=0.1406p pd=1.12u as=0.1406p ps=1.12u w=0.74u l=0.13u
X1441 VPWR VGND.t234 VPWR VPWR sg13_lv_pmos ad=0.19p pd=1.38u as=0 ps=0 w=1u l=1u
X1442 sg13cmos5l_dfrbpq_1_7.CLK a_11355_11458# VPWR VPWR sg13_lv_pmos ad=0.2128p pd=1.5u as=0.2128p ps=1.5u w=1.12u l=0.13u
X1443 VGND.t940 sg13cmos5l_nand3_1_1.Y a_7849_12970# VGND.t43 sg13_lv_nmos ad=0.1045p pd=0.93u as=0.187p ps=1.78u w=0.55u l=0.13u
X1444 VGND.t877 VPWR VGND.t876 VGND.t875 sg13_lv_nmos ad=0.1428p pd=1.52u as=0 ps=0 w=0.42u l=1u
X1445 VPWR VGND.t87 VPWR VPWR sg13_lv_pmos ad=0.19p pd=1.38u as=0 ps=0 w=1u l=1u
X1446 a_11171_13997# sg13cmos5l_nor3_2_0.C VGND.t71 VGND.t114 sg13_lv_nmos ad=0.187p pd=1.78u as=0.1045p ps=0.93u w=0.55u l=0.13u
X1447 VPWR VGND.t904 VPWR VPWR sg13_lv_pmos ad=0.19p pd=1.38u as=0 ps=0 w=1u l=1u
X1448 VGND.t28 a_5135_11065# a_5802_10704# VGND.t2 sg13_lv_nmos ad=0.1406p pd=1.12u as=0.2516p ps=2.16u w=0.74u l=0.13u
X1449 VGND.t747 VPWR VGND.t747 VGND.t750 sg13_lv_nmos ad=0.1428p pd=1.52u as=0 ps=0 w=0.42u l=1u
X1450 VPWR VGND.t148 VPWR VPWR sg13_lv_pmos ad=0.34p pd=2.68u as=0 ps=0 w=1u l=1u
X1451 VPWR VGND.t672 VPWR VPWR sg13_lv_pmos ad=0.34p pd=2.68u as=0 ps=0 w=1u l=1u
X1452 VGND.t357 VPWR VGND.t357 VGND.t358 sg13_lv_nmos ad=79.8f pd=0.8u as=0 ps=0 w=0.42u l=1u
X1453 sg13cmos5l_dfrbpq_1_3.Q a_5802_10704# VPWR VPWR sg13_lv_pmos ad=0.3808p pd=2.92u as=0.2128p ps=1.5u w=1.12u l=0.13u
X1454 VGND.t572 VPWR VGND.t572 VGND.t596 sg13_lv_nmos ad=79.8f pd=0.8u as=0 ps=0 w=0.42u l=1u
X1455 VPWR VGND.t484 VPWR VPWR sg13_lv_pmos ad=0.34p pd=2.68u as=0 ps=0 w=1u l=1u
X1456 VPWR VGND.t18 VPWR VPWR sg13_lv_pmos ad=0.34p pd=2.68u as=0 ps=0 w=1u l=1u
X1457 sg13cmos5l_mux2_1_0.S sg13cmos5l_nor3_2_0.A VGND.t16 VGND.t15 sg13_lv_nmos ad=0.1406p pd=1.12u as=0.2553p ps=2.17u w=0.74u l=0.13u
X1458 a_8772_13284# a_8746_13189# VGND.t1006 VGND.t1005 sg13_lv_nmos ad=0.2516p pd=2.16u as=0.1626p ps=1.415u w=0.74u l=0.13u
X1459 VGND.t688 VPWR VGND.t688 VGND.t86 sg13_lv_nmos ad=0.1428p pd=1.52u as=0 ps=0 w=0.42u l=1u
X1460 VPWR enable_i a_808_3144# VPWR sg13_lv_pmos ad=0.2114p pd=1.54u as=0.2856p ps=2.36u w=0.84u l=0.13u
X1461 sg13cmos5l_nor3_2_0.C sg13cmos5l_nand4_1_1.A a_8702_12582# VGND.t965 sg13_lv_nmos ad=0.2516p pd=2.16u as=0.1406p ps=1.12u w=0.74u l=0.13u
X1462 VGND.t897 VPWR VGND.t899 VGND.t898 sg13_lv_nmos ad=79.8f pd=0.8u as=0 ps=0 w=0.42u l=1u
X1463 VPWR VGND.t6 VPWR VPWR sg13_lv_pmos ad=0.34p pd=2.68u as=0 ps=0 w=1u l=1u
X1464 a_5220_9955# a_5451_10064# a_4906_10165# VGND.t100 sg13_lv_nmos ad=0.2373p pd=1.97u as=79.8f ps=0.8u w=0.42u l=0.13u
X1465 VPWR VGND.t608 VPWR VPWR sg13_lv_pmos ad=0.19p pd=1.38u as=0 ps=0 w=1u l=1u
X1466 VPWR VGND.t484 VPWR VPWR sg13_lv_pmos ad=0.34p pd=2.68u as=0 ps=0 w=1u l=1u
X1467 VPWR VGND.t663 VPWR VPWR sg13_lv_pmos ad=0.34p pd=2.68u as=0 ps=0 w=1u l=1u
X1468 VGND.t613 VPWR VGND.t613 VGND.t615 sg13_lv_nmos ad=79.8f pd=0.8u as=0 ps=0 w=0.42u l=1u
X1469 VPWR VGND.t484 VPWR VPWR sg13_lv_pmos ad=0.34p pd=2.68u as=0 ps=0 w=1u l=1u
X1470 VGND.t333 VPWR VGND.t333 VGND.t351 sg13_lv_nmos ad=79.8f pd=0.8u as=0 ps=0 w=0.42u l=1u
X1471 a_8045_13264# sg13cmos5l_xor2_1_2.B a_7943_13264# VPWR sg13_lv_pmos ad=0.1575p pd=1.315u as=0.19p ps=1.38u w=1u l=0.13u
X1472 VPWR VGND.t572 VPWR VPWR sg13_lv_pmos ad=0.19p pd=1.38u as=0 ps=0 w=1u l=1u
X1473 VGND.t213 VPWR VGND.t212 VGND.t211 sg13_lv_nmos ad=0.1428p pd=1.52u as=0 ps=0 w=0.42u l=1u
X1474 VPWR VGND.t204 VPWR VPWR sg13_lv_pmos ad=0.19p pd=1.38u as=0 ps=0 w=1u l=1u
X1475 VGND.t195 VPWR VGND.t196 VGND.t232 sg13_lv_nmos ad=0.1428p pd=1.52u as=0 ps=0 w=0.42u l=1u
X1476 VPWR a_4462_13995# sg13cmos5l_nand4_1_0.C VPWR sg13_lv_pmos ad=0.2254p pd=1.53u as=0.4256p ps=3u w=1.12u l=0.13u
X1477 VGND.t668 VPWR VGND.t668 VGND.t86 sg13_lv_nmos ad=0.1428p pd=1.52u as=0 ps=0 w=0.42u l=1u
X1478 VPWR VGND.t668 VPWR VPWR sg13_lv_pmos ad=0.34p pd=2.68u as=0 ps=0 w=1u l=1u
X1479 VPWR VGND.t521 VPWR VPWR sg13_lv_pmos ad=0.34p pd=2.68u as=0 ps=0 w=1u l=1u
X1480 VGND.t603 VPWR VGND.t608 VGND.t607 sg13_lv_nmos ad=79.8f pd=0.8u as=0 ps=0 w=0.42u l=1u
X1481 VGND.t342 VPWR VGND.t344 VGND.t343 sg13_lv_nmos ad=79.8f pd=0.8u as=0 ps=0 w=0.42u l=1u
X1482 VPWR sg13cmos5l_a21oi_1_1.A1 a_10715_13728# VPWR sg13_lv_pmos ad=0.2128p pd=1.5u as=0.2128p ps=1.5u w=1.12u l=0.13u
X1483 VGND.t700 VPWR VGND.t700 VGND.t86 sg13_lv_nmos ad=0.1428p pd=1.52u as=0 ps=0 w=0.42u l=1u
X1484 VPWR VGND.t572 VPWR VPWR sg13_lv_pmos ad=0.19p pd=1.38u as=0 ps=0 w=1u l=1u
X1485 a_12386_9942# sg13cmos5l_dfrbpq_1_5.RESET_B VGND.t1 VGND.t34 sg13_lv_nmos ad=60.89999f pd=0.71u as=0.1626p ps=1.415u w=0.42u l=0.13u
X1486 VGND.t57 sg13cmos5l_dfrbpq_1_0.RESET_B a_4740_9942# VGND.t1003 sg13_lv_nmos ad=0.1626p pd=1.415u as=60.89999f ps=0.71u w=0.42u l=0.13u
X1487 VPWR sg13cmos5l_dfrbpq_1_0.RESET_B a_4646_9942# VPWR sg13_lv_pmos ad=0.36237p pd=2.605u as=79.8f ps=0.8u w=0.42u l=0.13u
X1488 VGND.t23 a_8133_9921# a_8235_10064# VGND.t22 sg13_lv_nmos ad=2.99005p pd=19.165u as=0.2516p ps=2.16u w=0.74u l=0.13u
X1489 VGND.t613 VPWR VGND.t613 VGND.t572 sg13_lv_nmos ad=79.8f pd=0.8u as=0 ps=0 w=0.42u l=1u
X1490 VPWR VGND.t572 VPWR VPWR sg13_lv_pmos ad=0.34p pd=2.68u as=0 ps=0 w=1u l=1u
X1491 a_3876_12220# a_3850_12184# VPWR VPWR sg13_lv_pmos ad=0.34p pd=2.68u as=0.36237p ps=2.605u w=1u l=0.13u
X1492 VPWR VGND.t255 VPWR VPWR sg13_lv_pmos ad=0.19p pd=1.38u as=0 ps=0 w=1u l=1u
X1493 VGND.t87 enable_i a_808_3144# VGND.t86 sg13_lv_nmos ad=0.14875p pd=1.16u as=0.187p ps=1.78u w=0.55u l=0.13u
X1494 VPWR sg13cmos5l_buf_1_0.X sg13cmos5l_nand3_1_0.Y VPWR sg13_lv_pmos ad=0.2128p pd=1.5u as=0.3808p ps=2.92u w=1.12u l=0.13u
X1495 VPWR VGND.t688 VPWR VPWR sg13_lv_pmos ad=0.34p pd=2.68u as=0 ps=0 w=1u l=1u
X1496 VGND.t200 sg13cmos5l_dlygate4sd3_1_1.X a_3642_13691# VGND.t975 sg13_lv_nmos ad=0.374p pd=2.46u as=0.17462p ps=1.185u w=0.55u l=0.13u
X1497 VPWR VGND.t344 VPWR VPWR sg13_lv_pmos ad=0.19p pd=1.38u as=0 ps=0 w=1u l=1u
X1498 VPWR sg13cmos5l_a21oi_1_0.A1 a_7355_9192# VPWR sg13_lv_pmos ad=0.2128p pd=1.5u as=0.2128p ps=1.5u w=1.12u l=0.13u
X1499 VPWR VGND.t603 VPWR VPWR sg13_lv_pmos ad=0.19p pd=1.38u as=0 ps=0 w=1u l=1u
X1500 a_5135_12577# a_4293_12227# a_5041_12577# VGND.t32 sg13_lv_nmos ad=0.12665p pd=1.145u as=0.1428p ps=1.52u w=0.42u l=0.13u
X1501 a_6575_13043# a_5733_12945# a_5316_13284# VPWR sg13_lv_pmos ad=0.2048p pd=1.63u as=0.34p ps=2.68u w=1u l=0.13u
X1502 a_5392_12458# sg13cmos5l_dfrbpq_1_2.RESET_B VPWR VPWR sg13_lv_pmos ad=79.8f pd=0.8u as=2.16757p ps=13.96u w=0.42u l=0.13u
X1503 VGND.t572 VPWR VGND.t572 VGND.t598 sg13_lv_nmos ad=79.8f pd=0.8u as=0 ps=0 w=0.42u l=1u
X1504 VGND.t882 VPWR VGND.t881 VGND.t880 sg13_lv_nmos ad=0.1428p pd=1.52u as=0 ps=0 w=0.42u l=1u
X1505 a_8314_10668# sg13cmos5l_o21ai_1_0.Y VGND.t7 VGND.t2 sg13_lv_nmos ad=0.1428p pd=1.52u as=79.8f ps=0.8u w=0.42u l=0.13u
X1506 VPWR VGND.t188 VPWR VPWR sg13_lv_pmos ad=0.34p pd=2.68u as=0 ps=0 w=1u l=1u
X1507 a_14074_9910# sg13cmos5l_mux2_1_0.X VPWR VPWR sg13_lv_pmos ad=0.1428p pd=1.52u as=0.1523p ps=1.38u w=0.42u l=0.13u
X1508 VPWR VGND.t221 VPWR VPWR sg13_lv_pmos ad=0.34p pd=2.68u as=0 ps=0 w=1u l=1u
X1509 VGND.t688 VPWR VGND.t688 VGND.t86 sg13_lv_nmos ad=0.1428p pd=1.52u as=0 ps=0 w=0.42u l=1u
X1510 VGND.t590 VPWR VGND.t590 VGND.t592 sg13_lv_nmos ad=79.8f pd=0.8u as=0 ps=0 w=0.42u l=1u
X1511 VPWR VGND.t18 VPWR VPWR sg13_lv_pmos ad=0.19p pd=1.38u as=0 ps=0 w=1u l=1u
X1512 a_5316_13284# a_5290_13189# VPWR VPWR sg13_lv_pmos ad=0.34p pd=2.68u as=0.36237p ps=2.605u w=1u l=0.13u
X1513 VPWR VGND.t87 VPWR VPWR sg13_lv_pmos ad=0.34p pd=2.68u as=0 ps=0 w=1u l=1u
X1514 VPWR VGND.t668 VPWR VPWR sg13_lv_pmos ad=0.34p pd=2.68u as=0 ps=0 w=1u l=1u
X1515 a_9449_14424# a_9573_14521# VPWR VPWR sg13_lv_pmos ad=0.2442p pd=2.06u as=11.27927p ps=73.965u w=0.66u l=0.13u
X1516 VGND.t684 VPWR VGND.t684 VGND.t86 sg13_lv_nmos ad=79.8f pd=0.8u as=0 ps=0 w=0.42u l=1u
X1517 VGND.t372 VPWR VGND.t62 VGND.t373 sg13_lv_nmos ad=79.8f pd=0.8u as=0 ps=0 w=0.42u l=1u
X1518 sg13cmos5l_a21oi_1_0.A2 a_7177_10728# VPWR VPWR sg13_lv_pmos ad=0.3808p pd=2.92u as=0.3822p ps=1.84u w=1.12u l=0.13u
X1519 a_1740_10970# sg13cmos5l_xnor2_1_0.B VPWR VPWR sg13_lv_pmos ad=0.1596p pd=1.22u as=0.2891p ps=1.695u w=0.84u l=0.13u
X1520 VPWR VGND.t577 VPWR VPWR sg13_lv_pmos ad=0.19p pd=1.38u as=0 ps=0 w=1u l=1u
X1521 VGND.t51 VPWR VGND.t51 VGND.t353 sg13_lv_nmos ad=79.8f pd=0.8u as=0 ps=0 w=0.42u l=1u
X1522 sg13cmos5l_nand4_1_0.Y sg13cmos5l_dfrbpq_1_0.Q VPWR VPWR sg13_lv_pmos ad=0.2128p pd=1.5u as=0.2128p ps=1.5u w=1.12u l=0.13u
X1523 a_11835_10333# a_10943_10212# a_11733_10100# VPWR sg13_lv_pmos ad=63f pd=0.72u as=79.8f ps=0.8u w=0.42u l=0.13u
X1524 VGND.t18 sg13cmos5l_xor2_1_2.B a_12022_12962# VGND.t1069 sg13_lv_nmos ad=0.1406p pd=1.12u as=0.2516p ps=2.16u w=0.74u l=0.15u
X1525 VPWR VGND.t572 VPWR VPWR sg13_lv_pmos ad=0.19p pd=1.38u as=0 ps=0 w=1u l=1u
X1526 VGND.t917 VPWR VGND.t919 VGND.t918 sg13_lv_nmos ad=79.8f pd=0.8u as=0 ps=0 w=0.42u l=1u
X1527 VGND.t668 VPWR VGND.t668 VGND.t86 sg13_lv_nmos ad=0.1428p pd=1.52u as=0 ps=0 w=0.42u l=1u
X1528 VPWR VGND.t410 VPWR VPWR sg13_lv_pmos ad=0.34p pd=2.68u as=0 ps=0 w=1u l=1u
X1529 a_4426_11422# sg13cmos5l_buf_8_0.A VPWR VPWR sg13_lv_pmos ad=0.3808p pd=2.92u as=0.2128p ps=1.5u w=1.12u l=0.13u
X1530 VGND.t12 sg13cmos5l_xnor2_1_0.B a_1594_12970# VGND.t137 sg13_lv_nmos ad=0.2516p pd=2.16u as=0.1406p ps=1.12u w=0.74u l=0.13u
X1531 VGND.t747 VPWR VGND.t747 VGND.t762 sg13_lv_nmos ad=79.8f pd=0.8u as=0 ps=0 w=0.42u l=1u
X1532 VPWR VGND.t484 VPWR VPWR sg13_lv_pmos ad=0.34p pd=2.68u as=0 ps=0 w=1u l=1u
X1533 VPWR VGND.t387 VPWR VPWR sg13_lv_pmos ad=0.19p pd=1.38u as=0 ps=0 w=1u l=1u
X1534 VGND.t608 VPWR VGND.t608 VGND.t610 sg13_lv_nmos ad=79.8f pd=0.8u as=0 ps=0 w=0.42u l=1u
X1535 a_11733_12263# a_10791_12303# a_11639_12263# VPWR sg13_lv_pmos ad=79.8f pd=0.8u as=0.1428p ps=1.52u w=0.42u l=0.13u
X1536 VPWR VGND.t613 VPWR VPWR sg13_lv_pmos ad=0.19p pd=1.38u as=0 ps=0 w=1u l=1u
X1537 VPWR VGND.t419 VPWR VPWR sg13_lv_pmos ad=0.19p pd=1.38u as=0 ps=0 w=1u l=1u
X1538 VGND.t28 a_4426_11422# sg13cmos5l_dfrbpq_1_0.CLK VGND.t15 sg13_lv_nmos ad=0.1406p pd=1.12u as=0.1406p ps=1.12u w=0.74u l=0.13u
X1539 VGND.t130 a_9836_14442# count_o[4] VGND.t1051 sg13_lv_nmos ad=0.14875p pd=1.16u as=0.2886p ps=2.26u w=0.74u l=0.13u
X1540 VPWR sg13cmos5l_nand2_1_0.Y a_1940_13264# VPWR sg13_lv_pmos ad=0.2128p pd=1.5u as=0.2128p ps=1.5u w=1.12u l=0.13u
X1541 VPWR a_10812_9906# a_11835_10333# VPWR sg13_lv_pmos ad=0.1563p pd=1.22u as=63f ps=0.72u w=0.42u l=0.13u
X1542 VPWR VGND.t572 VPWR VPWR sg13_lv_pmos ad=0.34p pd=2.68u as=0 ps=0 w=1u l=1u
X1543 VGND.t360 VPWR VGND.t57 VGND.t359 sg13_lv_nmos ad=0.1428p pd=1.52u as=0 ps=0 w=0.42u l=1u
X1544 VPWR a_8091_11458# sg13cmos5l_buf_8_0.A VPWR sg13_lv_pmos ad=0.3864p pd=2.93u as=0.2128p ps=1.5u w=1.12u l=0.13u
X1545 VPWR VGND.t603 VPWR VPWR sg13_lv_pmos ad=0.19p pd=1.38u as=0 ps=0 w=1u l=1u
X1546 sg13cmos5l_dfrbpq_1_0.CLK a_4426_11422# VPWR VPWR sg13_lv_pmos ad=0.2128p pd=1.5u as=0.2128p ps=1.5u w=1.12u l=0.13u
X1547 VPWR VGND.t87 VPWR VPWR sg13_lv_pmos ad=0.34p pd=2.68u as=0 ps=0 w=1u l=1u
X1548 VGND.t392 VPWR VGND.t392 VGND.t443 sg13_lv_nmos ad=0.1428p pd=1.52u as=0 ps=0 w=0.42u l=1u
X1549 VPWR VGND.t608 VPWR VPWR sg13_lv_pmos ad=0.19p pd=1.38u as=0 ps=0 w=1u l=1u
X1550 VGND.t572 VPWR VGND.t572 VGND.t585 sg13_lv_nmos ad=79.8f pd=0.8u as=0 ps=0 w=0.42u l=1u
X1551 VGND.t329 VPWR VGND.t331 VGND.t330 sg13_lv_nmos ad=79.8f pd=0.8u as=0 ps=0 w=0.42u l=1u
X1552 VPWR VGND.t590 VPWR VPWR sg13_lv_pmos ad=0.19p pd=1.38u as=0 ps=0 w=1u l=1u
X1553 VPWR VGND.t590 VPWR VPWR sg13_lv_pmos ad=0.34p pd=2.68u as=0 ps=0 w=1u l=1u
X1554 VGND.t572 VPWR VGND.t572 VGND.t597 sg13_lv_nmos ad=0.1428p pd=1.52u as=0 ps=0 w=0.42u l=1u
X1555 VPWR sg13cmos5l_dfrbpq_1_7.CLK a_10943_10212# VPWR sg13_lv_pmos ad=1.3227p pd=8.28u as=0.4088p ps=2.97u w=1.12u l=0.13u
X1556 VPWR VGND.t301 VPWR VPWR sg13_lv_pmos ad=0.34p pd=2.68u as=0 ps=0 w=1u l=1u
X1557 VGND.t663 VPWR VGND.t663 VGND.t86 sg13_lv_nmos ad=0.1428p pd=1.52u as=0 ps=0 w=0.42u l=1u
X1558 VPWR a_11355_11458# sg13cmos5l_dfrbpq_1_7.CLK VPWR sg13_lv_pmos ad=0.2128p pd=1.5u as=0.2128p ps=1.5u w=1.12u l=0.13u
X1559 VGND.t752 VPWR VGND.t747 VGND.t756 sg13_lv_nmos ad=79.8f pd=0.8u as=0 ps=0 w=0.42u l=1u
X1560 VPWR VGND.t668 VPWR VPWR sg13_lv_pmos ad=0.34p pd=2.68u as=0 ps=0 w=1u l=1u
X1561 VGND.t572 VPWR VGND.t603 VGND.t602 sg13_lv_nmos ad=79.8f pd=0.8u as=0 ps=0 w=0.42u l=1u
X1562 VPWR VGND.t219 VPWR VPWR sg13_lv_pmos ad=0.19p pd=1.38u as=0 ps=0 w=1u l=1u
X1563 VGND.t745 VPWR VGND.t745 VGND.t744 sg13_lv_nmos ad=0.1428p pd=1.52u as=0 ps=0 w=0.42u l=1u
X1564 VPWR a_6106_13969# sg13cmos5l_dfrbpq_1_1.RESET_B VPWR sg13_lv_pmos ad=1.7455p pd=10.885u as=0.3927p ps=2.99u w=1.155u l=0.13u
X1565 VPWR VGND.t939 VPWR VPWR sg13_lv_pmos ad=0.19p pd=1.38u as=0 ps=0 w=1u l=1u
X1566 VPWR VGND.t572 VPWR VPWR sg13_lv_pmos ad=0.19p pd=1.38u as=0 ps=0 w=1u l=1u
X1567 VPWR VGND.t608 VPWR VPWR sg13_lv_pmos ad=0.34p pd=2.68u as=0 ps=0 w=1u l=1u
X1568 VGND.t847 VPWR VGND.t849 VGND.t848 sg13_lv_nmos ad=79.8f pd=0.8u as=0 ps=0 w=0.42u l=1u
X1569 VGND.t51 VPWR VGND.t51 VGND.t352 sg13_lv_nmos ad=0.1428p pd=1.52u as=0 ps=0 w=0.42u l=1u
X1570 VGND.t747 VPWR VGND.t747 VGND.t775 sg13_lv_nmos ad=79.8f pd=0.8u as=0 ps=0 w=0.42u l=1u
X1571 VGND.t16 sg13cmos5l_nor3_2_0.A sg13cmos5l_mux2_1_0.S VGND.t15 sg13_lv_nmos ad=0.3293p pd=1.63u as=0.1406p ps=1.12u w=0.74u l=0.13u
X1572 VGND.t104 a_4570_12934# a_4289_13156# VGND.t103 sg13_lv_nmos ad=79.8f pd=0.8u as=0.1428p ps=1.52u w=0.42u l=0.5u
X1573 VGND.t747 VPWR VGND.t765 VGND.t764 sg13_lv_nmos ad=79.8f pd=0.8u as=0 ps=0 w=0.42u l=1u
X1574 VGND.t608 VPWR VGND.t613 VGND.t612 sg13_lv_nmos ad=79.8f pd=0.8u as=0 ps=0 w=0.42u l=1u
X1575 VGND.t392 VPWR VGND.t392 VGND.t393 sg13_lv_nmos ad=79.8f pd=0.8u as=0 ps=0 w=0.42u l=1u
X1576 VPWR VGND.t747 VPWR VPWR sg13_lv_pmos ad=0.19p pd=1.38u as=0 ps=0 w=1u l=1u
X1577 VPWR VGND.t275 VPWR VPWR sg13_lv_pmos ad=0.19p pd=1.38u as=0 ps=0 w=1u l=1u
X1578 VGND.t6 sg13cmos5l_tiehi_5.L_HI a_7524_9942# VGND.t21 sg13_lv_nmos ad=0.1626p pd=1.415u as=60.89999f ps=0.71u w=0.42u l=0.13u
X1579 VPWR VGND.t484 VPWR VPWR sg13_lv_pmos ad=0.34p pd=2.68u as=0 ps=0 w=1u l=1u
X1580 a_13673_11042# a_13797_10741# VPWR VPWR sg13_lv_pmos ad=0.2442p pd=2.06u as=1.38282p ps=8.655u w=0.66u l=0.13u
X1581 a_8998_12979# sg13cmos5l_dfrbpq_1_4.RESET_B VGND.t272 VGND.t1081 sg13_lv_nmos ad=37.8f pd=0.6u as=0.1701p ps=1.65u w=0.42u l=0.13u
X1582 VPWR VGND.t572 VPWR VPWR sg13_lv_pmos ad=0.34p pd=2.68u as=0 ps=0 w=1u l=1u
X1583 VGND.t59 sg13cmos5l_a21oi_1_0.B1 sg13cmos5l_dlygate4sd3_1_8.A VGND.t1031 sg13_lv_nmos ad=0.2516p pd=2.16u as=0.1406p ps=1.12u w=0.74u l=0.13u
X1584 VPWR VGND.t884 VPWR VPWR sg13_lv_pmos ad=0.19p pd=1.38u as=0 ps=0 w=1u l=1u
X1585 a_5326_13995# a_5441_13994# VGND.t127 VGND.t983 sg13_lv_nmos ad=0.1428p pd=1.52u as=0.1426p ps=1.16u w=0.42u l=0.5u
X1586 sg13cmos5l_nand3_1_1.Y sg13cmos5l_dfrbpq_1_7.Q VPWR VPWR sg13_lv_pmos ad=0.3808p pd=2.92u as=0.2128p ps=1.5u w=1.12u l=0.13u
X1587 VGND.t304 VPWR VGND.t303 VGND.t15 sg13_lv_nmos ad=0.1428p pd=1.52u as=0 ps=0 w=0.42u l=1u
X1588 VPWR VGND.t663 VPWR VPWR sg13_lv_pmos ad=0.34p pd=2.68u as=0 ps=0 w=1u l=1u
X1589 VPWR VGND.t608 VPWR VPWR sg13_lv_pmos ad=0.19p pd=1.38u as=0 ps=0 w=1u l=1u
X1590 a_8498_12582# sg13cmos5l_dfrbpq_1_0.Q VGND.t1059 VGND.t135 sg13_lv_nmos ad=0.1406p pd=1.12u as=0.2516p ps=2.16u w=0.74u l=0.13u
X1591 VGND.t202 VPWR VGND.t204 VGND.t203 sg13_lv_nmos ad=79.8f pd=0.8u as=0 ps=0 w=0.42u l=1u
X1592 a_3850_10672# a_4293_10715# a_3590_11142# VGND.t38 sg13_lv_nmos ad=79.8f pd=0.8u as=0.1296p ps=1.52u w=0.42u l=0.13u
X1593 VGND.t188 VPWR VGND.t188 VGND.t187 sg13_lv_nmos ad=0.1428p pd=1.52u as=0 ps=0 w=0.42u l=1u
X1594 VGND.t375 VPWR VGND.t62 VGND.t374 sg13_lv_nmos ad=0.1428p pd=1.52u as=0 ps=0 w=0.42u l=1u
X1595 VGND.t521 VPWR VGND.t521 VGND.t484 sg13_lv_nmos ad=79.8f pd=0.8u as=0 ps=0 w=0.42u l=1u
X1596 VPWR VGND.t424 VPWR VPWR sg13_lv_pmos ad=0.34p pd=2.68u as=0 ps=0 w=1u l=1u
X1597 VPWR a_10112_12503# sg13cmos5l_dfrbpq_1_6.Q VPWR sg13_lv_pmos ad=0.2128p pd=1.5u as=0.3808p ps=2.92u w=1.12u l=0.13u
X1598 VGND.t572 VPWR VGND.t572 VGND.t599 sg13_lv_nmos ad=0.1428p pd=1.52u as=0 ps=0 w=0.42u l=1u
X1599 a_11518_9562# sg13cmos5l_mux2_1_0.A1 a_11421_9562# VGND.t1115 sg13_lv_nmos ad=0.1628p pd=1.18u as=0.13135p ps=1.095u w=0.74u l=0.13u
X1600 VGND.t765 VPWR VGND.t747 VGND.t769 sg13_lv_nmos ad=79.8f pd=0.8u as=0 ps=0 w=0.42u l=1u
X1601 a_5030_12966# a_5835_13088# a_5290_13189# VPWR sg13_lv_pmos ad=0.1428p pd=1.52u as=79.8f ps=0.8u w=0.42u l=0.13u
X1602 VGND.t747 VPWR VGND.t747 VGND.t758 sg13_lv_nmos ad=79.8f pd=0.8u as=0 ps=0 w=0.42u l=1u
X1603 VGND.t603 VPWR VGND.t603 VGND.t605 sg13_lv_nmos ad=79.8f pd=0.8u as=0 ps=0 w=0.42u l=1u
X1604 VPWR VGND.t747 VPWR VPWR sg13_lv_pmos ad=0.19p pd=1.38u as=0 ps=0 w=1u l=1u
X1605 sg13cmos5l_dfrbpq_1_6.D a_12150_13752# VGND.t71 VGND.t992 sg13_lv_nmos ad=0.2516p pd=2.16u as=0.1426p ps=1.16u w=0.74u l=0.13u
X1606 VGND.t438 VPWR VGND.t438 VGND.t440 sg13_lv_nmos ad=0.1428p pd=1.52u as=0 ps=0 w=0.42u l=1u
X1607 VPWR VGND.t572 VPWR VPWR sg13_lv_pmos ad=0.19p pd=1.38u as=0 ps=0 w=1u l=1u
X1608 VPWR VGND.t613 VPWR VPWR sg13_lv_pmos ad=0.34p pd=2.68u as=0 ps=0 w=1u l=1u
X1609 VPWR a_5135_12577# a_5392_12458# VPWR sg13_lv_pmos ad=2.16757p pd=13.96u as=79.8f ps=0.8u w=0.42u l=0.13u
X1610 a_10112_10117# a_10231_9906# VGND.t93 VGND.t117 sg13_lv_nmos ad=0.2516p pd=2.16u as=0.1406p ps=1.12u w=0.74u l=0.13u
X1611 VPWR a_11854_14667# sg13cmos5l_a21oi_1_1.A1 VPWR sg13_lv_pmos ad=0.2254p pd=1.53u as=0.4256p ps=3u w=1.12u l=0.13u
X1612 VGND.t51 VPWR VGND.t51 VGND.t354 sg13_lv_nmos ad=0.1428p pd=1.52u as=0 ps=0 w=0.42u l=1u
X1613 VGND.t590 VPWR VGND.t590 VGND.t593 sg13_lv_nmos ad=0.1428p pd=1.52u as=0 ps=0 w=0.42u l=1u
X1614 VPWR VGND.t572 VPWR VPWR sg13_lv_pmos ad=0.34p pd=2.68u as=0 ps=0 w=1u l=1u
X1615 VPWR a_13594_10945# sg13cmos5l_dfrbpq_1_5.RESET_B VPWR sg13_lv_pmos ad=1.38282p pd=8.655u as=0.3927p ps=2.99u w=1.155u l=0.13u
X1616 VGND.t484 VPWR VGND.t484 VGND.t503 sg13_lv_nmos ad=79.8f pd=0.8u as=0 ps=0 w=0.42u l=1u
X1617 VPWR VGND.t484 VPWR VPWR sg13_lv_pmos ad=0.19p pd=1.38u as=0 ps=0 w=1u l=1u
X1618 a_6448_10162# a_6191_10019# a_6610_9942# VGND.t108 sg13_lv_nmos ad=0.1428p pd=1.52u as=37.8f ps=0.6u w=0.42u l=0.13u
X1619 VGND.t747 VPWR VGND.t752 VGND.t751 sg13_lv_nmos ad=79.8f pd=0.8u as=0 ps=0 w=0.42u l=1u
X1620 a_7066_11458# sg13cmos5l_dfrbpq_1_0.Q VGND.t7 VGND.t15 sg13_lv_nmos ad=0.1406p pd=1.12u as=0.2516p ps=2.16u w=0.74u l=0.13u
X1621 VPWR VGND.t603 VPWR VPWR sg13_lv_pmos ad=0.19p pd=1.38u as=0 ps=0 w=1u l=1u
X1622 VGND.t49 a_5135_12577# a_5802_12216# VGND.t972 sg13_lv_nmos ad=0.1406p pd=1.12u as=0.2516p ps=2.16u w=0.74u l=0.13u
X1623 VGND.t222 VPWR VGND.t221 VGND.t220 sg13_lv_nmos ad=0.1428p pd=1.52u as=0 ps=0 w=0.42u l=1u
X1624 VPWR sg13cmos5l_dfrbpq_1_6.RESET_B a_10444_12654# VPWR sg13_lv_pmos ad=2.16757p pd=13.96u as=79.8f ps=0.8u w=0.42u l=0.13u
X1625 VGND.t608 VPWR VGND.t608 VGND.t611 sg13_lv_nmos ad=0.1428p pd=1.52u as=0 ps=0 w=0.42u l=1u
X1626 VPWR VGND.t572 VPWR VPWR sg13_lv_pmos ad=0.34p pd=2.68u as=0 ps=0 w=1u l=1u
X1627 VGND.t700 VPWR VGND.t700 VGND.t86 sg13_lv_nmos ad=79.8f pd=0.8u as=0 ps=0 w=0.42u l=1u
X1628 VGND.t902 VPWR VGND.t901 VGND.t900 sg13_lv_nmos ad=0.1428p pd=1.52u as=0 ps=0 w=0.42u l=1u
X1629 a_5135_11065# a_4293_10715# a_3876_10708# VPWR sg13_lv_pmos ad=0.2048p pd=1.63u as=0.34p ps=2.68u w=1u l=0.13u
X1630 VPWR VGND.t51 VPWR VPWR sg13_lv_pmos ad=0.19p pd=1.38u as=0 ps=0 w=1u l=1u
X1631 VGND.t148 VPWR VGND.t148 VGND.t315 sg13_lv_nmos ad=0.1428p pd=1.52u as=0 ps=0 w=0.42u l=1u
X1632 VPWR VGND.t484 VPWR VPWR sg13_lv_pmos ad=0.19p pd=1.38u as=0 ps=0 w=1u l=1u
X1633 a_8878_10971# a_8993_10970# VGND.t3 VGND.t2 sg13_lv_nmos ad=0.1428p pd=1.52u as=0.1426p ps=1.16u w=0.42u l=0.5u
X1634 VPWR VGND.t929 VPWR VPWR sg13_lv_pmos ad=0.19p pd=1.38u as=0 ps=0 w=1u l=1u
X1635 VPWR VGND.t577 VPWR VPWR sg13_lv_pmos ad=0.19p pd=1.38u as=0 ps=0 w=1u l=1u
X1636 VPWR VGND.t603 VPWR VPWR sg13_lv_pmos ad=0.34p pd=2.68u as=0 ps=0 w=1u l=1u
X1637 VGND.t400 VPWR VGND.t400 VGND.t402 sg13_lv_nmos ad=0.1428p pd=1.52u as=0 ps=0 w=0.42u l=1u
X1638 a_7690_10165# a_8133_9921# a_7430_9942# VGND.t21 sg13_lv_nmos ad=79.8f pd=0.8u as=0.1296p ps=1.52u w=0.42u l=0.13u
X1639 VPWR VGND.t18 VPWR VPWR sg13_lv_pmos ad=0.19p pd=1.38u as=0 ps=0 w=1u l=1u
X1640 a_4164_11129# a_3876_10708# a_4102_11129# VGND.t4 sg13_lv_nmos ad=0.1428p pd=1.52u as=37.8f ps=0.6u w=0.42u l=0.13u
X1641 VGND.t301 VPWR VGND.t302 VGND.t15 sg13_lv_nmos ad=79.8f pd=0.8u as=0 ps=0 w=0.42u l=1u
X1642 VGND.t253 VPWR VGND.t124 VGND.t252 sg13_lv_nmos ad=0.1428p pd=1.52u as=0 ps=0 w=0.42u l=1u
X1643 VGND.t747 VPWR VGND.t747 VGND.t771 sg13_lv_nmos ad=79.8f pd=0.8u as=0 ps=0 w=0.42u l=1u
X1644 VGND.t572 VPWR VGND.t572 VGND.t586 sg13_lv_nmos ad=0.1428p pd=1.52u as=0 ps=0 w=0.42u l=1u
X1645 VGND.t3 a_8091_11458# sg13cmos5l_buf_8_0.A VGND.t15 sg13_lv_nmos ad=0.1406p pd=1.12u as=0.1406p ps=1.12u w=0.74u l=0.13u
X1646 sg13cmos5l_nor3_2_0.C sg13cmos5l_o21ai_1_0.B1 VPWR VPWR sg13_lv_pmos ad=0.2128p pd=1.5u as=0.2128p ps=1.5u w=1.12u l=0.13u
X1647 VPWR VGND.t684 VPWR VPWR sg13_lv_pmos ad=0.19p pd=1.38u as=0 ps=0 w=1u l=1u
X1648 VPWR VGND.t438 VPWR VPWR sg13_lv_pmos ad=0.19p pd=1.38u as=0 ps=0 w=1u l=1u
X1649 VPWR VGND.t747 VPWR VPWR sg13_lv_pmos ad=0.19p pd=1.38u as=0 ps=0 w=1u l=1u
X1650 VGND.t937 VPWR VGND.t939 VGND.t938 sg13_lv_nmos ad=79.8f pd=0.8u as=0 ps=0 w=0.42u l=1u
X1651 VPWR VGND.t613 VPWR VPWR sg13_lv_pmos ad=0.34p pd=2.68u as=0 ps=0 w=1u l=1u
X1652 VPWR a_4426_11422# sg13cmos5l_dfrbpq_1_0.CLK VPWR sg13_lv_pmos ad=0.2128p pd=1.5u as=0.2128p ps=1.5u w=1.12u l=0.13u
X1653 VGND.t788 VPWR VGND.t788 VGND.t790 sg13_lv_nmos ad=79.8f pd=0.8u as=0 ps=0 w=0.42u l=1u
X1654 VPWR a_13678_10131# sg13cmos5l_dfrbpq_1_5.D VPWR sg13_lv_pmos ad=0.2254p pd=1.53u as=0.4256p ps=3u w=1.12u l=0.13u
X1655 VPWR a_8975_10019# a_9642_10240# VPWR sg13_lv_pmos ad=0.2128p pd=1.5u as=0.3864p ps=2.93u w=1.12u l=0.13u
X1656 VPWR a_10288_13186# a_10233_13281# VPWR sg13_lv_pmos ad=1.7455p pd=10.885u as=93.45f ps=0.865u w=0.42u l=0.13u
X1657 VGND.t357 VPWR VGND.t51 VGND.t356 sg13_lv_nmos ad=0.1428p pd=1.52u as=0 ps=0 w=0.42u l=1u
X1658 VGND.t572 VPWR VGND.t572 VGND.t595 sg13_lv_nmos ad=0.1428p pd=1.52u as=0 ps=0 w=0.42u l=1u
X1659 VPWR VGND.t572 VPWR VPWR sg13_lv_pmos ad=0.34p pd=2.68u as=0 ps=0 w=1u l=1u
X1660 VGND.t7 clk_i a_8091_11458# VGND.t15 sg13_lv_nmos ad=0.1406p pd=1.12u as=0.1406p ps=1.12u w=0.74u l=0.13u
X1661 sg13cmos5l_nor2_1_1.B a_1914_13162# VGND.t12 VGND.t11 sg13_lv_nmos ad=0.1628p pd=1.18u as=0.3108p ps=2.32u w=0.74u l=0.13u
X1662 VPWR VGND.t484 VPWR VPWR sg13_lv_pmos ad=0.19p pd=1.38u as=0 ps=0 w=1u l=1u
X1663 sg13cmos5l_a21oi_1_0.Y sg13cmos5l_a21oi_1_0.B1 VGND.t6 VGND.t1029 sg13_lv_nmos ad=0.1406p pd=1.12u as=0.2516p ps=2.16u w=0.74u l=0.13u
X1664 VGND.t16 a_11355_11458# sg13cmos5l_dfrbpq_1_7.CLK VGND.t15 sg13_lv_nmos ad=0.1406p pd=1.12u as=0.1406p ps=1.12u w=0.74u l=0.13u
X1665 VGND.t752 VPWR VGND.t752 VGND.t754 sg13_lv_nmos ad=79.8f pd=0.8u as=0 ps=0 w=0.42u l=1u
X1666 VGND.t521 VPWR VGND.t521 VGND.t484 sg13_lv_nmos ad=79.8f pd=0.8u as=0 ps=0 w=0.42u l=1u
X1667 VPWR VGND.t752 VPWR VPWR sg13_lv_pmos ad=0.19p pd=1.38u as=0 ps=0 w=1u l=1u
X1668 VPWR VGND.t603 VPWR VPWR sg13_lv_pmos ad=0.19p pd=1.38u as=0 ps=0 w=1u l=1u
X1669 VGND.t87 VPWR VGND.t87 VGND.t86 sg13_lv_nmos ad=0.1428p pd=1.52u as=0 ps=0 w=0.42u l=1u
X1670 VPWR a_9742_13995# sg13cmos5l_nand4_1_1.A VPWR sg13_lv_pmos ad=0.2254p pd=1.53u as=0.4256p ps=3u w=1.12u l=0.13u
X1671 VGND.t765 VPWR VGND.t765 VGND.t766 sg13_lv_nmos ad=0.1428p pd=1.52u as=0 ps=0 w=0.42u l=1u
X1672 VGND.t778 VPWR VGND.t783 VGND.t782 sg13_lv_nmos ad=79.8f pd=0.8u as=0 ps=0 w=0.42u l=1u
X1673 VGND.t613 VPWR VGND.t613 VGND.t614 sg13_lv_nmos ad=0.1428p pd=1.52u as=0 ps=0 w=0.42u l=1u
X1674 VGND.t395 VPWR VGND.t395 VGND.t394 sg13_lv_nmos ad=0.1428p pd=1.52u as=0 ps=0 w=0.42u l=1u
X1675 VGND.t188 VPWR VGND.t188 VGND.t229 sg13_lv_nmos ad=0.1428p pd=1.52u as=0 ps=0 w=0.42u l=1u
X1676 VPWR VGND.t59 VPWR VPWR sg13_lv_pmos ad=0.19p pd=1.38u as=0 ps=0 w=1u l=1u
X1677 VPWR VGND.t521 VPWR VPWR sg13_lv_pmos ad=0.19p pd=1.38u as=0 ps=0 w=1u l=1u
X1678 VPWR VGND.t590 VPWR VPWR sg13_lv_pmos ad=0.34p pd=2.68u as=0 ps=0 w=1u l=1u
X1679 VPWR sg13cmos5l_dlygate4sd3_1_1.X a_4094_13728# VPWR sg13_lv_pmos ad=0.36p pd=2.72u as=0.1225p ps=1.245u w=1u l=0.13u
X1680 sg13cmos5l_nor2_1_1.Y sg13cmos5l_a21oi_1_0.B1 VGND.t12 VGND.t1028 sg13_lv_nmos ad=0.1406p pd=1.12u as=0.2516p ps=2.16u w=0.74u l=0.13u
X1681 VGND.t684 VPWR VGND.t688 VGND.t86 sg13_lv_nmos ad=79.8f pd=0.8u as=0 ps=0 w=0.42u l=1u
X1682 VGND.t148 VPWR VGND.t148 VGND.t292 sg13_lv_nmos ad=0.1428p pd=1.52u as=0 ps=0 w=0.42u l=1u
X1683 VGND.t217 VPWR VGND.t219 VGND.t218 sg13_lv_nmos ad=79.8f pd=0.8u as=0 ps=0 w=0.42u l=1u
X1684 VPWR VGND.t28 VPWR VPWR sg13_lv_pmos ad=0.34p pd=2.68u as=0 ps=0 w=1u l=1u
X1685 VPWR VGND.t424 VPWR VPWR sg13_lv_pmos ad=0.19p pd=1.38u as=0 ps=0 w=1u l=1u
X1686 VGND.t16 sg13cmos5l_buf_8_0.A a_11355_11458# VGND.t15 sg13_lv_nmos ad=0.1406p pd=1.12u as=0.2553p ps=2.17u w=0.74u l=0.13u
X1687 VGND.t1 sg13cmos5l_dfrbpq_1_5.RESET_B a_11990_9955# VGND.t37 sg13_lv_nmos ad=0.1701p pd=1.65u as=37.8f ps=0.6u w=0.42u l=0.13u
X1688 a_5220_9955# a_4932_10260# a_5158_9955# VGND.t1037 sg13_lv_nmos ad=0.1428p pd=1.52u as=37.8f ps=0.6u w=0.42u l=0.13u
X1689 VGND.t484 VPWR VGND.t484 VGND.t503 sg13_lv_nmos ad=79.8f pd=0.8u as=0 ps=0 w=0.42u l=1u
X1690 a_10702_9942# a_10943_10212# a_10231_9906# VGND.t944 sg13_lv_nmos ad=0.1428p pd=1.52u as=0.12665p ps=1.145u w=0.42u l=0.13u
X1691 a_6778_12180# sg13cmos5l_nand2_1_1.A VPWR VPWR sg13_lv_pmos ad=0.1428p pd=1.52u as=0.1523p ps=1.38u w=0.42u l=0.13u
X1692 VPWR VGND.t1 VPWR VPWR sg13_lv_pmos ad=0.34p pd=2.68u as=0 ps=0 w=1u l=1u
X1693 VGND.t747 VPWR VGND.t747 VGND.t759 sg13_lv_nmos ad=0.1428p pd=1.52u as=0 ps=0 w=0.42u l=1u
X1694 VGND.t342 VPWR VGND.t96 VGND.t341 sg13_lv_nmos ad=0.1428p pd=1.52u as=0 ps=0 w=0.42u l=1u
X1695 VPWR VGND.t608 VPWR VPWR sg13_lv_pmos ad=0.34p pd=2.68u as=0 ps=0 w=1u l=1u
X1696 VPWR VGND.t484 VPWR VPWR sg13_lv_pmos ad=0.19p pd=1.38u as=0 ps=0 w=1u l=1u
X1697 VGND.t260 VPWR VGND.t260 VGND.t281 sg13_lv_nmos ad=0.1428p pd=1.52u as=0 ps=0 w=0.42u l=1u
X1698 VGND.t333 VPWR VGND.t333 VGND.t350 sg13_lv_nmos ad=0.1428p pd=1.52u as=0 ps=0 w=0.42u l=1u
X1699 VGND.t747 VPWR VGND.t747 VGND.t773 sg13_lv_nmos ad=79.8f pd=0.8u as=0 ps=0 w=0.42u l=1u
X1700 VGND.t572 VPWR VGND.t572 VGND.t588 sg13_lv_nmos ad=0.1428p pd=1.52u as=0 ps=0 w=0.42u l=1u
X1701 VPWR VGND.t484 VPWR VPWR sg13_lv_pmos ad=0.19p pd=1.38u as=0 ps=0 w=1u l=1u
X1702 VGND.t745 VPWR VGND.t747 VGND.t746 sg13_lv_nmos ad=79.8f pd=0.8u as=0 ps=0 w=0.42u l=1u
X1703 VGND.t867 VPWR VGND.t869 VGND.t868 sg13_lv_nmos ad=79.8f pd=0.8u as=0 ps=0 w=0.42u l=1u
X1704 VPWR VGND.t747 VPWR VPWR sg13_lv_pmos ad=0.19p pd=1.38u as=0 ps=0 w=1u l=1u
X1705 VPWR VGND.t572 VPWR VPWR sg13_lv_pmos ad=0.34p pd=2.68u as=0 ps=0 w=1u l=1u
X1706 VPWR VGND.t87 VPWR VPWR sg13_lv_pmos ad=0.34p pd=2.68u as=0 ps=0 w=1u l=1u
X1707 VPWR VGND.t260 VPWR VPWR sg13_lv_pmos ad=0.34p pd=2.68u as=0 ps=0 w=1u l=1u
X1708 VGND.t133 sg13cmos5l_xnor2_1_0.B a_3810_12974# VGND.t141 sg13_lv_nmos ad=0.2886p pd=2.26u as=0.1406p ps=1.12u w=0.74u l=0.13u
X1709 VPWR sg13cmos5l_dfrbpq_1_4.RESET_B a_8746_13189# VPWR sg13_lv_pmos ad=0.1563p pd=1.22u as=0.147p ps=1.54u w=0.42u l=0.13u
X1710 VGND.t676 VPWR VGND.t676 VGND.t86 sg13_lv_nmos ad=79.8f pd=0.8u as=0 ps=0 w=0.42u l=1u
X1711 VPWR VGND.t572 VPWR VPWR sg13_lv_pmos ad=0.34p pd=2.68u as=0 ps=0 w=1u l=1u
X1712 a_9232_10162# a_8975_10019# a_9394_9942# VGND.t60 sg13_lv_nmos ad=0.1428p pd=1.52u as=37.8f ps=0.6u w=0.42u l=0.13u
X1713 VPWR VGND.t676 VPWR VPWR sg13_lv_pmos ad=0.19p pd=1.38u as=0 ps=0 w=1u l=1u
X1714 VPWR VGND.t484 VPWR VPWR sg13_lv_pmos ad=0.19p pd=1.38u as=0 ps=0 w=1u l=1u
X1715 a_10702_12654# a_10444_12654# VGND.t10 VGND.t105 sg13_lv_nmos ad=0.1428p pd=1.52u as=79.8f ps=0.8u w=0.42u l=0.13u
X1716 a_10112_12503# a_10231_12180# VPWR VPWR sg13_lv_pmos ad=0.3864p pd=2.93u as=0.2128p ps=1.5u w=1.12u l=0.13u
X1717 VGND.t2 sg13cmos5l_tiehi_0.L_HI a_3684_11142# VGND.t952 sg13_lv_nmos ad=0.1626p pd=1.415u as=60.89999f ps=0.71u w=0.42u l=0.13u
X1718 VPWR a_6191_10019# a_6448_10162# VPWR sg13_lv_pmos ad=1.38282p pd=8.655u as=79.8f ps=0.8u w=0.42u l=0.13u
X1719 a_11171_13997# sg13cmos5l_inv_1_1.A VGND.t71 VGND.t70 sg13_lv_nmos ad=0.198p pd=1.27u as=0.13395p ps=1.12u w=0.55u l=0.13u
X1720 VGND.t752 VPWR VGND.t752 VGND.t753 sg13_lv_nmos ad=0.1428p pd=1.52u as=0 ps=0 w=0.42u l=1u
X1721 VGND.t783 VPWR VGND.t783 VGND.t785 sg13_lv_nmos ad=79.8f pd=0.8u as=0 ps=0 w=0.42u l=1u
X1722 VGND.t613 VPWR VGND.t613 VGND.t616 sg13_lv_nmos ad=0.1428p pd=1.52u as=0 ps=0 w=0.42u l=1u
X1723 VPWR VGND.t765 VPWR VPWR sg13_lv_pmos ad=0.34p pd=2.68u as=0 ps=0 w=1u l=1u
X1724 VGND.t372 VPWR VGND.t371 VGND.t370 sg13_lv_nmos ad=0.1428p pd=1.52u as=0 ps=0 w=0.42u l=1u
X1725 VGND.t18 sg13cmos5l_dfrbpq_1_6.RESET_B a_11990_12641# VGND.t149 sg13_lv_nmos ad=0.1701p pd=1.65u as=37.8f ps=0.6u w=0.42u l=0.13u
X1726 VPWR VGND.t696 VPWR VPWR sg13_lv_pmos ad=0.19p pd=1.38u as=0 ps=0 w=1u l=1u
X1727 VGND.t608 VPWR VGND.t608 VGND.t609 sg13_lv_nmos ad=0.1428p pd=1.52u as=0 ps=0 w=0.42u l=1u
X1728 a_8681_9530# a_8805_9229# VPWR VPWR sg13_lv_pmos ad=0.2442p pd=2.06u as=11.27927p ps=73.965u w=0.66u l=0.13u
X1729 VPWR VGND.t891 VPWR VPWR sg13_lv_pmos ad=0.34p pd=2.68u as=0 ps=0 w=1u l=1u
X1730 sg13cmos5l_dlygate4sd3_1_12.X a_11190_10728# VPWR VPWR sg13_lv_pmos ad=0.4256p pd=3u as=0.2254p ps=1.53u w=1.12u l=0.13u
X1731 VPWR VGND.t747 VPWR VPWR sg13_lv_pmos ad=0.19p pd=1.38u as=0 ps=0 w=1u l=1u
X1732 VPWR VGND.t613 VPWR VPWR sg13_lv_pmos ad=0.34p pd=2.68u as=0 ps=0 w=1u l=1u
X1733 sg13cmos5l_a21oi_1_0.B1 sg13cmos5l_buf_1_1.X VPWR VPWR sg13_lv_pmos ad=0.3808p pd=2.92u as=0.3808p ps=2.92u w=1.12u l=0.13u
X1734 a_12022_12962# sg13cmos5l_nor3_2_0.C VGND.t18 VGND.t113 sg13_lv_nmos ad=0.1406p pd=1.12u as=0.1406p ps=1.12u w=0.74u l=0.15u
X1735 VPWR VGND.t484 VPWR VPWR sg13_lv_pmos ad=0.19p pd=1.38u as=0 ps=0 w=1u l=1u
X1736 VGND.t237 sg13cmos5l_dfrbpq_1_2.Q a_2920_14516# VGND.t1022 sg13_lv_nmos ad=0.14875p pd=1.16u as=0.187p ps=1.78u w=0.55u l=0.13u
X1737 VGND.t747 VPWR VGND.t747 VGND.t760 sg13_lv_nmos ad=79.8f pd=0.8u as=0 ps=0 w=0.42u l=1u
X1738 VGND.t852 VPWR VGND.t851 VGND.t850 sg13_lv_nmos ad=0.1428p pd=1.52u as=0 ps=0 w=0.42u l=1u
X1739 VPWR VGND.t672 VPWR VPWR sg13_lv_pmos ad=0.19p pd=1.38u as=0 ps=0 w=1u l=1u
X1740 VPWR VGND.t676 VPWR VPWR sg13_lv_pmos ad=0.19p pd=1.38u as=0 ps=0 w=1u l=1u
X1741 sg13cmos5l_dfrbpq_1_0.Q a_6858_10240# VPWR VPWR sg13_lv_pmos ad=0.3808p pd=2.92u as=0.2128p ps=1.5u w=1.12u l=0.13u
X1742 VPWR VGND.t747 VPWR VPWR sg13_lv_pmos ad=0.19p pd=1.38u as=0 ps=0 w=1u l=1u
X1743 VGND.t778 VPWR VGND.t778 VGND.t779 sg13_lv_nmos ad=0.1428p pd=1.52u as=0 ps=0 w=0.42u l=1u
X1744 VGND.t747 VPWR VGND.t747 VGND.t772 sg13_lv_nmos ad=0.1428p pd=1.52u as=0 ps=0 w=0.42u l=1u
X1745 sg13cmos5l_nand2_1_1.Y sg13cmos5l_dfrbpq_1_0.Q VPWR VPWR sg13_lv_pmos ad=0.2128p pd=1.5u as=0.3808p ps=2.92u w=1.12u l=0.13u
X1746 VPWR VGND.t295 VPWR VPWR sg13_lv_pmos ad=0.34p pd=2.68u as=0 ps=0 w=1u l=1u
X1747 VGND.t18 VPWR VGND.t260 VGND.t280 sg13_lv_nmos ad=79.8f pd=0.8u as=0 ps=0 w=0.42u l=1u
X1748 VPWR a_6575_13043# a_7242_13264# VPWR sg13_lv_pmos ad=0.2128p pd=1.5u as=0.3864p ps=2.93u w=1.12u l=0.13u
X1749 a_8018_12582# sg13cmos5l_dfrbpq_1_0.Q VGND.t940 VGND.t135 sg13_lv_nmos ad=0.1406p pd=1.12u as=0.2886p ps=2.26u w=0.74u l=0.13u
X1750 VPWR VGND.t747 VPWR VPWR sg13_lv_pmos ad=0.34p pd=2.68u as=0 ps=0 w=1u l=1u
X1751 VGND.t747 VPWR VGND.t778 VGND.t777 sg13_lv_nmos ad=79.8f pd=0.8u as=0 ps=0 w=0.42u l=1u
X1752 a_1775_11074# a_1740_10970# sg13cmos5l_nor2_1_0.B VGND.t25 sg13_lv_nmos ad=0.1406p pd=1.12u as=0.2516p ps=2.16u w=0.74u l=0.13u
X1753 VPWR VGND.t1 VPWR VPWR sg13_lv_pmos ad=0.34p pd=2.68u as=0 ps=0 w=1u l=1u
X1754 VPWR VGND.t224 VPWR VPWR sg13_lv_pmos ad=0.34p pd=2.68u as=0 ps=0 w=1u l=1u
X1755 VGND.t676 VPWR VGND.t684 VGND.t86 sg13_lv_nmos ad=79.8f pd=0.8u as=0 ps=0 w=0.42u l=1u
X1756 VGND.t872 VPWR VGND.t874 VGND.t873 sg13_lv_nmos ad=79.8f pd=0.8u as=0 ps=0 w=0.42u l=1u
X1757 VPWR VGND.t572 VPWR VPWR sg13_lv_pmos ad=0.34p pd=2.68u as=0 ps=0 w=1u l=1u
X1758 VPWR VGND.t676 VPWR VPWR sg13_lv_pmos ad=0.19p pd=1.38u as=0 ps=0 w=1u l=1u
X1759 VPWR VGND.t484 VPWR VPWR sg13_lv_pmos ad=0.19p pd=1.38u as=0 ps=0 w=1u l=1u
X1760 VPWR VGND.t521 VPWR VPWR sg13_lv_pmos ad=0.19p pd=1.38u as=0 ps=0 w=1u l=1u
X1761 VGND.t53 a_8218_9156# a_7937_9458# VGND.t47 sg13_lv_nmos ad=79.8f pd=0.8u as=0.1428p ps=1.52u w=0.42u l=0.5u
X1762 VGND.t200 a_4085_14482# sg13cmos5l_xor2_1_2.B VGND.t1018 sg13_lv_nmos ad=0.2516p pd=2.16u as=0.1406p ps=1.12u w=0.74u l=0.13u
X1763 VPWR VGND.t484 VPWR VPWR sg13_lv_pmos ad=0.34p pd=2.68u as=0 ps=0 w=1u l=1u
X1764 VGND.t752 VPWR VGND.t752 VGND.t755 sg13_lv_nmos ad=0.1428p pd=1.52u as=0 ps=0 w=0.42u l=1u
X1765 VGND.t783 VPWR VGND.t788 VGND.t787 sg13_lv_nmos ad=79.8f pd=0.8u as=0 ps=0 w=0.42u l=1u
X1766 VGND.t572 VPWR VGND.t572 VGND.t601 sg13_lv_nmos ad=0.1428p pd=1.52u as=0 ps=0 w=0.42u l=1u
X1767 VPWR a_8602_9433# sg13cmos5l_tiehi_5.L_HI VPWR sg13_lv_pmos ad=11.27927p pd=73.965u as=0.3927p ps=2.99u w=1.155u l=0.13u
X1768 VGND.t2 a_4426_11422# sg13cmos5l_dfrbpq_1_0.CLK VGND.t1121 sg13_lv_nmos ad=0.1406p pd=1.12u as=0.1406p ps=1.12u w=0.74u l=0.13u
X1769 VGND.t696 VPWR VGND.t700 VGND.t86 sg13_lv_nmos ad=79.8f pd=0.8u as=0 ps=0 w=0.42u l=1u
X1770 VPWR VGND.t752 VPWR VPWR sg13_lv_pmos ad=0.34p pd=2.68u as=0 ps=0 w=1u l=1u
X1771 VPWR VGND.t603 VPWR VPWR sg13_lv_pmos ad=0.34p pd=2.68u as=0 ps=0 w=1u l=1u
X1772 a_5326_13995# a_5441_13994# VPWR VPWR sg13_lv_pmos ad=0.34p pd=2.68u as=0.2254p ps=1.53u w=1u l=0.5u
X1773 VPWR VGND.t484 VPWR VPWR sg13_lv_pmos ad=0.19p pd=1.38u as=0 ps=0 w=1u l=1u
X1774 VPWR VGND.t696 VPWR VPWR sg13_lv_pmos ad=0.19p pd=1.38u as=0 ps=0 w=1u l=1u
X1775 VPWR a_8782_13995# sg13cmos5l_dfrbpq_1_4.D VPWR sg13_lv_pmos ad=0.2254p pd=1.53u as=0.4256p ps=3u w=1.12u l=0.13u
X1776 VPWR a_8091_11458# sg13cmos5l_buf_8_0.A VPWR sg13_lv_pmos ad=0.2128p pd=1.5u as=0.2128p ps=1.5u w=1.12u l=0.13u
X1777 VGND.t302 VPWR VGND.t302 VGND.t2 sg13_lv_nmos ad=79.8f pd=0.8u as=0 ps=0 w=0.42u l=1u
X1778 VGND.t405 VPWR VGND.t410 VGND.t456 sg13_lv_nmos ad=79.8f pd=0.8u as=0 ps=0 w=0.42u l=1u
X1779 VGND.t18 VPWR VGND.t18 VGND.t257 sg13_lv_nmos ad=79.8f pd=0.8u as=0 ps=0 w=0.42u l=1u
X1780 VPWR VGND.t484 VPWR VPWR sg13_lv_pmos ad=0.19p pd=1.38u as=0 ps=0 w=1u l=1u
X1781 VPWR VGND.t688 VPWR VPWR sg13_lv_pmos ad=0.34p pd=2.68u as=0 ps=0 w=1u l=1u
X1782 VPWR VGND.t747 VPWR VPWR sg13_lv_pmos ad=0.19p pd=1.38u as=0 ps=0 w=1u l=1u
X1783 VGND.t36 VPWR VGND.t378 VGND.t377 sg13_lv_nmos ad=0.1428p pd=1.52u as=0 ps=0 w=0.42u l=1u
X1784 a_7918_10971# a_8033_10970# VPWR VPWR sg13_lv_pmos ad=0.34p pd=2.68u as=0.2254p ps=1.53u w=1u l=0.5u
X1785 a_4932_10260# a_4906_10165# VPWR VPWR sg13_lv_pmos ad=0.34p pd=2.68u as=0.36237p ps=2.605u w=1u l=0.13u
X1786 VGND.t688 VPWR VGND.t688 VGND.t86 sg13_lv_nmos ad=79.8f pd=0.8u as=0 ps=0 w=0.42u l=1u
X1787 VPWR VGND.t613 VPWR VPWR sg13_lv_pmos ad=0.34p pd=2.68u as=0 ps=0 w=1u l=1u
X1788 VPWR sg13cmos5l_tiehi_5.L_HI a_7430_9942# VPWR sg13_lv_pmos ad=0.36237p pd=2.605u as=79.8f ps=0.8u w=0.42u l=0.13u
X1789 a_6682_10668# sg13cmos5l_dfrbpq_1_0.Q VPWR VPWR sg13_lv_pmos ad=0.1428p pd=1.52u as=0.1523p ps=1.38u w=0.42u l=0.13u
X1790 VPWR VGND.t676 VPWR VPWR sg13_lv_pmos ad=0.19p pd=1.38u as=0 ps=0 w=1u l=1u
X1791 VPWR VGND.t484 VPWR VPWR sg13_lv_pmos ad=0.19p pd=1.38u as=0 ps=0 w=1u l=1u
X1792 VPWR clk_i a_8091_11458# VPWR sg13_lv_pmos ad=0.2128p pd=1.5u as=0.2128p ps=1.5u w=1.12u l=0.13u
X1793 VPWR VGND.t684 VPWR VPWR sg13_lv_pmos ad=0.19p pd=1.38u as=0 ps=0 w=1u l=1u
X1794 VPWR a_11355_11458# sg13cmos5l_dfrbpq_1_7.CLK VPWR sg13_lv_pmos ad=0.2128p pd=1.5u as=0.2128p ps=1.5u w=1.12u l=0.13u
X1795 a_12038_13728# a_11768_13769# VPWR VPWR sg13_lv_pmos ad=0.34p pd=2.68u as=0.1523p ps=1.38u w=1u l=0.5u
X1796 VGND.t778 VPWR VGND.t778 VGND.t781 sg13_lv_nmos ad=0.1428p pd=1.52u as=0 ps=0 w=0.42u l=1u
X1797 VGND.t747 VPWR VGND.t747 VGND.t774 sg13_lv_nmos ad=0.1428p pd=1.52u as=0 ps=0 w=0.42u l=1u
X1798 VPWR VGND.t200 VPWR VPWR sg13_lv_pmos ad=0.19p pd=1.38u as=0 ps=0 w=1u l=1u
X1799 a_4174_13155# a_4289_13156# VGND.t133 VGND.t173 sg13_lv_nmos ad=0.1428p pd=1.52u as=0.1426p ps=1.16u w=0.42u l=0.5u
X1800 VPWR sg13cmos5l_dfrbpq_1_5.RESET_B a_10444_9942# VPWR sg13_lv_pmos ad=1.38282p pd=8.655u as=79.8f ps=0.8u w=0.42u l=0.13u
X1801 VPWR VGND.t778 VPWR VPWR sg13_lv_pmos ad=0.34p pd=2.68u as=0 ps=0 w=1u l=1u
X1802 VPWR VGND.t752 VPWR VPWR sg13_lv_pmos ad=0.19p pd=1.38u as=0 ps=0 w=1u l=1u
X1803 VPWR VGND.t395 VPWR VPWR sg13_lv_pmos ad=0.19p pd=1.38u as=0 ps=0 w=1u l=1u
X1804 a_11733_12263# sg13cmos5l_dfrbpq_1_6.RESET_B VPWR VPWR sg13_lv_pmos ad=0.147p pd=1.54u as=0.1563p ps=1.22u w=0.42u l=0.13u
X1805 VGND.t59 VPWR VGND.t59 VGND.t209 sg13_lv_nmos ad=79.8f pd=0.8u as=0 ps=0 w=0.42u l=1u
X1806 a_6286_10971# a_6401_10970# VPWR VPWR sg13_lv_pmos ad=0.34p pd=2.68u as=0.2254p ps=1.53u w=1u l=0.5u
X1807 VGND.t778 VPWR VGND.t778 VGND.t780 sg13_lv_nmos ad=79.8f pd=0.8u as=0 ps=0 w=0.42u l=1u
X1808 a_5392_10946# sg13cmos5l_tiehi_0.L_HI VPWR VPWR sg13_lv_pmos ad=79.8f pd=0.8u as=1.38282p ps=8.655u w=0.42u l=0.13u
X1809 VPWR VGND.t700 VPWR VPWR sg13_lv_pmos ad=0.19p pd=1.38u as=0 ps=0 w=1u l=1u
X1810 VGND.t684 VPWR VGND.t684 VGND.t86 sg13_lv_nmos ad=79.8f pd=0.8u as=0 ps=0 w=0.42u l=1u
X1811 VPWR VGND.t921 VPWR VPWR sg13_lv_pmos ad=0.34p pd=2.68u as=0 ps=0 w=1u l=1u
X1812 VGND.t200 sg13cmos5l_dlygate4sd3_1_1.X a_3798_14086# VGND.t974 sg13_lv_nmos ad=0.15245p pd=1.17u as=88.8f ps=0.98u w=0.74u l=0.13u
X1813 VGND.t400 VPWR VGND.t400 VGND.t450 sg13_lv_nmos ad=79.8f pd=0.8u as=0 ps=0 w=0.42u l=1u
X1814 VGND.t133 a_4174_13155# sg13cmos5l_xnor2_1_0.B VGND.t996 sg13_lv_nmos ad=0.1426p pd=1.16u as=0.2516p ps=2.16u w=0.74u l=0.13u
X1815 VGND.t329 VPWR VGND.t328 VGND.t327 sg13_lv_nmos ad=0.1428p pd=1.52u as=0 ps=0 w=0.42u l=1u
X1816 a_9189_12945# sg13cmos5l_dfrbpq_1_7.CLK VGND.t31 VGND.t65 sg13_lv_nmos ad=0.2516p pd=2.16u as=3.92842p ps=25.025u w=0.74u l=0.13u
X1817 VGND.t765 VPWR VGND.t765 VGND.t768 sg13_lv_nmos ad=0.1428p pd=1.52u as=0 ps=0 w=0.42u l=1u
X1818 VPWR sg13cmos5l_buf_8_0.A a_11355_11458# VPWR sg13_lv_pmos ad=0.2128p pd=1.5u as=0.3808p ps=2.92u w=1.12u l=0.13u
X1819 sg13cmos5l_dlygate4sd3_1_8.A sg13cmos5l_a21oi_1_0.B1 a_8213_13728# VPWR sg13_lv_pmos ad=0.3808p pd=2.92u as=0.2128p ps=1.5u w=1.12u l=0.13u
X1820 VPWR VGND.t484 VPWR VPWR sg13_lv_pmos ad=0.34p pd=2.68u as=0 ps=0 w=1u l=1u
X1821 VPWR VGND.t676 VPWR VPWR sg13_lv_pmos ad=0.34p pd=2.68u as=0 ps=0 w=1u l=1u
X1822 VGND.t747 VPWR VGND.t747 VGND.t757 sg13_lv_nmos ad=0.1428p pd=1.52u as=0 ps=0 w=0.42u l=1u
X1823 VPWR VGND.t305 VPWR VPWR sg13_lv_pmos ad=0.19p pd=1.38u as=0 ps=0 w=1u l=1u
X1824 VGND.t62 a_9232_10162# a_8881_10019# VGND.t110 sg13_lv_nmos ad=79.8f pd=0.8u as=0.1428p ps=1.52u w=0.42u l=0.13u
X1825 VPWR VGND.t752 VPWR VPWR sg13_lv_pmos ad=0.34p pd=2.68u as=0 ps=0 w=1u l=1u
X1826 VPWR VGND.t572 VPWR VPWR sg13_lv_pmos ad=0.19p pd=1.38u as=0 ps=0 w=1u l=1u
X1827 VPWR VGND.t484 VPWR VPWR sg13_lv_pmos ad=0.19p pd=1.38u as=0 ps=0 w=1u l=1u
X1828 a_10233_13281# a_9291_13088# a_10031_13043# VPWR sg13_lv_pmos ad=93.45f pd=0.865u as=0.2048p ps=1.63u w=0.42u l=0.13u
X1829 VPWR VGND.t688 VPWR VPWR sg13_lv_pmos ad=0.19p pd=1.38u as=0 ps=0 w=1u l=1u
X1830 VPWR a_10112_10117# sg13cmos5l_dfrbpq_1_5.Q VPWR sg13_lv_pmos ad=0.2128p pd=1.5u as=0.3808p ps=2.92u w=1.12u l=0.13u
X1831 VGND.t783 VPWR VGND.t783 VGND.t786 sg13_lv_nmos ad=0.1428p pd=1.52u as=0 ps=0 w=0.42u l=1u
X1832 a_3684_11142# sg13cmos5l_nor2_1_0.Y a_3590_11142# VGND.t33 sg13_lv_nmos ad=60.89999f pd=0.71u as=0.1428p ps=1.52u w=0.42u l=0.13u
X1833 VPWR VGND.t676 VPWR VPWR sg13_lv_pmos ad=0.19p pd=1.38u as=0 ps=0 w=1u l=1u
X1834 VGND.t410 VPWR VGND.t410 VGND.t458 sg13_lv_nmos ad=79.8f pd=0.8u as=0 ps=0 w=0.42u l=1u
X1835 a_4164_12641# a_3876_12220# a_4102_12641# VGND.t947 sg13_lv_nmos ad=0.1428p pd=1.52u as=37.8f ps=0.6u w=0.42u l=0.13u
X1836 sg13cmos5l_mux2_1_0.S sg13cmos5l_nor3_2_0.C VGND.t16 VGND.t15 sg13_lv_nmos ad=0.1406p pd=1.12u as=0.1406p ps=1.12u w=0.74u l=0.13u
X1837 a_5162_14776# sg13cmos5l_a21oi_1_0.B1 VPWR VPWR sg13_lv_pmos ad=0.1176p pd=1.33u as=0.4032p ps=2.96u w=1.12u l=0.13u
X1838 VPWR sg13cmos5l_xor2_1_2.A a_3932_11752# VPWR sg13_lv_pmos ad=0.2128p pd=1.5u as=0.3808p ps=2.92u w=1.12u l=0.13u
X1839 a_7849_12970# sg13cmos5l_xor2_1_2.B VGND.t940 VGND.t43 sg13_lv_nmos ad=0.198p pd=1.27u as=0.1045p ps=0.93u w=0.55u l=0.13u
X1840 VPWR VGND.t484 VPWR VPWR sg13_lv_pmos ad=0.34p pd=2.68u as=0 ps=0 w=1u l=1u
X1841 VPWR a_14828_14442# count_o[7] VPWR sg13_lv_pmos ad=0.2114p pd=1.54u as=0.42p ps=2.99u w=1.12u l=0.13u
X1842 a_6382_12483# a_6497_12482# VGND.t164 VGND.t135 sg13_lv_nmos ad=0.1428p pd=1.52u as=0.1426p ps=1.16u w=0.42u l=0.5u
X1843 a_7318_11450# sg13cmos5l_nand2_1_1.Y VGND.t7 VGND.t15 sg13_lv_nmos ad=0.1406p pd=1.12u as=0.1406p ps=1.12u w=0.74u l=0.15u
X1844 VPWR VGND.t255 VPWR VPWR sg13_lv_pmos ad=0.19p pd=1.38u as=0 ps=0 w=1u l=1u
X1845 VGND.t250 VPWR VGND.t12 VGND.t251 sg13_lv_nmos ad=79.8f pd=0.8u as=0 ps=0 w=0.42u l=1u
X1846 VGND.t260 VPWR VGND.t260 VGND.t282 sg13_lv_nmos ad=79.8f pd=0.8u as=0 ps=0 w=0.42u l=1u
X1847 VGND.t688 VPWR VGND.t696 VGND.t86 sg13_lv_nmos ad=79.8f pd=0.8u as=0 ps=0 w=0.42u l=1u
X1848 VPWR VGND.t572 VPWR VPWR sg13_lv_pmos ad=0.34p pd=2.68u as=0 ps=0 w=1u l=1u
X1849 a_5349_9921# sg13cmos5l_dfrbpq_1_0.CLK VPWR VPWR sg13_lv_pmos ad=0.4088p pd=2.97u as=1.3227p ps=8.28u w=1.12u l=0.13u
X1850 VPWR VGND.t684 VPWR VPWR sg13_lv_pmos ad=0.19p pd=1.38u as=0 ps=0 w=1u l=1u
X1851 VPWR VGND.t521 VPWR VPWR sg13_lv_pmos ad=0.19p pd=1.38u as=0 ps=0 w=1u l=1u
X1852 VGND.t484 VPWR VGND.t484 VGND.t518 sg13_lv_nmos ad=0.1428p pd=1.52u as=0 ps=0 w=0.42u l=1u
X1853 VPWR VGND.t484 VPWR VPWR sg13_lv_pmos ad=0.34p pd=2.68u as=0 ps=0 w=1u l=1u
X1854 VPWR VGND.t269 VPWR VPWR sg13_lv_pmos ad=0.34p pd=2.68u as=0 ps=0 w=1u l=1u
X1855 VGND.t747 VPWR VGND.t747 VGND.t761 sg13_lv_nmos ad=0.1428p pd=1.52u as=0 ps=0 w=0.42u l=1u
X1856 VGND.t747 VPWR VGND.t747 VGND.t750 sg13_lv_nmos ad=0.1428p pd=1.52u as=0 ps=0 w=0.42u l=1u
X1857 VPWR VGND.t747 VPWR VPWR sg13_lv_pmos ad=0.34p pd=2.68u as=0 ps=0 w=1u l=1u
X1858 VPWR VGND.t765 VPWR VPWR sg13_lv_pmos ad=0.34p pd=2.68u as=0 ps=0 w=1u l=1u
X1859 VGND.t36 sg13cmos5l_mux2_1_0.S a_11195_9248# VGND.t1116 sg13_lv_nmos ad=0.18945p pd=1.27u as=0.187p ps=1.78u w=0.55u l=0.13u
X1860 VGND.t672 VPWR VGND.t672 VGND.t86 sg13_lv_nmos ad=79.8f pd=0.8u as=0 ps=0 w=0.42u l=1u
X1861 VGND.t400 VPWR VGND.t405 VGND.t452 sg13_lv_nmos ad=79.8f pd=0.8u as=0 ps=0 w=0.42u l=1u
X1862 a_6777_13281# a_5835_13088# a_6575_13043# VPWR sg13_lv_pmos ad=93.45f pd=0.865u as=0.2048p ps=1.63u w=0.42u l=0.13u
X1863 VGND.t747 VPWR VGND.t747 VGND.t770 sg13_lv_nmos ad=0.1428p pd=1.52u as=0 ps=0 w=0.42u l=1u
X1864 sg13cmos5l_tiehi_0.L_HI a_2238_10194# VPWR VPWR sg13_lv_pmos ad=0.3927p pd=2.99u as=1.38282p ps=8.655u w=1.155u l=0.13u
X1865 VGND.t684 VPWR VGND.t684 VGND.t86 sg13_lv_nmos ad=0.1428p pd=1.52u as=0 ps=0 w=0.42u l=1u
X1866 VPWR VGND.t484 VPWR VPWR sg13_lv_pmos ad=0.34p pd=2.68u as=0 ps=0 w=1u l=1u
X1867 VPWR VGND.t684 VPWR VPWR sg13_lv_pmos ad=0.34p pd=2.68u as=0 ps=0 w=1u l=1u
X1868 VGND.t71 sg13cmos5l_a21oi_1_1.A2 a_10817_14076# VGND.t988 sg13_lv_nmos ad=0.2516p pd=2.16u as=0.1406p ps=1.12u w=0.74u l=0.13u
X1869 VPWR VGND.t747 VPWR VPWR sg13_lv_pmos ad=0.34p pd=2.68u as=0 ps=0 w=1u l=1u
X1870 VGND.t688 VPWR VGND.t688 VGND.t86 sg13_lv_nmos ad=79.8f pd=0.8u as=0 ps=0 w=0.42u l=1u
X1871 VPWR VGND.t688 VPWR VPWR sg13_lv_pmos ad=0.19p pd=1.38u as=0 ps=0 w=1u l=1u
X1872 VPWR VGND.t696 VPWR VPWR sg13_lv_pmos ad=0.19p pd=1.38u as=0 ps=0 w=1u l=1u
X1873 a_8746_13189# a_9189_12945# a_9129_13357# VPWR sg13_lv_pmos ad=79.8f pd=0.8u as=63f ps=0.72u w=0.42u l=0.13u
X1874 a_11733_10100# a_10791_10160# a_11594_10100# VGND.t167 sg13_lv_nmos ad=79.8f pd=0.8u as=0.2373p ps=1.97u w=0.42u l=0.13u
X1875 VGND.t788 VPWR VGND.t788 VGND.t789 sg13_lv_nmos ad=0.1428p pd=1.52u as=0 ps=0 w=0.42u l=1u
X1876 VGND.t139 sg13cmos5l_xnor2_1_0.B a_1775_11074# VGND.t138 sg13_lv_nmos ad=0.1898p pd=1.36u as=0.1406p ps=1.12u w=0.74u l=0.13u
X1877 VGND.t395 VPWR VGND.t395 VGND.t446 sg13_lv_nmos ad=79.8f pd=0.8u as=0 ps=0 w=0.42u l=1u
X1878 VPWR a_14074_9910# a_13793_10132# VPWR sg13_lv_pmos ad=0.1523p pd=1.38u as=0.34p ps=2.68u w=1u l=0.5u
X1879 VGND.t6 a_7822_9459# sg13cmos5l_dlygate4sd3_1_15.X VGND.t47 sg13_lv_nmos ad=0.1426p pd=1.16u as=0.2516p ps=2.16u w=0.74u l=0.13u
X1880 VGND.t872 VPWR VGND.t871 VGND.t870 sg13_lv_nmos ad=0.1428p pd=1.52u as=0 ps=0 w=0.42u l=1u
X1881 VPWR sg13cmos5l_dfrbpq_1_1.RESET_B a_5030_12966# VPWR sg13_lv_pmos ad=0.36237p pd=2.605u as=79.8f ps=0.8u w=0.42u l=0.13u
X1882 VPWR VGND.t747 VPWR VPWR sg13_lv_pmos ad=0.19p pd=1.38u as=0 ps=0 w=1u l=1u
X1883 sg13cmos5l_dfrbpq_1_4.Q a_10698_13264# VPWR VPWR sg13_lv_pmos ad=0.3808p pd=2.92u as=0.2128p ps=1.5u w=1.12u l=0.13u
X1884 a_1802_12216# sg13cmos5l_a21oi_1_0.B1 VPWR VPWR sg13_lv_pmos ad=0.1176p pd=1.33u as=0.4032p ps=2.96u w=1.12u l=0.13u
X1885 VPWR VGND.t438 VPWR VPWR sg13_lv_pmos ad=0.34p pd=2.68u as=0 ps=0 w=1u l=1u
X1886 VGND.t696 VPWR VGND.t696 VGND.t86 sg13_lv_nmos ad=79.8f pd=0.8u as=0 ps=0 w=0.42u l=1u
X1887 VPWR VGND.t747 VPWR VPWR sg13_lv_pmos ad=0.34p pd=2.68u as=0 ps=0 w=1u l=1u
X1888 VPWR VGND.t312 VPWR VPWR sg13_lv_pmos ad=0.34p pd=2.68u as=0 ps=0 w=1u l=1u
X1889 VPWR VGND.t672 VPWR VPWR sg13_lv_pmos ad=0.19p pd=1.38u as=0 ps=0 w=1u l=1u
X1890 count_o[6] a_11368_14516# VGND.t71 VGND.t1096 sg13_lv_nmos ad=0.2886p pd=2.26u as=0.14875p ps=1.16u w=0.74u l=0.13u
X1891 VPWR VGND.t521 VPWR VPWR sg13_lv_pmos ad=0.34p pd=2.68u as=0 ps=0 w=1u l=1u
X1892 VGND.t747 VPWR VGND.t747 VGND.t763 sg13_lv_nmos ad=0.1428p pd=1.52u as=0 ps=0 w=0.42u l=1u
X1893 VPWR a_8218_9156# a_7937_9458# VPWR sg13_lv_pmos ad=0.1523p pd=1.38u as=0.34p ps=2.68u w=1u l=0.5u
X1894 VGND.t71 a_12038_13728# a_12150_13752# VGND.t102 sg13_lv_nmos ad=0.1426p pd=1.16u as=0.1428p ps=1.52u w=0.42u l=0.5u
X1895 VGND.t892 VPWR VGND.t894 VGND.t893 sg13_lv_nmos ad=79.8f pd=0.8u as=0 ps=0 w=0.42u l=1u
X1896 VPWR VGND.t684 VPWR VPWR sg13_lv_pmos ad=0.34p pd=2.68u as=0 ps=0 w=1u l=1u
X1897 a_4094_13728# sg13cmos5l_nand4_1_0.Y a_3642_13691# VPWR sg13_lv_pmos ad=0.1225p pd=1.245u as=0.34p ps=2.68u w=1u l=0.13u
X1898 VPWR VGND.t747 VPWR VPWR sg13_lv_pmos ad=0.34p pd=2.68u as=0 ps=0 w=1u l=1u
X1899 VPWR a_4426_11422# sg13cmos5l_dfrbpq_1_0.CLK VPWR sg13_lv_pmos ad=0.2128p pd=1.5u as=0.2128p ps=1.5u w=1.12u l=0.13u
X1900 a_3761_11508# sg13cmos5l_xor2_1_2.B a_3729_11776# VPWR sg13_lv_pmos ad=0.34p pd=2.68u as=0.1225p ps=1.245u w=1u l=0.13u
X1901 VPWR VGND.t752 VPWR VPWR sg13_lv_pmos ad=0.34p pd=2.68u as=0 ps=0 w=1u l=1u
X1902 VPWR VGND.t688 VPWR VPWR sg13_lv_pmos ad=0.19p pd=1.38u as=0 ps=0 w=1u l=1u
X1903 a_4164_12641# a_4395_12227# a_3850_12184# VGND.t1112 sg13_lv_nmos ad=0.2373p pd=1.97u as=79.8f ps=0.8u w=0.42u l=0.13u
X1904 a_5135_11065# a_4293_10715# a_5041_11065# VGND.t2 sg13_lv_nmos ad=0.12665p pd=1.145u as=0.1428p ps=1.52u w=0.42u l=0.13u
X1905 VPWR sg13cmos5l_o21ai_1_0.B1 a_7373_10728# VPWR sg13_lv_pmos ad=0.3822p pd=1.84u as=0.1575p ps=1.315u w=1u l=0.13u
X1906 a_3590_12654# sg13cmos5l_nor2_1_1.Y VPWR VPWR sg13_lv_pmos ad=79.8f pd=0.8u as=0.1428p ps=1.52u w=0.42u l=0.13u
X1907 VGND.t23 a_5349_9921# a_5451_10064# VGND.t170 sg13_lv_nmos ad=2.99005p pd=19.165u as=0.2516p ps=2.16u w=0.74u l=0.13u
X1908 a_9232_10162# sg13cmos5l_tiehi_5.L_HI VPWR VPWR sg13_lv_pmos ad=79.8f pd=0.8u as=1.38282p ps=8.655u w=0.42u l=0.13u
X1909 VPWR VGND.t249 VPWR VPWR sg13_lv_pmos ad=0.34p pd=2.68u as=0 ps=0 w=1u l=1u
X1910 VGND.t684 VPWR VGND.t684 VGND.t86 sg13_lv_nmos ad=0.1428p pd=1.52u as=0 ps=0 w=0.42u l=1u
X1911 VPWR VGND.t484 VPWR VPWR sg13_lv_pmos ad=0.34p pd=2.68u as=0 ps=0 w=1u l=1u
X1912 VPWR VGND.t684 VPWR VPWR sg13_lv_pmos ad=0.34p pd=2.68u as=0 ps=0 w=1u l=1u
X1913 VGND.t484 VPWR VGND.t484 VGND.t518 sg13_lv_nmos ad=0.1428p pd=1.52u as=0 ps=0 w=0.42u l=1u
X1914 VGND.t688 VPWR VGND.t688 VGND.t86 sg13_lv_nmos ad=79.8f pd=0.8u as=0 ps=0 w=0.42u l=1u
X1915 a_9060_12979# a_8772_13284# a_8998_12979# VGND.t997 sg13_lv_nmos ad=0.1428p pd=1.52u as=37.8f ps=0.6u w=0.42u l=0.13u
X1916 a_11171_13997# sg13cmos5l_nor3_2_0.C a_11469_13752# VPWR sg13_lv_pmos ad=0.34p pd=2.68u as=0.19p ps=1.38u w=1u l=0.13u
X1917 VGND.t298 VPWR VGND.t28 VGND.t15 sg13_lv_nmos ad=0.1428p pd=1.52u as=0 ps=0 w=0.42u l=1u
X1918 VGND.t788 VPWR VGND.t788 VGND.t791 sg13_lv_nmos ad=0.1428p pd=1.52u as=0 ps=0 w=0.42u l=1u
X1919 VPWR VGND.t668 VPWR VPWR sg13_lv_pmos ad=0.19p pd=1.38u as=0 ps=0 w=1u l=1u
X1920 VGND.t395 VPWR VGND.t400 VGND.t448 sg13_lv_nmos ad=79.8f pd=0.8u as=0 ps=0 w=0.42u l=1u
R0 VGND.t32 VGND.n231 46775.5
R1 VGND.n146 VGND.n406 6727.13
R2 VGND.t86 VGND.n71 6300
R3 VGND.t86 VGND.n169 6300
R4 VGND.n408 VGND.n169 6300
R5 VGND.n408 VGND.n407 6300
R6 VGND.n407 VGND.n127 6300
R7 VGND.n127 VGND.n136 6300
R8 VGND.n136 VGND.n146 6300
R9 VGND.n232 VGND.t32 4262.19
R10 VGND.t850 VGND.n32 182.042
R11 VGND.t860 VGND.n32 182.042
R12 VGND.t873 VGND.n32 183.805
R13 VGND.n32 VGND.t885 182.042
R14 VGND.n32 VGND.t895 182.042
R15 VGND.t903 VGND.n32 183.805
R16 VGND.t913 VGND.n32 183.805
R17 VGND.n32 VGND.t918 183.805
R18 VGND.t923 VGND.n32 183.805
R19 VGND.n71 VGND.n32 6413.31
R20 VGND.t23 VGND.t384 109.644
R21 VGND.t60 VGND.t23 72.0407
R22 VGND.t1092 VGND.t59 42.0646
R23 VGND.n74 VGND.t994 92.4073
R24 VGND.t227 VGND.t59 109.986
R25 VGND.n77 VGND.t1009 423.127
R26 VGND.n41 VGND.t23 0.613873
R27 VGND.n55 VGND.t143 415.002
R28 VGND.n407 VGND.n175 411.43
R29 VGND.t23 VGND.n127 427.5
R30 VGND.t349 VGND.n91 242.846
R31 VGND.t381 VGND.n93 242.846
R32 VGND.t386 VGND.n86 242.846
R33 VGND.t117 VGND.n94 341.418
R34 VGND.n20 VGND.n136 427.132
R35 VGND.t287 VGND.t2 109.7
R36 VGND.n56 VGND.n146 427.5
R37 VGND.t230 VGND.n33 109.7
R38 VGND.t1022 VGND.n18 72.9428
R39 VGND.t1122 VGND.n371 408.31
R40 VGND.t835 VGND.n32 181.875
R41 VGND.t865 VGND.n32 182.042
R42 VGND.t875 VGND.n32 182.042
R43 VGND.n32 VGND.t890 182.042
R44 VGND.t935 VGND.n32 182.042
R45 VGND.n29 VGND.t1015 22.5529
R46 VGND.t1031 VGND.n195 402.858
R47 VGND.t1033 VGND.n396 402.858
R48 VGND.n358 VGND.t957 398.572
R49 VGND.n273 VGND.t166 398.572
R50 VGND.t101 VGND.n262 398.572
R51 VGND.t137 VGND.n228 398.572
R52 VGND.n37 VGND.t59 15.2045
R53 VGND.n395 VGND.t1084 397.132
R54 VGND.n197 VGND.t1035 394.286
R55 VGND.n398 VGND.t1086 394.286
R56 VGND.n32 VGND.t838 183.804
R57 VGND.n32 VGND.t843 183.805
R58 VGND.n32 VGND.t848 183.806
R59 VGND.t965 VGND.n42 386.502
R60 VGND.t958 VGND.n253 385.714
R61 VGND.t1079 VGND.n192 385.714
R62 VGND.n402 VGND.t70 385.714
R63 VGND.t146 VGND.n367 384.274
R64 VGND.t1047 VGND.n234 382.522
R65 VGND.t122 VGND.n227 381.43
R66 VGND.t1021 VGND.n182 381.43
R67 VGND.n200 VGND.t966 381.43
R68 VGND.n366 VGND.t138 377.144
R69 VGND.t1098 VGND.t1063 376.625
R70 VGND.n178 VGND.t1026 372.858
R71 VGND.t1039 VGND.n18 376.628
R72 VGND.n190 VGND.t1061 372.858
R73 VGND.t1020 VGND.n57 46.0351
R74 VGND.n400 VGND.t1041 372.858
R75 VGND.t141 VGND.n241 369.836
R76 VGND.n399 VGND.t988 368.572
R77 VGND.t114 VGND.n403 368.572
R78 VGND.n2 VGND.t944 367.135
R79 VGND.t39 VGND.n370 361.033
R80 VGND.n236 VGND.t30 361.033
R81 VGND.t1030 VGND.n252 355.714
R82 VGND.t1027 VGND.n21 57.4393
R83 VGND.n229 VGND.t1028 355.714
R84 VGND.t123 VGND.n226 355.714
R85 VGND.t960 VGND.n184 355.714
R86 VGND.n188 VGND.t1032 355.714
R87 VGND.t1120 VGND.n369 352.007
R88 VGND.t24 VGND.n268 351.43
R89 VGND.t92 VGND.n356 351.43
R90 VGND.t171 VGND.n261 351.43
R91 VGND.t25 VGND.n364 351.43
R92 VGND.t110 VGND.n269 347.144
R93 VGND.n272 VGND.t1111 347.144
R94 VGND.n265 VGND.t89 347.144
R95 VGND.t1075 VGND.n380 345.834
R96 VGND.n222 VGND.t48 341.668
R97 VGND.n58 VGND.t61 65.92
R98 VGND.n40 VGND.t23 13.0749
R99 VGND.t1018 VGND.n8 341.418
R100 VGND.t107 VGND.n355 338.572
R101 VGND.t982 VGND.n183 338.572
R102 VGND.n189 VGND.t126 338.572
R103 VGND.n198 VGND.t1023 338.572
R104 VGND.n199 VGND.t172 338.572
R105 VGND.t990 VGND.n191 338.572
R106 VGND.n404 VGND.t1093 338.572
R107 VGND.t992 VGND.n405 338.572
R108 VGND.t131 VGND.n224 337.5
R109 VGND.t853 VGND.n32 183.806
R110 VGND.t878 VGND.n32 183.806
R111 VGND.t898 VGND.n32 183.806
R112 VGND.t908 VGND.n32 183.806
R113 VGND.t928 VGND.n32 183.806
R114 VGND.t938 VGND.n32 183.806
R115 VGND.t19 VGND.n365 330
R116 VGND.t1038 VGND.n181 330
R117 VGND.n39 VGND.t963 72.5337
R118 VGND.t56 VGND.n255 329.168
R119 VGND.n382 VGND.t1000 329.168
R120 VGND.t996 VGND.n239 329.168
R121 VGND.n225 VGND.t74 329.168
R122 VGND.t1045 VGND.n17 328.56
R123 VGND.t1005 VGND.t1011 325
R124 VGND.t91 VGND.n278 320.834
R125 VGND.n375 VGND.t1119 320.834
R126 VGND.n83 VGND.t2 12.2561
R127 VGND.t31 VGND.t41 320.637
R128 VGND.t55 VGND.n47 319.99
R129 VGND.n27 VGND.t973 320.269
R130 VGND.n32 VGND.t930 182.042
R131 VGND.t920 VGND.n32 182.042
R132 VGND.n32 VGND.t915 182.042
R133 VGND.t910 VGND.n32 182.042
R134 VGND.n32 VGND.t905 182.042
R135 VGND.t900 VGND.n32 182.042
R136 VGND.n32 VGND.t893 183.805
R137 VGND.t888 VGND.n32 183.806
R138 VGND.t880 VGND.n32 182.042
R139 VGND.t870 VGND.n32 182.042
R140 VGND.t868 VGND.n32 183.806
R141 VGND.n32 VGND.t863 183.805
R142 VGND.n32 VGND.t855 182.042
R143 VGND.n32 VGND.t845 182.042
R144 VGND.t840 VGND.n32 182.042
R145 VGND.n32 VGND.t925 182.042
R146 VGND.t1034 VGND.n175 312.858
R147 VGND.t142 VGND.n362 312.858
R148 VGND.t1048 VGND.n177 312.858
R149 VGND.t1054 VGND.n179 312.858
R150 VGND.t991 VGND.t1085 312.858
R151 VGND.t1088 VGND.n402 312.858
R152 VGND.t978 VGND.t132 308.334
R153 VGND.n233 VGND.t1097 305.159
R154 VGND.t46 VGND.n208 305.159
R155 VGND.n360 VGND.t185 304.286
R156 VGND.n282 VGND.t157 304.286
R157 VGND.t998 VGND.n377 295.834
R158 VGND.n355 VGND.t26 291.43
R159 VGND.n189 VGND.t983 291.43
R160 VGND.n198 VGND.t1040 291.43
R161 VGND.n199 VGND.t987 291.43
R162 VGND.t67 VGND.n2 290.777
R163 VGND.t111 VGND.t13 287.144
R164 VGND.n230 VGND.t977 287.144
R165 VGND.n186 VGND.t974 287.144
R166 VGND.t1123 VGND.t15 283.668
R167 VGND.n10 VGND.t1060 281.418
R168 VGND.t1025 VGND.n16 281.418
R169 VGND.t181 VGND.n379 279.168
R170 VGND.n213 VGND.t113 279.168
R171 VGND.n274 VGND.t1117 275.072
R172 VGND.n374 VGND.t177 275.072
R173 VGND.t176 VGND.n233 275.072
R174 VGND.t66 VGND.n208 275.072
R175 VGND.t9 VGND.n49 274.2
R176 VGND.n8 VGND.t962 272.846
R177 VGND.t989 VGND.n17 272.846
R178 VGND.n275 VGND.t1115 266.046
R179 VGND.n91 VGND.t97 281.418
R180 VGND.t35 VGND.t118 265.714
R181 VGND.n14 VGND.t1071 260.269
R182 VGND.t1037 VGND.t1002 258.334
R183 VGND.n260 VGND.t169 258.334
R184 VGND.t946 VGND.n277 258.334
R185 VGND.t37 VGND.t85 258.334
R186 VGND.t951 VGND.t4 258.334
R187 VGND.t38 VGND.n376 258.334
R188 VGND.t1099 VGND.t947 258.334
R189 VGND.t174 VGND.n223 258.334
R190 VGND.n215 VGND.t1043 258.334
R191 VGND.t112 VGND.t149 258.334
R192 VGND.t1081 VGND.t997 258.334
R193 VGND.n386 VGND.t155 258.334
R194 VGND.t103 VGND.n236 257.88
R195 VGND.n86 VGND.t95 272.846
R196 VGND.t981 VGND.n179 257.144
R197 VGND.t1019 VGND.n193 257.144
R198 VGND.t129 VGND.t1051 252.857
R199 VGND.t747 VGND.t759 109.001
R200 VGND.t761 VGND.t747 109.001
R201 VGND.t747 VGND.t763 108.999
R202 VGND.t774 VGND.t747 109.001
R203 VGND.t747 VGND.t776 108.999
R204 VGND.t789 VGND.t747 109.001
R205 VGND.t747 VGND.t791 108.999
R206 VGND.t573 VGND.t572 109.001
R207 VGND.t578 VGND.t572 109.001
R208 VGND.t572 VGND.t588 108.999
R209 VGND.t591 VGND.t572 109.001
R210 VGND.t595 VGND.t572 109.001
R211 VGND.t572 VGND.t601 108.999
R212 VGND.t572 VGND.t606 108.999
R213 VGND.t609 VGND.t572 109.001
R214 VGND.t572 VGND.t611 108.999
R215 VGND.t484 VGND.t488 109.001
R216 VGND.t490 VGND.t484 109.001
R217 VGND.t484 VGND.t500 108.999
R218 VGND.t502 VGND.t484 109.001
R219 VGND.t484 VGND.t525 108.999
R220 VGND.t23 VGND.t356 252.065
R221 VGND.n61 VGND.t258 99.5776
R222 VGND.n70 VGND.t263 99.5776
R223 VGND.n65 VGND.t261 99.5774
R224 VGND.t59 VGND.n27 0.369499
R225 VGND.n14 VGND.t207 108.635
R226 VGND.n6 VGND.n71 427.5
R227 VGND.n169 VGND.n19 427.5
R228 VGND.n408 VGND.t484 427.5
R229 VGND.t382 VGND.n0 251.417
R230 VGND.n47 VGND.t256 251.417
R231 VGND.t189 VGND.n11 251.417
R232 VGND.n359 VGND.t1003 250.952
R233 VGND.n281 VGND.t34 250.952
R234 VGND.n244 VGND.t1100 250.952
R235 VGND.t151 VGND.n210 250.952
R236 VGND.t128 VGND.t72 250
R237 VGND.t1112 VGND.n237 249.002
R238 VGND.n43 VGND.t264 109.644
R239 VGND.t749 VGND.t747 109.992
R240 VGND.t747 VGND.t751 109.992
R241 VGND.t754 VGND.t747 109.992
R242 VGND.t747 VGND.t756 109.992
R243 VGND.t758 VGND.t747 109.992
R244 VGND.t767 VGND.t747 109.992
R245 VGND.t747 VGND.t769 109.993
R246 VGND.t771 VGND.t747 109.992
R247 VGND.t785 VGND.t747 109.992
R248 VGND.t747 VGND.t787 109.993
R249 VGND.t572 VGND.t571 109.986
R250 VGND.t572 VGND.t581 109.992
R251 VGND.t583 VGND.t572 109.992
R252 VGND.t587 VGND.t572 109.992
R253 VGND.t572 VGND.t598 109.993
R254 VGND.t605 VGND.t572 109.992
R255 VGND.t484 VGND.t485 109.986
R256 VGND.t484 VGND.t493 109.992
R257 VGND.t495 VGND.t484 109.992
R258 VGND.t484 VGND.t497 109.992
R259 VGND.t499 VGND.t484 109.992
R260 VGND.t484 VGND.t505 109.993
R261 VGND.t507 VGND.t484 109.992
R262 VGND.t484 VGND.t509 109.993
R263 VGND.t511 VGND.t484 109.992
R264 VGND.t484 VGND.t517 109.993
R265 VGND.t519 VGND.t484 109.992
R266 VGND.t484 VGND.t522 109.993
R267 VGND.n64 VGND.t31 9.30721
R268 VGND.n62 VGND.t31 9.30719
R269 VGND.n69 VGND.t31 9.30719
R270 VGND.n214 VGND.t1069 237.5
R271 VGND.n341 VGND.t441 235.714
R272 VGND.n342 VGND.t391 235.714
R273 VGND.t394 VGND.n340 235.714
R274 VGND.n343 VGND.t397 235.714
R275 VGND.t399 VGND.n337 235.714
R276 VGND.n344 VGND.t402 235.714
R277 VGND.t404 VGND.n336 235.714
R278 VGND.n345 VGND.t407 235.714
R279 VGND.t409 VGND.n334 235.714
R280 VGND.n346 VGND.t412 235.714
R281 VGND.t414 VGND.n332 235.714
R282 VGND.n347 VGND.t416 235.714
R283 VGND.t418 VGND.n331 235.714
R284 VGND.n348 VGND.t421 235.714
R285 VGND.t423 VGND.n329 235.714
R286 VGND.n349 VGND.t426 235.714
R287 VGND.t428 VGND.n327 235.714
R288 VGND.n350 VGND.t430 235.714
R289 VGND.t432 VGND.n326 235.714
R290 VGND.n351 VGND.t435 235.714
R291 VGND.t437 VGND.n325 235.714
R292 VGND.t23 VGND.t327 108.722
R293 VGND.t958 VGND.n36 34.7251
R294 VGND.t352 VGND.n38 105.684
R295 VGND.t336 VGND.n31 106.677
R296 VGND.n93 VGND.t338 251.417
R297 VGND.t23 VGND.n79 9.63523
R298 VGND.n357 VGND.t370 235.714
R299 VGND.n58 VGND.t374 238.992
R300 VGND.n94 VGND.t377 251.417
R301 VGND.t367 VGND.n263 235.714
R302 VGND.n365 VGND.t289 235.714
R303 VGND.t294 VGND.n72 105.684
R304 VGND.n56 VGND.t248 108.719
R305 VGND.t31 VGND.t252 108.993
R306 VGND.n209 VGND.t277 235.714
R307 VGND.n61 VGND.t279 242.431
R308 VGND.n65 VGND.t281 242.431
R309 VGND.t211 VGND.n393 235.714
R310 VGND.n73 VGND.t1067 26.8308
R311 VGND.t440 VGND.t482 235.006
R312 VGND.t390 VGND.n67 4.49263
R313 VGND.n89 VGND.t100 249.002
R314 VGND.t167 VGND.n276 233.333
R315 VGND.t180 VGND.n217 233.333
R316 VGND.t961 VGND.t1017 231.429
R317 VGND.t359 VGND.n256 229.167
R318 VGND.n219 VGND.t271 229.167
R319 VGND.n342 VGND.t442 227.143
R320 VGND.t444 VGND.n340 227.143
R321 VGND.n343 VGND.t446 227.143
R322 VGND.t448 VGND.n337 227.143
R323 VGND.n344 VGND.t450 227.143
R324 VGND.t452 VGND.n336 227.143
R325 VGND.n345 VGND.t454 227.143
R326 VGND.t456 VGND.n334 227.143
R327 VGND.n346 VGND.t458 227.143
R328 VGND.t460 VGND.n332 227.143
R329 VGND.n347 VGND.t462 227.143
R330 VGND.t464 VGND.n331 227.143
R331 VGND.n348 VGND.t466 227.143
R332 VGND.t468 VGND.n329 227.143
R333 VGND.n349 VGND.t470 227.143
R334 VGND.t472 VGND.n327 227.143
R335 VGND.n350 VGND.t474 227.143
R336 VGND.t476 VGND.n326 227.143
R337 VGND.n351 VGND.t478 227.143
R338 VGND.t480 VGND.n325 227.143
R339 VGND.n360 VGND.t358 227.143
R340 VGND.n63 VGND.t376 102.457
R341 VGND.n84 VGND.t379 242.846
R342 VGND.n368 VGND.t291 227.143
R343 VGND.t147 VGND.t292 227.143
R344 VGND.n55 VGND.t251 109.942
R345 VGND.t257 VGND.n62 234.188
R346 VGND.t259 VGND.n64 234.188
R347 VGND.t262 VGND.n69 234.188
R348 VGND.n59 VGND.t203 232.714
R349 VGND.t942 VGND.t1083 227.143
R350 VGND.n396 VGND.t214 227.143
R351 VGND.t59 VGND.t218 109.986
R352 VGND.t995 VGND.t11 222.857
R353 VGND.n75 VGND.t976 224.005
R354 VGND.t23 VGND.n30 100.312
R355 VGND.n76 VGND.t2 100.312
R356 VGND.t59 VGND.t240 222.042
R357 VGND.n28 VGND.t235 102.703
R358 VGND.t210 VGND.t59 222.041
R359 VGND.t283 VGND.n43 221.71
R360 VGND.n406 VGND.t187 221.417
R361 VGND.n11 VGND.t231 221.417
R362 VGND.n259 VGND.t361 220.833
R363 VGND.n387 VGND.t274 220.833
R364 VGND.t183 VGND.n275 212.5
R365 VGND.t1101 VGND.t152 208.333
R366 VGND.t388 VGND.t969 205.714
R367 VGND.n40 VGND.t369 208.992
R368 VGND.t314 VGND.n20 221.417
R369 VGND.n70 VGND.t283 212.431
R370 VGND.t231 VGND.n177 205.714
R371 VGND.n26 VGND.t59 96.0268
R372 VGND.n28 VGND.t1039 46.4355
R373 VGND.t201 VGND.t1095 205.714
R374 VGND.t205 VGND.n60 15.001
R375 VGND.n82 VGND.t59 8.48857
R376 VGND.n82 VGND.t245 102.707
R377 VGND.n7 VGND.t975 204.274
R378 VGND.t1092 VGND.t192 201.429
R379 VGND.t746 VGND.t747 109.986
R380 VGND.t764 VGND.t747 109.993
R381 VGND.t773 VGND.t747 109.993
R382 VGND.t782 VGND.t747 109.993
R383 VGND.t589 VGND.t572 109.993
R384 VGND.t594 VGND.t572 109.993
R385 VGND.t602 VGND.t572 109.993
R386 VGND.t513 VGND.t484 109.993
R387 VGND.t442 VGND.n303 200.613
R388 VGND.t393 VGND.n302 200.613
R389 VGND.n304 VGND.t444 200.613
R390 VGND.n305 VGND.t396 200.613
R391 VGND.t446 VGND.n301 200.613
R392 VGND.t398 VGND.n300 200.613
R393 VGND.n306 VGND.t448 200.613
R394 VGND.n307 VGND.t401 200.613
R395 VGND.t450 VGND.n299 200.613
R396 VGND.t403 VGND.n298 200.613
R397 VGND.n308 VGND.t452 200.613
R398 VGND.n309 VGND.t406 200.613
R399 VGND.t454 VGND.n297 200.613
R400 VGND.t408 VGND.n296 200.613
R401 VGND.n310 VGND.t456 200.613
R402 VGND.n311 VGND.t411 200.613
R403 VGND.t458 VGND.n295 200.613
R404 VGND.t413 VGND.n294 200.613
R405 VGND.n312 VGND.t460 200.613
R406 VGND.n313 VGND.t415 200.613
R407 VGND.t462 VGND.n293 200.613
R408 VGND.t417 VGND.n292 200.613
R409 VGND.n314 VGND.t464 200.613
R410 VGND.n315 VGND.t420 200.613
R411 VGND.t466 VGND.n291 200.613
R412 VGND.t422 VGND.n290 200.613
R413 VGND.n316 VGND.t468 200.613
R414 VGND.n317 VGND.t425 200.613
R415 VGND.t470 VGND.n289 200.613
R416 VGND.t427 VGND.n288 200.613
R417 VGND.n318 VGND.t472 200.613
R418 VGND.n319 VGND.t429 200.613
R419 VGND.t474 VGND.n287 200.613
R420 VGND.t431 VGND.n286 200.613
R421 VGND.n320 VGND.t476 200.613
R422 VGND.n321 VGND.t434 200.613
R423 VGND.t478 VGND.n285 200.613
R424 VGND.t436 VGND.n284 200.613
R425 VGND.n322 VGND.t480 200.613
R426 VGND.n323 VGND.t439 200.613
R427 VGND.t482 VGND.n283 200.613
R428 VGND.t330 VGND.t23 109.986
R429 VGND.t351 VGND.n35 23.2336
R430 VGND.n38 VGND.t334 106.677
R431 VGND.t23 VGND.n34 86.7547
R432 VGND.t355 VGND.n30 9.68073
R433 VGND.t389 VGND.n68 23.2336
R434 VGND.t343 VGND.n67 106.159
R435 VGND.n63 VGND.t23 7.66905
R436 VGND.n66 VGND.t2 86.7547
R437 VGND.n72 VGND.t316 106.677
R438 VGND.n76 VGND.t296 9.68073
R439 VGND.n55 VGND.t31 0.0849623
R440 VGND.t254 VGND.t31 109.986
R441 VGND.t233 VGND.t59 109.7
R442 VGND.t239 VGND.t59 109.981
R443 VGND.t358 VGND.n4 199.989
R444 VGND.n5 VGND.t339 100.822
R445 VGND.n46 VGND.t257 199.989
R446 VGND.n45 VGND.t259 199.989
R447 VGND.n44 VGND.t262 199.989
R448 VGND.t214 VGND.n395 199.989
R449 VGND.t959 VGND.t199 197.143
R450 VGND.t616 VGND.t572 108.999
R451 VGND.t790 VGND.t747 109.992
R452 VGND.t786 VGND.t747 108.999
R453 VGND.t747 VGND.t784 109.001
R454 VGND.t781 VGND.t747 108.999
R455 VGND.t747 VGND.t779 109.001
R456 VGND.t747 VGND.t777 109.993
R457 VGND.t775 VGND.t747 109.992
R458 VGND.t772 VGND.t747 108.999
R459 VGND.t747 VGND.t770 109.001
R460 VGND.t768 VGND.t747 108.999
R461 VGND.t747 VGND.t766 109.001
R462 VGND.t762 VGND.t747 109.992
R463 VGND.t747 VGND.t760 109.992
R464 VGND.t747 VGND.t757 109.001
R465 VGND.t755 VGND.t747 109.001
R466 VGND.t747 VGND.t753 109.001
R467 VGND.t750 VGND.t747 109.001
R468 VGND.t747 VGND.t748 109.001
R469 VGND.n6 VGND.t744 108.722
R470 VGND.t572 VGND.t614 109.001
R471 VGND.t572 VGND.t612 109.993
R472 VGND.t610 VGND.t572 109.992
R473 VGND.t572 VGND.t607 109.993
R474 VGND.t572 VGND.t604 109.001
R475 VGND.t572 VGND.t599 109.001
R476 VGND.t597 VGND.t572 108.999
R477 VGND.t596 VGND.t572 109.992
R478 VGND.t593 VGND.t572 108.999
R479 VGND.t592 VGND.t572 109.992
R480 VGND.t572 VGND.t586 109.001
R481 VGND.t584 VGND.t572 109.001
R482 VGND.t572 VGND.t582 109.001
R483 VGND.t580 VGND.t572 109.001
R484 VGND.t579 VGND.t572 109.992
R485 VGND.t575 VGND.t572 109.001
R486 VGND.t574 VGND.t572 109.992
R487 VGND.t569 VGND.n19 108.722
R488 VGND.t484 VGND.t523 109.001
R489 VGND.t520 VGND.t484 108.999
R490 VGND.t484 VGND.t518 109.001
R491 VGND.t516 VGND.t484 108.999
R492 VGND.t484 VGND.t514 109.001
R493 VGND.t512 VGND.t484 108.999
R494 VGND.t484 VGND.t510 109.001
R495 VGND.t508 VGND.t484 108.999
R496 VGND.t484 VGND.t506 109.001
R497 VGND.t504 VGND.t484 108.999
R498 VGND.t503 VGND.t484 109.992
R499 VGND.t484 VGND.t501 109.993
R500 VGND.t484 VGND.t498 109.001
R501 VGND.t496 VGND.t484 109.001
R502 VGND.t484 VGND.t494 109.001
R503 VGND.t492 VGND.t484 109.001
R504 VGND.t491 VGND.t484 109.992
R505 VGND.t484 VGND.t489 109.992
R506 VGND.t484 VGND.t486 109.001
R507 VGND.t483 VGND.t484 108.722
R508 VGND.t481 VGND.n283 192.042
R509 VGND.n323 VGND.t437 192.042
R510 VGND.n322 VGND.t479 192.042
R511 VGND.t435 VGND.n284 192.042
R512 VGND.t477 VGND.n285 192.042
R513 VGND.n321 VGND.t432 192.042
R514 VGND.n320 VGND.t475 192.042
R515 VGND.t430 VGND.n286 192.042
R516 VGND.t473 VGND.n287 192.042
R517 VGND.n319 VGND.t428 192.042
R518 VGND.n318 VGND.t471 192.042
R519 VGND.t426 VGND.n288 192.042
R520 VGND.t469 VGND.n289 192.042
R521 VGND.n317 VGND.t423 192.042
R522 VGND.n316 VGND.t467 192.042
R523 VGND.t421 VGND.n290 192.042
R524 VGND.t465 VGND.n291 192.042
R525 VGND.n315 VGND.t418 192.042
R526 VGND.n314 VGND.t463 192.042
R527 VGND.t416 VGND.n292 192.042
R528 VGND.t461 VGND.n293 192.042
R529 VGND.n313 VGND.t414 192.042
R530 VGND.n312 VGND.t459 192.042
R531 VGND.t412 VGND.n294 192.042
R532 VGND.t457 VGND.n295 192.042
R533 VGND.n311 VGND.t409 192.042
R534 VGND.n310 VGND.t455 192.042
R535 VGND.t407 VGND.n296 192.042
R536 VGND.t453 VGND.n297 192.042
R537 VGND.n309 VGND.t404 192.042
R538 VGND.n308 VGND.t451 192.042
R539 VGND.t402 VGND.n298 192.042
R540 VGND.t449 VGND.n299 192.042
R541 VGND.n307 VGND.t399 192.042
R542 VGND.n306 VGND.t447 192.042
R543 VGND.t397 VGND.n300 192.042
R544 VGND.t445 VGND.n301 192.042
R545 VGND.n305 VGND.t394 192.042
R546 VGND.n304 VGND.t443 192.042
R547 VGND.t391 VGND.n302 192.042
R548 VGND.t354 VGND.n31 105.683
R549 VGND.t335 VGND.n34 22.2411
R550 VGND.t23 VGND.n38 3.31705
R551 VGND.t23 VGND.n35 86.7547
R552 VGND.t350 VGND.n36 101.781
R553 VGND.t23 VGND.n68 86.7547
R554 VGND.t23 VGND.t388 192.042
R555 VGND.n66 VGND.t315 22.2411
R556 VGND.t292 VGND.t2 192.042
R557 VGND.t2 VGND.t284 192.042
R558 VGND.n56 VGND.t31 0.281784
R559 VGND.t225 VGND.t59 108.993
R560 VGND.t59 VGND.t220 108.993
R561 VGND.t59 VGND.t216 108.993
R562 VGND.t59 VGND.n60 96.0214
R563 VGND.t59 VGND.t201 192.042
R564 VGND.n26 VGND.t232 12.9737
R565 VGND.t59 VGND.t229 192.042
R566 VGND.n77 VGND.t347 108.638
R567 VGND.n0 VGND.t338 191.417
R568 VGND.n3 VGND.t370 191.417
R569 VGND.n264 VGND.t367 191.417
R570 VGND.t277 VGND.n46 191.417
R571 VGND.t279 VGND.n45 191.417
R572 VGND.t281 VGND.n44 191.417
R573 VGND.n10 VGND.t189 191.417
R574 VGND.t197 VGND.n27 108.635
R575 VGND.n276 VGND.t183 187.5
R576 VGND.n257 VGND.t359 186.502
R577 VGND.t349 VGND.n254 184.286
R578 VGND.t381 VGND.n282 184.286
R579 VGND.t382 VGND.n5 182.764
R580 VGND.n354 VGND.t386 184.286
R581 VGND.t379 VGND.n270 184.286
R582 VGND.t291 VGND.n363 184.286
R583 VGND.n83 VGND.t182 188.381
R584 VGND.t976 VGND.t1056 184.286
R585 VGND.n62 VGND.t278 100.883
R586 VGND.n64 VGND.t280 100.883
R587 VGND.n69 VGND.t282 100.883
R588 VGND.t192 VGND.n176 184.286
R589 VGND.t199 VGND.n185 184.286
R590 VGND.t209 VGND.n196 184.286
R591 VGND.t975 VGND.t1036 180
R592 VGND.t361 VGND.n258 179.167
R593 VGND.t274 VGND.n217 179.167
R594 VGND.t385 VGND.n79 99.5817
R595 VGND.n271 VGND.t377 175.714
R596 VGND.t289 VGND.n364 175.714
R597 VGND.t256 VGND.n209 175.714
R598 VGND.n394 VGND.t211 175.714
R599 VGND.t60 VGND.t373 171.429
R600 VGND.t108 VGND.t368 171.429
R601 VGND.t380 VGND.n280 170.833
R602 VGND.t271 VGND.n218 170.833
R603 VGND.t962 VGND.n9 169.989
R604 VGND.n13 VGND.t1019 169.989
R605 VGND.n12 VGND.t942 169.989
R606 VGND.t1071 VGND.n196 167.143
R607 VGND.n260 VGND.t100 166.667
R608 VGND.n277 VGND.t167 166.667
R609 VGND.n376 VGND.t948 166.667
R610 VGND.n238 VGND.t1112 166.667
R611 VGND.n223 VGND.t154 166.667
R612 VGND.t106 VGND.n215 166.667
R613 VGND.n386 VGND.t180 166.667
R614 VGND.n237 VGND.t103 165.669
R615 VGND.t136 VGND.t210 162.857
R616 VGND.t1069 VGND.n213 162.5
R617 VGND.t203 VGND.t980 158.571
R618 VGND.t223 VGND.t58 158.571
R619 VGND.t0 VGND.t380 158.333
R620 VGND.n52 VGND.t174 157.335
R621 VGND.n92 VGND.t95 169.989
R622 VGND.n80 VGND.t981 169.989
R623 VGND.n393 VGND.t989 154.286
R624 VGND.t993 VGND.n404 154.286
R625 VGND.n405 VGND.t1094 154.286
R626 VGND.n255 VGND.t1003 154.167
R627 VGND.t34 VGND.n280 154.167
R628 VGND.t952 VGND.n382 154.167
R629 VGND.t1100 VGND.n243 154.167
R630 VGND.n211 VGND.t151 154.167
R631 VGND.t1080 VGND.n220 154.167
R632 VGND.t363 VGND.n89 165.669
R633 VGND.t154 VGND.t972 150
R634 VGND.n221 VGND.t135 150
R635 VGND.n387 VGND.t105 150
R636 VGND.t97 VGND.n253 145.714
R637 VGND.t369 VGND.t949 145.714
R638 VGND.t1060 VGND.n176 145.714
R639 VGND.n59 VGND.t168 92.4056
R640 VGND.n192 VGND.t1025 145.714
R641 VGND.n74 VGND.t223 232.714
R642 VGND.t1115 VGND.n274 141.834
R643 VGND.t169 VGND.n259 141.667
R644 VGND.n377 VGND.t38 141.667
R645 VGND.n239 VGND.t29 141.667
R646 VGND.t29 VGND.t173 141.667
R647 VGND.t985 VGND.t1113 141.667
R648 VGND.t155 VGND.n218 141.667
R649 VGND.t21 VGND.t5 141.429
R650 VGND.t177 VGND.n372 137.536
R651 VGND.n234 VGND.t176 137.536
R652 VGND.t441 VGND.t950 137.143
R653 VGND.t1052 VGND.t993 137.143
R654 VGND.t1094 VGND.t102 137.143
R655 VGND.t59 VGND.t1052 136.327
R656 VGND.t102 VGND.t59 136.327
R657 VGND.n49 VGND.t943 132.976
R658 VGND.t948 VGND.t1118 129.167
R659 VGND.t974 VGND.n184 124.287
R660 VGND.n39 VGND.t941 136.9
R661 VGND.n278 VGND.t54 120.834
R662 VGND.n380 VGND.t181 120.834
R663 VGND.t113 VGND.n212 120.834
R664 VGND.t1116 VGND.t67 120.344
R665 VGND.t26 VGND.n354 120.001
R666 VGND.n187 VGND.t961 120.001
R667 VGND.t983 VGND.n180 120.001
R668 VGND.t1040 VGND.n194 120.001
R669 VGND.t987 VGND.n193 120.001
R670 VGND.n201 VGND.t129 120.001
R671 VGND.n48 VGND.t112 119.835
R672 VGND.t173 VGND.n238 116.668
R673 VGND.t943 VGND.t106 116.668
R674 VGND.t374 VGND.t76 115.715
R675 VGND.n367 VGND.t142 114.275
R676 VGND.t1087 VGND.t66 107.451
R677 VGND.t185 VGND.n359 107.144
R678 VGND.t157 VGND.n281 107.144
R679 VGND.n268 VGND.t47 107.144
R680 VGND.n261 VGND.t363 107.144
R681 VGND.n266 VGND.t111 107.144
R682 VGND.n83 VGND.t33 77.2391
R683 VGND.t11 VGND.n227 107.144
R684 VGND.n210 VGND.t55 107.144
R685 VGND.t973 VGND.n185 107.144
R686 VGND.t240 VGND.t1050 107.144
R687 VGND.n258 VGND.t1037 104.168
R688 VGND.t85 VGND.n279 104.168
R689 VGND.t4 VGND.n378 104.168
R690 VGND.n378 VGND.t998 104.168
R691 VGND.t1118 VGND.n375 104.168
R692 VGND.t947 VGND.n240 104.168
R693 VGND.t997 VGND.n219 104.168
R694 VGND.t1042 VGND.t9 103.153
R695 VGND.t41 VGND.t144 102.858
R696 VGND.t941 VGND.t209 102.858
R697 VGND.n341 VGND.t1034 98.5719
R698 VGND.n178 VGND.t1048 98.5719
R699 VGND.n190 VGND.t1054 98.5719
R700 VGND.t1050 VGND.n57 112.823
R701 VGND.n201 VGND.t1045 98.5719
R702 VGND.t1085 VGND.n400 98.5719
R703 VGND.n39 VGND.t59 3.73753
R704 VGND.t356 VGND.t50 94.2862
R705 VGND.t373 VGND.t954 94.2862
R706 VGND.t368 VGND.t1001 94.2862
R707 VGND.t954 VGND.n269 90.0005
R708 VGND.n272 VGND.t35 90.0005
R709 VGND.t1001 VGND.n265 90.0005
R710 VGND.n16 VGND.t990 88.5605
R711 VGND.t23 VGND.t0 87.1423
R712 VGND.t74 VGND.n51 86.5025
R713 VGND.t17 VGND.n48 86.5025
R714 VGND.t1117 VGND.t945 85.9604
R715 VGND.n356 VGND.t117 85.7148
R716 VGND.n40 VGND.t109 65.92
R717 VGND.n187 VGND.t1018 85.7148
R718 VGND.t972 VGND.n222 83.3338
R719 VGND.t50 VGND.n252 81.4291
R720 VGND.n21 VGND.t19 95.0343
R721 VGND.n229 VGND.t995 81.4291
R722 VGND.n188 VGND.t1038 81.4291
R723 VGND.n3 VGND.t110 79.9891
R724 VGND.t89 VGND.n264 79.9891
R725 VGND.n279 VGND.t91 79.1672
R726 VGND.t1119 VGND.n369 79.1672
R727 VGND.t72 VGND.n211 79.1672
R728 VGND.t977 VGND.t140 77.1434
R729 VGND.t76 VGND.t23 76.3274
R730 VGND.t949 VGND.t23 76.3264
R731 VGND.n79 VGND.t107 79.5741
R732 VGND.t126 VGND.n181 72.8576
R733 VGND.t1023 VGND.n195 72.8576
R734 VGND.t172 VGND.n194 72.8576
R735 VGND.t1093 VGND.n37 74.0048
R736 VGND.n4 VGND.t1030 71.4177
R737 VGND.n7 VGND.t960 71.4177
R738 VGND.n256 VGND.t56 70.8338
R739 VGND.t1000 VGND.n381 70.8338
R740 VGND.t132 VGND.n242 70.8338
R741 VGND.n240 VGND.t996 70.8338
R742 VGND.t1043 VGND.t17 70.8338
R743 VGND.n212 VGND.t128 70.8338
R744 VGND.n385 VGND.t1005 70.8338
R745 VGND.t971 VGND.n52 69.8359
R746 VGND.n403 VGND.t1073 68.5719
R747 VGND.t945 VGND.n1 67.2827
R748 VGND.n50 VGND.t1042 67.2827
R749 VGND.t182 VGND.t952 66.6672
R750 VGND.n232 VGND.t985 66.6672
R751 VGND.t43 VGND.t1080 66.6672
R752 VGND.t1111 VGND.n270 64.2862
R753 VGND.n358 VGND.t24 60.0005
R754 VGND.n63 VGND.t92 68.6832
R755 VGND.t944 VGND.n273 60.0005
R756 VGND.n262 VGND.t171 60.0005
R757 VGND.n366 VGND.t25 60.0005
R758 VGND.t1017 VGND.n183 60.0005
R759 VGND.t1036 VGND.t59 59.1846
R760 VGND.t48 VGND.n221 58.3338
R761 VGND.n370 VGND.t1120 55.8744
R762 VGND.t118 VGND.n271 55.7148
R763 VGND.t23 VGND.t108 72.0407
R764 VGND.t2 VGND.n21 2.74604
R765 VGND.t1028 VGND.n228 55.7148
R766 VGND.t1032 VGND.n182 55.7148
R767 VGND.t950 VGND.n303 54.8988
R768 VGND.t59 VGND.t1096 54.8988
R769 VGND.t59 VGND.n57 2.09988
R770 VGND.n381 VGND.t1075 54.1672
R771 VGND.t23 VGND.t37 53.8079
R772 VGND.t1002 VGND.n257 53.1692
R773 VGND.n241 VGND.t1099 53.1692
R774 VGND.n42 VGND.t1081 53.1692
R775 VGND.t30 VGND.n235 51.5764
R776 VGND.t443 VGND.t393 51.4291
R777 VGND.t396 VGND.t445 51.4291
R778 VGND.t447 VGND.t398 51.4291
R779 VGND.t401 VGND.t449 51.4291
R780 VGND.t451 VGND.t403 51.4291
R781 VGND.t406 VGND.t453 51.4291
R782 VGND.t455 VGND.t408 51.4291
R783 VGND.t411 VGND.t457 51.4291
R784 VGND.t459 VGND.t413 51.4291
R785 VGND.t415 VGND.t461 51.4291
R786 VGND.t463 VGND.t417 51.4291
R787 VGND.t420 VGND.t465 51.4291
R788 VGND.t467 VGND.t422 51.4291
R789 VGND.t425 VGND.t469 51.4291
R790 VGND.t471 VGND.t427 51.4291
R791 VGND.t429 VGND.t473 51.4291
R792 VGND.t475 VGND.t431 51.4291
R793 VGND.t434 VGND.t477 51.4291
R794 VGND.t479 VGND.t436 51.4291
R795 VGND.t439 VGND.t481 51.4291
R796 VGND.t332 VGND.n35 22.2411
R797 VGND.t353 VGND.n34 23.2336
R798 VGND.t341 VGND.n68 22.2411
R799 VGND.n66 VGND.t293 23.2336
R800 VGND.t984 VGND.t1101 50.0005
R801 VGND.t152 VGND.t971 50.0005
R802 VGND.t140 VGND.n226 47.1434
R803 VGND.n242 VGND.t141 45.8338
R804 VGND.n50 VGND.t1087 45.7928
R805 VGND.n9 VGND.t1021 45.7034
R806 VGND.t1083 VGND.n13 45.7034
R807 VGND.t966 VGND.n12 45.7034
R808 VGND.n231 VGND.n51 44.8359
R809 VGND.t5 VGND.n266 42.8576
R810 VGND.n368 VGND.t146 42.8576
R811 VGND.n197 VGND.t136 42.8576
R812 VGND.t988 VGND.n398 42.8576
R813 VGND.t980 VGND.t59 42.0407
R814 VGND.t70 VGND.n401 41.4177
R815 VGND.n33 VGND.t1026 54.6304
R816 VGND.t1016 VGND.t982 38.5719
R817 VGND.t1061 VGND.n180 38.5719
R818 VGND.t1051 VGND.n191 38.5719
R819 VGND.t1041 VGND.n399 38.5719
R820 VGND.n82 VGND.t1098 46.4351
R821 VGND.n224 VGND.t984 37.5005
R822 VGND.t149 VGND.n214 37.5005
R823 VGND.n54 VGND.t979 37.1319
R824 VGND.t138 VGND.n363 34.2862
R825 VGND.t979 VGND.t123 34.2862
R826 VGND.n29 VGND.t1016 49.6853
R827 VGND.n231 VGND.t131 33.3338
R828 VGND.n1 VGND.t1116 32.8988
R829 VGND.t1035 VGND.n15 32.8462
R830 VGND.t1086 VGND.n397 32.8462
R831 VGND.n371 VGND.t1121 30.0865
R832 VGND.n235 VGND.t1047 30.0865
R833 VGND.n92 VGND.t969 45.7034
R834 VGND.t284 VGND.t314 30.0005
R835 VGND.n230 VGND.t122 30.0005
R836 VGND.n75 VGND.t145 26.8308
R837 VGND.t229 VGND.t187 30.0005
R838 VGND.n26 VGND.t194 15.0018
R839 VGND.n186 VGND.t959 30.0005
R840 VGND.n80 VGND.t1095 45.7034
R841 VGND.t238 VGND.n60 12.9744
R842 VGND.t1084 VGND.n394 30.0005
R843 VGND.t1073 VGND.t1088 30.0005
R844 VGND.n37 VGND.t967 26.8307
R845 VGND.n73 VGND.t992 74.0048
R846 VGND.n379 VGND.t1076 29.1672
R847 VGND.n385 VGND.t965 29.1672
R848 VGND.t143 VGND.n53 28.5605
R849 VGND.n53 VGND.t137 28.5605
R850 VGND.n200 VGND.t1079 25.7148
R851 VGND.n29 VGND.t59 0.95266
R852 VGND.n41 VGND.t1029 22.913
R853 VGND.n15 VGND.t1031 24.2748
R854 VGND.n397 VGND.t1033 24.2748
R855 VGND.t1121 VGND.t39 21.4905
R856 VGND.n374 VGND.t1123 21.4905
R857 VGND.t337 VGND.n30 10.7159
R858 VGND.n76 VGND.t317 10.7159
R859 VGND.t54 VGND.t946 20.8338
R860 VGND.n243 VGND.t978 20.8338
R861 VGND.t1056 VGND.n54 19.9891
R862 VGND.t1097 VGND.n232 18.2932
R863 VGND.t2 VGND.n20 0.649832
R864 VGND.t438 VGND.n325 17.0005
R865 VGND.t438 VGND.n351 17.0005
R866 VGND.t438 VGND.n326 17.0005
R867 VGND.t438 VGND.n350 17.0005
R868 VGND.t438 VGND.n327 17.0005
R869 VGND.t438 VGND.n349 17.0005
R870 VGND.t438 VGND.n329 17.0005
R871 VGND.t438 VGND.n348 17.0005
R872 VGND.t438 VGND.n331 17.0005
R873 VGND.t438 VGND.n347 17.0005
R874 VGND.t438 VGND.n332 17.0005
R875 VGND.t438 VGND.n346 17.0005
R876 VGND.t438 VGND.n334 17.0005
R877 VGND.t438 VGND.n345 17.0005
R878 VGND.t438 VGND.n336 17.0005
R879 VGND.t438 VGND.n344 17.0005
R880 VGND.t438 VGND.n337 17.0005
R881 VGND.t438 VGND.n343 17.0005
R882 VGND.t438 VGND.n340 17.0005
R883 VGND.t438 VGND.n342 17.0005
R884 VGND.t438 VGND.n341 17.0005
R885 VGND.t438 VGND.n175 17.0005
R886 VGND.n359 VGND.t23 17.0005
R887 VGND.t23 VGND.n360 17.0005
R888 VGND.t23 VGND.n252 17.0005
R889 VGND.t23 VGND.n31 3.31704
R890 VGND.t23 VGND.n36 7.34144
R891 VGND.t23 VGND.n253 17.0005
R892 VGND.t23 VGND.n91 0.649813
R893 VGND.t23 VGND.n254 17.0005
R894 VGND.n89 VGND.t23 0.666899
R895 VGND.t23 VGND.n260 17.0005
R896 VGND.n259 VGND.t23 17.0005
R897 VGND.n258 VGND.t23 17.0005
R898 VGND.n256 VGND.t23 17.0005
R899 VGND.t23 VGND.n255 17.0005
R900 VGND.n261 VGND.t23 17.0005
R901 VGND.n265 VGND.t23 17.0005
R902 VGND.n263 VGND.t23 17.0005
R903 VGND.n262 VGND.t23 17.0005
R904 VGND.t23 VGND.n266 17.0005
R905 VGND.n84 VGND.t23 0.649813
R906 VGND.t23 VGND.n270 17.0005
R907 VGND.t23 VGND.n272 17.0005
R908 VGND.t23 VGND.n271 17.0005
R909 VGND.t23 VGND.n94 0.649813
R910 VGND.n356 VGND.t23 17.0005
R911 VGND.t23 VGND.n58 13.0749
R912 VGND.t23 VGND.n269 17.0005
R913 VGND.n357 VGND.t23 17.0005
R914 VGND.t23 VGND.n358 17.0005
R915 VGND.t23 VGND.n268 17.0005
R916 VGND.t23 VGND.n279 17.0005
R917 VGND.t23 VGND.n278 17.0005
R918 VGND.t23 VGND.n277 17.0005
R919 VGND.t23 VGND.n276 17.0005
R920 VGND.t23 VGND.n275 17.0005
R921 VGND.t23 VGND.n274 17.0005
R922 VGND.t23 VGND.n273 17.0005
R923 VGND.t23 VGND.n5 9.30147
R924 VGND.t23 VGND.n93 0.649813
R925 VGND.t23 VGND.n282 17.0005
R926 VGND.t23 VGND.n281 17.0005
R927 VGND.t23 VGND.n280 17.0005
R928 VGND.n92 VGND.t23 0.649813
R929 VGND.n86 VGND.t23 0.649813
R930 VGND.n354 VGND.t23 17.0005
R931 VGND.n355 VGND.t23 17.0005
R932 VGND.t2 VGND.n72 3.31705
R933 VGND.t2 VGND.n362 17.0005
R934 VGND.t2 VGND.n368 17.0005
R935 VGND.t2 VGND.n363 17.0005
R936 VGND.t2 VGND.n366 17.0005
R937 VGND.t2 VGND.n364 17.0005
R938 VGND.t2 VGND.n365 17.0005
R939 VGND.t2 VGND.n369 17.0005
R940 VGND.t2 VGND.n375 17.0005
R941 VGND.t2 VGND.n376 17.0005
R942 VGND.t2 VGND.n377 17.0005
R943 VGND.t2 VGND.n378 17.0005
R944 VGND.t2 VGND.n379 17.0005
R945 VGND.t2 VGND.n380 17.0005
R946 VGND.t2 VGND.n381 17.0005
R947 VGND.t2 VGND.n382 17.0005
R948 VGND.t2 VGND.n374 17.0005
R949 VGND.t2 VGND.n372 17.0005
R950 VGND.t2 VGND.n371 17.0005
R951 VGND.t2 VGND.n370 17.0005
R952 VGND.n244 VGND.t31 17.0005
R953 VGND.t31 VGND.n226 17.0005
R954 VGND.t31 VGND.n230 17.0005
R955 VGND.t31 VGND.n227 17.0005
R956 VGND.t31 VGND.n229 17.0005
R957 VGND.t31 VGND.n228 17.0005
R958 VGND.n238 VGND.t31 17.0005
R959 VGND.n239 VGND.t31 17.0005
R960 VGND.n240 VGND.t31 17.0005
R961 VGND.n242 VGND.t31 17.0005
R962 VGND.n243 VGND.t31 17.0005
R963 VGND.n233 VGND.t31 17.0005
R964 VGND.n234 VGND.t31 17.0005
R965 VGND.n235 VGND.t31 17.0005
R966 VGND.n236 VGND.t31 17.0005
R967 VGND.t31 VGND.n221 17.0005
R968 VGND.t31 VGND.n222 17.0005
R969 VGND.t31 VGND.n223 17.0005
R970 VGND.t31 VGND.n224 17.0005
R971 VGND.t31 VGND.n225 17.0005
R972 VGND.t31 VGND.n387 17.0005
R973 VGND.t31 VGND.n217 17.0005
R974 VGND.t31 VGND.n386 17.0005
R975 VGND.t31 VGND.n218 17.0005
R976 VGND.t31 VGND.n219 17.0005
R977 VGND.t31 VGND.n385 17.0005
R978 VGND.t31 VGND.n220 17.0005
R979 VGND.t31 VGND.n208 17.0005
R980 VGND.t31 VGND.n70 9.63483
R981 VGND.t31 VGND.n65 9.63482
R982 VGND.t31 VGND.n61 9.63483
R983 VGND.t31 VGND.n209 17.0005
R984 VGND.t31 VGND.n210 17.0005
R985 VGND.t31 VGND.n211 17.0005
R986 VGND.t31 VGND.n212 17.0005
R987 VGND.t31 VGND.n213 17.0005
R988 VGND.t31 VGND.n214 17.0005
R989 VGND.t31 VGND.n215 17.0005
R990 VGND.n74 VGND.t59 10.7817
R991 VGND.n73 VGND.t59 15.2046
R992 VGND.n405 VGND.t59 17.0005
R993 VGND.n404 VGND.t59 17.0005
R994 VGND.n403 VGND.t59 17.0005
R995 VGND.n402 VGND.t59 17.0005
R996 VGND.n400 VGND.t59 17.0005
R997 VGND.n399 VGND.t59 17.0005
R998 VGND.n398 VGND.t59 17.0005
R999 VGND.n396 VGND.t59 17.0005
R1000 VGND.n394 VGND.t59 17.0005
R1001 VGND.n393 VGND.t59 17.0005
R1002 VGND.t59 VGND.n201 17.0005
R1003 VGND.t59 VGND.n191 17.0005
R1004 VGND.t59 VGND.n192 17.0005
R1005 VGND.t59 VGND.n200 17.0005
R1006 VGND.t59 VGND.n193 17.0005
R1007 VGND.t59 VGND.n199 17.0005
R1008 VGND.t59 VGND.n194 17.0005
R1009 VGND.t59 VGND.n198 17.0005
R1010 VGND.t59 VGND.n195 17.0005
R1011 VGND.t59 VGND.n197 17.0005
R1012 VGND.t59 VGND.n196 17.0005
R1013 VGND.n80 VGND.t59 0.649813
R1014 VGND.t59 VGND.n179 17.0005
R1015 VGND.t59 VGND.n190 17.0005
R1016 VGND.t59 VGND.n180 17.0005
R1017 VGND.t59 VGND.n189 17.0005
R1018 VGND.t59 VGND.n181 17.0005
R1019 VGND.t59 VGND.n188 17.0005
R1020 VGND.t59 VGND.n182 17.0005
R1021 VGND.t59 VGND.n187 17.0005
R1022 VGND.t59 VGND.n183 17.0005
R1023 VGND.t59 VGND.n184 17.0005
R1024 VGND.t59 VGND.n186 17.0005
R1025 VGND.t59 VGND.n185 17.0005
R1026 VGND.t59 VGND.n28 8.48814
R1027 VGND.n18 VGND.t59 12.5808
R1028 VGND.t59 VGND.n176 17.0005
R1029 VGND.t59 VGND.n177 17.0005
R1030 VGND.t59 VGND.n178 17.0005
R1031 VGND.n401 VGND.t991 15.7034
R1032 VGND.t957 VGND.n357 12.8576
R1033 VGND.n84 VGND.t166 28.5605
R1034 VGND.n263 VGND.t101 12.8576
R1035 VGND.t59 VGND.t1063 12.5837
R1036 VGND.t1113 VGND.n225 12.5005
R1037 VGND.n423 VGND.n160 9.0005
R1038 VGND.n410 VGND.n160 9.0005
R1039 VGND.n245 VGND.n205 9.0005
R1040 VGND.n249 VGND.n248 9.0005
R1041 VGND.n391 VGND.n390 9.0005
R1042 VGND.n392 VGND.n391 9.0005
R1043 VGND.n171 VGND.n170 9.0005
R1044 VGND.n415 VGND.n414 9.0005
R1045 VGND.n362 VGND.t147 8.57193
R1046 VGND.n90 VGND.t260 0.776428
R1047 VGND.t936 VGND.n115 0.130189
R1048 VGND.t934 VGND.n32 8.501
R1049 VGND.t931 VGND.n114 0.130189
R1050 VGND.n113 VGND.t926 0.130189
R1051 VGND.t924 VGND.n32 8.501
R1052 VGND.n112 VGND.t921 0.130189
R1053 VGND.t919 VGND.n32 8.501
R1054 VGND.n111 VGND.t916 0.130189
R1055 VGND.t914 VGND.n32 8.501
R1056 VGND.n110 VGND.t911 0.130189
R1057 VGND.t909 VGND.n32 8.501
R1058 VGND.n109 VGND.t906 0.130189
R1059 VGND.t904 VGND.n32 8.501
R1060 VGND.n108 VGND.t901 0.130189
R1061 VGND.t899 VGND.n32 8.501
R1062 VGND.n107 VGND.t896 0.130189
R1063 VGND.t894 VGND.n32 8.501
R1064 VGND.n106 VGND.t891 0.130189
R1065 VGND.t889 VGND.n32 8.501
R1066 VGND.n105 VGND.t886 0.130189
R1067 VGND.t884 VGND.n32 8.501
R1068 VGND.n104 VGND.t881 0.130189
R1069 VGND.t879 VGND.n32 8.501
R1070 VGND.n103 VGND.t876 0.130189
R1071 VGND.t874 VGND.n32 8.501
R1072 VGND.n102 VGND.t871 0.130189
R1073 VGND.t869 VGND.n32 8.501
R1074 VGND.n101 VGND.t866 0.130189
R1075 VGND.t864 VGND.n32 8.501
R1076 VGND.n100 VGND.t861 0.130189
R1077 VGND.t859 VGND.n32 8.501
R1078 VGND.n99 VGND.t856 0.130189
R1079 VGND.t854 VGND.n32 8.501
R1080 VGND.n98 VGND.t851 0.130189
R1081 VGND.t849 VGND.n32 8.501
R1082 VGND.n97 VGND.t846 0.130189
R1083 VGND.t844 VGND.n32 8.501
R1084 VGND.n96 VGND.t841 0.130189
R1085 VGND.t839 VGND.n32 8.501
R1086 VGND.n32 VGND.n95 3.33079
R1087 VGND.n87 VGND.t23 0.889691
R1088 VGND.t333 VGND.n123 0.485614
R1089 VGND.n126 VGND.t23 3.33079
R1090 VGND.t331 VGND.t23 8.501
R1091 VGND.n128 VGND.t23 3.33079
R1092 VGND.t364 VGND.n125 0.383235
R1093 VGND.t362 VGND.t23 8.501
R1094 VGND.n124 VGND.t57 0.129991
R1095 VGND.t6 VGND.n116 0.80697
R1096 VGND.n120 VGND.t23 0.626016
R1097 VGND.t378 VGND.n119 0.130189
R1098 VGND.t93 VGND.t23 8.501
R1099 VGND.t62 VGND.n118 0.238005
R1100 VGND.n117 VGND.t371 0.130189
R1101 VGND.t1 VGND.n121 0.235729
R1102 VGND.t340 VGND.t23 8.501
R1103 VGND.t96 VGND.n122 0.439794
R1104 VGND.t387 VGND.n85 0.219597
R1105 VGND.n139 VGND.t2 1.09101
R1106 VGND.t139 VGND.t2 8.501
R1107 VGND.t20 VGND.n138 0.130189
R1108 VGND.t288 VGND.t2 8.501
R1109 VGND.n137 VGND.t2 3.33348
R1110 VGND.t312 VGND.n135 0.112943
R1111 VGND.t2 VGND.t311 8.501
R1112 VGND.t308 VGND.n134 0.130189
R1113 VGND.t306 VGND.n133 0.256315
R1114 VGND.t305 VGND.t2 8.501
R1115 VGND.n132 VGND.t303 0.130189
R1116 VGND.t16 VGND.n131 0.817081
R1117 VGND.t302 VGND.t2 8.501
R1118 VGND.t3 VGND.n130 0.288567
R1119 VGND.t134 VGND.n129 0.89753
R1120 VGND.t28 VGND.n24 0.0331752
R1121 VGND.n145 VGND.t31 5.64548
R1122 VGND.n144 VGND.t31 3.33079
R1123 VGND.t12 VGND.n148 0.573103
R1124 VGND.n147 VGND.t31 3.33079
R1125 VGND.n232 VGND.t31 8.501
R1126 VGND.n81 VGND.t270 0.0997385
R1127 VGND.n143 VGND.t276 0.72893
R1128 VGND.t31 VGND.t65 4.25087
R1129 VGND.t275 VGND.t31 8.501
R1130 VGND.n142 VGND.t31 3.33079
R1131 VGND.n159 VGND.t246 0.112943
R1132 VGND.t228 VGND.t59 8.501
R1133 VGND.t224 VGND.n158 0.130189
R1134 VGND.t221 VGND.n157 0.256315
R1135 VGND.t219 VGND.t59 8.501
R1136 VGND.t71 VGND.n156 0.130189
R1137 VGND.t215 VGND.n155 0.839797
R1138 VGND.n154 VGND.t212 0.130189
R1139 VGND.n153 VGND.t204 0.123414
R1140 VGND.t202 VGND.n152 0.256124
R1141 VGND.n151 VGND.t59 4.20744
R1142 VGND.t234 VGND.t59 8.501
R1143 VGND.n150 VGND.t196 0.123414
R1144 VGND.t193 VGND.t59 8.501
R1145 VGND.t190 VGND.n149 0.386263
R1146 VGND.t929 VGND.n32 8.5005
R1147 VGND.t438 VGND.t440 8.48862
R1148 VGND.t23 VGND.n67 3.83526
R1149 VGND.t44 VGND.n140 0.148231
R1150 VGND.n81 VGND.t31 3.32884
R1151 VGND.t125 VGND.n88 0.177814
R1152 VGND.n23 VGND.t212 0.321873
R1153 VGND.n151 VGND.t236 0.0735143
R1154 VGND.t1076 VGND.t951 8.33383
R1155 VGND.t363 VGND.t170 7.1604
R1156 VGND.t47 VGND.t22 7.1604
R1157 VGND.t175 VGND.t135 7.1604
R1158 VGND.t105 VGND.t65 7.1604
R1159 VGND.t43 VGND.t31 0.737184
R1160 VGND.t31 VGND.n140 3.32934
R1161 VGND.n115 VGND.n32 3.33079
R1162 VGND.n114 VGND.n32 3.33079
R1163 VGND.n32 VGND.n112 3.33079
R1164 VGND.n111 VGND.n32 3.33079
R1165 VGND.n32 VGND.n110 3.33079
R1166 VGND.n109 VGND.n32 3.33079
R1167 VGND.n32 VGND.n108 3.33079
R1168 VGND.n107 VGND.n32 3.33079
R1169 VGND.n32 VGND.n106 3.33079
R1170 VGND.n105 VGND.n32 3.33079
R1171 VGND.n32 VGND.n104 3.33079
R1172 VGND.n103 VGND.n32 3.33079
R1173 VGND.n32 VGND.n102 3.33079
R1174 VGND.n101 VGND.n32 3.33079
R1175 VGND.n32 VGND.n100 3.33079
R1176 VGND.n99 VGND.n32 3.33079
R1177 VGND.n32 VGND.n98 3.33079
R1178 VGND.n97 VGND.n32 3.33079
R1179 VGND.n32 VGND.n96 3.33079
R1180 VGND.t837 VGND.n95 0.0863258
R1181 VGND.t329 VGND.n128 0.0863258
R1182 VGND.n124 VGND.t23 3.33087
R1183 VGND.t23 VGND.n119 3.33079
R1184 VGND.t23 VGND.n117 3.33079
R1185 VGND.n85 VGND.t23 2.33234
R1186 VGND.t2 VGND.n138 3.33079
R1187 VGND.n137 VGND.t286 0.0818513
R1188 VGND.t2 VGND.n134 3.33079
R1189 VGND.n132 VGND.t2 3.33079
R1190 VGND.n144 VGND.t253 0.0863258
R1191 VGND.t250 VGND.n147 0.0863258
R1192 VGND.t164 VGND.n78 0.739109
R1193 VGND.n142 VGND.t273 0.0863258
R1194 VGND.t1059 VGND.n141 0.231606
R1195 VGND.n88 VGND.t31 3.30696
R1196 VGND.t59 VGND.n158 3.33079
R1197 VGND.n156 VGND.t59 3.33079
R1198 VGND.n154 VGND.t59 3.33079
R1199 VGND.n153 VGND.t59 3.33348
R1200 VGND.n150 VGND.t59 3.33348
R1201 VGND.n420 VGND.n419 5.16578
R1202 VGND.n248 VGND.t198 4.61666
R1203 VGND.t221 VGND.n392 4.61666
R1204 VGND.t133 VGND.n384 4.5005
R1205 VGND.n383 VGND.t295 4.5005
R1206 VGND.n361 VGND.t51 4.5005
R1207 VGND.t400 VGND.n174 4.5005
R1208 VGND.n409 VGND.t484 4.5005
R1209 VGND.t577 VGND.n411 4.5005
R1210 VGND.n422 VGND.t668 4.5005
R1211 VGND.t752 VGND.n162 4.5005
R1212 VGND.t854 VGND.n421 4.5005
R1213 VGND.n388 VGND.t18 4.5005
R1214 VGND.t306 VGND.n206 4.5005
R1215 VGND.t340 VGND.n353 4.5005
R1216 VGND.n352 VGND.t433 4.5005
R1217 VGND.t521 VGND.n173 4.5005
R1218 VGND.n412 VGND.t608 4.5005
R1219 VGND.n418 VGND.t696 4.5005
R1220 VGND.n419 VGND.t783 4.5005
R1221 VGND.n251 VGND.n250 4.49573
R1222 VGND.n417 VGND.n416 4.49573
R1223 VGND.n426 VGND.n425 4.49046
R1224 VGND.n424 VGND.n160 4.49046
R1225 VGND.n426 VGND.n161 4.49046
R1226 VGND.n249 VGND.n246 4.49046
R1227 VGND.n247 VGND.n205 4.49046
R1228 VGND.n389 VGND.n203 4.49046
R1229 VGND.n391 VGND.n204 4.49046
R1230 VGND.n203 VGND.n202 4.49046
R1231 VGND.n415 VGND.n172 4.49046
R1232 VGND.n413 VGND.n171 4.49046
R1233 VGND.n372 VGND.t1122 4.29849
R1234 VGND.t1009 VGND.n254 4.28621
R1235 VGND.t144 VGND.n244 4.28621
R1236 VGND.t1096 VGND.t114 4.28621
R1237 VGND.n159 VGND.t59 2.80634
R1238 VGND.t22 VGND.t23 4.251
R1239 VGND.t170 VGND.t23 4.2505
R1240 VGND.t31 VGND.t175 4.2505
R1241 VGND.n141 VGND.t31 2.29755
R1242 VGND.t59 VGND.t1055 4.177
R1243 VGND.t1011 VGND.n220 4.16717
R1244 VGND.t47 VGND.t21 3.50108
R1245 VGND.t939 VGND.n32 3.46301
R1246 VGND.n135 VGND.t2 2.80712
R1247 VGND.n267 VGND.t23 3.3417
R1248 VGND.t59 VGND.t188 3.33329
R1249 VGND.t23 VGND.n118 2.31523
R1250 VGND.t23 VGND.n121 2.31585
R1251 VGND.n133 VGND.t2 2.01734
R1252 VGND.n157 VGND.t59 2.01734
R1253 VGND.t59 VGND.n152 2.0173
R1254 VGND.n130 VGND.t2 1.99216
R1255 VGND.t105 VGND.n216 2.49634
R1256 VGND.n216 VGND.t46 2.49634
R1257 VGND.n373 VGND.t2 2.29795
R1258 VGND.n391 VGND.n205 2.17938
R1259 VGND.n415 VGND.n160 2.17938
R1260 VGND.t59 VGND.n149 1.53817
R1261 VGND.t23 VGND.t21 1.88939
R1262 VGND.t23 VGND.n122 1.35976
R1263 VGND.n125 VGND.t23 1.27486
R1264 VGND.t667 VGND.t700 1.51817
R1265 VGND.t438 VGND.n338 1.51808
R1266 VGND.t43 VGND.t135 1.37665
R1267 VGND.t295 VGND.n139 0.716681
R1268 VGND.n207 VGND.t10 1.32123
R1269 VGND.t31 VGND.n216 1.30819
R1270 VGND.n164 VGND.t688 1.23023
R1271 VGND.t424 VGND.n324 1.23023
R1272 VGND.n22 VGND.t788 0.00980952
R1273 VGND.t572 VGND.n25 0.554952
R1274 VGND.n148 VGND.t31 0.99161
R1275 VGND.n24 VGND.t2 0.827229
R1276 VGND.t778 VGND.t747 0.343103
R1277 VGND.n267 VGND.t53 1.12681
R1278 VGND.t59 VGND.n23 0.946174
R1279 VGND.t208 VGND.t59 0.919613
R1280 VGND.t747 VGND.t765 0.372226
R1281 VGND.t2 VGND.t318 1.05046
R1282 VGND.t303 VGND.t1106 1.04989
R1283 VGND.n207 VGND.t18 1.04561
R1284 VGND.t200 VGND.t127 1.04346
R1285 VGND.t104 VGND.t75 1.04173
R1286 VGND.n333 VGND.t410 1.0417
R1287 VGND.n328 VGND.t424 1.0417
R1288 VGND.n167 VGND.t676 1.0417
R1289 VGND.n165 VGND.t688 1.0417
R1290 VGND.n335 VGND.t405 1.03988
R1291 VGND.n330 VGND.t419 1.03988
R1292 VGND.n163 VGND.t672 1.03988
R1293 VGND.n166 VGND.t684 1.03988
R1294 VGND.t198 VGND.t200 1.00896
R1295 VGND.n129 VGND.t7 1.06075
R1296 VGND.n339 VGND.t395 1.00054
R1297 VGND.n168 VGND.t663 1.00054
R1298 VGND.n123 VGND.t23 0.842316
R1299 VGND.n155 VGND.t71 1.05742
R1300 VGND.n78 VGND.t49 0.116953
R1301 VGND.n165 VGND.t684 0.981234
R1302 VGND.n167 VGND.t672 0.981234
R1303 VGND.n328 VGND.t419 0.981234
R1304 VGND.n333 VGND.t405 0.981234
R1305 VGND.t410 VGND.n330 0.98027
R1306 VGND.t676 VGND.n166 0.98027
R1307 VGND.n116 VGND.t53 0.101028
R1308 VGND.t1106 VGND.n131 0.0734893
R1309 VGND.t400 VGND.n335 0.91027
R1310 VGND.t668 VGND.n163 0.91027
R1311 VGND.t104 VGND.t133 0.909003
R1312 VGND.n120 VGND.t36 0.755133
R1313 VGND.n22 VGND.t747 0.554952
R1314 VGND.n78 VGND.t31 0.663028
R1315 VGND.t572 VGND.t590 0.393869
R1316 VGND.t18 VGND.n90 0.923882
R1317 VGND.t31 VGND.n143 0.669537
R1318 VGND.t747 VGND.t752 0.364351
R1319 VGND.t572 VGND.t577 0.364351
R1320 VGND.t357 VGND.n87 0.628759
R1321 VGND.n123 VGND.t51 0.804048
R1322 VGND.n120 VGND.t1 0.899606
R1323 VGND.n168 VGND.t87 0.740249
R1324 VGND.n339 VGND.t392 0.740249
R1325 VGND.t700 VGND.n168 0.730756
R1326 VGND.t438 VGND.n339 0.730756
R1327 VGND.t31 VGND.n90 0.611102
R1328 VGND.t745 VGND.t747 0.708889
R1329 VGND.t570 VGND.t572 0.708889
R1330 VGND.t51 VGND.n87 0.785965
R1331 VGND.t49 VGND.t75 0.683939
R1332 VGND.t572 VGND.t603 0.343103
R1333 VGND.n257 VGND.t23 0.666899
R1334 VGND.n237 VGND.t31 0.666899
R1335 VGND.n241 VGND.t31 0.666899
R1336 VGND.t31 VGND.n52 0.666899
R1337 VGND.t31 VGND.n51 0.666899
R1338 VGND.t31 VGND.n42 0.666899
R1339 VGND.t31 VGND.n48 0.666899
R1340 VGND.n421 VGND.n162 0.66578
R1341 VGND.n422 VGND.n162 0.66578
R1342 VGND.n411 VGND.n409 0.66578
R1343 VGND.n409 VGND.n174 0.66578
R1344 VGND.n361 VGND.n174 0.66578
R1345 VGND.n383 VGND.n361 0.66578
R1346 VGND.n384 VGND.n383 0.66578
R1347 VGND.n419 VGND.n418 0.66578
R1348 VGND.n412 VGND.n173 0.66578
R1349 VGND.n352 VGND.n173 0.66578
R1350 VGND.n353 VGND.n352 0.66578
R1351 VGND.n353 VGND.n206 0.66578
R1352 VGND.n388 VGND.n206 0.66578
R1353 VGND.t104 VGND.t31 0.663218
R1354 VGND.t700 VGND.n166 0.663193
R1355 VGND.t700 VGND.n163 0.663193
R1356 VGND.t438 VGND.n330 0.663193
R1357 VGND.t438 VGND.n335 0.663193
R1358 VGND.t23 VGND.n116 0.557426
R1359 VGND.n139 VGND.t148 0.534589
R1360 VGND.t23 VGND.n4 0.649813
R1361 VGND.n264 VGND.t23 0.649813
R1362 VGND.n41 VGND.t13 32.8822
R1363 VGND.t23 VGND.n3 0.649813
R1364 VGND.t23 VGND.n0 0.649813
R1365 VGND.n367 VGND.t2 0.649813
R1366 VGND.t31 VGND.n75 15.2046
R1367 VGND.t31 VGND.n54 0.649813
R1368 VGND.t31 VGND.n53 0.649813
R1369 VGND.t31 VGND.n43 0.356984
R1370 VGND.t31 VGND.n44 0.649813
R1371 VGND.t31 VGND.n45 0.649813
R1372 VGND.t31 VGND.n46 0.649813
R1373 VGND.t31 VGND.n47 0.649813
R1374 VGND.n401 VGND.t59 0.649813
R1375 VGND.n397 VGND.t59 0.649813
R1376 VGND.n395 VGND.t59 0.649813
R1377 VGND.t59 VGND.n17 0.649813
R1378 VGND.t59 VGND.n16 0.649813
R1379 VGND.t59 VGND.n12 0.649813
R1380 VGND.t59 VGND.n13 0.649813
R1381 VGND.t59 VGND.n15 0.649813
R1382 VGND.t59 VGND.n14 0.369499
R1383 VGND.t59 VGND.n59 10.7815
R1384 VGND.t59 VGND.n9 0.649813
R1385 VGND.t59 VGND.n8 0.649813
R1386 VGND.t59 VGND.n7 0.649813
R1387 VGND.t59 VGND.n10 0.649813
R1388 VGND.t59 VGND.n11 0.649813
R1389 VGND.n406 VGND.t59 0.649813
R1390 VGND.t23 VGND.n2 0.648546
R1391 VGND.t23 VGND.n1 0.648101
R1392 VGND.t31 VGND.n50 0.648101
R1393 VGND.n155 VGND.t59 0.509524
R1394 VGND.n148 VGND.t124 0.682693
R1395 VGND.n338 VGND.t400 0.582865
R1396 VGND.t668 VGND.t667 0.582204
R1397 VGND VGND.n426 0.56194
R1398 VGND.t342 VGND.n122 0.0899486
R1399 VGND.n143 VGND.t10 0.615107
R1400 VGND.n411 VGND.n410 0.52498
R1401 VGND.n414 VGND.n412 0.52498
R1402 VGND.n207 VGND.t31 0.507035
R1403 VGND.n129 VGND.t2 0.427536
R1404 VGND.t59 VGND.t200 0.504774
R1405 VGND.n164 VGND.t696 0.502493
R1406 VGND.n324 VGND.t433 0.502493
R1407 VGND.t191 VGND.n149 0.0910287
R1408 VGND.t365 VGND.t6 0.479414
R1409 VGND.n131 VGND.t2 0.408361
R1410 VGND.t365 VGND.n125 0.0721407
R1411 VGND.n373 VGND.t3 0.454947
R1412 VGND.t667 VGND.t663 0.451523
R1413 VGND.n338 VGND.t395 0.450919
R1414 VGND.n384 VGND.n251 0.4229
R1415 VGND.n390 VGND.n388 0.4229
R1416 VGND.t7 VGND.n373 0.422702
R1417 VGND.n141 VGND.t1006 0.172547
R1418 VGND.t608 VGND.n25 0.00832401
R1419 VGND.t193 VGND.t191 0.406181
R1420 VGND.t301 VGND.t302 0.40178
R1421 VGND.t344 VGND.t342 0.397273
R1422 VGND.n130 VGND.t301 0.0930303
R1423 VGND.t700 VGND.n165 0.387972
R1424 VGND.t700 VGND.n167 0.387972
R1425 VGND.t438 VGND.n328 0.387972
R1426 VGND.t438 VGND.n333 0.387972
R1427 VGND.n157 VGND.t222 0.0836481
R1428 VGND.n133 VGND.t307 0.0836481
R1429 VGND.t93 VGND.t375 0.344973
R1430 VGND.t383 VGND.t340 0.344562
R1431 VGND.t375 VGND.n118 0.0931939
R1432 VGND.n121 VGND.t383 0.0923073
R1433 VGND.t222 VGND.t224 0.329613
R1434 VGND.t307 VGND.t308 0.329613
R1435 VGND.t204 VGND.n152 0.40171
R1436 VGND.t190 VGND.t188 0.308403
R1437 VGND.t125 VGND.t1059 0.301114
R1438 VGND.t44 VGND.t164 0.300775
R1439 VGND.t940 VGND.n88 0.118193
R1440 VGND.t272 VGND.t1006 0.283644
R1441 VGND.t1055 VGND.t202 0.283644
R1442 VGND.n267 VGND.t371 0.280926
R1443 VGND.t700 VGND.n164 0.27355
R1444 VGND.n324 VGND.t438 0.27355
R1445 VGND.t270 VGND.t940 0.257846
R1446 VGND.t269 VGND.n140 0.0991044
R1447 VGND.t234 VGND.t195 0.227075
R1448 VGND.t208 VGND.t206 0.227075
R1449 VGND.t286 VGND.t288 0.227075
R1450 VGND.t362 VGND.t360 0.227075
R1451 VGND.t937 VGND.t939 0.226736
R1452 VGND.t932 VGND.t934 0.226736
R1453 VGND.t331 VGND.t329 0.226736
R1454 VGND.t311 VGND.t310 0.226736
R1455 VGND.t304 VGND.t305 0.226736
R1456 VGND.t275 VGND.t273 0.226736
R1457 VGND.t255 VGND.t253 0.226736
R1458 VGND.t12 VGND.t250 0.226736
R1459 VGND.t228 VGND.t226 0.226736
R1460 VGND.t217 VGND.t219 0.226736
R1461 VGND.t213 VGND.t215 0.226736
R1462 VGND.t837 VGND.t839 0.226736
R1463 VGND.t844 VGND.t842 0.226736
R1464 VGND.t847 VGND.t849 0.226736
R1465 VGND.t854 VGND.t852 0.226736
R1466 VGND.t857 VGND.t859 0.226736
R1467 VGND.t864 VGND.t862 0.226736
R1468 VGND.t867 VGND.t869 0.226736
R1469 VGND.t874 VGND.t872 0.226736
R1470 VGND.t877 VGND.t879 0.226736
R1471 VGND.t884 VGND.t882 0.226736
R1472 VGND.t887 VGND.t889 0.226736
R1473 VGND.t894 VGND.t892 0.226736
R1474 VGND.t897 VGND.t899 0.226736
R1475 VGND.t904 VGND.t902 0.226736
R1476 VGND.t907 VGND.t909 0.226736
R1477 VGND.t914 VGND.t912 0.226736
R1478 VGND.t917 VGND.t919 0.226736
R1479 VGND.t298 VGND.t134 0.226736
R1480 VGND.t139 VGND.t290 0.226736
R1481 VGND.t36 VGND.n119 0.312561
R1482 VGND.t62 VGND.t372 0.226736
R1483 VGND.t333 VGND.n126 0.312561
R1484 VGND.t924 VGND.t922 0.226736
R1485 VGND.n126 VGND.t348 0.130189
R1486 VGND.t836 VGND.n95 0.130189
R1487 VGND.n97 VGND.t847 0.0863258
R1488 VGND.n99 VGND.t857 0.0863258
R1489 VGND.n101 VGND.t867 0.0863258
R1490 VGND.n103 VGND.t877 0.0863258
R1491 VGND.n105 VGND.t887 0.0863258
R1492 VGND.n107 VGND.t897 0.0863258
R1493 VGND.n109 VGND.t907 0.0863258
R1494 VGND.n111 VGND.t917 0.0863258
R1495 VGND.n113 VGND.t927 0.0863258
R1496 VGND.n154 VGND.t213 0.0863258
R1497 VGND.n156 VGND.t217 0.0863258
R1498 VGND.n158 VGND.t226 0.0863258
R1499 VGND.n142 VGND.t272 0.130189
R1500 VGND.n24 VGND.t298 0.180684
R1501 VGND.n132 VGND.t304 0.0863258
R1502 VGND.n134 VGND.t310 0.0863258
R1503 VGND.t290 VGND.n138 0.0863258
R1504 VGND.t372 VGND.n117 0.0863258
R1505 VGND.n128 VGND.t328 0.130189
R1506 VGND.n144 VGND.t124 0.130189
R1507 VGND.n147 VGND.t249 0.130189
R1508 VGND.n114 VGND.t932 0.0863258
R1509 VGND.n115 VGND.t937 0.0863258
R1510 VGND.t922 VGND.n112 0.0863258
R1511 VGND.t912 VGND.n110 0.0863258
R1512 VGND.t902 VGND.n108 0.0863258
R1513 VGND.t892 VGND.n106 0.0863258
R1514 VGND.t882 VGND.n104 0.0863258
R1515 VGND.t872 VGND.n102 0.0863258
R1516 VGND.t862 VGND.n100 0.0863258
R1517 VGND.t852 VGND.n98 0.0863258
R1518 VGND.t842 VGND.n96 0.0863258
R1519 VGND.t27 VGND.n85 0.216133
R1520 VGND.n124 VGND.t360 0.0861948
R1521 VGND.t127 VGND.t1055 0.214894
R1522 VGND.t927 VGND.n420 0.210486
R1523 VGND.n150 VGND.t195 0.0818513
R1524 VGND.n153 VGND.t206 0.0818513
R1525 VGND.t285 VGND.n137 0.123414
R1526 VGND.t269 VGND.t63 0.193232
R1527 VGND.t63 VGND.n81 0.149192
R1528 VGND.t130 VGND.n23 0.0211171
R1529 VGND.n135 VGND.t313 0.0572468
R1530 VGND.n159 VGND.t247 0.0860085
R1531 VGND.t237 VGND.n151 0.0737702
R1532 VGND.t198 VGND.t236 0.130789
R1533 VGND.t700 VGND.t86 0.113833
R1534 VGND.n145 VGND.t255 0.0346178
R1535 VGND.t934 VGND.t936 0.0855
R1536 VGND.t929 VGND.t931 0.0855
R1537 VGND.t378 VGND.t93 0.0855
R1538 VGND.t340 VGND.t27 0.0855
R1539 VGND.t96 VGND.t387 0.0855
R1540 VGND.t362 VGND.t364 0.0855
R1541 VGND.t57 VGND.t357 0.0855
R1542 VGND.t348 VGND.t331 0.0855
R1543 VGND.t305 VGND.t306 0.0855
R1544 VGND.t148 VGND.t139 0.0855
R1545 VGND.t20 VGND.t288 0.0855
R1546 VGND.t219 VGND.t221 0.0855
R1547 VGND.t839 VGND.t841 0.0855
R1548 VGND.t846 VGND.t844 0.0855
R1549 VGND.t849 VGND.t851 0.0855
R1550 VGND.t856 VGND.t854 0.0855
R1551 VGND.t859 VGND.t861 0.0855
R1552 VGND.t866 VGND.t864 0.0855
R1553 VGND.t869 VGND.t871 0.0855
R1554 VGND.t876 VGND.t874 0.0855
R1555 VGND.t879 VGND.t881 0.0855
R1556 VGND.t886 VGND.t884 0.0855
R1557 VGND.t889 VGND.t891 0.0855
R1558 VGND.t896 VGND.t894 0.0855
R1559 VGND.t899 VGND.t901 0.0855
R1560 VGND.t906 VGND.t904 0.0855
R1561 VGND.t909 VGND.t911 0.0855
R1562 VGND.t916 VGND.t914 0.0855
R1563 VGND.t919 VGND.t921 0.0855
R1564 VGND.t926 VGND.t924 0.0855
R1565 VGND.t311 VGND.t312 0.07425
R1566 VGND.t302 VGND.t16 0.07425
R1567 VGND.t276 VGND.t275 0.07425
R1568 VGND.t246 VGND.t228 0.07425
R1569 VGND.t234 VGND.t237 0.07425
R1570 VGND.t196 VGND.t193 0.07425
R1571 VGND.t133 VGND.n145 0.138232
R1572 VGND.n425 VGND.n424 0.0436411
R1573 VGND.n247 VGND.n246 0.0436411
R1574 VGND.n424 VGND.n161 0.0436411
R1575 VGND.n413 VGND.n172 0.0436411
R1576 VGND.n389 VGND.n204 0.0436411
R1577 VGND.n204 VGND.n202 0.0436411
R1578 VGND.t295 VGND.t318 0.043
R1579 VGND.n251 VGND.n245 0.04274
R1580 VGND.n417 VGND.n170 0.04274
R1581 VGND.t31 VGND.n49 0.0266767
R1582 VGND.t747 VGND.t780 109.992
R1583 VGND.t572 VGND.t615 109.992
R1584 VGND.t572 VGND.t600 109.992
R1585 VGND.t572 VGND.t585 109.992
R1586 VGND.t572 VGND.t576 109.992
R1587 VGND.t484 VGND.t524 109.992
R1588 VGND.t484 VGND.t515 109.992
R1589 VGND.t484 VGND.t487 109.992
R1590 VGND.t438 VGND.n283 0.0258175
R1591 VGND.t438 VGND.n323 0.0258175
R1592 VGND.t438 VGND.n322 0.0258175
R1593 VGND.t438 VGND.n284 0.0258175
R1594 VGND.t438 VGND.n285 0.0258175
R1595 VGND.t438 VGND.n321 0.0258175
R1596 VGND.t438 VGND.n320 0.0258175
R1597 VGND.t438 VGND.n286 0.0258175
R1598 VGND.t438 VGND.n287 0.0258175
R1599 VGND.t438 VGND.n319 0.0258175
R1600 VGND.t438 VGND.n318 0.0258175
R1601 VGND.t438 VGND.n288 0.0258175
R1602 VGND.t438 VGND.n289 0.0258175
R1603 VGND.t438 VGND.n317 0.0258175
R1604 VGND.t438 VGND.n316 0.0258175
R1605 VGND.t438 VGND.n290 0.0258175
R1606 VGND.t438 VGND.n291 0.0258175
R1607 VGND.t438 VGND.n315 0.0258175
R1608 VGND.t438 VGND.n314 0.0258175
R1609 VGND.t438 VGND.n292 0.0258175
R1610 VGND.t438 VGND.n293 0.0258175
R1611 VGND.t438 VGND.n313 0.0258175
R1612 VGND.t438 VGND.n312 0.0258175
R1613 VGND.t438 VGND.n294 0.0258175
R1614 VGND.t438 VGND.n295 0.0258175
R1615 VGND.t438 VGND.n311 0.0258175
R1616 VGND.t438 VGND.n310 0.0258175
R1617 VGND.t438 VGND.n296 0.0258175
R1618 VGND.t438 VGND.n297 0.0258175
R1619 VGND.t438 VGND.n309 0.0258175
R1620 VGND.t438 VGND.n308 0.0258175
R1621 VGND.t438 VGND.n298 0.0258175
R1622 VGND.t438 VGND.n299 0.0258175
R1623 VGND.t438 VGND.n307 0.0258175
R1624 VGND.t438 VGND.n306 0.0258175
R1625 VGND.t438 VGND.n300 0.0258175
R1626 VGND.t438 VGND.n301 0.0258175
R1627 VGND.t438 VGND.n305 0.0258175
R1628 VGND.t438 VGND.n304 0.0258175
R1629 VGND.t438 VGND.n302 0.0258175
R1630 VGND.t438 VGND.n303 0.0258175
R1631 VGND.t58 VGND.t59 42.0522
R1632 VGND.n410 VGND.n161 0.0220706
R1633 VGND.n425 VGND.n423 0.0220706
R1634 VGND.n246 VGND.n245 0.0220706
R1635 VGND.n248 VGND.n247 0.0220706
R1636 VGND.n390 VGND.n389 0.0220706
R1637 VGND.n392 VGND.n202 0.0220706
R1638 VGND.n172 VGND.n170 0.0220706
R1639 VGND.n414 VGND.n413 0.0220706
R1640 VGND.n391 VGND.n203 0.02162
R1641 VGND.n426 VGND.n160 0.02162
R1642 VGND.n421 VGND 0.01986
R1643 VGND.n420 VGND.t929 0.01675
R1644 VGND.t783 VGND.n22 0.00832401
R1645 VGND.n25 VGND.t613 0.00980952
R1646 VGND.n423 VGND.n422 0.01458
R1647 VGND.n418 VGND.n417 0.01458
R1648 VGND.n250 VGND.n205 0.0115476
R1649 VGND.n250 VGND.n249 0.0115476
R1650 VGND.n416 VGND.n171 0.0115476
R1651 VGND.n416 VGND.n415 0.0115476
R1652 VGND.t933 VGND.n32 183.805
R1653 VGND.n32 VGND.t883 183.805
R1654 VGND.t858 VGND.n32 183.805
R1655 VGND.n113 VGND.n32 3.63334
R1656 VGND.n77 VGND.t23 1.35169
R1657 VGND.t747 VGND.n6 1.23537
R1658 VGND.n33 VGND.t59 1.20904
R1659 VGND.t15 VGND.t2 1.15979
R1660 VGND.t572 VGND.n19 1.14807
R1661 VGND.t484 VGND.t521 1.07649
C0 a_6176_12302# VPWR 0.0807f
C1 VPWR sg13cmos5l_nor2_1_3.B 0.40454f
C2 a_8782_13995# a_8897_13994# 0.67711f
C3 a_6575_13043# a_7242_13264# 0.13494f
C4 sg13cmos5l_dfrbpq_1_5.Q VPWR 1.89682f
C5 a_4293_10715# sg13cmos5l_dfrbpq_1_3.Q 0.01605f
C6 sg13cmos5l_nand3_1_0.Y sg13cmos5l_nand4_1_0.C 0.21362f
C7 sg13cmos5l_xor2_1_2.A a_3932_11752# 0.01269f
C8 a_3590_11142# sg13cmos5l_xor2_1_2.A 0.01909f
C9 sg13cmos5l_dlygate4sd3_1_8.A sg13cmos5l_dfrbpq_1_4.D 0.3295f
C10 a_4906_10165# a_5349_9921# 0.02241f
C11 a_4646_9942# a_4932_10260# 0.50066f
C12 sg13cmos5l_dfrbpq_1_0.CLK a_3876_12220# 0.07385f
C13 sg13cmos5l_dfrbpq_1_5.Q a_15016_12302# 0.01107f
C14 sg13cmos5l_xor2_1_2.B a_10604_11752# 0.1137f
C15 sg13cmos5l_tiehi_0.L_HI a_3850_10672# 0.34581f
C16 sg13cmos5l_buf_1_0.X a_2039_10023# 0.01845f
C17 a_10031_13043# sg13cmos5l_xor2_1_2.B 0.01647f
C18 sg13cmos5l_nor2_1_1.B a_1940_13264# 0.11727f
C19 a_13793_10132# sg13cmos5l_mux2_1_0.X 0.0244f
C20 sg13cmos5l_nand4_1_0.Y sg13cmos5l_nand4_1_0.C 1.75769f
C21 sg13cmos5l_dfrbpq_1_6.RESET_B a_11639_12263# 0.09089f
C22 sg13cmos5l_o21ai_1_0.B1 sg13cmos5l_nor3_2_0.C 0.27048f
C23 a_9189_12945# sg13cmos5l_xor2_1_2.B 0.02026f
C24 sg13cmos5l_buf_1_0.X a_3668_13728# 0.01029f
C25 sg13cmos5l_nand4_1_1.A sg13cmos5l_dfrbpq_1_4.RESET_B 0.11079f
C26 sg13cmos5l_dfrbpq_1_0.CLK sg13cmos5l_dfrbpq_1_2.RESET_B 0.02372f
C27 a_5733_12945# a_5135_12577# 0.02258f
C28 sg13cmos5l_dfrbpq_1_0.CLK a_4395_12227# 0.03018f
C29 a_3642_13691# sg13cmos5l_nand4_1_0.Y 0.41422f
C30 sg13cmos5l_nor3_2_0.C sg13cmos5l_dfrbpq_1_6.D 0.11858f
C31 sg13cmos5l_buf_1_1.X a_5451_10064# 0.01723f
C32 VPWR a_4646_9942# 0.93016f
C33 a_10231_12180# sg13cmos5l_inv_1_1.A 0.02461f
C34 sg13cmos5l_dlygate4sd3_1_1.X a_3876_12220# 0.04181f
C35 sg13cmos5l_dfrbpq_1_4.RESET_B VPWR 1.57487f
C36 a_10812_12577# a_10702_12654# 0.4858f
C37 a_6832_13186# a_6481_13043# 0.01017f
C38 sg13cmos5l_dlygate4sd3_1_1.X a_8091_11458# 0.01083f
C39 sg13cmos5l_dlygate4sd3_1_12.X sg13cmos5l_mux2_1_0.A0 0.12637f
C40 a_3708_12974# sg13cmos5l_nand3_1_0.Y 0.01608f
C41 a_13793_10132# a_13797_10741# 0.01091f
C42 a_7822_9459# a_7937_9458# 0.67711f
C43 a_5030_12966# a_4570_12934# 0.01714f
C44 sg13cmos5l_a21oi_1_0.Y a_8681_9530# 0.01929f
C45 sg13cmos5l_dfrbpq_1_4.Q sg13cmos5l_dfrbpq_1_6.Q 0.17541f
C46 sg13cmos5l_dlygate4sd3_1_1.X sg13cmos5l_dfrbpq_1_2.RESET_B 0.24361f
C47 sg13cmos5l_nor3_2_0.C sg13cmos5l_dfrbpq_1_7.Q 0.31496f
C48 sg13cmos5l_a21oi_1_2.A1 sg13cmos5l_o21ai_1_2.Y 0.08734f
C49 sg13cmos5l_dlygate4sd3_1_1.X a_4395_12227# 0.01774f
C50 a_7148_14442# sg13cmos5l_nand2_1_1.A 0.32058f
C51 rst_ni sg13cmos5l_buf_1_0.X 0.04266f
C52 a_10943_12187# a_11594_12496# 0.01562f
C53 a_6856_14610# VPWR 0.19364f
C54 sg13cmos5l_nor2_1_1.Y sg13cmos5l_dfrbpq_1_2.RESET_B 0.13944f
C55 VPWR a_10943_12187# 0.27862f
C56 a_13673_11042# a_13594_10945# 0.16626f
C57 a_10231_9906# a_10791_10160# 0.3087f
C58 sg13cmos5l_buf_1_1.X a_10444_9942# 0.01027f
C59 sg13cmos5l_a21oi_1_0.Y VPWR 0.34273f
C60 clk_i sg13cmos5l_xor2_1_2.B 0.153f
C61 sg13cmos5l_dfrbpq_1_1.RESET_B a_5722_13692# 0.07676f
C62 sg13cmos5l_nand2_1_0.Y a_1940_13264# 0.03826f
C63 sg13cmos5l_xor2_1_1.X a_6185_14066# 0.02213f
C64 a_7318_11450# sg13cmos5l_o21ai_1_0.Y 0.11628f
C65 a_11192_12970# sg13cmos5l_inv_1_1.A 0.05508f
C66 VPWR a_1664_10074# 0.07571f
C67 a_10231_9906# sg13cmos5l_dfrbpq_1_5.RESET_B 0.19897f
C68 a_7242_13264# sg13cmos5l_a21oi_1_0.B1 0.05838f
C69 a_9449_14424# sg13cmos5l_o21ai_1_2.Y 0.0192f
C70 a_10943_10212# a_10812_9906# 0.49014f
C71 a_7624_13098# sg13cmos5l_nand2_1_1.A 0.02431f
C72 sg13cmos5l_tiehi_0.L_HI VPWR 1.82609f
C73 sg13cmos5l_dfrbpq_1_4.D sg13cmos5l_dlygate4sd3_1_1.X 0.01527f
C74 a_8782_13995# sg13cmos5l_a21oi_1_0.B1 0.03462f
C75 VPWR a_4577_13994# 0.24024f
C76 sg13cmos5l_dfrbpq_1_0.CLK sg13cmos5l_nand2_1_1.A 0.01971f
C77 sg13cmos5l_dfrbpq_1_1.D VPWR 0.40039f
C78 sg13cmos5l_o21ai_1_0.B1 a_8314_10668# 0.06435f
C79 a_11462_12970# sg13cmos5l_inv_1_1.A 0.02958f
C80 a_10791_10160# sg13cmos5l_dfrbpq_1_5.RESET_B 0.55136f
C81 a_3876_12220# sg13cmos5l_dfrbpq_1_2.Q 0.043f
C82 sg13cmos5l_tiehi_0.L_HI a_2238_10194# 0.07438f
C83 sg13cmos5l_dlygate4sd3_1_1.X sg13cmos5l_nand3_1_0.Y 0.02484f
C84 sg13cmos5l_a21oi_1_0.A2 sg13cmos5l_tiehi_5.L_HI 0.04069f
C85 a_10812_9906# a_11733_10100# 0.43042f
C86 a_5316_13284# a_6481_13043# 0.4858f
C87 a_5030_12966# a_5733_12945# 0.02453f
C88 sg13cmos5l_dlygate4sd3_1_1.X sg13cmos5l_nand4_1_0.Y 0.34564f
C89 sg13cmos5l_dfrbpq_1_5.D sg13cmos5l_dfrbpq_1_5.RESET_B 0.13717f
C90 a_4395_12227# sg13cmos5l_dfrbpq_1_2.Q 0.01903f
C91 sg13cmos5l_dfrbpq_1_2.RESET_B sg13cmos5l_buf_1_0.X 0.32302f
C92 sg13cmos5l_nor2_1_1.Y sg13cmos5l_nand4_1_0.Y 0.01999f
C93 sg13cmos5l_dlygate4sd3_1_1.X sg13cmos5l_nand2_1_1.A 0.53911f
C94 a_10816_11752# sg13cmos5l_mux2_1_0.S 0.30817f
C95 sg13cmos5l_nand2_1_0.Y sg13cmos5l_nor2_1_1.B 0.06413f
C96 a_8746_13189# a_8772_13284# 0.43042f
C97 sg13cmos5l_dfrbpq_1_1.RESET_B a_5733_12945# 0.05279f
C98 a_10288_13186# a_10698_13264# 0.1396f
C99 sg13cmos5l_dfrbpq_1_7.CLK a_10816_11752# 0.03382f
C100 a_6191_10019# a_6682_10668# 0.01133f
C101 a_15104_7050# VPWR 0.05657f
C102 a_8486_12966# a_9060_12979# 0.36169f
C103 sg13cmos5l_or3_1_2.X sg13cmos5l_a21oi_1_0.B1 0.21349f
C104 a_2920_14516# a_2728_14610# 0.01225f
C105 sg13cmos5l_dfrbpq_1_0.CLK sg13cmos5l_dfrbpq_1_0.RESET_B 0.47269f
C106 a_9291_13088# sg13cmos5l_dfrbpq_1_7.CLK 0.01696f
C107 sg13cmos5l_mux2_1_0.A0 sg13cmos5l_mux2_1_0.S 0.09967f
C108 sg13cmos5l_nand3_1_0.Y sg13cmos5l_dfrbpq_1_2.Q 0.01443f
C109 sg13cmos5l_a21oi_1_1.Y sg13cmos5l_a21oi_1_0.B1 0.22186f
C110 count_o[5] a_10988_14442# 0.29036f
C111 sg13cmos5l_nand3_1_0.Y sg13cmos5l_buf_1_0.X 1.51723f
C112 sg13cmos5l_mux2_1_0.A0 sg13cmos5l_dfrbpq_1_7.CLK 0.12313f
C113 sg13cmos5l_xor2_1_2.B a_10702_12654# 0.01723f
C114 sg13cmos5l_nor3_2_0.A a_10024_11586# 0.02135f
C115 a_11518_9562# a_11632_9562# 0.03097f
C116 a_11195_9248# a_11421_9216# 0.02749f
C117 count_o[4] a_8705_14668# 0.02558f
C118 a_4293_12227# sg13cmos5l_dfrbpq_1_3.Q 0.05015f
C119 sg13cmos5l_xor2_1_2.B sg13cmos5l_dfrbpq_1_3.Q 1.07037f
C120 sg13cmos5l_nand4_1_0.Y sg13cmos5l_buf_1_0.X 1.18054f
C121 sg13cmos5l_xor2_1_2.B sg13cmos5l_buf_8_0.A 1.4174f
C122 VPWR a_7416_11772# 0.01861f
C123 a_11969_14668# sg13cmos5l_o21ai_1_1.Y 0.01209f
C124 a_7918_10971# a_8033_10970# 0.67711f
C125 sg13cmos5l_dfrbpq_1_7.CLK a_8235_10064# 0.01738f
C126 a_10444_12654# sg13cmos5l_dfrbpq_1_6.RESET_B 0.17693f
C127 sg13cmos5l_dfrbpq_1_0.CLK sg13cmos5l_nor2_1_3.B 0.08767f
C128 sg13cmos5l_dfrbpq_1_3.Q a_4462_13995# 0.01874f
C129 sg13cmos5l_nor3_2_0.C a_8091_11458# 0.01405f
C130 sg13cmos5l_xor2_1_2.B sg13cmos5l_nand3_1_1.Y 1.32556f
C131 sg13cmos5l_dlygate4sd3_1_8.A sg13cmos5l_dfrbpq_1_4.RESET_B 0.48961f
C132 sg13cmos5l_nand4_1_1.A a_9178_13692# 0.05751f
C133 a_6448_10162# sg13cmos5l_dfrbpq_1_0.RESET_B 0.17693f
C134 a_11854_14667# sg13cmos5l_a21oi_1_1.A1 0.19368f
C135 sg13cmos5l_dfrbpq_1_0.Q sg13cmos5l_xnor2_1_0.B 0.12758f
C136 VPWR a_6185_14066# 0.15439f
C137 a_11768_13769# a_12038_13728# 0.33585f
C138 sg13cmos5l_dfrbpq_1_2.Q a_2728_14610# 0.05868f
C139 sg13cmos5l_dfrbpq_1_7.CLK sg13cmos5l_tiehi_5.L_HI 0.14285f
C140 clk_i a_7816_11586# 0.02081f
C141 VPWR a_5290_13189# 0.0973f
C142 sg13cmos5l_inv_1_1.A VPWR 1.74919f
C143 a_9178_13692# VPWR 0.3298f
C144 a_13472_10074# a_13678_10131# 0.03208f
C145 a_6176_12302# sg13cmos5l_dlygate4sd3_1_1.X 0.013f
C146 a_14920_5538# a_14920_4742# 0.01095f
C147 a_1740_10970# a_1775_11074# 0.3658f
C148 sg13cmos5l_mux2_1_0.A0 sg13cmos5l_dfrbpq_1_5.Q 0.01105f
C149 a_14920_2514# VPWR 0.15357f
C150 a_7148_14442# a_6856_14610# 0.03269f
C151 a_10231_12180# a_10702_12654# 0.32273f
C152 sg13cmos5l_nand4_1_1.A a_9742_13995# 0.19355f
C153 sg13cmos5l_dfrbpq_1_0.Q a_2264_12582# 0.01116f
C154 a_8772_13284# sg13cmos5l_dfrbpq_1_7.Q 0.0407f
C155 a_13793_10132# sg13cmos5l_dfrbpq_1_5.D 0.01157f
C156 sg13cmos5l_mux2_1_0.X a_11733_10100# 0.01249f
C157 a_7716_10260# a_8975_10019# 0.01741f
C158 sg13cmos5l_dlygate4sd3_1_15.X a_7716_10260# 0.02542f
C159 sg13cmos5l_dfrbpq_1_6.Q sg13cmos5l_a21oi_1_0.B1 0.05533f
C160 a_6448_10162# a_6858_10240# 0.1396f
C161 a_7800_13708# sg13cmos5l_o21ai_1_2.Y 0.01087f
C162 a_10288_13186# sg13cmos5l_dfrbpq_1_4.RESET_B 0.17693f
C163 sg13cmos5l_o21ai_1_1.Y sg13cmos5l_dfrbpq_1_6.D 0.64971f
C164 sg13cmos5l_a21oi_1_1.A1 a_10715_13728# 0.04039f
C165 a_3590_12654# a_3876_12220# 0.50066f
C166 a_9742_13995# VPWR 0.2146f
C167 a_4928_13098# sg13cmos5l_dfrbpq_1_3.Q 0.07298f
C168 a_9291_13088# sg13cmos5l_dfrbpq_1_4.RESET_B 0.56804f
C169 sg13cmos5l_xnor2_1_0.B a_4174_13155# 0.23286f
C170 sg13cmos5l_mux2_1_0.X a_11518_9562# 0.24755f
C171 a_4906_10165# sg13cmos5l_dfrbpq_1_0.RESET_B 0.35124f
C172 sg13cmos5l_dfrbpq_1_2.RESET_B a_3590_12654# 0.0898f
C173 a_5835_13088# VPWR 0.21805f
C174 a_10604_11752# VPWR 0.41169f
C175 a_11768_13769# VPWR 0.33325f
C176 a_7702_14106# sg13cmos5l_o21ai_1_2.Y 0.11628f
C177 sg13cmos5l_or3_1_2.X sg13cmos5l_a21oi_1_2.A1 0.23394f
C178 a_3590_12654# a_4395_12227# 0.11742f
C179 sg13cmos5l_dfrbpq_1_0.Q a_5135_12577# 0.0266f
C180 a_6778_12180# a_6497_12482# 0.33585f
C181 a_3932_11752# sg13cmos5l_nor2_1_3.B 0.11841f
C182 a_10031_13043# VPWR 0.18627f
C183 a_3590_11142# sg13cmos5l_nor2_1_3.B 0.05292f
C184 a_6176_12302# sg13cmos5l_dfrbpq_1_2.Q 0.01429f
C185 sg13cmos5l_dfrbpq_1_7.CLK a_10791_12303# 0.04639f
C186 enable_i VPWR 0.25649f
C187 a_1740_10970# sg13cmos5l_nor2_1_0.Y 0.0202f
C188 sg13cmos5l_nor2_1_0.B a_1775_11074# 0.04203f
C189 a_9189_12945# VPWR 0.31699f
C190 a_6191_10019# sg13cmos5l_dfrbpq_1_0.RESET_B 0.19875f
C191 sg13cmos5l_dfrbpq_1_3.Q a_4085_14482# 0.03274f
C192 sg13cmos5l_dfrbpq_1_3.Q sg13cmos5l_xor2_1_1.X 0.19827f
C193 sg13cmos5l_mux2_1_0.S a_10812_9906# 0.04995f
C194 a_3876_12220# a_5041_12577# 0.4858f
C195 sg13cmos5l_mux2_1_0.A1 a_11786_10704# 0.01382f
C196 sg13cmos5l_dfrbpq_1_7.CLK a_10812_9906# 0.08353f
C197 a_2142_13666# VPWR 0.1072f
C198 a_13594_13969# a_13472_13814# 0.03255f
C199 a_13673_14066# a_13797_13765# 0.13707f
C200 a_14920_4026# a_14920_4742# 0.01275f
C201 sg13cmos5l_nor3_2_0.C sg13cmos5l_mux2_1_0.S 0.34309f
C202 a_4840_14610# a_4085_14482# 0.03591f
C203 a_5392_12458# a_5802_12216# 0.1396f
C204 a_7416_11772# sg13cmos5l_o21ai_1_0.Y 0.01087f
C205 sg13cmos5l_a21oi_1_0.B1 sg13cmos5l_nor2_1_3.Y 0.24292f
C206 a_11828_10668# a_11355_11458# 0.0116f
C207 a_1480_12302# VPWR 0.16627f
C208 sg13cmos5l_xor2_1_2.B a_4289_13156# 0.04143f
C209 a_4293_12227# a_4289_13156# 0.02358f
C210 sg13cmos5l_dfrbpq_1_7.CLK sg13cmos5l_nor3_2_0.C 1.00677f
C211 a_3876_10708# a_5135_11065# 0.01741f
C212 a_11854_14667# VPWR 0.21452f
C213 sg13cmos5l_dfrbpq_1_4.Q sg13cmos5l_a21oi_1_0.B1 0.58485f
C214 sg13cmos5l_dfrbpq_1_6.D sg13cmos5l_dfrbpq_1_6.RESET_B 0.15099f
C215 a_5349_9921# a_6097_10019# 0.01058f
C216 a_6191_10019# a_6858_10240# 0.13494f
C217 clk_i VPWR 2.74866f
C218 count_o[6] sg13cmos5l_a21oi_1_1.A1 0.19532f
C219 a_4395_10715# a_5135_11065# 0.3087f
C220 a_11828_10668# a_12141_11052# 0.0594f
C221 a_8881_10019# a_8133_9921# 0.01058f
C222 VPWR a_8133_9921# 0.25151f
C223 sg13cmos5l_nor2_1_0.B sg13cmos5l_nor2_1_0.Y 0.27879f
C224 sg13cmos5l_dfrbpq_1_6.Q sg13cmos5l_dfrbpq_1_7.Q 0.54965f
C225 sg13cmos5l_a21oi_1_0.B1 sg13cmos5l_xnor2_1_0.B 0.59552f
C226 a_6778_12180# VPWR 0.42141f
C227 VPWR a_3729_11776# 0.01072f
C228 a_5030_12966# sg13cmos5l_dfrbpq_1_0.Q 0.0442f
C229 VPWR a_7690_10165# 0.09656f
C230 VPWR a_1184_14610# 0.12003f
C231 sg13cmos5l_a21oi_1_0.Y sg13cmos5l_tiehi_5.L_HI 0.07084f
C232 sg13cmos5l_xnor2_1_0.B a_1914_13162# 0.05174f
C233 VPWR a_15016_13814# 0.17232f
C234 VPWR a_10715_13728# 0.278f
C235 sg13cmos5l_xor2_1_2.A a_3488_11586# 0.03994f
C236 a_4906_10165# a_4646_9942# 0.87117f
C237 a_8782_13995# sg13cmos5l_dfrbpq_1_4.D 0.19465f
C238 sg13cmos5l_tiehi_0.L_HI a_3590_11142# 0.11731f
C239 count_o[2] a_5516_14442# 0.29591f
C240 sg13cmos5l_dfrbpq_1_2.Q a_4577_13994# 0.01054f
C241 a_7528_13814# sg13cmos5l_xor2_1_2.B 0.06719f
C242 sg13cmos5l_dfrbpq_1_1.RESET_B sg13cmos5l_dfrbpq_1_0.Q 0.25795f
C243 sg13cmos5l_dfrbpq_1_6.D a_11639_12263# 0.29958f
C244 sg13cmos5l_dfrbpq_1_1.D sg13cmos5l_dfrbpq_1_2.Q 0.49738f
C245 sg13cmos5l_tiehi_0.L_HI sg13cmos5l_buf_1_0.X 0.04495f
C246 sg13cmos5l_dfrbpq_1_0.Q sg13cmos5l_a21oi_1_0.B1 0.18696f
C247 a_8486_12966# sg13cmos5l_xor2_1_2.B 0.02245f
C248 sg13cmos5l_dlygate4sd3_1_12.X a_11355_11458# 0.03107f
C249 count_o[7] VPWR 0.27983f
C250 sg13cmos5l_a21oi_1_0.B1 a_7177_10728# 0.04857f
C251 a_5802_10704# VPWR 0.45621f
C252 a_9178_13692# sg13cmos5l_dlygate4sd3_1_8.A 0.50824f
C253 sg13cmos5l_nor3_2_0.C sg13cmos5l_dfrbpq_1_5.Q 0.02798f
C254 sg13cmos5l_xor2_1_2.B sg13cmos5l_nand2_1_1.Y 0.56355f
C255 a_7242_13264# sg13cmos5l_nand2_1_1.A 0.13249f
C256 sg13cmos5l_o21ai_1_2.Y sg13cmos5l_dfrbpq_1_4.RESET_B 0.45607f
C257 sg13cmos5l_o21ai_1_0.B1 a_8878_10971# 0.20501f
C258 sg13cmos5l_buf_1_1.X a_4932_10260# 0.0121f
C259 a_14920_2514# a_15104_2514# 0.11523f
C260 a_1184_10790# sg13cmos5l_a21oi_1_0.B1 0.04303f
C261 sg13cmos5l_buf_1_1.X a_9232_10162# 0.01006f
C262 sg13cmos5l_dlygate4sd3_1_12.X a_12141_11052# 0.13677f
C263 a_8681_9530# a_8805_9229# 0.13707f
C264 sg13cmos5l_dfrbpq_1_4.D a_7849_12970# 0.03513f
C265 a_9370_14699# VPWR 0.0932f
C266 sg13cmos5l_dfrbpq_1_4.Q sg13cmos5l_dfrbpq_1_7.Q 0.20929f
C267 a_10791_12303# a_10943_12187# 0.66105f
C268 a_10812_12577# a_11733_12263# 0.43042f
C269 sg13cmos5l_dlygate4sd3_1_2.X sg13cmos5l_dfrbpq_1_1.D 0.55387f
C270 VPWR a_10702_12654# 0.0195f
C271 a_10112_10117# a_10444_9942# 0.1396f
C272 sg13cmos5l_or3_1_2.X sg13cmos5l_dfrbpq_1_4.D 0.08744f
C273 sg13cmos5l_buf_1_1.X VPWR 1.62572f
C274 a_8805_9229# VPWR 0.07877f
C275 a_5835_13088# a_5604_12979# 0.15089f
C276 sg13cmos5l_xor2_1_2.B sg13cmos5l_nor3_2_0.A 0.11005f
C277 a_7822_9459# VPWR 0.21778f
C278 a_8218_9156# sg13cmos5l_a21oi_1_0.Y 0.52378f
C279 VPWR sg13cmos5l_dfrbpq_1_3.Q 1.16845f
C280 sg13cmos5l_dfrbpq_1_4.D a_8772_13284# 0.01797f
C281 sg13cmos5l_dfrbpq_1_0.Q sg13cmos5l_dlygate4sd3_1_15.X 0.02606f
C282 sg13cmos5l_dfrbpq_1_1.RESET_B a_6575_13043# 0.19875f
C283 VPWR a_15016_10790# 0.17547f
C284 a_10288_13186# sg13cmos5l_inv_1_1.A 0.01308f
C285 sg13cmos5l_a21oi_1_0.A2 a_7716_10260# 0.02867f
C286 a_6575_13043# sg13cmos5l_a21oi_1_0.B1 0.01554f
C287 VPWR sg13cmos5l_buf_8_0.A 2.0867f
C288 count_o[6] VPWR 0.33256f
C289 a_9573_14521# a_9370_14699# 0.04716f
C290 VPWR a_13678_10131# 0.2254f
C291 a_13594_10945# a_13797_10741# 0.04716f
C292 a_10943_10212# a_10791_10160# 0.6663f
C293 sg13cmos5l_buf_1_1.X a_11639_10333# 0.03467f
C294 a_7849_12970# sg13cmos5l_nand2_1_1.A 0.05065f
C295 a_1480_10074# a_1664_10074# 0.11523f
C296 sg13cmos5l_nand4_1_1.A sg13cmos5l_nand3_1_1.Y 0.47737f
C297 a_4840_14610# VPWR 0.14774f
C298 sg13cmos5l_o21ai_1_0.B1 a_7177_10728# 0.37944f
C299 a_10943_10212# sg13cmos5l_dfrbpq_1_5.RESET_B 0.05307f
C300 clk_i sg13cmos5l_o21ai_1_0.Y 0.27178f
C301 sg13cmos5l_xor2_1_2.A a_4426_11422# 0.02723f
C302 sg13cmos5l_nor3_2_0.C a_10943_12187# 0.02794f
C303 VPWR sg13cmos5l_nand3_1_1.Y 1.12374f
C304 a_11733_10100# sg13cmos5l_dfrbpq_1_5.RESET_B 0.34402f
C305 VPWR a_9274_10668# 0.39523f
C306 a_5802_10704# a_6286_10971# 0.03282f
C307 a_7849_12970# a_7943_13264# 0.02103f
C308 a_5162_14776# sg13cmos5l_dfrbpq_1_1.D 0.01407f
C309 clk_i sg13cmos5l_nand4_1_0.C 0.38681f
C310 sg13cmos5l_mux2_1_0.A1 VPWR 0.24451f
C311 sg13cmos5l_dfrbpq_1_7.Q sg13cmos5l_dfrbpq_1_0.Q 0.1168f
C312 a_5835_13088# sg13cmos5l_dfrbpq_1_0.CLK 0.01959f
C313 a_10604_11752# a_10816_11752# 0.24335f
C314 sg13cmos5l_dfrbpq_1_1.RESET_B a_5030_12966# 0.11373f
C315 a_11828_10668# sg13cmos5l_dfrbpq_1_5.RESET_B 0.02035f
C316 a_10031_13043# a_10288_13186# 0.40419f
C317 count_o[5] VPWR 0.28135f
C318 sg13cmos5l_dfrbpq_1_7.CLK a_11355_11458# 1.09764f
C319 sg13cmos5l_mux2_1_0.A1 a_11639_10333# 0.05046f
C320 a_15104_7766# VPWR 0.05671f
C321 a_9291_13088# a_10031_13043# 0.3087f
C322 count_o[4] a_9836_14442# 0.29571f
C323 a_9189_12945# a_9291_13088# 0.66105f
C324 a_8772_13284# sg13cmos5l_dfrbpq_1_7.CLK 0.09435f
C325 a_10288_13186# a_9937_13043# 0.01017f
C326 a_14920_4742# VPWR 0.13817f
C327 a_8878_10971# a_8993_10970# 0.67711f
C328 count_o[2] sg13cmos5l_xor2_1_1.X 0.05439f
C329 sg13cmos5l_dfrbpq_1_1.RESET_B sg13cmos5l_a21oi_1_0.B1 0.01962f
C330 sg13cmos5l_mux2_1_0.A1 a_11195_9248# 0.15417f
C331 sg13cmos5l_xor2_1_2.B a_10812_12577# 0.02462f
C332 a_11171_13997# a_11469_13752# 0.02103f
C333 sg13cmos5l_mux2_1_0.X sg13cmos5l_dfrbpq_1_5.Q 0.04758f
C334 a_11078_10704# a_10808_10745# 0.33585f
C335 VPWR a_7918_10971# 0.21317f
C336 sg13cmos5l_nand4_1_1.A count_o[4] 0.09244f
C337 clk_i a_7624_13098# 0.0153f
C338 sg13cmos5l_xor2_1_2.B a_3761_11508# 0.42053f
C339 sg13cmos5l_dfrbpq_1_0.Q sg13cmos5l_xor2_1_2.A 0.04641f
C340 clk_i sg13cmos5l_dfrbpq_1_0.CLK 0.02598f
C341 VPWR a_3304_12302# 0.14265f
C342 sg13cmos5l_nor2_1_0.Y VPWR 0.65598f
C343 VPWR a_6664_11586# 0.14394f
C344 count_o[4] VPWR 0.30843f
C345 sg13cmos5l_dfrbpq_1_2.RESET_B a_4426_11422# 0.02447f
C346 VPWR a_5802_12216# 0.47422f
C347 sg13cmos5l_dfrbpq_1_7.CLK a_7716_10260# 0.08566f
C348 sg13cmos5l_buf_8_0.A sg13cmos5l_o21ai_1_0.Y 0.03494f
C349 VPWR a_1940_13264# 0.25021f
C350 a_8782_13995# sg13cmos5l_dfrbpq_1_4.RESET_B 0.01306f
C351 sg13cmos5l_dlygate4sd3_1_12.X sg13cmos5l_dfrbpq_1_5.RESET_B 0.02279f
C352 a_5626_11675# a_5829_11497# 0.04716f
C353 a_10112_12503# sg13cmos5l_dfrbpq_1_6.Q 0.13351f
C354 sg13cmos5l_dfrbpq_1_5.Q a_11355_11458# 0.01755f
C355 count_o[4] a_9573_14521# 0.07074f
C356 clk_i sg13cmos5l_dlygate4sd3_1_1.X 0.03999f
C357 a_14920_7050# a_15104_7050# 0.11523f
C358 VPWR a_5326_13995# 0.21555f
C359 a_7177_10728# sg13cmos5l_a21oi_1_0.A1 0.0421f
C360 a_6832_13186# VPWR 0.19187f
C361 VPWR a_4289_13156# 0.24983f
C362 a_9178_13692# sg13cmos5l_o21ai_1_2.Y 0.01343f
C363 a_6778_12180# sg13cmos5l_dlygate4sd3_1_1.X 0.01124f
C364 a_10702_9942# a_10812_9906# 0.4858f
C365 a_11594_10100# a_11639_10333# 0.36169f
C366 a_14074_9910# VPWR 0.38507f
C367 a_808_3144# VPWR 0.271f
C368 a_5326_13995# a_5441_13994# 0.67711f
C369 a_5802_10704# sg13cmos5l_dfrbpq_1_0.CLK 0.04605f
C370 a_10231_12180# a_10812_12577# 0.01741f
C371 a_2142_13666# sg13cmos5l_buf_1_0.X 0.01675f
C372 a_4577_13994# a_4570_12934# 0.01931f
C373 sg13cmos5l_dfrbpq_1_7.CLK sg13cmos5l_dfrbpq_1_6.RESET_B 0.03441f
C374 sg13cmos5l_dfrbpq_1_2.RESET_B sg13cmos5l_xnor2_1_0.B 2.24787f
C375 count_o[3] VPWR 0.2887f
C376 sg13cmos5l_dfrbpq_1_1.D a_4570_12934# 0.01095f
C377 a_10698_13264# sg13cmos5l_dfrbpq_1_6.Q 0.01355f
C378 a_8133_9921# a_8235_10064# 0.66105f
C379 sg13cmos5l_dfrbpq_1_0.Q a_6682_10668# 0.54445f
C380 a_15104_1002# VPWR 0.05685f
C381 a_6682_10668# a_7177_10728# 0.05097f
C382 sg13cmos5l_dfrbpq_1_7.CLK sg13cmos5l_dfrbpq_1_6.Q 0.01725f
C383 sg13cmos5l_inv_1_1.A sg13cmos5l_nor3_2_0.C 0.50492f
C384 VPWR sg13cmos5l_nor2_1_1.B 0.37193f
C385 a_12250_14446# a_12038_13728# 0.01258f
C386 sg13cmos5l_dfrbpq_1_7.Q sg13cmos5l_a21oi_1_0.B1 0.0272f
C387 a_5135_11065# sg13cmos5l_dfrbpq_1_0.RESET_B 0.03373f
C388 a_11072_13098# sg13cmos5l_dfrbpq_1_6.Q 0.07416f
C389 a_13472_10790# VPWR 0.06917f
C390 clk_i sg13cmos5l_dfrbpq_1_2.Q 0.02259f
C391 a_8772_13284# sg13cmos5l_dfrbpq_1_4.RESET_B 0.49474f
C392 sg13cmos5l_tiehi_5.L_HI a_8133_9921# 0.09646f
C393 a_7177_10728# sg13cmos5l_a21oi_1_0.A2 0.23447f
C394 clk_i sg13cmos5l_buf_1_0.X 0.43586f
C395 sg13cmos5l_nand4_1_1.A a_8486_12966# 0.01527f
C396 a_13594_10945# sg13cmos5l_dfrbpq_1_5.RESET_B 0.07271f
C397 sg13cmos5l_dfrbpq_1_0.CLK sg13cmos5l_buf_1_1.X 0.02682f
C398 a_5316_13284# VPWR 0.10649f
C399 sg13cmos5l_dfrbpq_1_2.RESET_B sg13cmos5l_dfrbpq_1_0.Q 0.03585f
C400 sg13cmos5l_mux2_1_0.S a_10231_9906# 0.01675f
C401 sg13cmos5l_a21oi_1_0.B1 a_5349_9921# 0.01185f
C402 a_10024_11586# VPWR 0.16649f
C403 sg13cmos5l_xor2_1_2.B a_4293_12227# 0.01255f
C404 a_9857_13994# VPWR 0.24597f
C405 sg13cmos5l_dfrbpq_1_0.CLK sg13cmos5l_dfrbpq_1_3.Q 1.22628f
C406 a_6382_12483# a_6176_12302# 0.03208f
C407 a_7528_13814# VPWR 0.20337f
C408 sg13cmos5l_nand3_1_0.Y sg13cmos5l_xnor2_1_0.B 0.04729f
C409 sg13cmos5l_dfrbpq_1_6.Q a_11264_14610# 0.06473f
C410 sg13cmos5l_dfrbpq_1_7.CLK a_10231_9906# 0.0148f
C411 a_8486_12966# VPWR 0.9356f
C412 a_7690_10165# sg13cmos5l_tiehi_5.L_HI 0.3454f
C413 sg13cmos5l_dfrbpq_1_0.CLK sg13cmos5l_buf_8_0.A 0.03708f
C414 sg13cmos5l_dfrbpq_1_3.Q a_2920_14516# 0.01166f
C415 sg13cmos5l_mux2_1_0.S a_10791_10160# 0.02614f
C416 a_3876_12220# a_5135_12577# 0.01741f
C417 count_o[2] VPWR 0.27862f
C418 a_9060_12979# VPWR 0.01304f
C419 VPWR sg13cmos5l_nand2_1_1.Y 0.60546f
C420 sg13cmos5l_nand4_1_0.Y sg13cmos5l_xnor2_1_0.B 0.06398f
C421 sg13cmos5l_a21oi_1_2.A1 sg13cmos5l_a21oi_1_0.B1 0.14764f
C422 sg13cmos5l_buf_1_1.X sg13cmos5l_mux2_1_0.A0 0.16973f
C423 a_3850_10672# a_4293_10715# 0.02241f
C424 a_11190_10728# a_11078_10704# 0.67711f
C425 a_1943_14033# VPWR 0.08539f
C426 sg13cmos5l_dfrbpq_1_7.CLK a_10791_10160# 0.04062f
C427 sg13cmos5l_mux2_1_0.S sg13cmos5l_dfrbpq_1_5.RESET_B 0.01784f
C428 sg13cmos5l_nor3_2_0.C a_10604_11752# 0.01492f
C429 sg13cmos5l_dlygate4sd3_1_1.X sg13cmos5l_dfrbpq_1_3.Q 0.01688f
C430 sg13cmos5l_nor3_2_0.C a_11768_13769# 0.01144f
C431 sg13cmos5l_dfrbpq_1_2.RESET_B a_5135_12577# 0.19897f
C432 a_7624_13098# sg13cmos5l_nand3_1_1.Y 0.04886f
C433 a_4395_12227# a_5135_12577# 0.3087f
C434 a_4426_11422# sg13cmos5l_dfrbpq_1_0.RESET_B 0.08414f
C435 VPWR sg13cmos5l_nand2_1_0.Y 0.9012f
C436 sg13cmos5l_xor2_1_2.B a_4462_13995# 0.05651f
C437 sg13cmos5l_a21oi_1_0.B1 a_2039_10023# 0.06622f
C438 a_12120_13284# VPWR 0.01784f
C439 sg13cmos5l_dfrbpq_1_5.Q sg13cmos5l_dfrbpq_1_6.RESET_B 0.03666f
C440 sg13cmos5l_dfrbpq_1_7.CLK sg13cmos5l_dfrbpq_1_5.RESET_B 0.02364f
C441 sg13cmos5l_dlygate4sd3_1_1.X sg13cmos5l_buf_8_0.A 0.03475f
C442 a_10698_13264# sg13cmos5l_dfrbpq_1_4.Q 0.16891f
C443 a_3876_10708# a_4395_10715# 0.38871f
C444 a_4293_10715# a_4164_11129# 0.01562f
C445 a_12250_14446# VPWR 0.39553f
C446 a_4160_10074# sg13cmos5l_nor2_1_3.B 0.04323f
C447 sg13cmos5l_nor2_1_3.Y sg13cmos5l_dfrbpq_1_0.RESET_B 0.14781f
C448 sg13cmos5l_xor2_1_1.X a_6106_13969# 0.06633f
C449 sg13cmos5l_o21ai_1_0.B1 sg13cmos5l_dfrbpq_1_7.Q 0.15908f
C450 sg13cmos5l_nand4_1_0.Y sg13cmos5l_dfrbpq_1_0.Q 0.07368f
C451 a_5349_9921# a_5220_9955# 0.01562f
C452 sg13cmos5l_nor3_2_0.A VPWR 0.44879f
C453 a_10984_9278# sg13cmos5l_mux2_1_0.S 0.04588f
C454 a_11072_13098# sg13cmos5l_dfrbpq_1_4.Q 0.0141f
C455 sg13cmos5l_buf_1_1.X a_8235_10064# 0.02332f
C456 a_9642_10240# a_8975_10019# 0.13494f
C457 a_8004_9955# a_8133_9921# 0.01562f
C458 VPWR a_7430_9942# 0.92788f
C459 a_8218_9156# a_8133_9921# 0.02322f
C460 sg13cmos5l_nor2_1_0.B a_1740_10970# 0.26683f
C461 sg13cmos5l_buf_1_1.X a_6448_10162# 0.01006f
C462 sg13cmos5l_nand2_1_1.A sg13cmos5l_dfrbpq_1_0.Q 0.71722f
C463 sg13cmos5l_dlygate4sd3_1_1.X sg13cmos5l_nand3_1_1.Y 0.01302f
C464 sg13cmos5l_a21oi_1_0.B1 sg13cmos5l_a21oi_1_0.A1 1.08081f
C465 count_o[1] VPWR 0.32162f
C466 sg13cmos5l_nand4_1_0.C a_1940_13264# 0.02499f
C467 sg13cmos5l_dfrbpq_1_4.D a_8897_13994# 0.01043f
C468 VPWR a_5626_11675# 0.0973f
C469 sg13cmos5l_mux2_1_0.A1 sg13cmos5l_mux2_1_0.A0 1.57841f
C470 sg13cmos5l_dfrbpq_1_4.Q a_11264_14610# 0.05839f
C471 sg13cmos5l_buf_1_1.X sg13cmos5l_tiehi_5.L_HI 0.07504f
C472 a_10231_12180# sg13cmos5l_xor2_1_2.B 0.04519f
C473 a_7822_9459# sg13cmos5l_tiehi_5.L_HI 0.01758f
C474 sg13cmos5l_dfrbpq_1_3.Q sg13cmos5l_dfrbpq_1_2.Q 0.72257f
C475 sg13cmos5l_buf_1_1.X sg13cmos5l_buf_1_0.X 0.49519f
C476 VPWR a_13673_14066# 0.15806f
C477 sg13cmos5l_nand4_1_0.C a_4289_13156# 0.02249f
C478 sg13cmos5l_dfrbpq_1_3.Q sg13cmos5l_buf_1_0.X 0.22914f
C479 a_4293_10715# VPWR 0.2443f
C480 sg13cmos5l_nor2_1_3.Y sg13cmos5l_nor2_1_3.B 0.2961f
C481 sg13cmos5l_dfrbpq_1_6.RESET_B a_10943_12187# 0.05204f
C482 a_11171_13997# sg13cmos5l_inv_1_1.A 0.34362f
C483 VPWR a_13797_13765# 0.07972f
C484 sg13cmos5l_dfrbpq_1_7.Q a_9642_10240# 0.1361f
C485 a_3876_10708# sg13cmos5l_xor2_1_2.A 0.03252f
C486 count_o[5] a_10784_14610# 0.0114f
C487 sg13cmos5l_dfrbpq_1_5.Q sg13cmos5l_dfrbpq_1_5.RESET_B 0.38303f
C488 a_4932_10260# a_5451_10064# 0.38902f
C489 a_5392_10946# VPWR 0.18658f
C490 a_5041_11065# sg13cmos5l_dfrbpq_1_3.Q 0.0102f
C491 a_11192_12970# sg13cmos5l_xor2_1_2.B 0.04792f
C492 sg13cmos5l_dfrbpq_1_0.Q sg13cmos5l_dfrbpq_1_0.RESET_B 0.01209f
C493 a_8986_14446# sg13cmos5l_dfrbpq_1_4.RESET_B 0.0625f
C494 a_3400_13814# sg13cmos5l_xor2_1_1.X 0.02781f
C495 a_7040_10790# sg13cmos5l_nand2_1_1.Y 0.04428f
C496 sg13cmos5l_buf_1_1.X a_4906_10165# 0.01791f
C497 sg13cmos5l_xor2_1_2.B a_4085_14482# 0.34857f
C498 sg13cmos5l_xor2_1_2.B sg13cmos5l_xor2_1_1.X 0.04397f
C499 sg13cmos5l_a21oi_1_0.A1 sg13cmos5l_dlygate4sd3_1_15.X 0.19032f
C500 sg13cmos5l_nand4_1_1.A a_8705_14668# 0.0106f
C501 sg13cmos5l_nand4_1_0.C sg13cmos5l_nor2_1_1.B 0.19302f
C502 count_o[0] VPWR 0.31605f
C503 sg13cmos5l_dfrbpq_1_0.CLK a_5802_12216# 0.02958f
C504 sg13cmos5l_tiehi_0.L_HI a_5135_11065# 0.19897f
C505 a_13288_10074# a_13288_10790# 0.01275f
C506 a_11462_12970# sg13cmos5l_xor2_1_2.B 0.03325f
C507 a_10688_10790# sg13cmos5l_dfrbpq_1_5.Q 0.07389f
C508 a_1943_13803# sg13cmos5l_dfrbpq_1_2.RESET_B 0.01787f
C509 sg13cmos5l_dfrbpq_1_1.RESET_B a_4395_12227# 0.01833f
C510 a_9370_14699# sg13cmos5l_o21ai_1_2.Y 0.06f
C511 sg13cmos5l_o21ai_1_0.B1 a_8993_10970# 0.01011f
C512 a_14920_1718# a_14920_1002# 0.01275f
C513 a_8590_14667# a_8705_14668# 0.67711f
C514 sg13cmos5l_o21ai_1_0.B1 sg13cmos5l_a21oi_1_0.A1 0.10426f
C515 VPWR a_5451_10064# 0.22667f
C516 count_o[3] a_7148_14442# 0.29036f
C517 sg13cmos5l_nand2_1_1.Y sg13cmos5l_o21ai_1_0.Y 0.01335f
C518 a_8705_14668# VPWR 0.23987f
C519 a_10812_12577# a_11594_12496# 0.4806f
C520 VPWR a_10812_12577# 0.1638f
C521 VPWR a_10112_10117# 0.46153f
C522 sg13cmos5l_nor2_1_3.Y a_4646_9942# 0.30411f
C523 a_7937_9458# VPWR 0.2434f
C524 a_1775_11074# sg13cmos5l_buf_1_0.X 0.01118f
C525 a_5316_13284# a_5604_12979# 0.4806f
C526 sg13cmos5l_a21oi_1_0.Y a_8602_9433# 0.06127f
C527 a_5733_12945# a_5290_13189# 0.02241f
C528 sg13cmos5l_dfrbpq_1_4.D a_8746_13189# 0.01087f
C529 sg13cmos5l_nor2_1_1.Y sg13cmos5l_nor2_1_0.Y 0.02203f
C530 clk_i a_8314_10668# 0.01197f
C531 a_11171_13997# a_11768_13769# 0.08233f
C532 a_10112_12503# a_10444_12654# 0.1396f
C533 sg13cmos5l_dfrbpq_1_0.Q a_6858_10240# 0.15224f
C534 a_10943_12187# a_11639_12263# 0.02453f
C535 VPWR a_3761_11508# 0.24936f
C536 VPWR a_11733_12263# 0.11089f
C537 a_13673_11042# a_13472_10790# 0.0167f
C538 sg13cmos5l_buf_1_1.X a_10812_9906# 0.01397f
C539 VPWR a_10444_9942# 0.19816f
C540 sg13cmos5l_dfrbpq_1_4.D sg13cmos5l_a21oi_1_0.B1 0.10479f
C541 sg13cmos5l_dfrbpq_1_7.Q a_8993_10970# 0.0109f
C542 a_11594_10100# sg13cmos5l_mux2_1_0.A0 0.02141f
C543 VPWR a_2039_10257# 0.11292f
C544 sg13cmos5l_dlygate4sd3_1_1.X a_4289_13156# 0.02117f
C545 sg13cmos5l_a21oi_1_0.A2 sg13cmos5l_dlygate4sd3_1_15.X 0.36081f
C546 a_7918_10971# sg13cmos5l_tiehi_5.L_HI 0.01522f
C547 a_10943_10212# a_11733_10100# 0.02241f
C548 sg13cmos5l_o21ai_1_2.Y sg13cmos5l_nand3_1_1.Y 0.03153f
C549 sg13cmos5l_nand4_1_0.C sg13cmos5l_nand2_1_0.Y 0.57682f
C550 a_2366_12582# sg13cmos5l_buf_1_0.X 0.01826f
C551 a_2238_10194# a_2039_10257# 0.16626f
C552 a_10988_14442# VPWR 0.25379f
C553 VPWR a_6106_13969# 0.10318f
C554 sg13cmos5l_nor3_2_0.C sg13cmos5l_buf_8_0.A 0.54997f
C555 sg13cmos5l_o21ai_1_0.B1 sg13cmos5l_a21oi_1_0.A2 0.01666f
C556 a_12022_12962# sg13cmos5l_inv_1_1.A 0.1174f
C557 VPWR a_8033_10970# 0.24047f
C558 a_10138_13692# a_9857_13994# 0.33585f
C559 a_3590_11142# sg13cmos5l_nor2_1_0.Y 0.29164f
C560 a_7457_9540# sg13cmos5l_a21oi_1_0.A1 0.01198f
C561 sg13cmos5l_o21ai_1_0.B1 a_8091_11458# 0.09476f
C562 sg13cmos5l_inv_1_1.A sg13cmos5l_o21ai_1_1.Y 0.27201f
C563 sg13cmos5l_nand2_1_1.A sg13cmos5l_a21oi_1_0.B1 1.56933f
C564 a_10444_12654# sg13cmos5l_dfrbpq_1_7.CLK 0.01083f
C565 a_11078_10704# VPWR 0.24598f
C566 sg13cmos5l_nor2_1_0.Y sg13cmos5l_buf_1_0.X 0.05074f
C567 a_5316_13284# sg13cmos5l_dfrbpq_1_0.CLK 0.09775f
C568 a_5733_12945# a_5835_13088# 0.66105f
C569 a_7355_9192# VPWR 0.27794f
C570 clk_i a_7242_13264# 0.01508f
C571 clk_i a_4570_12934# 0.01105f
C572 a_5802_12216# sg13cmos5l_dfrbpq_1_2.Q 0.13587f
C573 VPWR a_10808_10745# 0.36801f
C574 a_3488_10790# sg13cmos5l_nor2_1_0.Y 0.07082f
C575 sg13cmos5l_mux2_1_0.A1 a_10812_9906# 0.01542f
C576 a_15016_8562# VPWR 0.17266f
C577 a_8772_13284# a_10031_13043# 0.01741f
C578 sg13cmos5l_nor2_1_1.Y sg13cmos5l_nor2_1_1.B 0.17361f
C579 sg13cmos5l_a21oi_1_1.Y a_11768_13769# 0.51929f
C580 sg13cmos5l_dfrbpq_1_2.Q a_5326_13995# 0.03056f
C581 a_8486_12966# a_9291_13088# 0.11742f
C582 a_8772_13284# a_9189_12945# 0.48921f
C583 a_14920_5538# VPWR 0.13817f
C584 a_8772_13284# a_9937_13043# 0.4858f
C585 a_9291_13088# a_9060_12979# 0.15089f
C586 a_4085_14482# sg13cmos5l_xor2_1_1.X 0.01052f
C587 sg13cmos5l_nand4_1_1.A sg13cmos5l_xor2_1_2.B 1.27781f
C588 a_5516_14442# VPWR 0.33689f
C589 a_11192_12970# a_11462_12970# 0.33585f
C590 VPWR a_6401_10970# 0.26801f
C591 a_11768_13769# sg13cmos5l_o21ai_1_1.Y 0.01059f
C592 sg13cmos5l_dfrbpq_1_0.RESET_B a_5705_11400# 0.03029f
C593 a_808_3144# sg13cmos5l_buf_1_0.X 0.29373f
C594 sg13cmos5l_a21oi_1_0.B1 sg13cmos5l_dfrbpq_1_0.RESET_B 0.06439f
C595 clk_i a_7849_12970# 0.01103f
C596 a_3400_13814# VPWR 0.19211f
C597 sg13cmos5l_mux2_1_0.A1 a_11632_9562# 0.02007f
C598 clk_i a_5733_12945# 0.01836f
C599 sg13cmos5l_inv_1_1.A sg13cmos5l_dfrbpq_1_6.RESET_B 0.35695f
C600 VPWR a_4293_12227# 0.27228f
C601 sg13cmos5l_xor2_1_2.B VPWR 3.46129f
C602 a_1740_10970# VPWR 0.28372f
C603 a_7066_11458# sg13cmos5l_nand2_1_1.Y 0.02008f
C604 a_8897_13994# sg13cmos5l_dfrbpq_1_4.RESET_B 0.04875f
C605 sg13cmos5l_dlygate4sd3_1_2.X a_5326_13995# 0.19375f
C606 sg13cmos5l_dfrbpq_1_0.Q sg13cmos5l_dfrbpq_1_1.D 0.07064f
C607 a_7318_11450# sg13cmos5l_a21oi_1_0.B1 0.01069f
C608 sg13cmos5l_inv_1_1.A sg13cmos5l_dfrbpq_1_6.Q 2.12787f
C609 rst_ni a_808_8468# 0.33302f
C610 VPWR a_5392_12458# 0.20519f
C611 count_o[1] a_2920_14516# 0.2906f
C612 a_11368_14516# a_11854_14667# 0.03283f
C613 a_7177_10728# a_7373_10728# 0.01485f
C614 a_10702_9942# a_10231_9906# 0.32273f
C615 VPWR a_4462_13995# 0.21464f
C616 sg13cmos5l_dfrbpq_1_7.CLK a_8975_10019# 0.01826f
C617 sg13cmos5l_a21oi_1_0.B1 a_6858_10240# 0.01971f
C618 sg13cmos5l_nand2_1_1.A sg13cmos5l_dfrbpq_1_7.Q 0.14177f
C619 sg13cmos5l_a21oi_1_1.A2 a_10715_13728# 0.16794f
C620 a_10112_12503# sg13cmos5l_dfrbpq_1_7.Q 0.01184f
C621 VPWR a_3488_13098# 0.06649f
C622 a_4293_10715# sg13cmos5l_dfrbpq_1_0.CLK 0.35568f
C623 sg13cmos5l_dfrbpq_1_3.Q a_4570_12934# 0.5333f
C624 a_5220_9955# sg13cmos5l_dfrbpq_1_0.RESET_B 0.01936f
C625 sg13cmos5l_a21oi_1_0.B1 sg13cmos5l_nor2_1_3.B 0.14136f
C626 sg13cmos5l_dlygate4sd3_1_12.X a_11828_10668# 0.12879f
C627 sg13cmos5l_mux2_1_0.X sg13cmos5l_buf_1_1.X 0.08432f
C628 a_11594_10100# a_10812_9906# 0.4806f
C629 sg13cmos5l_o21ai_1_0.B1 sg13cmos5l_dfrbpq_1_7.CLK 0.01469f
C630 a_13472_10074# VPWR 0.06835f
C631 sg13cmos5l_a21oi_1_0.A2 sg13cmos5l_a21oi_1_0.A1 1.16483f
C632 a_14920_6254# a_14920_5538# 0.01275f
C633 a_14920_4026# VPWR 0.13977f
C634 a_8993_10970# a_8091_11458# 0.01654f
C635 sg13cmos5l_a21oi_1_1.Y a_10715_13728# 0.18612f
C636 a_8033_10970# sg13cmos5l_o21ai_1_0.Y 0.01675f
C637 a_4858_13692# a_4577_13994# 0.33585f
C638 sg13cmos5l_nor2_1_0.B VPWR 0.41971f
C639 sg13cmos5l_dfrbpq_1_1.D a_4858_13692# 0.02026f
C640 a_7808_12302# VPWR 0.09202f
C641 a_10031_13043# sg13cmos5l_dfrbpq_1_6.Q 0.03182f
C642 sg13cmos5l_mux2_1_0.X a_13678_10131# 0.0158f
C643 a_14920_4742# a_15104_4742# 0.11523f
C644 a_7716_10260# a_8133_9921# 0.48921f
C645 a_7430_9942# a_8235_10064# 0.11742f
C646 a_15104_1718# VPWR 0.05731f
C647 sg13cmos5l_buf_1_0.X sg13cmos5l_nand2_1_0.Y 0.30364f
C648 sg13cmos5l_dfrbpq_1_7.Q sg13cmos5l_mux2_1_0.S 0.01512f
C649 a_6286_10971# a_6401_10970# 0.67711f
C650 a_6185_14066# a_6309_13765# 0.13707f
C651 sg13cmos5l_nand2_1_1.A sg13cmos5l_a21oi_1_2.A1 0.01203f
C652 sg13cmos5l_o21ai_1_0.B1 a_7318_11450# 0.05615f
C653 a_10231_12180# VPWR 0.21104f
C654 a_4395_10715# sg13cmos5l_dfrbpq_1_0.RESET_B 0.01963f
C655 sg13cmos5l_inv_1_1.A sg13cmos5l_dfrbpq_1_4.Q 0.0136f
C656 a_9937_13043# sg13cmos5l_dfrbpq_1_6.Q 0.01606f
C657 sg13cmos5l_dfrbpq_1_7.CLK sg13cmos5l_dfrbpq_1_7.Q 0.61669f
C658 a_8746_13189# sg13cmos5l_dfrbpq_1_4.RESET_B 0.3638f
C659 sg13cmos5l_dfrbpq_1_0.CLK a_5451_10064# 0.03557f
C660 a_11190_10728# VPWR 0.21443f
C661 a_7690_10165# a_7716_10260# 0.43042f
C662 sg13cmos5l_tiehi_5.L_HI a_7430_9942# 0.12363f
C663 count_o[2] sg13cmos5l_dlygate4sd3_1_2.X 0.03838f
C664 sg13cmos5l_nand4_1_0.Y a_3668_13728# 0.03956f
C665 sg13cmos5l_a21oi_1_0.B1 a_4646_9942# 0.01065f
C666 a_4928_13098# VPWR 0.07894f
C667 sg13cmos5l_buf_1_1.X a_11355_11458# 0.01472f
C668 a_3850_12184# a_4293_12227# 0.02241f
C669 sg13cmos5l_xor2_1_2.B a_3850_12184# 0.01251f
C670 a_8213_13728# VPWR 0.3111f
C671 sg13cmos5l_dfrbpq_1_4.RESET_B sg13cmos5l_a21oi_1_0.B1 0.06779f
C672 count_o[1] sg13cmos5l_dfrbpq_1_2.Q 0.01109f
C673 sg13cmos5l_mux2_1_0.X sg13cmos5l_mux2_1_0.A1 0.15143f
C674 sg13cmos5l_dfrbpq_1_7.CLK a_9642_10240# 0.01137f
C675 a_5349_9921# sg13cmos5l_dfrbpq_1_0.RESET_B 0.06515f
C676 a_11355_11458# sg13cmos5l_buf_8_0.A 0.52714f
C677 sg13cmos5l_dfrbpq_1_2.RESET_B a_3876_12220# 0.49831f
C678 sg13cmos5l_mux2_1_0.S a_10943_10212# 0.02974f
C679 a_4293_12227# a_4164_12641# 0.01562f
C680 a_3304_12302# a_3488_12302# 0.11523f
C681 a_3876_12220# a_4395_12227# 0.38871f
C682 sg13cmos5l_xor2_1_2.B a_4164_12641# 0.01109f
C683 a_11192_12970# VPWR 0.33934f
C684 VPWR a_5829_11497# 0.07515f
C685 a_3876_10708# sg13cmos5l_nor2_1_3.B 0.03348f
C686 a_5030_12966# sg13cmos5l_dfrbpq_1_1.D 0.32781f
C687 sg13cmos5l_buf_1_1.X a_12141_11052# 0.37512f
C688 a_4094_13728# VPWR 0.0107f
C689 a_3590_11142# a_4293_10715# 0.02431f
C690 VPWR a_4085_14482# 0.59075f
C691 sg13cmos5l_dfrbpq_1_7.CLK a_10943_10212# 0.37159f
C692 sg13cmos5l_xor2_1_2.B sg13cmos5l_o21ai_1_0.Y 0.02555f
C693 a_15104_14610# VPWR 0.06319f
C694 sg13cmos5l_a21oi_1_0.Y sg13cmos5l_a21oi_1_0.B1 0.33727f
C695 VPWR sg13cmos5l_xor2_1_1.X 0.26675f
C696 sg13cmos5l_dfrbpq_1_2.RESET_B a_4395_12227# 0.55134f
C697 count_o[6] sg13cmos5l_a21oi_1_1.Y 0.02347f
C698 a_7849_12970# sg13cmos5l_nand3_1_1.Y 0.31612f
C699 a_6664_11586# a_6848_11586# 0.11523f
C700 a_11462_12970# VPWR 0.24762f
C701 a_4395_10715# sg13cmos5l_nor2_1_3.B 0.01406f
C702 a_10031_13043# sg13cmos5l_dfrbpq_1_4.Q 0.01194f
C703 sg13cmos5l_dfrbpq_1_0.Q a_5290_13189# 0.02766f
C704 sg13cmos5l_tiehi_0.L_HI sg13cmos5l_a21oi_1_0.B1 0.02982f
C705 sg13cmos5l_dfrbpq_1_1.RESET_B sg13cmos5l_dfrbpq_1_1.D 0.24012f
C706 sg13cmos5l_dfrbpq_1_1.D sg13cmos5l_a21oi_1_0.B1 0.39953f
C707 sg13cmos5l_xor2_1_2.B sg13cmos5l_nand4_1_0.C 0.19277f
C708 a_5451_10064# a_6448_10162# 0.06746f
C709 sg13cmos5l_xor2_1_2.A sg13cmos5l_dfrbpq_1_0.RESET_B 0.02501f
C710 a_4646_9942# a_5220_9955# 0.36169f
C711 a_7816_11586# VPWR 0.12734f
C712 a_11518_9562# sg13cmos5l_mux2_1_0.S 0.12002f
C713 sg13cmos5l_nand3_1_0.Y a_3968_14610# 0.04014f
C714 count_o[6] a_11368_14516# 0.2906f
C715 sg13cmos5l_dfrbpq_1_5.Q sg13cmos5l_dfrbpq_1_7.Q 0.46725f
C716 a_4293_10715# a_5041_11065# 0.01058f
C717 sg13cmos5l_a21oi_1_1.A1 VPWR 0.25065f
C718 a_8004_9955# a_7430_9942# 0.36169f
C719 sg13cmos5l_buf_1_1.X a_7716_10260# 0.02106f
C720 a_3642_13691# a_3400_13814# 0.03572f
C721 a_14828_14442# a_14624_14610# 0.03376f
C722 sg13cmos5l_o21ai_1_0.B1 sg13cmos5l_dfrbpq_1_4.RESET_B 0.01804f
C723 sg13cmos5l_dfrbpq_1_2.RESET_B sg13cmos5l_nand3_1_0.Y 0.03185f
C724 a_5135_11065# a_5802_10704# 0.13494f
C725 a_5392_10946# a_5041_11065# 0.01017f
C726 VPWR a_7240_10074# 0.14225f
C727 a_10988_14442# a_10784_14610# 0.03376f
C728 a_7937_9458# sg13cmos5l_tiehi_5.L_HI 0.01277f
C729 sg13cmos5l_a21oi_1_0.Y sg13cmos5l_dlygate4sd3_1_15.X 0.07147f
C730 sg13cmos5l_nand4_1_0.Y sg13cmos5l_dfrbpq_1_2.RESET_B 0.03129f
C731 a_1388_14442# a_1184_14610# 0.03376f
C732 a_4462_13995# sg13cmos5l_nand4_1_0.C 0.19351f
C733 a_3761_11508# a_3932_11752# 0.41432f
C734 a_6497_12482# VPWR 0.2728f
C735 a_9178_13692# a_8897_13994# 0.33585f
C736 a_6832_13186# a_7242_13264# 0.1396f
C737 a_3850_10672# VPWR 0.0942f
C738 a_4289_13156# a_4570_12934# 0.33585f
C739 sg13cmos5l_dfrbpq_1_4.RESET_B sg13cmos5l_dfrbpq_1_7.Q 0.10228f
C740 VPWR a_13288_13814# 0.14453f
C741 VPWR a_12038_13728# 0.24303f
C742 sg13cmos5l_xor2_1_2.A sg13cmos5l_nor2_1_3.B 0.07651f
C743 a_4646_9942# a_5349_9921# 0.02453f
C744 sg13cmos5l_dfrbpq_1_0.CLK a_4293_12227# 0.35375f
C745 sg13cmos5l_dfrbpq_1_0.CLK sg13cmos5l_xor2_1_2.B 0.07784f
C746 sg13cmos5l_xor2_1_2.B a_10816_11752# 0.04762f
C747 sg13cmos5l_buf_1_0.X a_2039_10257# 0.02401f
C748 sg13cmos5l_tiehi_0.L_HI a_3876_10708# 0.48467f
C749 a_5135_11065# sg13cmos5l_dfrbpq_1_3.Q 0.01558f
C750 a_10288_13186# sg13cmos5l_xor2_1_2.B 0.01617f
C751 a_14074_9910# sg13cmos5l_mux2_1_0.X 0.52288f
C752 sg13cmos5l_dfrbpq_1_6.RESET_B sg13cmos5l_buf_8_0.A 0.01562f
C753 clk_i sg13cmos5l_xnor2_1_0.B 0.06324f
C754 sg13cmos5l_nand4_1_0.Y sg13cmos5l_nand3_1_0.Y 0.04688f
C755 a_9836_14442# VPWR 0.33807f
C756 a_9291_13088# sg13cmos5l_xor2_1_2.B 0.02317f
C757 a_8033_10970# sg13cmos5l_tiehi_5.L_HI 0.03292f
C758 a_5451_10064# a_6191_10019# 0.3087f
C759 a_5733_12945# a_5802_12216# 0.01099f
C760 sg13cmos5l_dfrbpq_1_0.CLK a_5392_12458# 0.01019f
C761 sg13cmos5l_tiehi_0.L_HI a_4395_10715# 0.55134f
C762 sg13cmos5l_dlygate4sd3_1_12.X sg13cmos5l_dfrbpq_1_7.CLK 0.05648f
C763 a_8986_14446# a_9370_14699# 0.02409f
C764 sg13cmos5l_a21oi_1_2.A1 sg13cmos5l_dfrbpq_1_4.RESET_B 0.01304f
C765 VPWR a_4932_10260# 0.0876f
C766 a_14828_14442# sg13cmos5l_dfrbpq_1_5.Q 0.33093f
C767 a_10444_12654# sg13cmos5l_inv_1_1.A 0.02842f
C768 sg13cmos5l_dlygate4sd3_1_1.X a_4293_12227# 0.0108f
C769 sg13cmos5l_dlygate4sd3_1_1.X sg13cmos5l_xor2_1_2.B 0.26214f
C770 a_10812_12577# a_10791_12303# 0.38902f
C771 a_9573_14521# a_9836_14442# 0.03012f
C772 a_9232_10162# a_8881_10019# 0.01017f
C773 VPWR a_9232_10162# 0.19396f
C774 sg13cmos5l_nor2_1_3.Y a_4396_10240# 0.01554f
C775 sg13cmos5l_nand4_1_1.A VPWR 0.92066f
C776 a_8681_9530# VPWR 0.14136f
C777 a_8602_9433# a_8805_9229# 0.04716f
C778 a_5835_13088# a_6575_13043# 0.3087f
C779 a_8218_9156# a_7937_9458# 0.33585f
C780 a_5030_12966# a_5290_13189# 0.87117f
C781 clk_i sg13cmos5l_dfrbpq_1_0.Q 0.19942f
C782 a_1388_14442# sg13cmos5l_dfrbpq_1_3.Q 0.32083f
C783 a_8590_14667# VPWR 0.23537f
C784 sg13cmos5l_dlygate4sd3_1_8.A a_8213_13728# 0.18517f
C785 a_9449_14424# sg13cmos5l_dfrbpq_1_4.RESET_B 0.02708f
C786 VPWR a_11594_12496# 0.02325f
C787 sg13cmos5l_buf_1_1.X a_10791_10160# 0.02298f
C788 sg13cmos5l_dfrbpq_1_3.Q a_4426_11422# 0.05548f
C789 sg13cmos5l_dfrbpq_1_1.RESET_B a_6185_14066# 0.01792f
C790 sg13cmos5l_dlygate4sd3_1_1.X a_4462_13995# 0.0356f
C791 a_7816_11586# sg13cmos5l_o21ai_1_0.Y 0.02124f
C792 a_4426_11422# sg13cmos5l_buf_8_0.A 0.54377f
C793 VPWR a_2238_10194# 0.11711f
C794 sg13cmos5l_buf_1_1.X sg13cmos5l_nor2_1_3.Y 0.05429f
C795 sg13cmos5l_dfrbpq_1_1.RESET_B a_5290_13189# 0.34712f
C796 sg13cmos5l_buf_1_1.X sg13cmos5l_dfrbpq_1_5.RESET_B 0.85062f
C797 sg13cmos5l_nor3_2_0.C a_10812_12577# 0.06917f
C798 VPWR a_15016_12302# 0.18605f
C799 VPWR a_11639_10333# 0.94599f
C800 a_9573_14521# VPWR 0.06685f
C801 VPWR a_5441_13994# 0.24197f
C802 sg13cmos5l_xor2_1_2.B a_3932_11752# 0.0414f
C803 a_3642_13691# sg13cmos5l_xor2_1_1.X 0.25007f
C804 a_11574_13034# sg13cmos5l_inv_1_1.A 0.21006f
C805 sg13cmos5l_nor3_2_0.C a_11733_12263# 0.05244f
C806 a_4293_12227# sg13cmos5l_dfrbpq_1_2.Q 0.02833f
C807 a_9742_13995# a_9536_13814# 0.03208f
C808 sg13cmos5l_xor2_1_2.B sg13cmos5l_dfrbpq_1_2.Q 0.01952f
C809 sg13cmos5l_dfrbpq_1_5.D a_13678_10131# 0.20254f
C810 sg13cmos5l_tiehi_0.L_HI sg13cmos5l_xor2_1_2.A 0.12246f
C811 a_5733_12945# a_6481_13043# 0.01058f
C812 sg13cmos5l_xor2_1_2.B sg13cmos5l_buf_1_0.X 0.01231f
C813 a_10112_12503# sg13cmos5l_dfrbpq_1_7.CLK 0.01154f
C814 a_1740_10970# sg13cmos5l_buf_1_0.X 0.1638f
C815 a_5030_12966# a_5835_13088# 0.11742f
C816 a_11195_9248# VPWR 1.00205f
C817 a_5316_13284# a_5733_12945# 0.48921f
C818 clk_i a_6575_13043# 0.0187f
C819 sg13cmos5l_dlygate4sd3_1_12.X sg13cmos5l_dfrbpq_1_5.Q 0.87776f
C820 VPWR a_8672_10790# 0.07792f
C821 a_1418_10704# sg13cmos5l_nor2_1_0.Y 0.01578f
C822 sg13cmos5l_a21oi_1_0.Y sg13cmos5l_a21oi_1_0.A1 0.28552f
C823 sg13cmos5l_dlygate4sd3_1_2.X a_5516_14442# 0.04054f
C824 sg13cmos5l_or3_1_2.X a_8486_12966# 0.04459f
C825 sg13cmos5l_dfrbpq_1_0.CLK a_5829_11497# 0.01487f
C826 a_8746_13189# a_9189_12945# 0.02241f
C827 a_8486_12966# a_8772_13284# 0.50066f
C828 sg13cmos5l_mux2_1_0.A1 sg13cmos5l_dfrbpq_1_5.RESET_B 0.02442f
C829 sg13cmos5l_dfrbpq_1_1.RESET_B a_5835_13088# 0.56082f
C830 sg13cmos5l_dfrbpq_1_7.CLK sg13cmos5l_mux2_1_0.S 0.63129f
C831 a_10031_13043# sg13cmos5l_a21oi_1_0.B1 0.01028f
C832 a_14920_6254# VPWR 0.13817f
C833 a_8772_13284# a_9060_12979# 0.4806f
C834 sg13cmos5l_buf_1_0.X a_3488_13098# 0.04441f
C835 sg13cmos5l_dfrbpq_1_4.RESET_B a_8091_11458# 0.01185f
C836 sg13cmos5l_buf_1_1.X sg13cmos5l_dfrbpq_1_0.Q 0.02296f
C837 a_10698_13264# a_11072_13098# 0.03403f
C838 VPWR a_6286_10971# 0.2232f
C839 a_11768_13769# a_11969_14668# 0.01258f
C840 sg13cmos5l_dfrbpq_1_0.Q sg13cmos5l_dfrbpq_1_3.Q 0.02757f
C841 sg13cmos5l_dfrbpq_1_5.Q a_15016_11586# 0.01107f
C842 count_o[5] sg13cmos5l_dfrbpq_1_4.Q 0.09066f
C843 sg13cmos5l_nor2_1_0.B sg13cmos5l_buf_1_0.X 0.0405f
C844 sg13cmos5l_dfrbpq_1_0.Q sg13cmos5l_buf_8_0.A 0.05704f
C845 sg13cmos5l_xor2_1_2.B a_10791_12303# 0.03362f
C846 a_11195_9248# a_11695_9216# 0.03336f
C847 a_11518_9562# a_11421_9216# 0.02925f
C848 clk_i a_5030_12966# 0.01899f
C849 a_1943_14033# a_1856_13814# 0.05972f
C850 a_1943_13803# a_2142_13666# 0.16626f
C851 VPWR a_3850_12184# 0.1103f
C852 sg13cmos5l_inv_1_1.A sg13cmos5l_dfrbpq_1_6.D 0.03444f
C853 count_o[4] a_8986_14446# 0.02451f
C854 VPWR a_7040_10790# 0.07644f
C855 sg13cmos5l_o21ai_1_0.B1 a_8600_12582# 0.01155f
C856 sg13cmos5l_a21oi_1_0.Y sg13cmos5l_a21oi_1_0.A2 0.04002f
C857 a_1480_12302# sg13cmos5l_a21oi_1_0.B1 0.04883f
C858 a_1775_11074# sg13cmos5l_xnor2_1_0.B 0.01512f
C859 VPWR a_4164_12641# 0.02488f
C860 sg13cmos5l_inv_1_1.A sg13cmos5l_dfrbpq_1_7.Q 0.10424f
C861 sg13cmos5l_dfrbpq_1_4.D sg13cmos5l_dfrbpq_1_4.RESET_B 0.19095f
C862 sg13cmos5l_dfrbpq_1_0.Q sg13cmos5l_nand3_1_1.Y 0.05406f
C863 a_12120_13284# sg13cmos5l_o21ai_1_1.Y 0.01459f
C864 VPWR sg13cmos5l_o21ai_1_0.Y 0.44533f
C865 sg13cmos5l_dfrbpq_1_1.RESET_B clk_i 0.15393f
C866 clk_i sg13cmos5l_a21oi_1_0.B1 0.18723f
C867 a_12250_14446# sg13cmos5l_o21ai_1_1.Y 0.52861f
C868 a_11854_14667# a_11969_14668# 0.67711f
C869 sg13cmos5l_nor3_2_0.C sg13cmos5l_xor2_1_2.B 1.06562f
C870 a_8314_10668# a_8033_10970# 0.33585f
C871 a_14920_7766# a_15104_7766# 0.11523f
C872 clk_i a_1914_13162# 0.01125f
C873 sg13cmos5l_dfrbpq_1_0.CLK a_6497_12482# 0.01094f
C874 sg13cmos5l_dfrbpq_1_3.Q a_4858_13692# 0.02478f
C875 sg13cmos5l_dfrbpq_1_5.Q sg13cmos5l_mux2_1_0.S 0.13324f
C876 sg13cmos5l_nand4_1_1.A sg13cmos5l_dlygate4sd3_1_8.A 0.03731f
C877 a_11594_10100# a_10791_10160# 0.15089f
C878 a_10702_9942# a_10943_10212# 0.01058f
C879 VPWR sg13cmos5l_nand4_1_0.C 0.98506f
C880 a_12150_13752# a_12038_13728# 0.67711f
C881 clk_i a_8000_11586# 0.04663f
C882 a_9742_13995# sg13cmos5l_dfrbpq_1_7.Q 0.05092f
C883 sg13cmos5l_dfrbpq_1_7.CLK sg13cmos5l_dfrbpq_1_5.Q 0.07534f
C884 a_5604_12979# VPWR 0.01148f
C885 sg13cmos5l_dfrbpq_1_2.Q sg13cmos5l_xor2_1_1.X 1.42114f
C886 a_4840_14610# a_4858_13692# 0.01294f
C887 sg13cmos5l_nor2_1_3.B sg13cmos5l_dfrbpq_1_0.RESET_B 0.02858f
C888 sg13cmos5l_a21oi_1_0.B1 a_10715_13728# 0.01705f
C889 sg13cmos5l_buf_1_0.X sg13cmos5l_xor2_1_1.X 0.29792f
C890 sg13cmos5l_nand4_1_1.A a_8702_12582# 0.01728f
C891 sg13cmos5l_dlygate4sd3_1_8.A VPWR 0.29933f
C892 a_13793_10132# a_13678_10131# 0.67711f
C893 a_6497_12482# sg13cmos5l_dlygate4sd3_1_1.X 0.02418f
C894 a_3642_13691# VPWR 0.25558f
C895 a_7430_9942# a_7716_10260# 0.50066f
C896 sg13cmos5l_nor2_1_0.Y sg13cmos5l_xnor2_1_0.B 0.04306f
C897 a_15104_2514# VPWR 0.06102f
C898 a_8672_10790# sg13cmos5l_o21ai_1_0.Y 0.07116f
C899 a_5722_13692# a_6106_13969# 0.02409f
C900 a_10231_12180# a_10791_12303# 0.3087f
C901 a_10444_12654# a_10702_12654# 0.01017f
C902 a_7148_14442# VPWR 0.3408f
C903 a_9189_12945# sg13cmos5l_dfrbpq_1_7.Q 0.02232f
C904 a_13673_11042# VPWR 0.15754f
C905 sg13cmos5l_dfrbpq_1_0.CLK a_4932_10260# 0.07588f
C906 a_7177_10728# a_7918_10971# 0.03385f
C907 sg13cmos5l_xnor2_1_0.B a_1940_13264# 0.01076f
C908 a_9937_13043# sg13cmos5l_dfrbpq_1_7.Q 0.01333f
C909 a_8213_13728# sg13cmos5l_o21ai_1_2.Y 0.03603f
C910 clk_i sg13cmos5l_o21ai_1_0.B1 0.06077f
C911 sg13cmos5l_dlygate4sd3_1_2.X sg13cmos5l_xor2_1_1.X 0.02075f
C912 a_3590_12654# a_4293_12227# 0.02431f
C913 a_10138_13692# VPWR 0.3482f
C914 sg13cmos5l_xor2_1_2.B a_3590_12654# 0.01587f
C915 sg13cmos5l_dfrbpq_1_7.CLK sg13cmos5l_dfrbpq_1_4.RESET_B 0.01481f
C916 a_8018_12582# sg13cmos5l_nand3_1_1.Y 0.01091f
C917 sg13cmos5l_dfrbpq_1_0.Q sg13cmos5l_nor2_1_0.Y 0.07874f
C918 sg13cmos5l_dfrbpq_1_0.Q a_6664_11586# 0.01126f
C919 a_7624_13098# VPWR 0.15086f
C920 a_4646_9942# sg13cmos5l_dfrbpq_1_0.RESET_B 0.135f
C921 sg13cmos5l_dfrbpq_1_0.CLK VPWR 3.08304f
C922 a_10816_11752# VPWR 0.37918f
C923 a_12150_13752# VPWR 0.22536f
C924 sg13cmos5l_dfrbpq_1_0.Q a_5802_12216# 0.02145f
C925 a_10288_13186# VPWR 0.19177f
C926 a_3590_11142# a_3850_10672# 0.87117f
C927 sg13cmos5l_dfrbpq_1_7.CLK a_10943_12187# 0.37386f
C928 sg13cmos5l_buf_1_1.X sg13cmos5l_a21oi_1_0.B1 6.69963f
C929 VPWR a_2920_14516# 0.34367f
C930 a_9291_13088# VPWR 0.2133f
C931 a_13673_14066# a_13594_13969# 0.16626f
C932 clk_i sg13cmos5l_dfrbpq_1_7.Q 0.01317f
C933 sg13cmos5l_dfrbpq_1_3.Q sg13cmos5l_a21oi_1_0.B1 0.09709f
C934 sg13cmos5l_buf_8_0.A a_5705_11400# 0.02192f
C935 a_4293_12227# a_5041_12577# 0.01058f
C936 sg13cmos5l_dfrbpq_1_0.Q a_5326_13995# 0.02674f
C937 sg13cmos5l_a21oi_1_0.B1 sg13cmos5l_buf_8_0.A 0.01537f
C938 sg13cmos5l_mux2_1_0.A0 VPWR 0.64748f
C939 a_3590_11142# a_4164_11129# 0.36169f
C940 sg13cmos5l_dlygate4sd3_1_1.X VPWR 1.23547f
C941 a_13594_13969# a_13797_13765# 0.04716f
C942 a_13673_14066# sg13cmos5l_dfrbpq_1_6.RESET_B 0.01787f
C943 sg13cmos5l_xnor2_1_0.B sg13cmos5l_nor2_1_1.B 0.462f
C944 a_4840_14610# sg13cmos5l_a21oi_1_0.B1 0.04411f
C945 a_11192_12970# sg13cmos5l_nor3_2_0.C 0.01275f
C946 a_5392_12458# a_5041_12577# 0.01017f
C947 a_5135_12577# a_5802_12216# 0.13494f
C948 sg13cmos5l_nor2_1_1.Y VPWR 1.13675f
C949 count_o[6] a_11969_14668# 0.01071f
C950 sg13cmos5l_mux2_1_0.A0 a_11639_10333# 0.02181f
C951 a_4293_12227# a_4570_12934# 0.0225f
C952 sg13cmos5l_tiehi_0.L_HI sg13cmos5l_dfrbpq_1_0.RESET_B 0.02973f
C953 sg13cmos5l_xor2_1_2.B a_4570_12934# 0.05532f
C954 a_10784_14610# VPWR 0.0878f
C955 a_9232_10162# a_8235_10064# 0.06746f
C956 a_7937_9458# a_7716_10260# 0.01136f
C957 a_11171_13997# sg13cmos5l_xor2_1_2.B 0.26875f
C958 sg13cmos5l_a21oi_1_0.B1 sg13cmos5l_nand3_1_1.Y 0.03569f
C959 a_11462_12970# sg13cmos5l_nor3_2_0.C 0.05299f
C960 a_5392_10946# a_5135_11065# 0.40419f
C961 VPWR a_8235_10064# 0.22378f
C962 sg13cmos5l_buf_1_1.X sg13cmos5l_dlygate4sd3_1_15.X 0.16212f
C963 a_9232_10162# sg13cmos5l_tiehi_5.L_HI 0.17758f
C964 a_10988_14442# a_11368_14516# 0.07249f
C965 sg13cmos5l_mux2_1_0.A0 a_11195_9248# 0.02763f
C966 a_7822_9459# sg13cmos5l_dlygate4sd3_1_15.X 0.19375f
C967 VPWR a_6448_10162# 0.19343f
C968 a_8681_9530# sg13cmos5l_tiehi_5.L_HI 0.03031f
C969 a_4426_11422# a_5626_11675# 0.03179f
C970 sg13cmos5l_buf_1_1.X sg13cmos5l_o21ai_1_0.B1 0.07635f
C971 VPWR a_3932_11752# 0.25021f
C972 a_3590_11142# VPWR 0.93785f
C973 a_6575_13043# a_6832_13186# 0.40419f
C974 a_5316_13284# sg13cmos5l_dfrbpq_1_0.Q 0.03996f
C975 a_4174_13155# a_4289_13156# 0.67711f
C976 VPWR sg13cmos5l_tiehi_5.L_HI 1.49062f
C977 VPWR sg13cmos5l_dfrbpq_1_2.Q 1.15105f
C978 a_3876_10708# sg13cmos5l_dfrbpq_1_3.Q 0.02629f
C979 sg13cmos5l_xnor2_1_0.B sg13cmos5l_nand2_1_0.Y 0.34515f
C980 sg13cmos5l_dfrbpq_1_6.RESET_B a_10812_12577# 0.49109f
C981 VPWR sg13cmos5l_buf_1_0.X 4.20603f
C982 sg13cmos5l_o21ai_1_0.B1 sg13cmos5l_buf_8_0.A 0.43933f
C983 VPWR a_10496_13814# 0.07945f
C984 a_7849_12970# sg13cmos5l_xor2_1_2.B 0.30452f
C985 a_4293_10715# a_4426_11422# 0.06508f
C986 sg13cmos5l_tiehi_0.L_HI sg13cmos5l_nor2_1_3.B 0.19481f
C987 a_4906_10165# a_4932_10260# 0.43042f
C988 a_3488_10790# VPWR 0.11728f
C989 sg13cmos5l_buf_1_0.X a_2238_10194# 0.01173f
C990 count_o[2] sg13cmos5l_dfrbpq_1_0.Q 0.01129f
C991 sg13cmos5l_dfrbpq_1_0.Q sg13cmos5l_nand2_1_1.Y 0.40514f
C992 a_13793_10132# a_14074_9910# 0.33585f
C993 a_3642_13691# sg13cmos5l_nand4_1_0.C 0.02891f
C994 sg13cmos5l_or3_1_2.X sg13cmos5l_xor2_1_2.B 0.06949f
C995 sg13cmos5l_dfrbpq_1_6.RESET_B a_11733_12263# 0.31806f
C996 a_7177_10728# sg13cmos5l_nand2_1_1.Y 0.26695f
C997 sg13cmos5l_buf_1_1.X sg13cmos5l_dfrbpq_1_7.Q 0.01563f
C998 a_8772_13284# sg13cmos5l_xor2_1_2.B 0.02346f
C999 a_4932_10260# a_6191_10019# 0.01741f
C1000 count_o[0] a_1388_14442# 0.29036f
C1001 a_8705_14668# a_8986_14446# 0.33585f
C1002 sg13cmos5l_dfrbpq_1_7.Q sg13cmos5l_buf_8_0.A 0.07856f
C1003 sg13cmos5l_buf_1_1.X a_5349_9921# 0.0138f
C1004 a_14920_2514# a_14920_1718# 0.01095f
C1005 sg13cmos5l_dlygate4sd3_1_2.X VPWR 0.26138f
C1006 VPWR a_4906_10165# 0.0962f
C1007 a_10112_12503# sg13cmos5l_inv_1_1.A 0.04665f
C1008 sg13cmos5l_dlygate4sd3_1_1.X a_3850_12184# 0.03875f
C1009 sg13cmos5l_nor2_1_0.Y sg13cmos5l_a21oi_1_0.B1 0.32275f
C1010 sg13cmos5l_nand4_1_1.A sg13cmos5l_o21ai_1_2.Y 1.80157f
C1011 a_6575_13043# a_6481_13043# 0.32273f
C1012 a_10112_10117# a_10231_9906# 0.13494f
C1013 a_5316_13284# a_6575_13043# 0.01741f
C1014 a_12022_12962# sg13cmos5l_xor2_1_2.B 0.09901f
C1015 a_10988_14442# sg13cmos5l_dfrbpq_1_6.Q 0.01592f
C1016 a_2142_13666# sg13cmos5l_dfrbpq_1_2.RESET_B 0.0713f
C1017 a_14920_1002# a_15104_1002# 0.11523f
C1018 sg13cmos5l_o21ai_1_1.Y sg13cmos5l_xor2_1_2.B 0.02668f
C1019 VPWR a_6191_10019# 0.19771f
C1020 sg13cmos5l_dlygate4sd3_1_1.X a_4164_12641# 0.01825f
C1021 sg13cmos5l_dfrbpq_1_0.Q a_7430_9942# 0.02076f
C1022 sg13cmos5l_o21ai_1_2.Y VPWR 0.41675f
C1023 a_10812_12577# a_11639_12263# 0.50066f
C1024 a_10791_12303# a_11594_12496# 0.15089f
C1025 sg13cmos5l_dfrbpq_1_7.Q sg13cmos5l_nand3_1_1.Y 0.27921f
C1026 a_10702_9942# sg13cmos5l_mux2_1_0.S 0.01821f
C1027 VPWR a_10791_12303# 0.23509f
C1028 a_10231_9906# a_10444_9942# 0.40419f
C1029 sg13cmos5l_buf_1_1.X a_10943_10212# 0.01934f
C1030 count_o[7] a_14828_14442# 0.29036f
C1031 a_8218_9156# VPWR 0.33269f
C1032 sg13cmos5l_dfrbpq_1_7.Q a_9274_10668# 0.52452f
C1033 a_1914_13162# a_1940_13264# 0.41432f
C1034 clk_i a_8091_11458# 0.53036f
C1035 sg13cmos5l_xor2_1_1.X a_5722_13692# 0.51774f
C1036 a_3761_11508# a_4426_11422# 0.03912f
C1037 sg13cmos5l_dfrbpq_1_1.RESET_B a_6832_13186# 0.17693f
C1038 sg13cmos5l_buf_1_1.X a_2039_10023# 0.03204f
C1039 VPWR a_1480_10074# 0.15409f
C1040 a_11733_12263# a_11639_12263# 0.87117f
C1041 sg13cmos5l_buf_1_1.X sg13cmos5l_xor2_1_2.A 0.06059f
C1042 sg13cmos5l_nand4_1_1.A sg13cmos5l_nor3_2_0.C 0.24318f
C1043 a_9449_14424# a_9370_14699# 0.16626f
C1044 a_13288_10790# a_13472_10790# 0.11523f
C1045 clk_i sg13cmos5l_dfrbpq_1_2.RESET_B 0.09322f
C1046 a_10444_9942# a_10791_10160# 0.07014f
C1047 sg13cmos5l_buf_1_1.X a_11733_10100# 0.02136f
C1048 VPWR a_10812_9906# 0.07608f
C1049 sg13cmos5l_dfrbpq_1_3.Q sg13cmos5l_xor2_1_2.A 1.76487f
C1050 sg13cmos5l_dfrbpq_1_7.CLK sg13cmos5l_inv_1_1.A 0.02578f
C1051 sg13cmos5l_dlygate4sd3_1_1.X sg13cmos5l_nand4_1_0.C 0.23512f
C1052 a_10444_9942# sg13cmos5l_dfrbpq_1_5.RESET_B 0.17013f
C1053 sg13cmos5l_xor2_1_2.A sg13cmos5l_buf_8_0.A 0.10944f
C1054 sg13cmos5l_nor3_2_0.C a_11594_12496# 0.02706f
C1055 sg13cmos5l_a21oi_1_0.A2 a_7690_10165# 0.01355f
C1056 sg13cmos5l_nor3_2_0.C VPWR 2.2422f
C1057 a_10812_9906# a_11639_10333# 0.50066f
C1058 a_11828_10668# sg13cmos5l_buf_1_1.X 0.33823f
C1059 a_5030_12966# a_5316_13284# 0.50066f
C1060 sg13cmos5l_dlygate4sd3_1_1.X a_3642_13691# 0.09773f
C1061 sg13cmos5l_buf_1_1.X sg13cmos5l_a21oi_1_0.A1 0.02964f
C1062 a_7849_12970# a_8045_13264# 0.01485f
C1063 sg13cmos5l_or3_1_2.X a_8213_13728# 0.11046f
C1064 sg13cmos5l_a21oi_1_0.B1 sg13cmos5l_nor2_1_1.B 0.096f
C1065 sg13cmos5l_tiehi_5.L_HI sg13cmos5l_o21ai_1_0.Y 0.03334f
C1066 sg13cmos5l_mux2_1_0.A1 a_10943_10212# 0.02275f
C1067 sg13cmos5l_xor2_1_2.B sg13cmos5l_dfrbpq_1_6.RESET_B 0.06316f
C1068 a_9291_13088# a_10138_13692# 0.01085f
C1069 rst_ni sg13cmos5l_buf_1_1.X 0.0112f
C1070 clk_i sg13cmos5l_nand3_1_0.Y 0.02732f
C1071 sg13cmos5l_buf_1_1.X a_808_8468# 0.29573f
C1072 a_10988_14442# sg13cmos5l_dfrbpq_1_4.Q 0.32949f
C1073 a_10604_11752# sg13cmos5l_mux2_1_0.S 0.10663f
C1074 a_1914_13162# sg13cmos5l_nor2_1_1.B 0.25369f
C1075 a_6106_13969# a_6309_13765# 0.04716f
C1076 sg13cmos5l_dfrbpq_1_6.Q sg13cmos5l_xor2_1_2.B 1.49258f
C1077 a_8746_13189# a_8486_12966# 0.87117f
C1078 sg13cmos5l_dfrbpq_1_1.RESET_B a_5316_13284# 0.47903f
C1079 a_10031_13043# a_10698_13264# 0.13494f
C1080 clk_i sg13cmos5l_nand4_1_0.Y 0.56297f
C1081 sg13cmos5l_mux2_1_0.A1 a_11733_10100# 0.02057f
C1082 a_9291_13088# a_10288_13186# 0.06746f
C1083 a_14920_7050# VPWR 0.13817f
C1084 count_o[4] sg13cmos5l_dfrbpq_1_7.Q 0.01119f
C1085 a_8486_12966# sg13cmos5l_a21oi_1_0.B1 0.01359f
C1086 clk_i sg13cmos5l_nand2_1_1.A 0.20366f
C1087 a_9189_12945# sg13cmos5l_dfrbpq_1_7.CLK 0.35663f
C1088 sg13cmos5l_dfrbpq_1_0.CLK sg13cmos5l_dlygate4sd3_1_1.X 0.28557f
C1089 sg13cmos5l_buf_1_0.X sg13cmos5l_nand4_1_0.C 1.021f
C1090 count_o[2] sg13cmos5l_a21oi_1_0.B1 0.02045f
C1091 sg13cmos5l_a21oi_1_0.B1 sg13cmos5l_nand2_1_1.Y 0.53805f
C1092 a_9274_10668# a_8993_10970# 0.33585f
C1093 a_15104_4742# VPWR 0.05657f
C1094 a_11828_10668# sg13cmos5l_mux2_1_0.A1 0.28295f
C1095 sg13cmos5l_mux2_1_0.A1 a_11518_9562# 0.57058f
C1096 a_11518_9562# a_11421_9562# 0.01637f
C1097 a_1943_13803# a_1943_14033# 0.13707f
C1098 VPWR a_3590_12654# 0.96826f
C1099 sg13cmos5l_buf_1_1.X sg13cmos5l_a21oi_1_0.A2 0.02932f
C1100 a_3876_12220# sg13cmos5l_dfrbpq_1_3.Q 0.0152f
C1101 a_6778_12180# sg13cmos5l_nand2_1_1.A 0.52538f
C1102 VPWR a_8314_10668# 0.32877f
C1103 a_7822_9459# sg13cmos5l_a21oi_1_0.A2 0.03542f
C1104 a_3642_13691# sg13cmos5l_buf_1_0.X 0.02962f
C1105 sg13cmos5l_a21oi_1_1.A2 sg13cmos5l_a21oi_1_1.A1 0.27886f
C1106 sg13cmos5l_dlygate4sd3_1_12.X sg13cmos5l_buf_1_1.X 0.58449f
C1107 a_4293_12227# a_4426_11422# 0.03082f
C1108 sg13cmos5l_xor2_1_2.B a_4426_11422# 0.03965f
C1109 a_1914_13162# sg13cmos5l_nand2_1_0.Y 0.40979f
C1110 VPWR a_3488_12302# 0.07063f
C1111 sg13cmos5l_dfrbpq_1_2.RESET_B sg13cmos5l_dfrbpq_1_3.Q 0.01427f
C1112 sg13cmos5l_buf_8_0.A a_8091_11458# 1.0873f
C1113 a_4395_12227# sg13cmos5l_dfrbpq_1_3.Q 0.02541f
C1114 sg13cmos5l_a21oi_1_1.Y sg13cmos5l_a21oi_1_1.A1 1.49851f
C1115 VPWR a_6848_11586# 0.07086f
C1116 sg13cmos5l_nor2_1_1.Y sg13cmos5l_dlygate4sd3_1_1.X 0.01851f
C1117 a_11969_14668# a_12250_14446# 0.33585f
C1118 VPWR a_5041_12577# 0.02087f
C1119 sg13cmos5l_dfrbpq_1_7.CLK a_8133_9921# 0.34586f
C1120 a_10231_12180# sg13cmos5l_dfrbpq_1_6.RESET_B 0.19875f
C1121 sg13cmos5l_nor2_1_0.Y sg13cmos5l_xor2_1_2.A 0.05283f
C1122 a_5733_12945# a_6497_12482# 0.01267f
C1123 sg13cmos5l_dfrbpq_1_4.Q sg13cmos5l_xor2_1_2.B 0.07388f
C1124 VPWR a_2366_13288# 0.01092f
C1125 a_9178_13692# sg13cmos5l_dfrbpq_1_4.RESET_B 0.087f
C1126 a_5626_11675# a_5705_11400# 0.16626f
C1127 sg13cmos5l_dfrbpq_1_0.CLK sg13cmos5l_dfrbpq_1_2.Q 1.68355f
C1128 count_o[4] a_9449_14424# 0.07453f
C1129 sg13cmos5l_a21oi_1_1.A1 sg13cmos5l_o21ai_1_1.Y 0.01739f
C1130 a_14920_7050# a_14920_6254# 0.01095f
C1131 a_11594_10100# a_10943_10212# 0.01562f
C1132 a_7918_10971# sg13cmos5l_a21oi_1_0.A1 0.20051f
C1133 VPWR a_5722_13692# 0.32865f
C1134 sg13cmos5l_dfrbpq_1_2.Q a_2920_14516# 0.33098f
C1135 a_7242_13264# VPWR 0.46673f
C1136 VPWR a_4570_12934# 0.36244f
C1137 sg13cmos5l_nand3_1_0.Y sg13cmos5l_dfrbpq_1_3.Q 0.06191f
C1138 sg13cmos5l_o21ai_1_0.B1 sg13cmos5l_nand2_1_1.Y 0.35409f
C1139 a_11171_13997# VPWR 0.36989f
C1140 a_8782_13995# VPWR 0.21347f
C1141 sg13cmos5l_dlygate4sd3_1_12.X sg13cmos5l_mux2_1_0.A1 0.28368f
C1142 a_14920_5538# a_15104_5538# 0.11523f
C1143 sg13cmos5l_mux2_1_0.X VPWR 0.86338f
C1144 a_15016_11586# a_15016_10790# 0.01095f
C1145 a_15016_3230# VPWR 0.17729f
C1146 a_1740_10970# sg13cmos5l_xnor2_1_0.B 0.43319f
C1147 sg13cmos5l_dlygate4sd3_1_1.X sg13cmos5l_dfrbpq_1_2.Q 1.42937f
C1148 a_9857_13994# sg13cmos5l_dfrbpq_1_7.Q 0.05757f
C1149 a_5722_13692# a_5441_13994# 0.33585f
C1150 a_5516_14442# sg13cmos5l_dfrbpq_1_0.Q 0.33093f
C1151 a_11192_12970# sg13cmos5l_dfrbpq_1_6.Q 0.51455f
C1152 count_o[7] a_14624_14610# 0.01144f
C1153 a_13472_10074# sg13cmos5l_dfrbpq_1_5.D 0.01341f
C1154 sg13cmos5l_mux2_1_0.X a_11639_10333# 0.01671f
C1155 sg13cmos5l_dfrbpq_1_0.Q a_6401_10970# 0.01638f
C1156 sg13cmos5l_dlygate4sd3_1_15.X a_7430_9942# 0.29049f
C1157 sg13cmos5l_nor2_1_1.Y sg13cmos5l_buf_1_0.X 0.02882f
C1158 sg13cmos5l_nand4_1_1.A a_7849_12970# 0.37739f
C1159 sg13cmos5l_nand2_1_1.A sg13cmos5l_buf_8_0.A 0.02297f
C1160 a_10031_13043# sg13cmos5l_dfrbpq_1_4.RESET_B 0.19875f
C1161 sg13cmos5l_o21ai_1_1.Y a_12038_13728# 0.02445f
C1162 a_3590_12654# a_3850_12184# 0.87117f
C1163 a_5802_10704# sg13cmos5l_dfrbpq_1_0.RESET_B 0.0177f
C1164 sg13cmos5l_dfrbpq_1_0.Q sg13cmos5l_xor2_1_2.B 2.43434f
C1165 a_13797_10741# VPWR 0.07699f
C1166 a_9189_12945# sg13cmos5l_dfrbpq_1_4.RESET_B 0.06152f
C1167 sg13cmos5l_xor2_1_2.B a_7177_10728# 0.27767f
C1168 sg13cmos5l_nand4_1_1.A sg13cmos5l_or3_1_2.X 0.61944f
C1169 sg13cmos5l_tiehi_5.L_HI a_8235_10064# 0.60226f
C1170 sg13cmos5l_mux2_1_0.X a_11195_9248# 0.02152f
C1171 a_7849_12970# VPWR 0.38177f
C1172 sg13cmos5l_nand4_1_1.A a_8772_13284# 0.0354f
C1173 a_6682_10668# a_6664_11586# 0.01294f
C1174 a_5733_12945# VPWR 0.25494f
C1175 sg13cmos5l_a21oi_1_0.B1 a_5451_10064# 0.01131f
C1176 a_11355_11458# VPWR 1.15854f
C1177 sg13cmos5l_buf_1_1.X sg13cmos5l_mux2_1_0.S 0.02593f
C1178 sg13cmos5l_dfrbpq_1_0.Q a_5392_12458# 0.04969f
C1179 a_3590_12654# a_4164_12641# 0.36169f
C1180 sg13cmos5l_a21oi_1_1.A2 VPWR 0.28406f
C1181 a_6382_12483# a_6497_12482# 0.67711f
C1182 sg13cmos5l_nand2_1_1.A sg13cmos5l_nand3_1_1.Y 0.21889f
C1183 sg13cmos5l_or3_1_2.X VPWR 0.44011f
C1184 sg13cmos5l_dfrbpq_1_6.Q sg13cmos5l_a21oi_1_1.A1 0.07775f
C1185 sg13cmos5l_buf_1_1.X sg13cmos5l_dfrbpq_1_7.CLK 2.97845f
C1186 sg13cmos5l_nor2_1_0.B sg13cmos5l_xnor2_1_0.B 0.06839f
C1187 sg13cmos5l_dfrbpq_1_7.Q sg13cmos5l_nor3_2_0.A 0.01346f
C1188 a_8772_13284# VPWR 0.12097f
C1189 sg13cmos5l_mux2_1_0.S sg13cmos5l_buf_8_0.A 0.03641f
C1190 a_8314_10668# sg13cmos5l_o21ai_1_0.Y 0.52536f
C1191 sg13cmos5l_a21oi_1_1.Y VPWR 0.21789f
C1192 sg13cmos5l_dfrbpq_1_2.Q sg13cmos5l_buf_1_0.X 0.86656f
C1193 sg13cmos5l_dfrbpq_1_5.Q a_15016_13814# 0.01107f
C1194 sg13cmos5l_buf_1_1.X sg13cmos5l_dfrbpq_1_0.RESET_B 0.05653f
C1195 a_7800_13708# sg13cmos5l_nand3_1_1.Y 0.01035f
C1196 a_12141_11052# VPWR 0.46412f
C1197 sg13cmos5l_dfrbpq_1_7.CLK sg13cmos5l_buf_8_0.A 0.23549f
C1198 a_3876_10708# a_4293_10715# 0.49014f
C1199 sg13cmos5l_dfrbpq_1_3.Q sg13cmos5l_dfrbpq_1_0.RESET_B 0.03583f
C1200 a_1856_13814# VPWR 0.11694f
C1201 a_13673_14066# a_13472_13814# 0.0167f
C1202 sg13cmos5l_nor3_2_0.C a_10816_11752# 0.06285f
C1203 a_5392_12458# a_5135_12577# 0.40419f
C1204 sg13cmos5l_buf_8_0.A sg13cmos5l_dfrbpq_1_0.RESET_B 0.08979f
C1205 sg13cmos5l_a21oi_1_0.B1 a_2039_10257# 0.06898f
C1206 a_12022_12962# VPWR 0.01888f
C1207 sg13cmos5l_mux2_1_0.A0 a_10812_9906# 0.01643f
C1208 a_3304_12302# a_3304_13098# 0.01095f
C1209 a_11192_12970# sg13cmos5l_dfrbpq_1_4.Q 0.05668f
C1210 a_4293_10715# a_4395_10715# 0.6663f
C1211 sg13cmos5l_o21ai_1_1.Y VPWR 0.81856f
C1212 count_o[7] sg13cmos5l_dfrbpq_1_5.Q 0.01095f
C1213 a_11368_14516# VPWR 0.25346f
C1214 sg13cmos5l_dfrbpq_1_1.RESET_B a_6106_13969# 0.07147f
C1215 a_7702_14106# sg13cmos5l_nand3_1_1.Y 0.08085f
C1216 a_7808_12302# sg13cmos5l_dfrbpq_1_0.Q 0.0472f
C1217 a_5451_10064# a_5220_9955# 0.15089f
C1218 a_6191_10019# a_6448_10162# 0.40419f
C1219 a_4932_10260# a_6097_10019# 0.4858f
C1220 sg13cmos5l_mux2_1_0.A1 sg13cmos5l_mux2_1_0.S 0.05569f
C1221 sg13cmos5l_dlygate4sd3_1_2.X sg13cmos5l_dfrbpq_1_2.Q 0.05504f
C1222 sg13cmos5l_nor3_2_0.C sg13cmos5l_dlygate4sd3_1_1.X 0.15281f
C1223 a_4395_10715# a_5392_10946# 0.07014f
C1224 a_8004_9955# a_8235_10064# 0.15089f
C1225 a_8881_10019# a_7716_10260# 0.4858f
C1226 VPWR a_7716_10260# 0.0727f
C1227 sg13cmos5l_a21oi_1_0.Y a_8133_9921# 0.01186f
C1228 a_6382_12483# VPWR 0.23851f
C1229 sg13cmos5l_buf_1_1.X sg13cmos5l_nor2_1_3.B 0.02335f
C1230 VPWR a_3488_11586# 0.09204f
C1231 clk_i sg13cmos5l_dfrbpq_1_1.D 0.02935f
C1232 a_8004_9955# sg13cmos5l_tiehi_5.L_HI 0.02309f
C1233 sg13cmos5l_dfrbpq_1_3.Q sg13cmos5l_nor2_1_3.B 0.05385f
C1234 sg13cmos5l_dfrbpq_1_4.Q sg13cmos5l_a21oi_1_1.A1 0.02866f
C1235 a_10444_12654# sg13cmos5l_xor2_1_2.B 0.0111f
C1236 a_8218_9156# sg13cmos5l_tiehi_5.L_HI 0.06135f
C1237 sg13cmos5l_buf_1_1.X sg13cmos5l_dfrbpq_1_5.Q 0.17746f
C1238 VPWR a_13594_13969# 0.10206f
C1239 sg13cmos5l_dfrbpq_1_5.Q sg13cmos5l_buf_8_0.A 0.17071f
C1240 a_14920_4026# a_15104_4026# 0.11523f
C1241 VPWR sg13cmos5l_dfrbpq_1_6.RESET_B 2.63527f
C1242 sg13cmos5l_a21oi_1_0.A1 a_7430_9942# 0.02028f
C1243 a_8746_13189# sg13cmos5l_xor2_1_2.B 0.0199f
C1244 sg13cmos5l_dfrbpq_1_0.Q sg13cmos5l_xor2_1_1.X 0.11978f
C1245 a_5349_9921# a_5451_10064# 0.66105f
C1246 a_5135_11065# VPWR 0.17697f
C1247 sg13cmos5l_dfrbpq_1_6.Q VPWR 0.92879f
C1248 a_7355_9192# sg13cmos5l_dlygate4sd3_1_15.X 0.08063f
C1249 a_9370_14699# sg13cmos5l_dfrbpq_1_4.RESET_B 0.08988f
C1250 sg13cmos5l_o21ai_1_0.B1 a_8033_10970# 0.01148f
C1251 sg13cmos5l_buf_1_1.X a_4646_9942# 0.01794f
C1252 VPWR a_4160_10074# 0.11728f
C1253 sg13cmos5l_dlygate4sd3_1_1.X a_3590_12654# 0.04969f
C1254 sg13cmos5l_xor2_1_2.B sg13cmos5l_a21oi_1_0.B1 1.93512f
C1255 a_9642_10240# a_10112_10117# 0.03469f
C1256 sg13cmos5l_nor2_1_1.Y a_3590_12654# 0.29622f
C1257 a_8681_9530# a_8602_9433# 0.16626f
C1258 a_11574_13034# sg13cmos5l_xor2_1_2.B 0.05176f
C1259 sg13cmos5l_dfrbpq_1_1.RESET_B a_5392_12458# 0.01111f
C1260 a_8986_14446# VPWR 0.32686f
C1261 a_10702_12654# a_10943_12187# 0.01058f
C1262 sg13cmos5l_dfrbpq_1_2.RESET_B sg13cmos5l_nand2_1_0.Y 0.12397f
C1263 a_7242_13264# a_7624_13098# 0.03295f
C1264 VPWR a_10231_9906# 0.19874f
C1265 a_8602_9433# VPWR 0.09687f
C1266 sg13cmos5l_nor2_1_1.Y a_3488_12302# 0.07193f
C1267 sg13cmos5l_a21oi_1_0.Y sg13cmos5l_buf_1_1.X 0.0756f
C1268 a_5733_12945# a_5604_12979# 0.01562f
C1269 a_15104_10074# VPWR 0.07833f
C1270 a_7822_9459# sg13cmos5l_a21oi_1_0.Y 0.01725f
C1271 sg13cmos5l_dfrbpq_1_4.D a_8486_12966# 0.33114f
C1272 VPWR a_1388_14442# 0.34014f
C1273 sg13cmos5l_buf_1_1.X a_1664_10074# 0.04525f
C1274 a_10231_12180# a_10444_12654# 0.40419f
C1275 sg13cmos5l_dfrbpq_1_0.Q a_7240_10074# 0.02427f
C1276 a_10031_13043# sg13cmos5l_inv_1_1.A 0.0211f
C1277 a_11594_12496# a_11639_12263# 0.36169f
C1278 sg13cmos5l_a21oi_1_0.A2 a_7430_9942# 0.05957f
C1279 VPWR a_4426_11422# 1.14336f
C1280 VPWR a_11639_12263# 0.97858f
C1281 a_13673_11042# a_13797_10741# 0.13707f
C1282 a_13594_10945# a_13472_10790# 0.03255f
C1283 VPWR a_10791_10160# 0.21716f
C1284 sg13cmos5l_tiehi_0.L_HI sg13cmos5l_buf_1_1.X 2.08289f
C1285 sg13cmos5l_dfrbpq_1_3.Q a_4577_13994# 0.05969f
C1286 VPWR sg13cmos5l_nor2_1_3.Y 0.44199f
C1287 sg13cmos5l_xor2_1_2.A a_3761_11508# 0.10186f
C1288 sg13cmos5l_dfrbpq_1_1.D sg13cmos5l_dfrbpq_1_3.Q 0.03171f
C1289 VPWR sg13cmos5l_dfrbpq_1_5.RESET_B 1.83524f
C1290 sg13cmos5l_nor3_2_0.C a_10791_12303# 0.04999f
C1291 sg13cmos5l_nor2_1_0.B sg13cmos5l_a21oi_1_0.B1 0.19521f
C1292 a_7528_13814# sg13cmos5l_nand2_1_1.A 0.01116f
C1293 a_8314_10668# sg13cmos5l_tiehi_5.L_HI 0.02889f
C1294 a_10791_10160# a_11639_10333# 0.11742f
C1295 VPWR sg13cmos5l_dfrbpq_1_5.D 0.53588f
C1296 a_2039_10023# a_2039_10257# 0.13707f
C1297 sg13cmos5l_mux2_1_0.X sg13cmos5l_mux2_1_0.A0 0.0695f
C1298 sg13cmos5l_dfrbpq_1_4.Q VPWR 0.85603f
C1299 VPWR a_6309_13765# 0.07723f
C1300 sg13cmos5l_o21ai_1_0.B1 sg13cmos5l_xor2_1_2.B 0.46202f
C1301 a_11639_10333# sg13cmos5l_dfrbpq_1_5.RESET_B 0.10757f
C1302 VPWR a_8878_10971# 0.21302f
C1303 sg13cmos5l_nand2_1_1.A sg13cmos5l_nand2_1_1.Y 0.36497f
C1304 a_7849_12970# a_7624_13098# 0.01026f
C1305 a_11639_10333# sg13cmos5l_dfrbpq_1_5.D 0.29779f
C1306 a_10688_10790# VPWR 0.11526f
C1307 a_6176_12302# a_5802_12216# 0.03403f
C1308 a_5733_12945# sg13cmos5l_dfrbpq_1_0.CLK 0.358f
C1309 a_10984_9278# VPWR 0.14817f
C1310 a_11355_11458# a_10816_11752# 0.10471f
C1311 clk_i a_5290_13189# 0.01424f
C1312 a_10943_10212# a_10808_10745# 0.01131f
C1313 a_10138_13692# sg13cmos5l_a21oi_1_1.Y 0.03682f
C1314 VPWR sg13cmos5l_xnor2_1_0.B 1.55293f
C1315 a_8213_13728# sg13cmos5l_a21oi_1_0.B1 0.02726f
C1316 sg13cmos5l_dfrbpq_1_7.Q sg13cmos5l_xor2_1_2.B 0.26213f
C1317 a_14920_7766# VPWR 0.13952f
C1318 a_8772_13284# a_9291_13088# 0.38902f
C1319 a_10031_13043# a_9937_13043# 0.32273f
C1320 a_5829_11497# a_5705_11400# 0.13707f
C1321 a_15104_5538# VPWR 0.05657f
C1322 a_9189_12945# a_9937_13043# 0.01058f
C1323 a_8878_10971# a_8672_10790# 0.03208f
C1324 sg13cmos5l_a21oi_1_0.A1 a_8033_10970# 0.01075f
C1325 sg13cmos5l_dfrbpq_1_1.RESET_B sg13cmos5l_xor2_1_1.X 0.01245f
C1326 a_11171_13997# a_11380_13752# 0.01485f
C1327 a_11195_9248# a_10984_9278# 0.0213f
C1328 count_o[4] sg13cmos5l_dfrbpq_1_4.RESET_B 0.04562f
C1329 sg13cmos5l_a21oi_1_0.B1 sg13cmos5l_xor2_1_1.X 1.11597f
C1330 sg13cmos5l_dfrbpq_1_0.Q VPWR 2.36659f
C1331 VPWR a_7177_10728# 0.37168f
C1332 a_12150_13752# sg13cmos5l_o21ai_1_1.Y 0.0522f
C1333 a_7355_9192# sg13cmos5l_a21oi_1_0.A1 0.04073f
C1334 a_12141_11052# sg13cmos5l_mux2_1_0.A0 0.13588f
C1335 sg13cmos5l_nor3_2_0.A sg13cmos5l_mux2_1_0.S 0.14592f
C1336 clk_i a_5835_13088# 0.02428f
C1337 a_11462_12970# a_11574_13034# 0.67711f
C1338 a_7318_11450# sg13cmos5l_nand2_1_1.Y 0.15034f
C1339 a_1184_10790# VPWR 0.12323f
C1340 sg13cmos5l_dfrbpq_1_0.Q a_5441_13994# 0.06513f
C1341 sg13cmos5l_dfrbpq_1_2.RESET_B a_3761_11508# 0.01051f
C1342 sg13cmos5l_xor2_1_2.B sg13cmos5l_xor2_1_2.A 0.41061f
C1343 sg13cmos5l_a21oi_1_1.A1 sg13cmos5l_a21oi_1_0.B1 0.09957f
C1344 VPWR a_5135_12577# 0.20391f
C1345 sg13cmos5l_dfrbpq_1_0.CLK a_6382_12483# 0.02091f
C1346 sg13cmos5l_tiehi_0.L_HI sg13cmos5l_nor2_1_0.Y 0.25963f
C1347 a_8307_14076# sg13cmos5l_a21oi_1_2.A1 0.01183f
C1348 a_8897_13994# VPWR 0.2421f
C1349 VPWR a_4858_13692# 0.3304f
C1350 sg13cmos5l_a21oi_1_0.B1 a_7240_10074# 0.02821f
C1351 a_7816_11586# a_8000_11586# 0.11523f
C1352 a_6575_13043# VPWR 0.20308f
C1353 VPWR a_4174_13155# 0.22091f
C1354 a_5626_11675# sg13cmos5l_dfrbpq_1_0.RESET_B 0.09106f
C1355 a_7355_9192# sg13cmos5l_a21oi_1_0.A2 0.0866f
C1356 sg13cmos5l_xor2_1_2.B sg13cmos5l_a21oi_1_0.A1 0.02173f
C1357 a_6382_12483# sg13cmos5l_dlygate4sd3_1_1.X 0.2044f
C1358 sg13cmos5l_dlygate4sd3_1_12.X a_11078_10704# 0.0131f
C1359 a_13793_10132# VPWR 0.26579f
C1360 a_15104_4026# VPWR 0.05669f
C1361 sg13cmos5l_inv_1_1.A sg13cmos5l_buf_8_0.A 0.02308f
C1362 count_o[3] a_6856_14610# 0.02116f
C1363 sg13cmos5l_dfrbpq_1_1.D a_5326_13995# 0.01351f
C1364 a_4293_10715# sg13cmos5l_dfrbpq_1_0.RESET_B 0.02167f
C1365 a_10288_13186# sg13cmos5l_dfrbpq_1_6.Q 0.01157f
C1366 sg13cmos5l_mux2_1_0.X a_10812_9906# 0.05604f
C1367 a_7716_10260# a_8235_10064# 0.38902f
C1368 a_14920_1002# VPWR 0.13916f
C1369 a_6682_10668# a_6401_10970# 0.33585f
C1370 a_9291_13088# sg13cmos5l_dfrbpq_1_6.Q 0.01807f
C1371 a_11171_13997# sg13cmos5l_nor3_2_0.C 0.26882f
C1372 sg13cmos5l_o21ai_1_0.B1 a_7816_11586# 0.04198f
C1373 a_10444_12654# VPWR 0.2078f
C1374 a_5392_10946# sg13cmos5l_dfrbpq_1_0.RESET_B 0.05699f
C1375 sg13cmos5l_nand4_1_1.A a_9536_13814# 0.01243f
C1376 a_13288_10790# VPWR 0.14649f
C1377 a_8486_12966# sg13cmos5l_dfrbpq_1_4.RESET_B 0.14754f
C1378 sg13cmos5l_dfrbpq_1_0.Q a_7040_10790# 0.07778f
C1379 a_7240_10074# sg13cmos5l_dlygate4sd3_1_15.X 0.07047f
C1380 sg13cmos5l_tiehi_5.L_HI a_7716_10260# 0.51977f
C1381 a_7690_10165# a_8133_9921# 0.02241f
C1382 a_6448_10162# a_6097_10019# 0.01017f
C1383 a_8213_13728# sg13cmos5l_a21oi_1_2.A1 0.04065f
C1384 a_13673_11042# sg13cmos5l_dfrbpq_1_5.RESET_B 0.01823f
C1385 a_5030_12966# VPWR 0.9362f
C1386 sg13cmos5l_a21oi_1_0.B1 a_4932_10260# 0.02976f
C1387 sg13cmos5l_or3_1_2.X sg13cmos5l_o21ai_1_2.Y 0.0324f
C1388 a_3876_12220# a_4293_12227# 0.49014f
C1389 a_9536_13814# VPWR 0.07833f
C1390 sg13cmos5l_xor2_1_2.B a_3876_12220# 0.01586f
C1391 sg13cmos5l_nand4_1_0.C sg13cmos5l_xnor2_1_0.B 2.87599f
C1392 sg13cmos5l_dfrbpq_1_7.CLK a_10812_12577# 0.08127f
C1393 sg13cmos5l_xor2_1_2.B a_8091_11458# 0.01105f
C1394 sg13cmos5l_nand4_1_1.A sg13cmos5l_a21oi_1_0.B1 0.02516f
C1395 sg13cmos5l_dfrbpq_1_7.CLK a_10112_10117# 0.01111f
C1396 a_8746_13189# VPWR 0.09794f
C1397 a_5451_10064# sg13cmos5l_dfrbpq_1_0.RESET_B 0.6031f
C1398 sg13cmos5l_dfrbpq_1_0.CLK a_4426_11422# 1.05837f
C1399 sg13cmos5l_dfrbpq_1_2.RESET_B a_4293_12227# 0.05264f
C1400 sg13cmos5l_dfrbpq_1_2.RESET_B sg13cmos5l_xor2_1_2.B 0.04095f
C1401 a_4293_12227# a_4395_12227# 0.6663f
C1402 sg13cmos5l_xor2_1_2.B a_4395_12227# 0.05455f
C1403 VPWR a_5705_11400# 0.14189f
C1404 a_4293_10715# sg13cmos5l_nor2_1_3.B 0.01296f
C1405 a_10138_13692# sg13cmos5l_dfrbpq_1_4.Q 0.53134f
C1406 a_5316_13284# sg13cmos5l_dfrbpq_1_1.D 0.01623f
C1407 sg13cmos5l_dfrbpq_1_1.RESET_B VPWR 1.58767f
C1408 a_3850_10672# a_3876_10708# 0.43042f
C1409 VPWR sg13cmos5l_a21oi_1_0.B1 2.93661f
C1410 sg13cmos5l_dfrbpq_1_7.CLK a_10444_9942# 0.01166f
C1411 a_1943_13803# VPWR 0.14797f
C1412 sg13cmos5l_nor3_2_0.C a_11355_11458# 0.02768f
C1413 sg13cmos5l_dfrbpq_1_2.RESET_B a_5392_12458# 0.17013f
C1414 a_4395_12227# a_5392_12458# 0.07014f
C1415 sg13cmos5l_dfrbpq_1_0.Q sg13cmos5l_nand4_1_0.C 0.30134f
C1416 VPWR a_1914_13162# 0.2601f
C1417 a_11574_13034# VPWR 0.21642f
C1418 sg13cmos5l_mux2_1_0.A0 a_10791_10160# 0.03739f
C1419 a_10288_13186# sg13cmos5l_dfrbpq_1_4.Q 0.0149f
C1420 a_5604_12979# sg13cmos5l_dfrbpq_1_0.Q 0.01726f
C1421 a_3876_10708# a_4164_11129# 0.4806f
C1422 a_11969_14668# VPWR 0.24354f
C1423 count_o[2] sg13cmos5l_dfrbpq_1_1.D 0.1039f
C1424 sg13cmos5l_dfrbpq_1_1.RESET_B a_5441_13994# 0.02558f
C1425 a_13288_13814# a_13472_13814# 0.11523f
C1426 sg13cmos5l_dfrbpq_1_4.D sg13cmos5l_xor2_1_2.B 0.07378f
C1427 sg13cmos5l_nor3_2_0.C sg13cmos5l_a21oi_1_1.Y 0.10086f
C1428 sg13cmos5l_xor2_1_1.X a_3668_13728# 0.11612f
C1429 sg13cmos5l_mux2_1_0.A0 sg13cmos5l_dfrbpq_1_5.RESET_B 0.58078f
C1430 a_11078_10704# sg13cmos5l_mux2_1_0.S 0.0398f
C1431 a_4932_10260# a_5220_9955# 0.4806f
C1432 a_8000_11586# VPWR 0.06259f
C1433 sg13cmos5l_nand3_1_0.Y sg13cmos5l_xor2_1_2.B 0.01487f
C1434 a_4164_11129# a_4395_10715# 0.15089f
C1435 clk_i sg13cmos5l_dfrbpq_1_3.Q 0.03106f
C1436 a_8004_9955# a_7716_10260# 0.4806f
C1437 a_9232_10162# a_8975_10019# 0.40419f
C1438 sg13cmos5l_buf_1_1.X a_8133_9921# 0.01753f
C1439 sg13cmos5l_mux2_1_0.S a_10808_10745# 0.0616f
C1440 a_11078_10704# sg13cmos5l_dfrbpq_1_7.CLK 0.0581f
C1441 a_12022_12962# sg13cmos5l_nor3_2_0.C 0.10157f
C1442 clk_i sg13cmos5l_buf_8_0.A 0.06363f
C1443 a_6191_10019# a_6097_10019# 0.32273f
C1444 sg13cmos5l_nor3_2_0.C sg13cmos5l_o21ai_1_1.Y 0.07276f
C1445 a_5135_11065# a_5041_11065# 0.32273f
C1446 sg13cmos5l_nand4_1_1.A sg13cmos5l_o21ai_1_0.B1 0.26636f
C1447 a_8881_10019# a_8975_10019# 0.32273f
C1448 VPWR a_8975_10019# 0.20562f
C1449 VPWR sg13cmos5l_dlygate4sd3_1_15.X 0.28244f
C1450 a_3304_13098# a_3488_13098# 0.11523f
C1451 sg13cmos5l_nand2_1_1.A sg13cmos5l_xor2_1_2.B 0.26465f
C1452 sg13cmos5l_buf_1_1.X a_7690_10165# 0.01903f
C1453 a_8602_9433# sg13cmos5l_tiehi_5.L_HI 0.09133f
C1454 sg13cmos5l_dfrbpq_1_5.Q a_10112_10117# 0.1348f
C1455 a_9836_14442# sg13cmos5l_dfrbpq_1_7.Q 0.33093f
C1456 a_3761_11508# sg13cmos5l_nor2_1_3.B 0.2565f
C1457 sg13cmos5l_nand4_1_0.C a_4174_13155# 0.02639f
C1458 sg13cmos5l_dlygate4sd3_1_1.X sg13cmos5l_xnor2_1_0.B 0.38617f
C1459 sg13cmos5l_o21ai_1_0.B1 VPWR 0.74525f
C1460 clk_i sg13cmos5l_nand3_1_1.Y 0.21428f
C1461 a_3876_10708# VPWR 0.07277f
C1462 sg13cmos5l_dfrbpq_1_0.CLK sg13cmos5l_dfrbpq_1_0.Q 0.30736f
C1463 a_11190_10728# sg13cmos5l_dlygate4sd3_1_12.X 0.25686f
C1464 a_13288_10074# a_13472_10074# 0.11523f
C1465 sg13cmos5l_nor2_1_1.Y sg13cmos5l_xnor2_1_0.B 0.2876f
C1466 sg13cmos5l_dfrbpq_1_6.RESET_B a_10791_12303# 0.55168f
C1467 VPWR a_13472_13814# 0.07279f
C1468 VPWR sg13cmos5l_dfrbpq_1_6.D 1.0383f
C1469 sg13cmos5l_nand4_1_1.A sg13cmos5l_dfrbpq_1_7.Q 0.06717f
C1470 a_4932_10260# a_5349_9921# 0.48921f
C1471 a_4646_9942# a_5451_10064# 0.11742f
C1472 a_4395_10715# VPWR 0.20638f
C1473 sg13cmos5l_xor2_1_2.B sg13cmos5l_mux2_1_0.S 0.24056f
C1474 sg13cmos5l_tiehi_0.L_HI a_4293_10715# 0.05306f
C1475 a_5802_10704# sg13cmos5l_dfrbpq_1_3.Q 0.14375f
C1476 a_10698_13264# sg13cmos5l_xor2_1_2.B 0.04038f
C1477 a_7702_14106# sg13cmos5l_xor2_1_2.B 0.09918f
C1478 a_3968_14610# a_4085_14482# 0.0101f
C1479 sg13cmos5l_dlygate4sd3_1_1.X sg13cmos5l_dfrbpq_1_0.Q 5.35282f
C1480 sg13cmos5l_dfrbpq_1_7.CLK sg13cmos5l_xor2_1_2.B 0.12076f
C1481 sg13cmos5l_dfrbpq_1_7.Q VPWR 1.99789f
C1482 sg13cmos5l_dfrbpq_1_4.Q a_10496_13814# 0.0773f
C1483 sg13cmos5l_dfrbpq_1_0.CLK a_5135_12577# 0.01305f
C1484 a_9232_10162# a_9642_10240# 0.1396f
C1485 sg13cmos5l_tiehi_0.L_HI a_5392_10946# 0.17013f
C1486 sg13cmos5l_nor2_1_1.Y sg13cmos5l_dfrbpq_1_0.Q 0.65936f
C1487 a_11078_10704# sg13cmos5l_dfrbpq_1_5.Q 0.01759f
C1488 sg13cmos5l_nor3_2_0.C sg13cmos5l_dfrbpq_1_6.RESET_B 0.65791f
C1489 a_8986_14446# sg13cmos5l_o21ai_1_2.Y 0.51783f
C1490 sg13cmos5l_o21ai_1_0.B1 a_8672_10790# 0.01347f
C1491 a_14920_1718# a_15104_1718# 0.11523f
C1492 VPWR a_5349_9921# 0.3153f
C1493 a_10812_12577# a_10943_12187# 0.48921f
C1494 sg13cmos5l_dfrbpq_1_5.Q a_10808_10745# 0.51887f
C1495 sg13cmos5l_nand4_1_1.A sg13cmos5l_a21oi_1_2.A1 0.06756f
C1496 VPWR a_9642_10240# 0.46176f
C1497 sg13cmos5l_nor2_1_1.Y a_1802_12216# 0.01295f
C1498 a_5835_13088# a_6832_13186# 0.06746f
C1499 a_5030_12966# a_5604_12979# 0.36169f
C1500 sg13cmos5l_xor2_1_2.B a_7318_11450# 0.12104f
C1501 a_5316_13284# a_5290_13189# 0.43042f
C1502 a_8218_9156# a_8602_9433# 0.02409f
C1503 sg13cmos5l_a21oi_1_0.Y a_7937_9458# 0.0239f
C1504 sg13cmos5l_buf_1_0.X sg13cmos5l_xnor2_1_0.B 1.2403f
C1505 sg13cmos5l_buf_1_1.X sg13cmos5l_dfrbpq_1_3.Q 0.09398f
C1506 sg13cmos5l_inv_1_1.A a_10024_11586# 0.03921f
C1507 a_8590_14667# sg13cmos5l_a21oi_1_2.A1 0.19354f
C1508 sg13cmos5l_a21oi_1_1.A2 a_11171_13997# 0.26827f
C1509 a_10112_12503# a_10231_12180# 0.13494f
C1510 a_10791_12303# a_11639_12263# 0.11742f
C1511 a_10943_12187# a_11733_12263# 0.02241f
C1512 sg13cmos5l_a21oi_1_2.A1 VPWR 0.4029f
C1513 sg13cmos5l_buf_1_1.X sg13cmos5l_buf_8_0.A 0.07325f
C1514 sg13cmos5l_dlygate4sd3_1_8.A a_9536_13814# 0.07232f
C1515 a_10231_9906# a_10812_9906# 0.01741f
C1516 VPWR a_10943_10212# 0.24649f
C1517 sg13cmos5l_dfrbpq_1_3.Q sg13cmos5l_buf_8_0.A 0.02704f
C1518 sg13cmos5l_nand2_1_0.Y a_1594_12970# 0.01564f
C1519 enable_i a_808_3144# 0.32156f
C1520 a_11171_13997# sg13cmos5l_a21oi_1_1.Y 0.01549f
C1521 VPWR a_2039_10023# 0.06978f
C1522 sg13cmos5l_nand3_1_0.Y a_4085_14482# 0.39625f
C1523 sg13cmos5l_dfrbpq_1_0.Q sg13cmos5l_dfrbpq_1_2.Q 0.10015f
C1524 sg13cmos5l_nand3_1_0.Y sg13cmos5l_xor2_1_1.X 0.04884f
C1525 sg13cmos5l_dlygate4sd3_1_1.X a_4174_13155# 0.04601f
C1526 VPWR sg13cmos5l_xor2_1_2.A 0.45118f
C1527 a_10943_10212# a_11639_10333# 0.02431f
C1528 a_10791_10160# a_10812_9906# 0.38871f
C1529 sg13cmos5l_nand4_1_0.C a_1914_13162# 0.11521f
C1530 VPWR a_11733_10100# 0.09795f
C1531 sg13cmos5l_dfrbpq_1_0.Q sg13cmos5l_buf_1_0.X 0.70287f
C1532 a_2238_10194# a_2039_10023# 0.04716f
C1533 a_9449_14424# VPWR 0.09158f
C1534 sg13cmos5l_dlygate4sd3_1_8.A sg13cmos5l_a21oi_1_0.B1 1.51409f
C1535 VPWR a_3668_13728# 0.25026f
C1536 sg13cmos5l_xor2_1_2.B sg13cmos5l_nor2_1_3.B 0.04138f
C1537 sg13cmos5l_nand4_1_0.Y sg13cmos5l_xor2_1_1.X 0.04843f
C1538 a_10812_9906# sg13cmos5l_dfrbpq_1_5.RESET_B 0.47837f
C1539 sg13cmos5l_nor3_2_0.C a_11639_12263# 0.07045f
C1540 sg13cmos5l_tiehi_0.L_HI a_2039_10257# 0.0215f
C1541 a_9742_13995# a_9857_13994# 0.67711f
C1542 sg13cmos5l_dfrbpq_1_5.Q sg13cmos5l_xor2_1_2.B 0.0141f
C1543 a_11639_10333# a_11733_10100# 0.87117f
C1544 sg13cmos5l_mux2_1_0.A1 sg13cmos5l_buf_1_1.X 0.14671f
C1545 a_10231_12180# sg13cmos5l_dfrbpq_1_7.CLK 0.01151f
C1546 a_11828_10668# VPWR 0.24103f
C1547 a_5316_13284# a_5835_13088# 0.38902f
C1548 a_11518_9562# VPWR 0.11965f
C1549 a_9573_14521# a_9449_14424# 0.13707f
C1550 clk_i a_6832_13186# 0.01415f
C1551 a_14828_14442# VPWR 0.26152f
C1552 clk_i a_4289_13156# 0.01687f
C1553 sg13cmos5l_a21oi_1_0.Y a_7355_9192# 0.19439f
C1554 a_11190_10728# sg13cmos5l_dfrbpq_1_7.CLK 0.05124f
C1555 sg13cmos5l_or3_1_2.X a_7849_12970# 0.24721f
C1556 sg13cmos5l_inv_1_1.A sg13cmos5l_nor3_2_0.A 0.22423f
C1557 a_5135_12577# sg13cmos5l_dfrbpq_1_2.Q 0.01591f
C1558 VPWR a_8993_10970# 0.24416f
C1559 VPWR sg13cmos5l_a21oi_1_0.A1 0.40134f
C1560 sg13cmos5l_o21ai_1_0.B1 sg13cmos5l_o21ai_1_0.Y 0.46322f
C1561 sg13cmos5l_dlygate4sd3_1_2.X sg13cmos5l_dfrbpq_1_0.Q 0.09983f
C1562 a_9189_12945# a_9857_13994# 0.01055f
C1563 rst_ni VPWR 0.16142f
C1564 a_808_8468# VPWR 0.26433f
C1565 sg13cmos5l_dfrbpq_1_0.CLK a_5705_11400# 0.01857f
C1566 sg13cmos5l_a21oi_1_1.A2 sg13cmos5l_a21oi_1_1.Y 0.01116f
C1567 sg13cmos5l_dfrbpq_1_2.Q a_4858_13692# 0.57508f
C1568 count_o[5] count_o[6] 0.03242f
C1569 a_8486_12966# a_9189_12945# 0.02453f
C1570 sg13cmos5l_dfrbpq_1_0.CLK sg13cmos5l_a21oi_1_0.B1 0.07299f
C1571 sg13cmos5l_dfrbpq_1_0.Q a_6191_10019# 0.01176f
C1572 a_15104_6254# VPWR 0.05657f
C1573 sg13cmos5l_dfrbpq_1_4.RESET_B sg13cmos5l_xor2_1_2.B 0.06722f
C1574 a_9189_12945# a_9060_12979# 0.01562f
C1575 a_11195_9248# a_11518_9562# 0.55132f
C1576 sg13cmos5l_dfrbpq_1_7.Q sg13cmos5l_o21ai_1_0.Y 0.01147f
C1577 VPWR a_6682_10668# 0.3362f
C1578 sg13cmos5l_xor2_1_2.B a_10943_12187# 0.01761f
C1579 sg13cmos5l_nor3_2_0.A a_10604_11752# 0.0958f
C1580 clk_i a_5316_13284# 0.0295f
C1581 a_11518_9562# a_11695_9216# 0.01068f
C1582 sg13cmos5l_dlygate4sd3_1_1.X sg13cmos5l_a21oi_1_0.B1 0.02001f
C1583 a_1943_14033# a_2142_13666# 0.04716f
C1584 VPWR a_3876_12220# 0.15824f
C1585 a_3968_14610# VPWR 0.08703f
C1586 sg13cmos5l_xor2_1_2.A a_6286_10971# 0.19404f
C1587 VPWR sg13cmos5l_a21oi_1_0.A2 0.4043f
C1588 sg13cmos5l_buf_1_1.X sg13cmos5l_nor2_1_0.Y 0.03746f
C1589 a_6497_12482# sg13cmos5l_nand2_1_1.A 0.01233f
C1590 sg13cmos5l_a21oi_1_1.Y sg13cmos5l_o21ai_1_1.Y 0.04442f
C1591 sg13cmos5l_dlygate4sd3_1_2.X a_4858_13692# 0.09226f
C1592 VPWR a_8091_11458# 1.17045f
C1593 a_11171_13997# sg13cmos5l_dfrbpq_1_6.Q 0.04992f
C1594 sg13cmos5l_nor2_1_1.Y sg13cmos5l_a21oi_1_0.B1 0.09556f
C1595 sg13cmos5l_dlygate4sd3_1_12.X VPWR 0.3809f
C1596 sg13cmos5l_dfrbpq_1_2.RESET_B VPWR 2.01502f
C1597 sg13cmos5l_nor3_2_0.C sg13cmos5l_dfrbpq_1_0.Q 0.03881f
C1598 a_11190_10728# sg13cmos5l_dfrbpq_1_5.Q 0.01238f
C1599 VPWR a_4395_12227# 0.22936f
C1600 sg13cmos5l_tiehi_0.L_HI sg13cmos5l_xor2_1_2.B 0.01246f
C1601 sg13cmos5l_xor2_1_2.B a_4577_13994# 0.03243f
C1602 sg13cmos5l_dlygate4sd3_1_8.A sg13cmos5l_dfrbpq_1_7.Q 0.05193f
C1603 a_12022_12962# sg13cmos5l_o21ai_1_1.Y 0.11628f
C1604 a_5030_12966# sg13cmos5l_dfrbpq_1_2.Q 0.01461f
C1605 sg13cmos5l_nand4_1_1.A sg13cmos5l_dfrbpq_1_4.D 0.09328f
C1606 a_7177_10728# a_7271_10728# 0.02103f
C1607 a_14920_7766# a_14920_7050# 0.01275f
C1608 sg13cmos5l_a21oi_1_0.B1 a_6448_10162# 0.01446f
C1609 clk_i sg13cmos5l_nand2_1_0.Y 0.03155f
C1610 VPWR a_3304_13098# 0.14184f
C1611 a_3876_10708# sg13cmos5l_dfrbpq_1_0.CLK 0.09254f
C1612 sg13cmos5l_dfrbpq_1_4.D VPWR 0.40149f
C1613 a_10702_9942# a_10444_9942# 0.01017f
C1614 a_14920_6254# a_15104_6254# 0.11523f
C1615 a_13288_10074# VPWR 0.14648f
C1616 a_11355_11458# sg13cmos5l_dfrbpq_1_6.RESET_B 0.06908f
C1617 a_12150_13752# sg13cmos5l_dfrbpq_1_6.D 0.19338f
C1618 sg13cmos5l_dfrbpq_1_2.Q sg13cmos5l_a21oi_1_0.B1 0.08245f
C1619 sg13cmos5l_nand3_1_0.Y VPWR 0.96953f
C1620 a_10138_13692# sg13cmos5l_dfrbpq_1_7.Q 0.02079f
C1621 a_4462_13995# a_4577_13994# 0.67711f
C1622 sg13cmos5l_dfrbpq_1_5.Q a_15104_14610# 0.06036f
C1623 a_4395_10715# sg13cmos5l_dfrbpq_1_0.CLK 0.01815f
C1624 a_15016_11586# VPWR 0.17269f
C1625 sg13cmos5l_a21oi_1_0.B1 sg13cmos5l_buf_1_0.X 0.24011f
C1626 sg13cmos5l_dlygate4sd3_1_8.A sg13cmos5l_a21oi_1_2.A1 0.12291f
C1627 sg13cmos5l_a21oi_1_1.A2 sg13cmos5l_dfrbpq_1_6.Q 0.2208f
C1628 sg13cmos5l_nand4_1_1.A sg13cmos5l_nand2_1_1.A 0.04577f
C1629 sg13cmos5l_a21oi_1_0.B1 a_10496_13814# 0.03839f
C1630 sg13cmos5l_o21ai_1_0.B1 sg13cmos5l_dlygate4sd3_1_1.X 0.29184f
C1631 a_7430_9942# a_8133_9921# 0.02453f
C1632 sg13cmos5l_nand4_1_0.Y VPWR 1.972f
C1633 a_14920_1718# VPWR 0.14076f
C1634 sg13cmos5l_buf_1_0.X a_1914_13162# 0.06955f
C1635 sg13cmos5l_a21oi_1_0.A1 sg13cmos5l_o21ai_1_0.Y 0.0297f
C1636 a_8772_13284# sg13cmos5l_dfrbpq_1_6.Q 0.01718f
C1637 a_6185_14066# a_6106_13969# 0.16626f
C1638 a_15016_11586# a_15016_12302# 0.01275f
C1639 a_10444_12654# a_10791_12303# 0.06746f
C1640 sg13cmos5l_mux2_1_0.X sg13cmos5l_dfrbpq_1_5.RESET_B 0.20418f
C1641 sg13cmos5l_nand2_1_1.A VPWR 1.93606f
C1642 sg13cmos5l_a21oi_1_1.Y sg13cmos5l_dfrbpq_1_6.Q 0.05986f
C1643 a_10112_12503# VPWR 0.4977f
C1644 sg13cmos5l_dfrbpq_1_0.Q a_3590_12654# 0.01413f
C1645 a_9291_13088# sg13cmos5l_dfrbpq_1_7.Q 0.02563f
C1646 a_13594_10945# VPWR 0.1079f
C1647 sg13cmos5l_mux2_1_0.X sg13cmos5l_dfrbpq_1_5.D 1.43577f
C1648 sg13cmos5l_dfrbpq_1_0.CLK a_5349_9921# 0.36384f
C1649 a_8235_10064# a_8975_10019# 0.3087f
C1650 a_7690_10165# a_7430_9942# 0.87117f
C1651 a_11594_10100# sg13cmos5l_mux2_1_0.A1 0.0146f
C1652 a_6858_10240# a_7240_10074# 0.03295f
C1653 a_3642_13691# a_3668_13728# 0.41432f
C1654 a_12022_12962# sg13cmos5l_dfrbpq_1_6.RESET_B 0.02384f
C1655 sg13cmos5l_o21ai_1_1.Y sg13cmos5l_dfrbpq_1_6.RESET_B 0.01878f
C1656 sg13cmos5l_dlygate4sd3_1_2.X sg13cmos5l_a21oi_1_0.B1 0.17833f
C1657 sg13cmos5l_a21oi_1_1.A1 a_10817_14076# 0.01235f
C1658 a_3850_12184# a_3876_12220# 0.43042f
C1659 a_7800_13708# VPWR 0.01816f
C1660 sg13cmos5l_dlygate4sd3_1_1.X sg13cmos5l_dfrbpq_1_7.Q 0.53816f
C1661 a_8120_12582# sg13cmos5l_nand3_1_1.Y 0.01828f
C1662 sg13cmos5l_nand4_1_1.A a_7702_14106# 0.05935f
C1663 sg13cmos5l_tiehi_5.L_HI a_8975_10019# 0.19977f
C1664 sg13cmos5l_dfrbpq_1_6.Q a_11368_14516# 0.32113f
C1665 sg13cmos5l_tiehi_5.L_HI sg13cmos5l_dlygate4sd3_1_15.X 0.16133f
C1666 sg13cmos5l_dfrbpq_1_7.CLK a_9232_10162# 0.01224f
C1667 sg13cmos5l_dfrbpq_1_0.Q a_6848_11586# 0.05018f
C1668 sg13cmos5l_nand4_1_1.A sg13cmos5l_dfrbpq_1_7.CLK 0.02936f
C1669 a_4932_10260# sg13cmos5l_dfrbpq_1_0.RESET_B 0.49654f
C1670 sg13cmos5l_dfrbpq_1_2.RESET_B a_3850_12184# 0.31943f
C1671 sg13cmos5l_a21oi_1_0.B1 a_6191_10019# 0.01986f
C1672 sg13cmos5l_mux2_1_0.S VPWR 0.32439f
C1673 a_3876_12220# a_4164_12641# 0.4806f
C1674 a_11192_12970# a_10943_12187# 0.01949f
C1675 a_10698_13264# VPWR 0.45654f
C1676 sg13cmos5l_buf_1_1.X sg13cmos5l_nand2_1_1.Y 0.02237f
C1677 a_3850_10672# sg13cmos5l_nor2_1_3.B 0.03511f
C1678 a_4928_13098# sg13cmos5l_dfrbpq_1_1.D 0.06804f
C1679 a_7702_14106# VPWR 0.01621f
C1680 a_3590_11142# a_3876_10708# 0.50066f
C1681 VPWR a_2728_14610# 0.21757f
C1682 a_14624_14610# VPWR 0.08824f
C1683 sg13cmos5l_dfrbpq_1_7.CLK VPWR 3.10203f
C1684 sg13cmos5l_dfrbpq_1_0.CLK sg13cmos5l_xor2_1_2.A 0.08651f
C1685 sg13cmos5l_o21ai_1_0.Y a_8091_11458# 0.10121f
C1686 sg13cmos5l_buf_8_0.A sg13cmos5l_nand2_1_1.Y 0.21056f
C1687 a_4164_12641# a_4395_12227# 0.15089f
C1688 a_11462_12970# a_10943_12187# 0.02423f
C1689 sg13cmos5l_dfrbpq_1_0.Q a_5722_13692# 0.03011f
C1690 sg13cmos5l_a21oi_1_0.B1 a_1480_10074# 0.01618f
C1691 a_11072_13098# VPWR 0.07792f
C1692 a_4164_11129# sg13cmos5l_nor2_1_3.B 0.01977f
C1693 VPWR sg13cmos5l_dfrbpq_1_0.RESET_B 1.64633f
C1694 sg13cmos5l_a21oi_1_1.A2 sg13cmos5l_dfrbpq_1_4.Q 0.0302f
C1695 sg13cmos5l_mux2_1_0.A0 a_10943_10212# 0.02282f
C1696 a_3590_11142# a_4395_10715# 0.11742f
C1697 a_13594_13969# sg13cmos5l_dfrbpq_1_6.RESET_B 0.07131f
C1698 a_4085_14482# a_4577_13994# 0.01387f
C1699 a_5135_12577# a_5041_12577# 0.32273f
C1700 a_12141_11052# sg13cmos5l_dfrbpq_1_5.RESET_B 0.01558f
C1701 sg13cmos5l_dfrbpq_1_1.D sg13cmos5l_xor2_1_1.X 0.01774f
C1702 a_7318_11450# VPWR 0.01375f
C1703 sg13cmos5l_a21oi_1_1.Y sg13cmos5l_dfrbpq_1_4.Q 0.07112f
C1704 a_11195_9248# sg13cmos5l_mux2_1_0.S 0.18707f
C1705 a_3876_10708# a_5041_11065# 0.4858f
C1706 a_11264_14610# VPWR 0.06988f
C1707 count_o[0] a_1184_14610# 0.01144f
C1708 sg13cmos5l_buf_1_1.X a_7430_9942# 0.01926f
C1709 sg13cmos5l_inv_1_1.A sg13cmos5l_xor2_1_2.B 1.79744f
C1710 sg13cmos5l_dlygate4sd3_1_1.X a_3668_13728# 0.01313f
C1711 sg13cmos5l_dfrbpq_1_2.RESET_B sg13cmos5l_nand4_1_0.C 0.07539f
C1712 sg13cmos5l_nor3_2_0.A sg13cmos5l_buf_8_0.A 0.05054f
C1713 a_11574_13034# sg13cmos5l_nor3_2_0.C 0.05124f
C1714 a_5392_10946# a_5802_10704# 0.1396f
C1715 count_o[1] sg13cmos5l_dfrbpq_1_3.Q 0.01432f
C1716 VPWR a_6858_10240# 0.46279f
C1717 sg13cmos5l_mux2_1_0.A0 a_11518_9562# 0.10282f
C1718 sg13cmos5l_buf_8_0.A a_5626_11675# 0.04333f
C1719 count_o[7] VGND 1.3195f
C1720 count_o[6] VGND 1.06694f
C1721 count_o[5] VGND 0.63468f
C1722 count_o[4] VGND 1.14983f
C1723 count_o[3] VGND 0.66517f
C1724 count_o[2] VGND 0.74086f
C1725 count_o[1] VGND 0.87396f
C1726 count_o[0] VGND 1.10118f
C1727 a_15104_1002# VGND 0.07556f ; **FLOATING
C1728 a_14920_1002# VGND 0.12355f ; **FLOATING
C1729 a_15104_1718# VGND 0.07452f ; **FLOATING
C1730 a_14920_1718# VGND 0.11992f ; **FLOATING
C1731 a_15104_2514# VGND 0.07465f ; **FLOATING
C1732 a_14920_2514# VGND 0.12147f ; **FLOATING
C1733 a_15016_3230# VGND 0.14075f ; **FLOATING
C1734 a_808_3144# VGND 0.28519f
C1735 a_15104_4026# VGND 0.0776f ; **FLOATING
C1736 a_14920_4026# VGND 0.1308f ; **FLOATING
C1737 a_15104_4742# VGND 0.07521f ; **FLOATING
C1738 a_14920_4742# VGND 0.12232f ; **FLOATING
C1739 a_15104_5538# VGND 0.07471f ; **FLOATING
C1740 a_14920_5538# VGND 0.12056f ; **FLOATING
C1741 a_15104_6254# VGND 0.07452f ; **FLOATING
C1742 a_14920_6254# VGND 0.11992f ; **FLOATING
C1743 a_15104_7050# VGND 0.07452f ; **FLOATING
C1744 a_14920_7050# VGND 0.11992f ; **FLOATING
C1745 a_15104_7766# VGND 0.07466f ; **FLOATING
C1746 a_14920_7766# VGND 0.12531f ; **FLOATING
C1747 a_15016_8562# VGND 0.14444f ; **FLOATING
C1748 a_808_8468# VGND 0.34028f
C1749 a_11695_9216# VGND 0.51309f
C1750 a_11421_9216# VGND 0.88687f
C1751 a_11632_9562# VGND 0.19996f
C1752 a_11421_9562# VGND 0.23102f
C1753 a_10984_9278# VGND 0.14271f ; **FLOATING
C1754 a_7355_9192# VGND 0.21696f
C1755 a_11518_9562# VGND 0.23061f
C1756 a_7937_9458# VGND 0.27702f
C1757 a_7457_9540# VGND 0.43077f
C1758 sg13cmos5l_a21oi_1_0.Y VGND 0.21372f
C1759 a_15104_10074# VGND 0.12222f ; **FLOATING
C1760 a_13793_10132# VGND 0.34622f
C1761 a_13472_10074# VGND 0.0456f ; **FLOATING
C1762 a_13288_10074# VGND 0.15108f ; **FLOATING
C1763 a_11990_9955# VGND 0.93461f
C1764 a_10702_9942# VGND 0.11473f
C1765 a_10538_9942# VGND 0.43318f
C1766 a_11594_10100# VGND 0.92634f
C1767 sg13cmos5l_dfrbpq_1_5.D VGND 0.21064f
C1768 a_11639_10333# VGND 0.58609f
C1769 a_9394_9942# VGND 0.35991f
C1770 a_10702_10257# VGND 0.30068f
C1771 a_10444_9942# VGND 0.10511f
C1772 a_8881_10019# VGND 0.24582f
C1773 a_7942_9955# VGND 0.07292f
C1774 a_8004_9955# VGND 0.31772f
C1775 a_9177_10257# VGND 0.16998f
C1776 a_7524_9942# VGND 0.2638f
C1777 a_8073_10333# VGND 0.86768f
C1778 a_7430_9942# VGND 0.50649f
C1779 sg13cmos5l_dlygate4sd3_1_15.X VGND 0.05221f
C1780 a_7240_10074# VGND 0.08159f ; **FLOATING
C1781 a_6097_10019# VGND 0.20683f
C1782 a_5158_9955# VGND 0.01753f
C1783 a_5220_9955# VGND 0.03666f
C1784 a_4740_9942# VGND 0.39974f
C1785 a_5289_10333# VGND 1.19263f
C1786 a_4932_10260# VGND 0.16019f
C1787 a_4646_9942# VGND 0.72259f
C1788 a_4396_10240# VGND 0.34288f
C1789 a_4160_10074# VGND 0.05816f ; **FLOATING
C1790 a_1664_10074# VGND 0.03642f ; **FLOATING
C1791 a_1480_10074# VGND 0.12066f ; **FLOATING
C1792 a_15016_10790# VGND 0.13436f ; **FLOATING
C1793 a_13472_10790# VGND 0.04259f ; **FLOATING
C1794 a_13288_10790# VGND 0.14927f ; **FLOATING
C1795 a_11786_10704# VGND 0.35969f
C1796 sg13cmos5l_mux2_1_0.A0 VGND 0.06989f
C1797 a_10688_10790# VGND 0.05837f ; **FLOATING
C1798 sg13cmos5l_dlygate4sd3_1_12.X VGND 0.04441f
C1799 a_8672_10790# VGND 0.04372f ; **FLOATING
C1800 a_8878_10971# VGND 0.19063f
C1801 a_7040_10790# VGND 0.04253f ; **FLOATING
C1802 a_8314_10668# VGND 0.56003f
C1803 a_7918_10971# VGND 0.08192f
C1804 a_4233_10751# VGND 1.08968f
C1805 a_5041_11065# VGND 0.28002f
C1806 a_4164_11129# VGND 0.32137f
C1807 a_4102_11129# VGND 0.18794f
C1808 a_3488_10790# VGND 0.06551f ; **FLOATING
C1809 a_1914_10704# VGND 0.05341f
C1810 a_1418_10704# VGND 0.79082f
C1811 a_3684_11142# VGND 1.83292f
C1812 a_3590_11142# VGND 2.46907f
C1813 sg13cmos5l_tiehi_0.L_HI VGND 0.11628f
C1814 a_1775_11074# VGND 0.21121f
C1815 a_1184_10790# VGND 0.06221f ; **FLOATING
C1816 a_15016_11586# VGND 0.13271f ; **FLOATING
C1817 a_10816_11752# VGND 0.01743f
C1818 a_10604_11752# VGND 0.24215f
C1819 a_10024_11586# VGND 0.12565f ; **FLOATING
C1820 a_8000_11586# VGND 0.03645f ; **FLOATING
C1821 a_7816_11586# VGND 0.07986f ; **FLOATING
C1822 a_7318_11450# VGND 0.68873f
C1823 a_7416_11772# VGND 0.21607f
C1824 a_6848_11586# VGND 0.03617f ; **FLOATING
C1825 a_6664_11586# VGND 0.11976f ; **FLOATING
C1826 a_3932_11752# VGND 0.1042f
C1827 a_3729_11776# VGND 0.55512f
C1828 a_3488_11586# VGND 0.09128f ; **FLOATING
C1829 a_5626_11675# VGND 0.11378f
C1830 a_15016_12302# VGND 0.13327f ; **FLOATING
C1831 a_11835_12263# VGND 0.978f
C1832 a_12386_12654# VGND 0.90615f
C1833 a_10702_12339# VGND 0.1885f
C1834 a_11639_12263# VGND 0.65285f
C1835 a_11990_12641# VGND 0.02124f
C1836 a_11594_12496# VGND 0.0579f
C1837 a_10702_12654# VGND 0.11471f
C1838 a_8702_12582# VGND 0.11918f
C1839 a_8600_12582# VGND 0.43018f
C1840 a_8498_12582# VGND 0.43428f
C1841 a_8120_12582# VGND 0.57144f
C1842 a_8018_12582# VGND 0.57641f
C1843 a_7808_12302# VGND 0.08461f ; **FLOATING
C1844 a_6176_12302# VGND 0.04912f ; **FLOATING
C1845 a_5337_12339# VGND 0.16857f
C1846 a_6382_12483# VGND 0.11301f
C1847 a_4233_12263# VGND 1.08718f
C1848 a_5554_12654# VGND 0.2186f
C1849 a_5041_12577# VGND 0.20453f
C1850 a_5392_12458# VGND 0.04755f
C1851 a_4164_12641# VGND 0.40331f
C1852 a_4102_12641# VGND 0.36665f
C1853 a_3488_12302# VGND 0.03912f ; **FLOATING
C1854 a_3304_12302# VGND 0.15859f ; **FLOATING
C1855 a_3684_12654# VGND 0.43034f
C1856 a_3590_12654# VGND 0.98493f
C1857 a_2162_12582# VGND 0.6708f
C1858 a_1480_12302# VGND 0.13338f ; **FLOATING
C1859 a_12022_12962# VGND 0.7529f
C1860 a_12120_13284# VGND 1.36424f
C1861 a_11574_13034# VGND 0.10122f
C1862 a_11072_13098# VGND 0.0448f ; **FLOATING
C1863 a_9937_13043# VGND 0.20635f
C1864 a_9060_12979# VGND 0.03666f
C1865 a_10233_13281# VGND 0.19965f
C1866 a_9129_13357# VGND 1.05607f
C1867 a_8486_12966# VGND 0.58312f
C1868 a_7624_13098# VGND 0.08529f ; **FLOATING
C1869 a_6481_13043# VGND 0.11477f
C1870 a_5604_12979# VGND 0.13919f
C1871 a_6777_13281# VGND 0.09719f
C1872 a_6832_13186# VGND 0.15995f
C1873 a_5673_13357# VGND 0.94954f
C1874 a_5316_13284# VGND 0.26979f
C1875 a_5030_12966# VGND 0.908f
C1876 a_4928_13098# VGND 0.04051f ; **FLOATING
C1877 a_3810_12974# VGND 0.19197f
C1878 a_3708_12974# VGND 0.2629f
C1879 a_3488_13098# VGND 0.04175f ; **FLOATING
C1880 a_3304_13098# VGND 0.15153f ; **FLOATING
C1881 a_2070_12982# VGND 0.2942f
C1882 a_1940_13264# VGND 0.1116f
C1883 sg13cmos5l_nor2_1_1.B VGND 0.3981f
C1884 a_15016_13814# VGND 0.15819f ; **FLOATING
C1885 a_13472_13814# VGND 0.04751f ; **FLOATING
C1886 a_13288_13814# VGND 0.16688f ; **FLOATING
C1887 a_10715_13728# VGND 0.41183f
C1888 a_13594_13969# VGND 0.08649f
C1889 a_13673_14066# VGND 0.10148f
C1890 a_10817_14076# VGND 0.63002f
C1891 a_10496_13814# VGND 0.04639f ; **FLOATING
C1892 a_12150_13752# VGND 0.23904f
C1893 a_11171_13997# VGND 0.02444f
C1894 a_9857_13994# VGND 0.23242f
C1895 a_9536_13814# VGND 0.05055f ; **FLOATING
C1896 a_8213_13728# VGND 0.15019f
C1897 a_7800_13708# VGND 0.26895f
C1898 a_8897_13994# VGND 0.19772f
C1899 a_8307_14076# VGND 0.52433f
C1900 sg13cmos5l_dfrbpq_1_4.D VGND 0.23489f
C1901 a_9178_13692# VGND 0.17023f
C1902 a_7528_13814# VGND 0.11024f ; **FLOATING
C1903 a_7702_14106# VGND 0.30643f
C1904 sg13cmos5l_nand3_1_1.Y VGND 0.01638f
C1905 a_3668_13728# VGND 0.09693f
C1906 a_4577_13994# VGND 0.03633f
C1907 a_6185_14066# VGND 0.09946f
C1908 a_5722_13692# VGND 0.14979f
C1909 a_5326_13995# VGND 0.3187f
C1910 a_3400_13814# VGND 0.1262f ; **FLOATING
C1911 a_1856_13814# VGND 0.05964f ; **FLOATING
C1912 a_15104_14610# VGND 0.08153f ; **FLOATING
C1913 a_14624_14610# VGND 0.09059f ; **FLOATING
C1914 sg13cmos5l_dfrbpq_1_5.Q VGND 0.2295f
C1915 a_11264_14610# VGND 0.04289f ; **FLOATING
C1916 a_10784_14610# VGND 0.08708f ; **FLOATING
C1917 sg13cmos5l_dfrbpq_1_6.Q VGND 0.15405f
C1918 a_10988_14442# VGND 0.13961f
C1919 a_9370_14699# VGND 0.0645f
C1920 a_8705_14668# VGND 0.51056f
C1921 a_8590_14667# VGND 0.08461f
C1922 a_6856_14610# VGND 0.10306f ; **FLOATING
C1923 a_5162_14776# VGND 0.25413f
C1924 a_4840_14610# VGND 0.0858f ; **FLOATING
C1925 a_3968_14610# VGND 0.08662f ; **FLOATING
C1926 a_2728_14610# VGND 0.1017f ; **FLOATING
C1927 a_1184_14610# VGND 0.06148f ; **FLOATING
C1928 VGND.t23 VGND 0.74872f
C1929 VGND.t484 VGND 0.6443f
C1930 VGND.t59 VGND 3.39646f
C1931 VGND.t2 VGND 1.49106f
C1932 VGND.t31 VGND 2.18237f
C1933 VGND.t788 VGND 0.11628f
C1934 VGND.t125 VGND 0.24769f
C1935 VGND.t667 VGND 0.56298f
C1936 VGND.t696 VGND 0.04251f
C1937 VGND.t847 VGND 1.40524f
C1938 VGND.t857 VGND 0.07278f
C1939 VGND.t856 VGND 0.07278f
C1940 VGND.t861 VGND 1.19904f
C1941 VGND.t862 VGND 1.19904f
C1942 VGND.t867 VGND 0.67571f
C1943 VGND.t871 VGND 0.17311f
C1944 VGND.t872 VGND 0.17311f
C1945 VGND.t877 VGND 0.08269f
C1946 VGND.t876 VGND 0.08269f
C1947 VGND.t882 VGND 0.41902f
C1948 VGND.t892 VGND 0.11237f
C1949 VGND.t897 VGND 0.37443f
C1950 VGND.t902 VGND 0.41575f
C1951 VGND.t912 VGND 0.18855f
C1952 VGND.t917 VGND 3.48771f
C1953 VGND.t937 VGND 0.38241f
C1954 VGND.t939 VGND 0.296f
C1955 VGND.t608 VGND 0.84689f
C1956 VGND.t190 VGND 0.41575f
C1957 VGND.t191 VGND 0.4092f
C1958 VGND.t193 VGND 0.4092f
C1959 VGND.t195 VGND 0.18569f
C1960 VGND.t202 VGND 1.25827f
C1961 VGND.t127 VGND 1.2307f
C1962 VGND.t206 VGND 0.28002f
C1963 VGND.t204 VGND 0.734f
C1964 VGND.t130 VGND 1.53956f
C1965 VGND.t213 VGND 1.1106f
C1966 VGND.t71 VGND 1.42792f
C1967 VGND.t215 VGND 1.1106f
C1968 VGND.t18 VGND 0.07715f
C1969 VGND.t260 VGND 0.01896f
C1970 VGND.t10 VGND 1.13626f
C1971 VGND.t276 VGND 0.51056f
C1972 VGND.t63 VGND 0.16032f
C1973 VGND.t44 VGND 0.07419f
C1974 VGND.t164 VGND 0.274f
C1975 VGND.t75 VGND 0.31748f
C1976 VGND.t49 VGND 0.14533f
C1977 VGND.t133 VGND 0.65956f
C1978 VGND.t124 VGND 0.33785f
C1979 VGND.t12 VGND 0.05144f
C1980 VGND.t250 VGND 0.51923f
C1981 VGND.t253 VGND 0.72628f
C1982 VGND.t51 VGND 0.09982f
C1983 VGND.t333 VGND 0.12564p
C1984 VGND.t357 VGND 1.28217f
C1985 VGND.t348 VGND 0.12564p
C1986 VGND.t329 VGND 1.43959f
C1987 VGND.t360 VGND 0.55661f
C1988 VGND.t57 VGND 0.08516f
C1989 VGND.t6 VGND 0.05221f
C1990 VGND.t365 VGND 0.12805f
C1991 VGND.t53 VGND 0.27702f
C1992 VGND.t62 VGND 0.0983f
C1993 VGND.t93 VGND 0.2295f
C1994 VGND.t36 VGND 0.97118f
C1995 VGND.t378 VGND 0.64644f
C1996 VGND.t383 VGND 0.01772f
C1997 VGND.t27 VGND 0.71218f
C1998 VGND.t96 VGND 0.86797f
C1999 VGND.t342 VGND 0.07396f
C2000 VGND.t148 VGND 0.20159f
C2001 VGND.t139 VGND 0.04476f
C2002 VGND.t7 VGND 2.43034f
C2003 VGND.t3 VGND 1.76387f
C2004 VGND.t302 VGND 1.71295f
C2005 VGND.t16 VGND 4.1255f
C2006 VGND.t304 VGND 0.75465f
C2007 VGND.t303 VGND 0.64856f
C2008 VGND.t307 VGND 1.38677f
C2009 VGND.t306 VGND 0.7731f
C2010 VGND.t310 VGND 0.52007f
C2011 VGND.t308 VGND 0.61367f
C2012 VGND.t313 VGND 0.24288p
C2013 VGND.t247 VGND 1.93931f
C2014 VGND.t196 VGND 0.14001f
C2015 VGND.t783 VGND 0.34819f
C2016 VGND.t745 VGND 0.08499f
C2017 VGND.t919 VGND 3.48771f
C2018 VGND.t899 VGND 0.1426f
C2019 VGND.t849 VGND 0.24215f
.ends
