* NGSPICE file created from heichips26_digital_project.ext - technology: ihp-sg13cmos5l

* Black-box entry subcircuit for sg13cmos5l_fill_2 abstract view
.subckt sg13cmos5l_fill_2 VDD VSS
.ends

* Black-box entry subcircuit for sg13cmos5l_dfrbpq_1 abstract view
.subckt sg13cmos5l_dfrbpq_1 Q CLK D RESET_B VDD VSS
.ends

* Black-box entry subcircuit for sg13cmos5l_decap_8 abstract view
.subckt sg13cmos5l_decap_8 VDD VSS
.ends

* Black-box entry subcircuit for sg13cmos5l_tiehi abstract view
.subckt sg13cmos5l_tiehi L_HI VDD VSS
.ends

* Black-box entry subcircuit for sg13cmos5l_fill_1 abstract view
.subckt sg13cmos5l_fill_1 VDD VSS
.ends

* Black-box entry subcircuit for sg13cmos5l_nor2_1 abstract view
.subckt sg13cmos5l_nor2_1 Y A B VDD VSS
.ends

* Black-box entry subcircuit for sg13cmos5l_nand3_1 abstract view
.subckt sg13cmos5l_nand3_1 Y A B C VDD VSS
.ends

* Black-box entry subcircuit for sg13cmos5l_o21ai_1 abstract view
.subckt sg13cmos5l_o21ai_1 Y A1 A2 B1 VDD VSS
.ends

* Black-box entry subcircuit for sg13cmos5l_xor2_1 abstract view
.subckt sg13cmos5l_xor2_1 X A B VDD VSS
.ends

* Black-box entry subcircuit for sg13cmos5l_a21oi_1 abstract view
.subckt sg13cmos5l_a21oi_1 Y A1 A2 B1 VDD VSS
.ends

* Black-box entry subcircuit for sg13cmos5l_and2_1 abstract view
.subckt sg13cmos5l_and2_1 X A B VDD VSS
.ends

* Black-box entry subcircuit for sg13cmos5l_nand2b_1 abstract view
.subckt sg13cmos5l_nand2b_1 Y A_N B VDD VSS
.ends

* Black-box entry subcircuit for sg13cmos5l_or3_1 abstract view
.subckt sg13cmos5l_or3_1 X A B C VDD VSS
.ends

* Black-box entry subcircuit for sg13cmos5l_nor4_1 abstract view
.subckt sg13cmos5l_nor4_1 Y A B C D VDD VSS
.ends

* Black-box entry subcircuit for sg13cmos5l_a22oi_1 abstract view
.subckt sg13cmos5l_a22oi_1 Y A1 A2 B1 B2 VDD VSS
.ends

* Black-box entry subcircuit for sg13cmos5l_xnor2_1 abstract view
.subckt sg13cmos5l_xnor2_1 Y A B VDD VSS
.ends

* Black-box entry subcircuit for sg13cmos5l_nand2_1 abstract view
.subckt sg13cmos5l_nand2_1 Y A B VDD VSS
.ends

* Black-box entry subcircuit for sg13cmos5l_inv_1 abstract view
.subckt sg13cmos5l_inv_1 Y A VDD VSS
.ends

* Black-box entry subcircuit for sg13cmos5l_a21o_1 abstract view
.subckt sg13cmos5l_a21o_1 X A1 A2 B1 VDD VSS
.ends

* Black-box entry subcircuit for sg13cmos5l_a221oi_1 abstract view
.subckt sg13cmos5l_a221oi_1 Y A1 A2 B1 B2 C1 VDD VSS
.ends

* Black-box entry subcircuit for sg13cmos5l_buf_1 abstract view
.subckt sg13cmos5l_buf_1 X A VDD VSS
.ends

* Black-box entry subcircuit for sg13cmos5l_decap_4 abstract view
.subckt sg13cmos5l_decap_4 VDD VSS
.ends

* Black-box entry subcircuit for sg13cmos5l_nor2b_1 abstract view
.subckt sg13cmos5l_nor2b_1 Y A B_N VDD VSS
.ends

* Black-box entry subcircuit for sg13cmos5l_nor3_1 abstract view
.subckt sg13cmos5l_nor3_1 Y A B C VDD VSS
.ends

* Black-box entry subcircuit for sg13cmos5l_mux2_1 abstract view
.subckt sg13cmos5l_mux2_1 X A0 A1 S VDD VSS
.ends

* Black-box entry subcircuit for sg13cmos5l_tielo abstract view
.subckt sg13cmos5l_tielo L_LO VDD VSS
.ends

* Black-box entry subcircuit for sg13cmos5l_buf_8 abstract view
.subckt sg13cmos5l_buf_8 X A VDD VSS
.ends

* Black-box entry subcircuit for sg13cmos5l_nand4_1 abstract view
.subckt sg13cmos5l_nand4_1 Y A B C D VDD VSS
.ends

* Black-box entry subcircuit for sg13cmos5l_or2_1 abstract view
.subckt sg13cmos5l_or2_1 X A B VDD VSS
.ends

* Black-box entry subcircuit for sg13cmos5l_dlygate4sd3_1 abstract view
.subckt sg13cmos5l_dlygate4sd3_1 X A VDD VSS
.ends

* Black-box entry subcircuit for sg13cmos5l_nand3b_1 abstract view
.subckt sg13cmos5l_nand3b_1 Y A_N B C VDD VSS
.ends

* Black-box entry subcircuit for sg13cmos5l_and3_1 abstract view
.subckt sg13cmos5l_and3_1 X A B C VDD VSS
.ends

* Black-box entry subcircuit for sg13cmos5l_inv_2 abstract view
.subckt sg13cmos5l_inv_2 Y A VDD VSS
.ends

* Black-box entry subcircuit for sg13cmos5l_inv_4 abstract view
.subckt sg13cmos5l_inv_4 Y A VDD VSS
.ends

* Black-box entry subcircuit for sg13cmos5l_or4_1 abstract view
.subckt sg13cmos5l_or4_1 X A B C D VDD VSS
.ends

* Black-box entry subcircuit for sg13cmos5l_and4_1 abstract view
.subckt sg13cmos5l_and4_1 X A B C D VDD VSS
.ends

* Black-box entry subcircuit for sg13cmos5l_inv_8 abstract view
.subckt sg13cmos5l_inv_8 Y A VDD VSS
.ends

* Black-box entry subcircuit for sg13cmos5l_antennanp abstract view
.subckt sg13cmos5l_antennanp A VDD VSS
.ends

.subckt heichips26_digital_project VGND VPWR clk ena rst_n ui_in[0] ui_in[10] ui_in[11]
+ ui_in[12] ui_in[13] ui_in[14] ui_in[15] ui_in[1] ui_in[2] ui_in[3] ui_in[4] ui_in[5]
+ ui_in[6] ui_in[7] ui_in[8] ui_in[9] uio_in[0] uio_in[10] uio_in[11] uio_in[12] uio_in[13]
+ uio_in[14] uio_in[15] uio_in[1] uio_in[2] uio_in[3] uio_in[4] uio_in[5] uio_in[6]
+ uio_in[7] uio_in[8] uio_in[9] uio_oe[0] uio_oe[10] uio_oe[11] uio_oe[12] uio_oe[13]
+ uio_oe[14] uio_oe[15] uio_oe[1] uio_oe[2] uio_oe[3] uio_oe[4] uio_oe[5] uio_oe[6]
+ uio_oe[7] uio_oe[8] uio_oe[9] uio_out[0] uio_out[10] uio_out[11] uio_out[12] uio_out[13]
+ uio_out[14] uio_out[15] uio_out[1] uio_out[2] uio_out[3] uio_out[4] uio_out[5] uio_out[6]
+ uio_out[7] uio_out[8] uio_out[9] uo_out[0] uo_out[10] uo_out[11] uo_out[12] uo_out[13]
+ uo_out[14] uo_out[15] uo_out[1] uo_out[2] uo_out[3] uo_out[4] uo_out[5] uo_out[6]
+ uo_out[7] uo_out[8] uo_out[9]
XFILLER_94_350 VPWR VGND sg13cmos5l_fill_2
X_18869_ _18869_/Q _18931_/CLK _18869_/D _18869_/RESET_B VPWR VGND sg13cmos5l_dfrbpq_1
XFILLER_55_715 VPWR VGND sg13cmos5l_decap_8
X_18814__1461 _18814_/RESET_B VPWR VGND sg13cmos5l_tiehi
XFILLER_39_299 VPWR VGND sg13cmos5l_fill_1
X_19719__1414 _19719_/RESET_B VPWR VGND sg13cmos5l_tiehi
XFILLER_51_965 VPWR VGND sg13cmos5l_decap_8
XFILLER_51_976 VPWR VGND sg13cmos5l_decap_8
X_19184__1064 _19184_/RESET_B VPWR VGND sg13cmos5l_tiehi
XFILLER_10_317 VPWR VGND sg13cmos5l_fill_2
X_19744__1007 _19744_/RESET_B VPWR VGND sg13cmos5l_tiehi
XFILLER_81_1007 VPWR VGND sg13cmos5l_fill_1
XFILLER_85_350 VPWR VGND sg13cmos5l_fill_1
XFILLER_19_929 VPWR VGND sg13cmos5l_fill_2
X_11900_ _18759_/D _11905_/A _11900_/B VPWR VGND sg13cmos5l_nor2_1
X_12880_ _12999_/B _12974_/B _12985_/B _12880_/C VPWR VGND sg13cmos5l_nand3_1
X_11831_ _11831_/Y _11819_/Y _11825_/Y _11830_/Y VPWR VGND sg13cmos5l_o21ai_1
XFILLER_27_973 VPWR VGND sg13cmos5l_fill_2
XFILLER_60_206 VPWR VGND sg13cmos5l_fill_2
X_14550_ _14731_/A _19169_/Q _14550_/B VPWR VGND sg13cmos5l_xor2_1
X_11762_ _11762_/Y _11865_/B _11865_/C _11865_/A VPWR VGND sg13cmos5l_a21oi_1
X_13501_ _13501_/X _14071_/A _13907_/A VPWR VGND sg13cmos5l_and2_1
X_10713_ _10713_/Y _13813_/A _13811_/A VPWR VGND sg13cmos5l_nand2b_1
X_19808__1578 _19808_/RESET_B VPWR VGND sg13cmos5l_tiehi
X_11693_ _11708_/D _18697_/Q _18695_/Q _18696_/Q VPWR VGND sg13cmos5l_or3_1
XFILLER_42_976 VPWR VGND sg13cmos5l_fill_1
X_14481_ _19159_/D _14648_/A _14575_/A VPWR VGND sg13cmos5l_nor2_1
XFILLER_14_689 VPWR VGND sg13cmos5l_fill_2
X_13432_ _13534_/A _13432_/A _13447_/B VPWR VGND sg13cmos5l_and2_1
X_18987__1273 _18987_/RESET_B VPWR VGND sg13cmos5l_tiehi
X_16220_ _16220_/Y _16243_/A _16220_/B VPWR VGND sg13cmos5l_nor2_1
X_10644_ _19800_/D _10644_/A _18547_/B VPWR VGND sg13cmos5l_nor2_1
X_13363_ _13363_/Y _13414_/A _13363_/B VPWR VGND sg13cmos5l_nand2b_1
X_16151_ _16168_/A _16152_/A _16167_/B VPWR VGND sg13cmos5l_nor2_1
X_10575_ _10923_/B _10575_/A _10575_/B VPWR VGND sg13cmos5l_nor2_1
X_12314_ _12333_/B _18843_/Q _18844_/Q _18845_/Q _18846_/Q VPWR VGND sg13cmos5l_nor4_1
X_15102_ _15102_/Y _15101_/A _15102_/B VPWR VGND sg13cmos5l_nand2b_1
X_13294_ _18971_/D _13296_/A _13294_/B VPWR VGND sg13cmos5l_nor2_1
XFILLER_5_343 VPWR VGND sg13cmos5l_fill_1
X_16082_ _19407_/D _16082_/A _16082_/B VPWR VGND sg13cmos5l_and2_1
X_12245_ _12245_/Y _12228_/B _12241_/S _12468_/A VPWR VGND sg13cmos5l_o21ai_1
X_15033_ _15033_/Y _15031_/Y _15032_/Y _15030_/Y VPWR VGND sg13cmos5l_a21oi_1
X_12176_ _12176_/Y _12151_/X _12186_/S _12192_/B VPWR VGND sg13cmos5l_o21ai_1
X_11127_ _11127_/Y _10029_/A _11625_/A _10871_/B _11107_/B VPWR VGND sg13cmos5l_a22oi_1
X_16984_ _16985_/A _19547_/Q _16984_/B VPWR VGND sg13cmos5l_xnor2_1
X_19772_ _19772_/Q clkload34/A _19772_/D _19772_/RESET_B VPWR VGND sg13cmos5l_dfrbpq_1
X_18723_ _18723_/Q clkload59/A _18723_/D _18723_/RESET_B VPWR VGND sg13cmos5l_dfrbpq_1
XFILLER_67_81 VPWR VGND sg13cmos5l_fill_2
X_11058_ _11075_/A _11058_/A _11058_/B VPWR VGND sg13cmos5l_and2_1
X_15935_ _16125_/A _16309_/A _16116_/A VPWR VGND sg13cmos5l_nand2_1
X_10009_ _10009_/Y _10009_/A VPWR VGND sg13cmos5l_inv_1
X_18654_ _18654_/Q _19087_/CLK _18654_/D _18654_/RESET_B VPWR VGND sg13cmos5l_dfrbpq_1
X_15866_ _15866_/Y _19361_/Q _19322_/Q VPWR VGND sg13cmos5l_xnor2_1
X_18585_ _18585_/Q _18594_/CLK _18585_/D _18585_/RESET_B VPWR VGND sg13cmos5l_dfrbpq_1
X_18774__1503 _18774_/RESET_B VPWR VGND sg13cmos5l_tiehi
X_17605_ _17605_/X _17487_/X _17676_/B _17604_/Y VPWR VGND sg13cmos5l_a21o_1
X_14817_ _14817_/Y _14795_/Y _14811_/Y _14816_/X VPWR VGND sg13cmos5l_o21ai_1
XFILLER_18_940 VPWR VGND sg13cmos5l_fill_2
X_17536_ _17539_/B _19618_/Q _17751_/A VPWR VGND sg13cmos5l_nor2_1
X_15797_ _15797_/Y _16047_/A _15798_/S _15796_/Y VPWR VGND sg13cmos5l_a21oi_1
X_14748_ _14748_/Y _14725_/B _14725_/C _14735_/Y _14737_/A _14757_/B VPWR VGND sg13cmos5l_a221oi_1
X_17467_ _17467_/Y _17467_/A _17467_/B VPWR VGND sg13cmos5l_nor2_1
X_14679_ _14679_/Y _14679_/A _14679_/B VPWR VGND sg13cmos5l_nand2_1
X_17398_ _17398_/Y _17937_/A _19616_/Q _17408_/C VPWR VGND sg13cmos5l_nand3_1
X_19206_ _19206_/Q _19262_/CLK _19206_/D _19206_/RESET_B VPWR VGND sg13cmos5l_dfrbpq_1
X_16418_ _16448_/B hold2549/X _16467_/B VPWR VGND sg13cmos5l_nand2b_1
X_16349_ _16349_/Y _19402_/Q _16349_/B VPWR VGND sg13cmos5l_nor2_1
X_19137_ _19137_/Q clkload49/A _19137_/D _19137_/RESET_B VPWR VGND sg13cmos5l_dfrbpq_1
XFILLER_105_208 VPWR VGND sg13cmos5l_fill_2
X_19068_ _19068_/Q clkload46/A _19068_/D _19068_/RESET_B VPWR VGND sg13cmos5l_dfrbpq_1
X_18019_ _18019_/X _18013_/X _18017_/Y _18012_/X VPWR VGND sg13cmos5l_a21o_1
XFILLER_99_442 VPWR VGND sg13cmos5l_fill_1
X_18712__1569 _18712_/RESET_B VPWR VGND sg13cmos5l_tiehi
X_19746__964 _19746_/RESET_B VPWR VGND sg13cmos5l_tiehi
Xfanout138 _12136_/B _12096_/X VPWR VGND sg13cmos5l_buf_1
XFILLER_99_464 VPWR VGND sg13cmos5l_fill_2
Xfanout116 _17495_/B _17499_/B VPWR VGND sg13cmos5l_buf_1
Xfanout105 _11473_/B _11453_/X VPWR VGND sg13cmos5l_buf_1
Xfanout127 _15840_/A _15615_/Y VPWR VGND sg13cmos5l_buf_1
Xfanout149 _17234_/B _17214_/Y VPWR VGND sg13cmos5l_buf_1
XFILLER_101_469 VPWR VGND sg13cmos5l_decap_8
XFILLER_101_458 VPWR VGND sg13cmos5l_fill_2
XFILLER_55_512 VPWR VGND sg13cmos5l_fill_2
XFILLER_27_214 VPWR VGND sg13cmos5l_fill_2
XFILLER_15_409 VPWR VGND sg13cmos5l_fill_1
XFILLER_70_537 VPWR VGND sg13cmos5l_fill_2
XFILLER_27_269 VPWR VGND sg13cmos5l_fill_1
XFILLER_70_548 VPWR VGND sg13cmos5l_fill_2
XFILLER_10_114 VPWR VGND sg13cmos5l_fill_2
XFILLER_11_659 VPWR VGND sg13cmos5l_fill_1
X_18975__1288 _18975_/RESET_B VPWR VGND sg13cmos5l_tiehi
X_10360_ _17116_/A _10360_/A VPWR VGND sg13cmos5l_inv_1
X_10291_ _11932_/A _10291_/A VPWR VGND sg13cmos5l_inv_1
X_12030_ _18784_/D _12200_/A _12140_/A VPWR VGND sg13cmos5l_nor2_1
XFILLER_2_335 VPWR VGND sg13cmos5l_decap_4
XFILLER_104_296 VPWR VGND sg13cmos5l_decap_4
XFILLER_74_810 VPWR VGND sg13cmos5l_fill_2
X_13981_ _13987_/B _19085_/Q _13983_/B VPWR VGND sg13cmos5l_nor2b_1
X_12932_ _13121_/A _12932_/A _12960_/B VPWR VGND sg13cmos5l_nor2_1
XFILLER_46_523 VPWR VGND sg13cmos5l_fill_2
X_15720_ _15720_/Y _15720_/A _15720_/B VPWR VGND sg13cmos5l_nor2_1
XFILLER_37_84 VPWR VGND sg13cmos5l_fill_2
XFILLER_37_73 VPWR VGND sg13cmos5l_fill_1
X_15651_ _15678_/A _15644_/Y _15648_/Y _15649_/Y VPWR VGND sg13cmos5l_a21o_1
X_12863_ _12984_/B _12863_/A _12875_/B VPWR VGND sg13cmos5l_nand2_1
XFILLER_37_95 VPWR VGND sg13cmos5l_fill_2
X_14602_ _14603_/C _14602_/A _14602_/B _14602_/C VPWR VGND sg13cmos5l_nand3_1
X_11814_ _12006_/A _12190_/A _11997_/A VPWR VGND sg13cmos5l_nand2_1
X_12794_ _12794_/Y _10005_/Y fanout96/X _12793_/Y VPWR VGND sg13cmos5l_a21oi_1
X_18370_ _18371_/B _18370_/A _18370_/B VPWR VGND sg13cmos5l_xnor2_1
X_15582_ _15582_/Y _15582_/A _15582_/B _15582_/C VPWR VGND sg13cmos5l_nor3_1
XFILLER_15_954 VPWR VGND sg13cmos5l_fill_2
X_11745_ _11841_/A _11710_/X _11727_/B _11522_/B VPWR VGND sg13cmos5l_a21o_1
X_17321_ _17322_/B _17375_/B _17201_/Y _17341_/B VPWR VGND sg13cmos5l_mux2_1
X_14533_ _14572_/A _14533_/A _14532_/Y VPWR VGND sg13cmos5l_nor2b_1
X_17252_ _17252_/Y _19589_/Q _19590_/Q VPWR VGND sg13cmos5l_xnor2_1
XFILLER_53_94 VPWR VGND sg13cmos5l_fill_2
XFILLER_14_475 VPWR VGND sg13cmos5l_decap_8
X_14464_ _14464_/X _14464_/A _14464_/B VPWR VGND sg13cmos5l_xor2_1
X_11676_ _11676_/Y _11645_/Y _11672_/S _11680_/B1 VPWR VGND sg13cmos5l_o21ai_1
X_13415_ _13415_/Y _13415_/A VPWR VGND sg13cmos5l_inv_1
X_16203_ _16255_/A _19436_/Q _16204_/B VPWR VGND sg13cmos5l_xnor2_1
X_17183_ _17296_/B _17203_/B _17178_/X _17181_/Y VPWR VGND sg13cmos5l_o21ai_1
X_10627_ _10627_/Y _10619_/Y _10625_/Y _10626_/Y VPWR VGND sg13cmos5l_o21ai_1
XFILLER_6_630 VPWR VGND sg13cmos5l_fill_2
X_14395_ _14395_/Y _14395_/A VPWR VGND sg13cmos5l_inv_1
X_13346_ _13346_/Y _10253_/Y _13347_/S _13345_/Y VPWR VGND sg13cmos5l_a21oi_1
X_16134_ _19411_/D _16320_/A _16134_/B VPWR VGND sg13cmos5l_nor2_1
X_10558_ _18542_/A _10564_/A _10557_/Y _10556_/Y VPWR VGND sg13cmos5l_a21oi_1
X_13277_ _18956_/D _13289_/B _13277_/B VPWR VGND sg13cmos5l_nor2_1
X_16065_ _16065_/Y _16041_/A _16063_/S _16318_/A VPWR VGND sg13cmos5l_o21ai_1
X_18891__510 _18891_/D VPWR VGND sg13cmos5l_tielo
X_12228_ _12229_/C _12228_/A _12228_/B VPWR VGND sg13cmos5l_nor2_1
X_10489_ _18384_/A _10484_/B _10489_/B VPWR VGND sg13cmos5l_nand2b_1
X_15016_ _15016_/Y _14995_/B _14995_/C _15011_/B VPWR VGND sg13cmos5l_a21oi_1
XFILLER_38_4 VPWR VGND sg13cmos5l_fill_2
XFILLER_97_968 VPWR VGND sg13cmos5l_fill_1
X_12159_ _12159_/Y _12145_/A _12145_/B _12156_/A _12156_/B _12158_/Y VPWR VGND sg13cmos5l_a221oi_1
X_18680__1613 _18680_/RESET_B VPWR VGND sg13cmos5l_tiehi
X_16967_ _16967_/Y _16967_/A _16967_/B VPWR VGND sg13cmos5l_xnor2_1
X_19755_ _19755_/Q clkload14/A _19755_/D _19755_/RESET_B VPWR VGND sg13cmos5l_dfrbpq_1
X_18706_ _18706_/Q clkload56/A _18706_/D _18706_/RESET_B VPWR VGND sg13cmos5l_dfrbpq_1
X_15918_ _15924_/A _16313_/A _15918_/B VPWR VGND sg13cmos5l_xnor2_1
X_19803__1753 _19803_/RESET_B VPWR VGND sg13cmos5l_tiehi
X_16898_ _16898_/Y _19483_/Q _19484_/Q VPWR VGND sg13cmos5l_xnor2_1
X_19686_ _19686_/Q clkload20/A _19686_/D _19686_/RESET_B VPWR VGND sg13cmos5l_dfrbpq_1
X_19444__780 _19444_/RESET_B VPWR VGND sg13cmos5l_tiehi
X_18637_ _18637_/Q clkload46/A _18637_/D _18637_/RESET_B VPWR VGND sg13cmos5l_dfrbpq_1
XFILLER_37_578 VPWR VGND sg13cmos5l_decap_8
X_15849_ _15969_/A _15944_/A _15944_/B VPWR VGND sg13cmos5l_nand2_1
X_18568_ _18568_/Q _19814_/CLK _18568_/D _18568_/RESET_B VPWR VGND sg13cmos5l_dfrbpq_1
X_17519_ _17644_/A _19628_/Q _17526_/B _17518_/Y VPWR VGND sg13cmos5l_a21oi_1
X_18499_ _18499_/Y _19786_/Q _18499_/B VPWR VGND sg13cmos5l_nand2_1
X_18930__1336 _18930_/RESET_B VPWR VGND sg13cmos5l_tiehi
X_19103__1151 _19103_/RESET_B VPWR VGND sg13cmos5l_tiehi
XFILLER_32_294 VPWR VGND sg13cmos5l_fill_2
Xclkbuf_4_12_0_clk clkbuf_4_12_0_clk/X clkbuf_0_clk/X VPWR VGND sg13cmos5l_buf_8
X_19807__1577 _19807_/RESET_B VPWR VGND sg13cmos5l_tiehi
XFILLER_59_114 VPWR VGND sg13cmos5l_fill_2
XFILLER_56_832 VPWR VGND sg13cmos5l_fill_1
XFILLER_67_191 VPWR VGND sg13cmos5l_decap_8
XFILLER_56_854 VPWR VGND sg13cmos5l_fill_1
XFILLER_16_718 VPWR VGND sg13cmos5l_fill_2
XFILLER_90_15 VPWR VGND sg13cmos5l_fill_1
X_11530_ _11559_/B _11524_/B _11530_/B VPWR VGND sg13cmos5l_nand2b_1
X_18906__1360 _18906_/RESET_B VPWR VGND sg13cmos5l_tiehi
XFILLER_8_906 VPWR VGND sg13cmos5l_fill_2
XFILLER_8_917 VPWR VGND sg13cmos5l_fill_2
X_11461_ _11461_/X _11473_/B _11459_/X _11458_/Y VPWR VGND sg13cmos5l_a21o_1
XFILLER_11_467 VPWR VGND sg13cmos5l_decap_4
X_11392_ _11392_/Y _11392_/A _11392_/B _11392_/C VPWR VGND sg13cmos5l_nor3_1
X_10412_ _19812_/D _19810_/D _19811_/D _19809_/D VPWR VGND sg13cmos5l_or3_1
X_13200_ _13200_/Y _13200_/A _13200_/B VPWR VGND sg13cmos5l_nand2_1
X_14180_ _14282_/A _14180_/A _14200_/B _14200_/C VPWR VGND sg13cmos5l_nand3_1
X_13131_ _13131_/Y _13131_/A _13136_/B VPWR VGND sg13cmos5l_nor2_1
X_10343_ _17706_/A _17959_/A VPWR VGND sg13cmos5l_inv_1
X_10274_ _10274_/Y _12750_/A VPWR VGND sg13cmos5l_inv_1
X_13062_ _13064_/A _13328_/B _13059_/Y _13061_/Y _18939_/Q _13060_/Y VPWR VGND sg13cmos5l_a221oi_1
X_12013_ _12014_/B _11999_/A _11999_/B _12012_/Y VPWR VGND sg13cmos5l_o21ai_1
X_17870_ _17870_/Y _17870_/A _17870_/B VPWR VGND sg13cmos5l_nand2_1
X_16821_ _19502_/D _16821_/A _16823_/B VPWR VGND sg13cmos5l_nor2_1
XFILLER_93_404 VPWR VGND sg13cmos5l_fill_1
XFILLER_78_478 VPWR VGND sg13cmos5l_fill_1
X_16752_ _16753_/B _16916_/A _16910_/A VPWR VGND sg13cmos5l_and2_1
X_19540_ _19540_/Q clkload33/A _19540_/D _19540_/RESET_B VPWR VGND sg13cmos5l_dfrbpq_1
XFILLER_59_692 VPWR VGND sg13cmos5l_decap_8
XFILLER_93_448 VPWR VGND sg13cmos5l_fill_2
XFILLER_74_640 VPWR VGND sg13cmos5l_decap_4
X_13964_ _13964_/Y _13956_/X _14149_/A _13963_/Y VPWR VGND sg13cmos5l_o21ai_1
X_15703_ _15706_/A _15703_/A VPWR VGND sg13cmos5l_inv_1
X_16683_ _16781_/A _16779_/B _16779_/C _16779_/A VPWR VGND sg13cmos5l_a21o_1
X_19471_ _19471_/Q clkload41/A _19471_/D _19471_/RESET_B VPWR VGND sg13cmos5l_dfrbpq_1
X_12915_ _12948_/B _18933_/Q _12916_/B VPWR VGND sg13cmos5l_xnor2_1
X_13895_ _13912_/A _18989_/Q _18990_/Q VPWR VGND sg13cmos5l_xor2_1
X_12846_ _12848_/B _12846_/A _12846_/B VPWR VGND sg13cmos5l_and2_1
X_15634_ _15634_/Y _19332_/Q _19347_/Q VPWR VGND sg13cmos5l_nand2_1
X_18422_ _18423_/B _18338_/X _18411_/Y _18445_/B VPWR VGND sg13cmos5l_mux2_1
X_18353_ _18443_/B _19753_/Q _18450_/B VPWR VGND sg13cmos5l_nand2_1
X_15565_ _15565_/Y _19283_/Q _15582_/B VPWR VGND sg13cmos5l_nor2_1
X_17304_ _17304_/Y _17304_/A _17304_/B _17304_/C _17304_/D VPWR VGND sg13cmos5l_nand4_1
X_12777_ _12777_/Y _12757_/B fanout50/X _13019_/B VPWR VGND sg13cmos5l_o21ai_1
X_14516_ _14517_/C _14516_/A _14516_/B VPWR VGND sg13cmos5l_or2_1
X_11728_ _11852_/A _11727_/X _11548_/Y _11742_/C VPWR VGND sg13cmos5l_mux2_1
X_18284_ _18284_/Y _18498_/B _18284_/B VPWR VGND sg13cmos5l_nand2_1
X_15496_ _15496_/Y _19314_/Q _15485_/Y _15495_/Y _19315_/Q _15491_/Y VPWR VGND sg13cmos5l_a221oi_1
X_11659_ _11659_/Y _10291_/A _11658_/Y _11654_/Y VPWR VGND sg13cmos5l_a21oi_1
X_17235_ _17235_/Y _17330_/B _17347_/A _17235_/C VPWR VGND sg13cmos5l_nand3_1
X_14447_ _14482_/A _19118_/Q _14457_/D VPWR VGND sg13cmos5l_xor2_1
X_17166_ _17166_/Y _17015_/B _17163_/X _17204_/A _17171_/A VPWR VGND sg13cmos5l_a22oi_1
X_14378_ _14378_/Y _19103_/Q _14380_/A VPWR VGND sg13cmos5l_nand2b_1
X_13329_ _13329_/Y _13329_/A _14077_/A _13329_/C VPWR VGND sg13cmos5l_nand3_1
XFILLER_7_972 VPWR VGND sg13cmos5l_decap_4
X_16117_ _16117_/Y _16117_/A _16117_/B VPWR VGND sg13cmos5l_nor2_1
X_17097_ _17097_/Y _17670_/A _19515_/Q _19516_/Q _17671_/A _17096_/Y VPWR VGND sg13cmos5l_a221oi_1
Xhold3008 _16767_/A _19499_/Q VPWR VGND sg13cmos5l_dlygate4sd3_1
Xhold3019 _13217_/A _18966_/Q VPWR VGND sg13cmos5l_dlygate4sd3_1
X_16048_ _16049_/B _16553_/A _16556_/A _16052_/C VPWR VGND sg13cmos5l_nand3_1
XFILLER_97_732 VPWR VGND sg13cmos5l_fill_1
Xhold2318 _10287_/A _18767_/Q VPWR VGND sg13cmos5l_dlygate4sd3_1
Xhold2307 _10070_/A _18956_/Q VPWR VGND sg13cmos5l_dlygate4sd3_1
XFILLER_96_231 VPWR VGND sg13cmos5l_fill_1
X_19807_ _19807_/Q _19814_/CLK _19807_/D _19807_/RESET_B VPWR VGND sg13cmos5l_dfrbpq_1
Xhold2329 _18642_/D _11138_/Y VPWR VGND sg13cmos5l_dlygate4sd3_1
XFILLER_29_0 VPWR VGND sg13cmos5l_fill_2
X_17999_ _17999_/Y hold1961/X fanout84/X _17930_/A VPWR VGND sg13cmos5l_o21ai_1
XFILLER_65_640 VPWR VGND sg13cmos5l_fill_1
X_19001__1259 _19001_/RESET_B VPWR VGND sg13cmos5l_tiehi
X_19738_ _19738_/Q _19738_/CLK _19738_/D _19738_/RESET_B VPWR VGND sg13cmos5l_dfrbpq_1
X_18644__1652 _18644_/RESET_B VPWR VGND sg13cmos5l_tiehi
X_19669_ _19669_/Q clkload11/A _19669_/D _19669_/RESET_B VPWR VGND sg13cmos5l_dfrbpq_1
XFILLER_25_515 VPWR VGND sg13cmos5l_fill_2
XFILLER_92_481 VPWR VGND sg13cmos5l_decap_4
XFILLER_80_632 VPWR VGND sg13cmos5l_fill_1
XFILLER_52_367 VPWR VGND sg13cmos5l_fill_1
X_19813__648 _19813_/RESET_B VPWR VGND sg13cmos5l_tiehi
XFILLER_106_358 VPWR VGND sg13cmos5l_fill_2
X_18569__1734 _18569_/RESET_B VPWR VGND sg13cmos5l_tiehi
X_18761__1517 _18761_/RESET_B VPWR VGND sg13cmos5l_tiehi
Xhold2841 _10069_/A _18955_/Q VPWR VGND sg13cmos5l_dlygate4sd3_1
Xhold2830 _11007_/A _18632_/Q VPWR VGND sg13cmos5l_dlygate4sd3_1
Xhold2874 hold2874/X _17062_/A VPWR VGND sg13cmos5l_dlygate4sd3_1
Xhold2863 hold2863/X _19814_/Q VPWR VGND sg13cmos5l_dlygate4sd3_1
Xhold2852 hold2852/X _18206_/B VPWR VGND sg13cmos5l_dlygate4sd3_1
Xhold2896 hold2896/X _19591_/Q VPWR VGND sg13cmos5l_dlygate4sd3_1
Xhold2885 _18091_/A _19711_/Q VPWR VGND sg13cmos5l_dlygate4sd3_1
XFILLER_84_982 VPWR VGND sg13cmos5l_fill_1
X_10961_ _10961_/Y _10989_/A _11174_/A VPWR VGND sg13cmos5l_nand2_1
X_13680_ _13688_/A _19043_/Q _13680_/B VPWR VGND sg13cmos5l_xnor2_1
X_12700_ _12700_/Y _12677_/Y _12694_/Y _12699_/Y VPWR VGND sg13cmos5l_o21ai_1
XFILLER_55_172 VPWR VGND sg13cmos5l_fill_1
X_12631_ _12639_/B _13021_/A _12633_/B VPWR VGND sg13cmos5l_and2_1
X_10892_ _10892_/Y _10567_/B _10918_/A _10890_/Y VPWR VGND sg13cmos5l_a21oi_1
XFILLER_31_507 VPWR VGND sg13cmos5l_fill_1
XFILLER_70_186 VPWR VGND sg13cmos5l_decap_4
XFILLER_24_581 VPWR VGND sg13cmos5l_fill_1
X_12562_ _12682_/A _12574_/B _12561_/Y _12560_/Y VPWR VGND sg13cmos5l_a21o_1
X_15350_ _15389_/B _19308_/Q _15383_/A VPWR VGND sg13cmos5l_xor2_1
XFILLER_15_1007 VPWR VGND sg13cmos5l_fill_1
X_12493_ _12494_/B _18873_/Q _13022_/A _12498_/C VPWR VGND sg13cmos5l_nand3_1
X_11513_ _11522_/A _11513_/A _11513_/B VPWR VGND sg13cmos5l_nor2_1
X_15281_ _15281_/Y _15278_/A _15278_/B _15303_/B _15282_/A VPWR VGND sg13cmos5l_a22oi_1
X_14301_ _14302_/B _14197_/A _14197_/B _14307_/S _14297_/X _14299_/Y VPWR VGND sg13cmos5l_a221oi_1
X_17020_ _17090_/B _16999_/A _17203_/A _17020_/S VPWR VGND sg13cmos5l_mux2_1
X_11444_ _11447_/B _11444_/A _11444_/B VPWR VGND sg13cmos5l_xor2_1
X_14232_ _14319_/A _14343_/A _14232_/B VPWR VGND sg13cmos5l_nand2_1
X_11375_ _11393_/C _18708_/Q _11378_/B _11374_/B VPWR VGND sg13cmos5l_o21ai_1
X_14163_ _14163_/Y _14162_/A _14163_/B VPWR VGND sg13cmos5l_nand2b_1
XFILLER_79_710 VPWR VGND sg13cmos5l_fill_2
X_13114_ _13115_/B _13114_/A _13136_/B VPWR VGND sg13cmos5l_nor2_1
X_18971_ _18971_/Q clkload66/A _18971_/D _18971_/RESET_B VPWR VGND sg13cmos5l_dfrbpq_1
X_10326_ _18261_/A _10326_/A VPWR VGND sg13cmos5l_inv_1
X_14094_ _14094_/Y _14094_/A _14103_/B VPWR VGND sg13cmos5l_nand2_1
X_13045_ _13045_/X _13045_/A _13045_/B VPWR VGND sg13cmos5l_and2_1
XFILLER_59_71 VPWR VGND sg13cmos5l_decap_4
X_17922_ _17923_/B _17900_/B _17897_/Y _17928_/S VPWR VGND sg13cmos5l_mux2_1
XFILLER_3_474 VPWR VGND sg13cmos5l_fill_1
X_10257_ _13848_/A _18982_/Q VPWR VGND sg13cmos5l_inv_1
X_18737__1541 _18737_/RESET_B VPWR VGND sg13cmos5l_tiehi
XFILLER_67_905 VPWR VGND sg13cmos5l_fill_2
XFILLER_39_618 VPWR VGND sg13cmos5l_fill_1
X_10188_ _18258_/A _10188_/A VPWR VGND sg13cmos5l_inv_1
X_17853_ _17853_/Y _17830_/X _17870_/B VPWR VGND sg13cmos5l_nand2b_1
X_16804_ _19490_/D _16804_/A _16804_/B VPWR VGND sg13cmos5l_and2_1
XFILLER_93_234 VPWR VGND sg13cmos5l_fill_1
XFILLER_82_908 VPWR VGND sg13cmos5l_fill_2
X_17784_ _19656_/D _17942_/A _17879_/A VPWR VGND sg13cmos5l_nor2_1
X_14996_ _14996_/X _14994_/Y _14995_/Y _14990_/Y VPWR VGND sg13cmos5l_a21o_1
X_16735_ _16735_/Y _17080_/A _16916_/A VPWR VGND sg13cmos5l_nand2_1
X_19523_ _19523_/Q clkload28/A _19523_/D _19523_/RESET_B VPWR VGND sg13cmos5l_dfrbpq_1
XFILLER_47_684 VPWR VGND sg13cmos5l_fill_2
X_13947_ _13947_/Y _19093_/Q _14050_/B _13933_/Y VPWR VGND sg13cmos5l_a21oi_1
X_16666_ _19486_/D _16825_/A _16666_/B VPWR VGND sg13cmos5l_nor2_1
X_19454_ _19454_/Q clkload6/A _19454_/D _19454_/RESET_B VPWR VGND sg13cmos5l_dfrbpq_1
XFILLER_35_846 VPWR VGND sg13cmos5l_fill_2
X_18970__1293 _18970_/RESET_B VPWR VGND sg13cmos5l_tiehi
XFILLER_62_654 VPWR VGND sg13cmos5l_decap_8
X_15617_ _15617_/Y _15617_/A _15840_/A VPWR VGND sg13cmos5l_nand2_1
X_18405_ _18406_/B _18405_/A _18414_/B _18414_/C VPWR VGND sg13cmos5l_nand3_1
X_13878_ _19071_/D _14436_/A _13878_/B VPWR VGND sg13cmos5l_and2_1
X_12829_ _12931_/B _12838_/B _12824_/Y _12827_/Y VPWR VGND sg13cmos5l_o21ai_1
X_16597_ _16597_/Y _16854_/A _16591_/A _16596_/A _10372_/Y _16592_/Y VPWR VGND sg13cmos5l_a221oi_1
X_19385_ _19385_/Q clkload19/A _19385_/D _19385_/RESET_B VPWR VGND sg13cmos5l_dfrbpq_1
XFILLER_22_529 VPWR VGND sg13cmos5l_fill_2
X_15548_ _15548_/Y _15532_/X _15541_/X _15582_/A _15553_/A _15544_/X VPWR VGND sg13cmos5l_a221oi_1
X_18336_ _18336_/Y _18341_/B _18302_/B VPWR VGND sg13cmos5l_nor2b_1
X_19806__1576 _19806_/RESET_B VPWR VGND sg13cmos5l_tiehi
X_18267_ _18267_/Y _18508_/A _18260_/B _18266_/A _18513_/B _18262_/Y VPWR VGND sg13cmos5l_a221oi_1
X_15479_ _15498_/C _15482_/C _15479_/B VPWR VGND sg13cmos5l_and2_1
XFILLER_30_551 VPWR VGND sg13cmos5l_fill_1
X_17218_ _17236_/A _17219_/A _17221_/B VPWR VGND sg13cmos5l_or2_1
X_18198_ _18198_/Y _18174_/Y _18192_/Y _18197_/Y VPWR VGND sg13cmos5l_o21ai_1
X_17149_ _19563_/D _09973_/Y fanout70/X _17148_/Y VPWR VGND sg13cmos5l_a21oi_1
X_09971_ _09971_/Y _09971_/A VPWR VGND sg13cmos5l_inv_1
Xhold2104 _10318_/A _18664_/Q VPWR VGND sg13cmos5l_dlygate4sd3_1
Xhold2126 _14679_/B _19148_/Q VPWR VGND sg13cmos5l_dlygate4sd3_1
Xhold2115 _19103_/D _14128_/Y VPWR VGND sg13cmos5l_dlygate4sd3_1
Xhold2137 _13842_/A _18979_/Q VPWR VGND sg13cmos5l_dlygate4sd3_1
Xhold2159 _10255_/A _18977_/Q VPWR VGND sg13cmos5l_dlygate4sd3_1
Xhold2148 _14932_/A _19188_/Q VPWR VGND sg13cmos5l_dlygate4sd3_1
XFILLER_29_106 VPWR VGND sg13cmos5l_fill_1
XFILLER_77_1001 VPWR VGND sg13cmos5l_fill_1
XFILLER_38_684 VPWR VGND sg13cmos5l_fill_2
XFILLER_37_172 VPWR VGND sg13cmos5l_decap_8
XFILLER_26_846 VPWR VGND sg13cmos5l_fill_2
XFILLER_25_356 VPWR VGND sg13cmos5l_fill_1
XFILLER_105_4 VPWR VGND sg13cmos5l_fill_2
X_11160_ _11160_/X _18611_/Q _18612_/Q _18618_/Q VPWR VGND sg13cmos5l_or3_1
X_11091_ _18638_/D _11091_/A _11091_/B VPWR VGND sg13cmos5l_nor2_1
XFILLER_0_422 VPWR VGND sg13cmos5l_fill_1
X_10111_ _15460_/A _10111_/A VPWR VGND sg13cmos5l_inv_1
X_10042_ _12462_/A _10042_/A VPWR VGND sg13cmos5l_inv_1
XFILLER_49_938 VPWR VGND sg13cmos5l_fill_1
Xhold2671 _10026_/A _18708_/Q VPWR VGND sg13cmos5l_dlygate4sd3_1
XFILLER_76_746 VPWR VGND sg13cmos5l_fill_1
X_14850_ _14850_/X _14850_/A _14916_/B VPWR VGND sg13cmos5l_and2_1
Xhold2660 _15053_/A _19256_/Q VPWR VGND sg13cmos5l_dlygate4sd3_1
Xhold2682 hold2682/X _14517_/Y VPWR VGND sg13cmos5l_dlygate4sd3_1
X_13801_ _19041_/D _13801_/A _13801_/B _13801_/C VPWR VGND sg13cmos5l_nor3_1
X_18725__1556 _18725_/RESET_B VPWR VGND sg13cmos5l_tiehi
Xhold2693 _11537_/A _18717_/Q VPWR VGND sg13cmos5l_dlygate4sd3_1
Xhold1981 hold1981/X _18732_/Q VPWR VGND sg13cmos5l_dlygate4sd3_1
XFILLER_57_982 VPWR VGND sg13cmos5l_fill_2
X_14781_ _14782_/B _14781_/A _14781_/B VPWR VGND sg13cmos5l_xor2_1
Xhold1970 hold1970/X _19361_/Q VPWR VGND sg13cmos5l_dlygate4sd3_1
X_11993_ _12028_/B _11993_/A _11993_/B VPWR VGND sg13cmos5l_xor2_1
Xhold1992 _10796_/A _18578_/Q VPWR VGND sg13cmos5l_dlygate4sd3_1
X_13732_ _13732_/Y _19025_/Q _18580_/Q VPWR VGND sg13cmos5l_xnor2_1
XFILLER_17_846 VPWR VGND sg13cmos5l_fill_1
X_16520_ _16520_/Y _16462_/X _16526_/B _16519_/Y VPWR VGND sg13cmos5l_a21oi_1
XFILLER_90_248 VPWR VGND sg13cmos5l_fill_1
X_10944_ _10954_/A _10944_/A _10977_/A VPWR VGND sg13cmos5l_xor2_1
XFILLER_44_654 VPWR VGND sg13cmos5l_decap_8
XFILLER_17_868 VPWR VGND sg13cmos5l_fill_2
X_13663_ _13663_/Y _13696_/A _13661_/Y _13662_/Y _19039_/Q VPWR VGND sg13cmos5l_a22oi_1
X_10875_ _10875_/Y hold2004/X fanout76/X _17930_/A VPWR VGND sg13cmos5l_o21ai_1
X_16451_ _16451_/X _16452_/C _16452_/D VPWR VGND sg13cmos5l_and2_1
X_12614_ _12614_/Y _18886_/Q _18885_/Q _18870_/Q VPWR VGND sg13cmos5l_nand3b_1
X_13594_ _13594_/Y _16820_/A _18573_/Q _13589_/Y _13593_/Y VPWR VGND sg13cmos5l_a22oi_1
X_15402_ _15405_/A _15393_/Y _15397_/Y _15401_/Y VPWR VGND sg13cmos5l_o21ai_1
X_19170_ _19170_/Q _19220_/CLK _19170_/D _19170_/RESET_B VPWR VGND sg13cmos5l_dfrbpq_1
X_16382_ _16417_/B _16382_/A _16383_/B VPWR VGND sg13cmos5l_xnor2_1
X_19095__1159 _19095_/RESET_B VPWR VGND sg13cmos5l_tiehi
X_12545_ _12545_/Y _18828_/Q _18821_/Q _12561_/A VPWR VGND sg13cmos5l_o21ai_1
X_15333_ _15334_/B _15333_/A _15426_/B VPWR VGND sg13cmos5l_nand2_1
X_18121_ _18124_/A _18112_/X _18116_/Y _18150_/A _18152_/A _18117_/X VPWR VGND sg13cmos5l_a221oi_1
XFILLER_61_94 VPWR VGND sg13cmos5l_decap_8
X_18052_ _18054_/B _18045_/B _18039_/B _18051_/Y VPWR VGND sg13cmos5l_o21ai_1
X_12476_ _12476_/Y _13020_/A _18812_/Q _12474_/Y _12475_/Y VPWR VGND sg13cmos5l_a22oi_1
X_17003_ _17020_/S _17011_/C _17011_/D VPWR VGND sg13cmos5l_nand2_1
X_15264_ _15271_/C _19241_/Q _19242_/Q _19243_/Q VPWR VGND sg13cmos5l_o21ai_1
X_11427_ _11444_/B _18657_/Q _11429_/B VPWR VGND sg13cmos5l_nor2b_1
XFILLER_8_599 VPWR VGND sg13cmos5l_fill_2
X_15195_ _15195_/Y _15741_/A _19233_/Q VPWR VGND sg13cmos5l_nor2_1
X_14215_ _14220_/A _14215_/A _14229_/B VPWR VGND sg13cmos5l_and2_1
XFILLER_99_838 VPWR VGND sg13cmos5l_fill_1
X_11358_ _18675_/D _11358_/A _11358_/B VPWR VGND sg13cmos5l_nor2_1
X_19766__775 _19766_/RESET_B VPWR VGND sg13cmos5l_tiehi
X_14146_ _14165_/D _19075_/Q _19073_/Q _19074_/Q VPWR VGND sg13cmos5l_or3_1
X_10309_ _11116_/A _10309_/A VPWR VGND sg13cmos5l_inv_1
X_18954_ _18954_/Q clkload65/A _18954_/D _18954_/RESET_B VPWR VGND sg13cmos5l_dfrbpq_1
X_11289_ _11289_/Y _11280_/Y _11284_/Y _11360_/B _11318_/A _11288_/Y VPWR VGND sg13cmos5l_a221oi_1
X_14077_ _19094_/D _14077_/A _14080_/A VPWR VGND sg13cmos5l_nor2_1
X_18885_ _18885_/Q clkload71/A _18885_/D _18885_/RESET_B VPWR VGND sg13cmos5l_dfrbpq_1
X_13028_ _18932_/D _13028_/A _13028_/B VPWR VGND sg13cmos5l_and2_1
X_17905_ _17914_/B _17942_/B _17904_/B _17904_/Y VPWR VGND sg13cmos5l_o21ai_1
XFILLER_6_1005 VPWR VGND sg13cmos5l_fill_1
X_19328__908 _19328_/RESET_B VPWR VGND sg13cmos5l_tiehi
X_17836_ _17836_/Y _18010_/B _17865_/A VPWR VGND sg13cmos5l_nor2_1
X_19506_ _19506_/Q _19546_/CLK _19506_/D _19506_/RESET_B VPWR VGND sg13cmos5l_dfrbpq_1
X_17767_ _17781_/S _17765_/A _17765_/B _17766_/X VPWR VGND sg13cmos5l_o21ai_1
X_14979_ _14995_/B _19201_/Q _19199_/Q _19200_/Q VPWR VGND sg13cmos5l_or3_1
XFILLER_35_610 VPWR VGND sg13cmos5l_fill_2
X_16718_ _16897_/A _19492_/Q _16722_/A VPWR VGND sg13cmos5l_xnor2_1
X_17698_ _17699_/A _17709_/C _17696_/Y _17697_/Y VPWR VGND sg13cmos5l_a21o_1
X_16649_ _16650_/B _13688_/A _16629_/Y _16648_/Y VPWR VGND sg13cmos5l_o21ai_1
X_19437_ _19437_/Q clkload9/A _19437_/D _19437_/RESET_B VPWR VGND sg13cmos5l_dfrbpq_1
XFILLER_34_164 VPWR VGND sg13cmos5l_fill_2
X_19368_ _19368_/Q clkload18/A _19368_/D _19368_/RESET_B VPWR VGND sg13cmos5l_dfrbpq_1
X_18319_ _18319_/Y _18319_/A _18341_/B VPWR VGND sg13cmos5l_nor2_1
X_19299_ _19299_/Q clkload44/A _19299_/D _19299_/RESET_B VPWR VGND sg13cmos5l_dfrbpq_1
XFILLER_58_757 VPWR VGND sg13cmos5l_fill_1
XFILLER_26_610 VPWR VGND sg13cmos5l_fill_1
X_19050__1207 _19050_/RESET_B VPWR VGND sg13cmos5l_tiehi
X_10660_ _10660_/Y _10659_/A _10664_/B _10658_/Y _10659_/Y VPWR VGND sg13cmos5l_a22oi_1
XFILLER_41_657 VPWR VGND sg13cmos5l_decap_4
X_10591_ _18547_/A _10592_/A _10592_/B VPWR VGND sg13cmos5l_nor2_1
X_12330_ _12341_/C _18832_/Q _18831_/Q _18830_/Q _18829_/Q VPWR VGND sg13cmos5l_nor4_1
X_12261_ _18820_/D _12527_/A _12378_/B VPWR VGND sg13cmos5l_and2_1
XFILLER_5_525 VPWR VGND sg13cmos5l_fill_2
X_11212_ _11212_/Y _18649_/Q _18610_/Q VPWR VGND sg13cmos5l_nand2_1
X_14000_ _14000_/Y _14080_/B VPWR VGND sg13cmos5l_inv_1
X_12192_ _18797_/D _12192_/A _12192_/B VPWR VGND sg13cmos5l_and2_1
X_11143_ _11143_/Y _11378_/B _11143_/B VPWR VGND sg13cmos5l_nand2_1
XFILLER_95_318 VPWR VGND sg13cmos5l_decap_4
X_11074_ _11074_/Y hold2765/X _11063_/Y _11073_/Y VPWR VGND sg13cmos5l_a21oi_1
X_15951_ _16140_/A _16107_/A _15951_/B VPWR VGND sg13cmos5l_and2_1
X_10025_ _11898_/A _10025_/A VPWR VGND sg13cmos5l_inv_1
X_18670_ _18670_/Q clkload55/A _18670_/D _18670_/RESET_B VPWR VGND sg13cmos5l_dfrbpq_1
X_14902_ _19211_/D _14902_/A _14902_/B VPWR VGND sg13cmos5l_nor2_1
X_15882_ _15989_/A _19387_/Q _15884_/B VPWR VGND sg13cmos5l_nor2_1
X_19805__1575 _19805_/RESET_B VPWR VGND sg13cmos5l_tiehi
X_17621_ _17622_/B hold3056/X _17522_/B _17503_/Y VPWR VGND sg13cmos5l_a21oi_1
Xhold2490 _19438_/D _16361_/Y VPWR VGND sg13cmos5l_dlygate4sd3_1
X_14833_ _14833_/Y _14833_/A _14843_/S VPWR VGND sg13cmos5l_nand2_1
X_11976_ _11976_/Y _11986_/D _11975_/C _11975_/A VPWR VGND sg13cmos5l_a21oi_1
X_17552_ _17552_/Y _17601_/B _17552_/B VPWR VGND sg13cmos5l_nor2_1
X_14764_ _14779_/A _14764_/A _14783_/B VPWR VGND sg13cmos5l_nor2_1
X_13715_ _13817_/B _13694_/Y _13713_/Y _13714_/Y VPWR VGND sg13cmos5l_a21o_1
X_17483_ _17484_/B _17585_/A _17585_/B VPWR VGND sg13cmos5l_nand2_1
X_10927_ _18614_/D _10926_/A _10926_/B _11089_/A VPWR VGND sg13cmos5l_a21oi_1
X_14695_ _14695_/Y _10229_/Y _14687_/Y _14694_/Y VPWR VGND sg13cmos5l_a21oi_1
X_16503_ _16504_/B _19456_/Q _16508_/B _16481_/Y VPWR VGND sg13cmos5l_a21oi_1
XFILLER_31_101 VPWR VGND sg13cmos5l_fill_2
X_13646_ _19030_/D _16624_/A _13646_/B VPWR VGND sg13cmos5l_and2_1
X_19222_ _19222_/Q clkload51/A _19222_/D _19222_/RESET_B VPWR VGND sg13cmos5l_dfrbpq_1
X_16434_ _16434_/X _16434_/A _16434_/B _16434_/C VPWR VGND sg13cmos5l_or3_1
X_10858_ _10858_/Y _10858_/A _10858_/B VPWR VGND sg13cmos5l_nor2_1
X_10789_ _13700_/A _13808_/A _13649_/B VPWR VGND sg13cmos5l_nor2_1
X_13577_ _19007_/D _13577_/A _13578_/B VPWR VGND sg13cmos5l_nor2_1
X_16365_ _16365_/Y _16555_/B _16365_/B VPWR VGND sg13cmos5l_nor2_1
X_19153_ _19153_/Q _19302_/CLK _19153_/D _19153_/RESET_B VPWR VGND sg13cmos5l_dfrbpq_1
X_19059__1198 _19059_/RESET_B VPWR VGND sg13cmos5l_tiehi
X_12528_ _18861_/D _12528_/A _12528_/B VPWR VGND sg13cmos5l_and2_1
X_19084_ _19084_/Q clkload52/A _19084_/D _19084_/RESET_B VPWR VGND sg13cmos5l_dfrbpq_1
X_18104_ _18315_/A _18476_/A _18104_/B VPWR VGND sg13cmos5l_xnor2_1
XFILLER_8_341 VPWR VGND sg13cmos5l_fill_1
X_16296_ _19416_/D hold2680/X fanout34/X _16295_/Y VPWR VGND sg13cmos5l_a21oi_1
X_15316_ _15426_/B _15316_/A _15331_/B VPWR VGND sg13cmos5l_nand2_1
X_12459_ _18839_/D _12459_/A _12460_/B VPWR VGND sg13cmos5l_nor2_1
X_18035_ _18035_/Y _17875_/A _18027_/Y _18057_/B _18038_/A VPWR VGND sg13cmos5l_a22oi_1
XFILLER_8_396 VPWR VGND sg13cmos5l_decap_4
X_15247_ _15247_/Y _15482_/B _15247_/B VPWR VGND sg13cmos5l_nand2_1
X_15178_ _19252_/D hold2753/X _15168_/Y _15177_/Y VPWR VGND sg13cmos5l_a21oi_1
Xfanout309 _11680_/B1 _11670_/Y VPWR VGND sg13cmos5l_buf_1
X_18607__1690 _18607_/RESET_B VPWR VGND sg13cmos5l_tiehi
X_14129_ _14129_/Y _14097_/Y _14131_/S _14375_/A VPWR VGND sg13cmos5l_o21ai_1
XFILLER_98_167 VPWR VGND sg13cmos5l_fill_1
XFILLER_79_370 VPWR VGND sg13cmos5l_fill_2
X_18937_ _18937_/Q _19092_/CLK _18937_/D _18937_/RESET_B VPWR VGND sg13cmos5l_dfrbpq_1
XFILLER_67_532 VPWR VGND sg13cmos5l_fill_1
X_18868_ _18868_/Q _18931_/CLK _18868_/D _18868_/RESET_B VPWR VGND sg13cmos5l_dfrbpq_1
XFILLER_11_0 VPWR VGND sg13cmos5l_fill_2
X_18799_ _18799_/Q clkload60/A _18799_/D _18799_/RESET_B VPWR VGND sg13cmos5l_dfrbpq_1
X_17819_ _17844_/B _18226_/A _17821_/B VPWR VGND sg13cmos5l_nand2_1
XFILLER_50_476 VPWR VGND sg13cmos5l_fill_1
Xheichips26_digital_project_1810 uio_oe[13] VPWR VGND sg13cmos5l_tiehi
X_18591__1708 _18591_/RESET_B VPWR VGND sg13cmos5l_tiehi
XFILLER_73_524 VPWR VGND sg13cmos5l_fill_2
X_11830_ _11830_/Y _11734_/Y _11902_/B _11903_/B _11844_/A VPWR VGND sg13cmos5l_a22oi_1
XFILLER_73_546 VPWR VGND sg13cmos5l_decap_4
X_11761_ _11865_/C _11760_/A _11760_/B _11772_/A VPWR VGND sg13cmos5l_o21ai_1
XFILLER_27_985 VPWR VGND sg13cmos5l_fill_2
X_10712_ _10712_/Y _18573_/Q _10710_/Y _10711_/Y VPWR VGND sg13cmos5l_o21ai_1
X_13500_ _13500_/Y _13500_/A _13500_/B _13500_/C _13500_/D VPWR VGND sg13cmos5l_nand4_1
X_11692_ _18736_/D _13807_/A _11692_/B VPWR VGND sg13cmos5l_and2_1
X_19014__1246 _19014_/RESET_B VPWR VGND sg13cmos5l_tiehi
X_14480_ _14575_/A _14487_/S _14479_/Y _14478_/Y VPWR VGND sg13cmos5l_a21oi_1
X_13431_ _13448_/A _13432_/A _13450_/B VPWR VGND sg13cmos5l_nor2_1
XFILLER_9_149 VPWR VGND sg13cmos5l_fill_2
X_10643_ _19799_/D _10643_/A _18547_/B VPWR VGND sg13cmos5l_nor2_1
X_13362_ _13414_/A _18950_/Q _13381_/D VPWR VGND sg13cmos5l_xor2_1
XFILLER_42_74 VPWR VGND sg13cmos5l_decap_8
X_16150_ _16150_/Y _16148_/Y _16149_/Y _16147_/Y VPWR VGND sg13cmos5l_a21oi_1
X_10574_ _18545_/A _10506_/Y _10572_/Y _10573_/Y _10564_/A VPWR VGND sg13cmos5l_a22oi_1
X_12313_ _12336_/D _18843_/Q _18844_/Q _18845_/Q VPWR VGND sg13cmos5l_or3_1
X_15101_ _15190_/B _15101_/A _15102_/B VPWR VGND sg13cmos5l_nor2b_1
XFILLER_10_896 VPWR VGND sg13cmos5l_fill_1
X_16081_ _19406_/D _16081_/A _16081_/B VPWR VGND sg13cmos5l_and2_1
X_13293_ _18970_/D _13297_/A _13293_/B VPWR VGND sg13cmos5l_and2_1
XFILLER_5_355 VPWR VGND sg13cmos5l_fill_1
X_15032_ _15032_/Y _19236_/Q _19197_/Q VPWR VGND sg13cmos5l_xnor2_1
X_12244_ _12244_/Y _10281_/Y _12241_/S _12243_/Y VPWR VGND sg13cmos5l_a21oi_1
X_12175_ _12175_/Y _12052_/A _12052_/B _12165_/Y _12173_/Y _12174_/Y VPWR VGND sg13cmos5l_a221oi_1
XFILLER_96_627 VPWR VGND sg13cmos5l_fill_2
XFILLER_96_616 VPWR VGND sg13cmos5l_fill_2
XFILLER_95_104 VPWR VGND sg13cmos5l_fill_1
X_11126_ _11126_/Y _11388_/A _11119_/B _11125_/A _11393_/B _11121_/Y VPWR VGND sg13cmos5l_a221oi_1
X_19771_ _19771_/Q clkload34/A _19771_/D _19771_/RESET_B VPWR VGND sg13cmos5l_dfrbpq_1
XFILLER_95_115 VPWR VGND sg13cmos5l_fill_2
X_16983_ _16983_/X _17011_/A _17011_/B _16989_/C VPWR VGND sg13cmos5l_a21o_1
X_18722_ _18722_/Q clkload59/A _18722_/D _18722_/RESET_B VPWR VGND sg13cmos5l_dfrbpq_1
X_11057_ _11058_/B _11057_/A _11057_/B VPWR VGND sg13cmos5l_xor2_1
X_15934_ _15944_/C _15898_/Y _15939_/B _15939_/C VPWR VGND sg13cmos5l_nand3b_1
X_10008_ _10008_/Y _12043_/A VPWR VGND sg13cmos5l_inv_1
XFILLER_76_373 VPWR VGND sg13cmos5l_fill_2
X_18653_ _18653_/Q clkload58/A _18653_/D _18653_/RESET_B VPWR VGND sg13cmos5l_dfrbpq_1
X_15865_ _15865_/Y _19363_/Q _19324_/Q VPWR VGND sg13cmos5l_nand2_1
X_18584_ _18584_/Q _18594_/CLK _18584_/D _18584_/RESET_B VPWR VGND sg13cmos5l_dfrbpq_1
X_17604_ _17604_/Y _17492_/A _17492_/B _17610_/S _17600_/X _17602_/Y VPWR VGND sg13cmos5l_a221oi_1
X_14816_ _14816_/X _14816_/A _15000_/A VPWR VGND sg13cmos5l_or2_1
X_17535_ _17601_/B _19634_/Q _17562_/D VPWR VGND sg13cmos5l_xnor2_1
X_15796_ _15796_/Y _15777_/A _15798_/S _15864_/A VPWR VGND sg13cmos5l_o21ai_1
XFILLER_18_996 VPWR VGND sg13cmos5l_decap_4
X_11959_ _11959_/Y _11942_/Y hold2365/X _11947_/Y VPWR VGND sg13cmos5l_a21oi_1
XFILLER_72_590 VPWR VGND sg13cmos5l_fill_2
XFILLER_44_292 VPWR VGND sg13cmos5l_fill_1
X_14747_ _19200_/D _14913_/A _14747_/B VPWR VGND sg13cmos5l_nor2_1
X_17466_ _17466_/X _17467_/A _17467_/B _17464_/Y VPWR VGND sg13cmos5l_a21o_1
X_19770__738 _19770_/RESET_B VPWR VGND sg13cmos5l_tiehi
X_14678_ _14678_/Y _10229_/Y _14663_/Y _14677_/Y VPWR VGND sg13cmos5l_o21ai_1
XFILLER_33_966 VPWR VGND sg13cmos5l_fill_2
X_13629_ _19019_/D _13629_/A _13628_/Y VPWR VGND sg13cmos5l_nor2b_1
X_17397_ _17397_/Y _19554_/Q _17397_/B VPWR VGND sg13cmos5l_nand2_1
X_19205_ _19205_/Q _19304_/CLK _19205_/D _19205_/RESET_B VPWR VGND sg13cmos5l_dfrbpq_1
X_16417_ _16448_/A _16467_/B _16417_/B _16417_/C VPWR VGND sg13cmos5l_nand3b_1
X_19136_ _19136_/Q _19136_/CLK _19136_/D _19136_/RESET_B VPWR VGND sg13cmos5l_dfrbpq_1
X_16348_ _16348_/Y _19440_/Q _16334_/Y _16347_/Y _19441_/Q _16343_/Y VPWR VGND sg13cmos5l_a221oi_1
X_19067_ _19067_/Q clkload46/A _19067_/D _19067_/RESET_B VPWR VGND sg13cmos5l_dfrbpq_1
X_16279_ _16279_/Y _16265_/A _16265_/B _16276_/A _16276_/B _16278_/Y VPWR VGND sg13cmos5l_a221oi_1
X_19790__1766 _19790_/RESET_B VPWR VGND sg13cmos5l_tiehi
X_18018_ _18018_/Y _18013_/X _18017_/Y _18012_/X VPWR VGND sg13cmos5l_a21oi_1
X_18720__1561 _18720_/RESET_B VPWR VGND sg13cmos5l_tiehi
Xfanout117 _17309_/B _17473_/A VPWR VGND sg13cmos5l_buf_1
Xfanout128 _15394_/B _15562_/A VPWR VGND sg13cmos5l_buf_1
Xfanout106 _16467_/B _16463_/B VPWR VGND sg13cmos5l_buf_1
Xfanout139 _12137_/B _12094_/Y VPWR VGND sg13cmos5l_buf_1
XFILLER_101_426 VPWR VGND sg13cmos5l_fill_1
XFILLER_68_896 VPWR VGND sg13cmos5l_fill_1
X_19090__1164 _19090_/RESET_B VPWR VGND sg13cmos5l_tiehi
X_19775__605 _19775_/RESET_B VPWR VGND sg13cmos5l_tiehi
XFILLER_24_933 VPWR VGND sg13cmos5l_fill_2
XFILLER_23_465 VPWR VGND sg13cmos5l_fill_2
X_18983__1280 _18983_/RESET_B VPWR VGND sg13cmos5l_tiehi
XFILLER_12_55 VPWR VGND sg13cmos5l_fill_1
X_10290_ _12230_/B _10290_/A VPWR VGND sg13cmos5l_inv_1
XFILLER_3_826 VPWR VGND sg13cmos5l_fill_1
X_21227_ _21227_/X _21227_/A VPWR VGND sg13cmos5l_buf_1
XFILLER_2_358 VPWR VGND sg13cmos5l_fill_2
XFILLER_104_286 VPWR VGND sg13cmos5l_fill_1
X_13980_ _13980_/X _13980_/A _13980_/B VPWR VGND sg13cmos5l_xor2_1
X_12931_ _12931_/Y _12931_/A _12931_/B _12931_/C _12931_/D VPWR VGND sg13cmos5l_nand4_1
XFILLER_46_502 VPWR VGND sg13cmos5l_fill_1
X_19232__1013 _19232_/RESET_B VPWR VGND sg13cmos5l_tiehi
X_12862_ _12882_/A _18923_/Q _12875_/B VPWR VGND sg13cmos5l_or2_1
X_15650_ _15650_/Y _15644_/Y _15648_/Y _15649_/Y VPWR VGND sg13cmos5l_a21oi_1
X_11813_ _11833_/B _11820_/C _11820_/D VPWR VGND sg13cmos5l_nand2_1
X_14601_ _14601_/X _14517_/Y _14600_/Y _14598_/Y VPWR VGND sg13cmos5l_a21o_1
X_12793_ _12793_/Y _18901_/Q fanout96/X _12797_/A VPWR VGND sg13cmos5l_o21ai_1
X_15581_ _19328_/D _15747_/A _15688_/A VPWR VGND sg13cmos5l_and2_1
X_11744_ _18741_/D _11891_/A _11744_/B VPWR VGND sg13cmos5l_nor2_1
X_17320_ _17341_/B _17344_/A _17318_/Y _17319_/Y _17315_/Y VPWR VGND sg13cmos5l_a22oi_1
XFILLER_53_40 VPWR VGND sg13cmos5l_fill_1
X_14532_ _14532_/Y _14721_/A _19166_/Q _19167_/Q VPWR VGND sg13cmos5l_o21ai_1
XFILLER_26_292 VPWR VGND sg13cmos5l_fill_1
X_11675_ _11675_/Y _11926_/A _11672_/S _11674_/Y VPWR VGND sg13cmos5l_a21oi_1
X_17251_ _17251_/Y _19574_/Q _19589_/Q VPWR VGND sg13cmos5l_nand2_1
X_14463_ _14463_/Y _14463_/A _14463_/B VPWR VGND sg13cmos5l_nor2_1
X_17182_ _17296_/A _17182_/A _17194_/B _17194_/C VPWR VGND sg13cmos5l_nand3_1
X_13414_ _13415_/A _13414_/A _13419_/B VPWR VGND sg13cmos5l_nor2_1
X_16202_ _16212_/B _19434_/Q _19436_/Q _19435_/Q _16202_/D VPWR VGND sg13cmos5l_nor4_1
X_10626_ _10626_/Y _10448_/Y _10461_/Y _10632_/A _10623_/Y VPWR VGND sg13cmos5l_a22oi_1
X_16133_ _16133_/Y _16134_/B VPWR VGND sg13cmos5l_inv_1
X_14394_ _14395_/A _14408_/C _14393_/Y _14392_/Y VPWR VGND sg13cmos5l_o21ai_1
X_13345_ _13345_/Y _13326_/A _13347_/S _13569_/B1 VPWR VGND sg13cmos5l_o21ai_1
X_10557_ _10557_/Y _10557_/A _10590_/B VPWR VGND sg13cmos5l_nor2_1
X_13276_ _13277_/B _13255_/B _13252_/A _13276_/S VPWR VGND sg13cmos5l_mux2_1
X_10488_ _10489_/B _19744_/Q _10497_/A _19745_/Q VPWR VGND sg13cmos5l_o21ai_1
XFILLER_6_697 VPWR VGND sg13cmos5l_fill_1
X_16064_ _19396_/D _16312_/B _16064_/B VPWR VGND sg13cmos5l_nor2_1
X_12227_ _12229_/B _12492_/A _12227_/B VPWR VGND sg13cmos5l_nor2_1
X_15015_ _15015_/Y _14999_/Y _15003_/Y _14832_/Y VPWR VGND sg13cmos5l_a21oi_1
XFILLER_64_1025 VPWR VGND sg13cmos5l_decap_4
X_12158_ _12158_/Y _12158_/A _12158_/B _12158_/C VPWR VGND sg13cmos5l_nor3_1
XFILLER_68_137 VPWR VGND sg13cmos5l_fill_2
X_12089_ _12095_/B _12461_/A _12090_/B VPWR VGND sg13cmos5l_and2_1
XFILLER_96_468 VPWR VGND sg13cmos5l_fill_1
X_16966_ _16967_/B _16966_/A _16966_/B VPWR VGND sg13cmos5l_xor2_1
X_11109_ _11120_/B _11123_/C _11108_/Y _11107_/Y VPWR VGND sg13cmos5l_o21ai_1
X_19754_ _19754_/Q _19756_/CLK _19754_/D _19754_/RESET_B VPWR VGND sg13cmos5l_dfrbpq_1
X_18705_ _18705_/Q clkload56/A _18705_/D _18705_/RESET_B VPWR VGND sg13cmos5l_dfrbpq_1
X_19685_ _19685_/Q clkload20/A _19685_/D _19685_/RESET_B VPWR VGND sg13cmos5l_dfrbpq_1
X_15917_ _16110_/A _19379_/Q _15918_/B VPWR VGND sg13cmos5l_xnor2_1
X_16897_ _16897_/X _16897_/A _16908_/D _16897_/C VPWR VGND sg13cmos5l_and3_1
XFILLER_76_192 VPWR VGND sg13cmos5l_fill_1
X_18636_ _18636_/Q clkload46/A _18636_/D _18636_/RESET_B VPWR VGND sg13cmos5l_dfrbpq_1
X_15848_ _15944_/B _15851_/B _15841_/B _15847_/Y VPWR VGND sg13cmos5l_o21ai_1
X_18567_ _18567_/Q _19814_/CLK _18567_/D _18567_/RESET_B VPWR VGND sg13cmos5l_dfrbpq_1
X_15779_ _15779_/Y _19318_/Q _15779_/B _15779_/C VPWR VGND sg13cmos5l_nor3_1
X_17518_ _17518_/Y _17637_/B _17637_/C _17637_/A VPWR VGND sg13cmos5l_a21oi_1
X_18498_ _18498_/Y _19724_/Q _18498_/B _18498_/C VPWR VGND sg13cmos5l_nand3_1
X_17449_ _17490_/A _19570_/Q _17461_/D VPWR VGND sg13cmos5l_xor2_1
XFILLER_60_560 VPWR VGND sg13cmos5l_fill_1
X_19733__1185 _19733_/RESET_B VPWR VGND sg13cmos5l_tiehi
XFILLER_106_507 VPWR VGND sg13cmos5l_decap_8
X_19119_ _19119_/Q clkload49/A _19119_/D _19119_/RESET_B VPWR VGND sg13cmos5l_dfrbpq_1
XFILLER_0_818 VPWR VGND sg13cmos5l_decap_8
XFILLER_0_829 VPWR VGND sg13cmos5l_fill_2
XFILLER_87_413 VPWR VGND sg13cmos5l_fill_1
XFILLER_87_457 VPWR VGND sg13cmos5l_fill_1
X_18648__1647 _18648_/RESET_B VPWR VGND sg13cmos5l_tiehi
XFILLER_74_107 VPWR VGND sg13cmos5l_fill_1
XFILLER_28_524 VPWR VGND sg13cmos5l_fill_2
XFILLER_70_302 VPWR VGND sg13cmos5l_fill_1
X_18881__1388 _18881_/RESET_B VPWR VGND sg13cmos5l_tiehi
X_19682__1777 _19682_/RESET_B VPWR VGND sg13cmos5l_tiehi
X_19044__495 _19044_/D VPWR VGND sg13cmos5l_tielo
XFILLER_11_435 VPWR VGND sg13cmos5l_fill_2
XFILLER_23_32 VPWR VGND sg13cmos5l_fill_1
X_11460_ _11462_/B _11473_/B _11459_/X _11458_/Y VPWR VGND sg13cmos5l_a21oi_1
X_19697__1733 _19697_/RESET_B VPWR VGND sg13cmos5l_tiehi
X_11391_ _11392_/C _11655_/A _11391_/B VPWR VGND sg13cmos5l_nor2_1
X_10411_ _19809_/D _10683_/A _10411_/B VPWR VGND sg13cmos5l_nor2_1
X_13130_ _13133_/A _13130_/A _13130_/B VPWR VGND sg13cmos5l_and2_1
X_10342_ _17969_/A _10342_/A VPWR VGND sg13cmos5l_inv_1
X_13061_ _13061_/Y _18959_/Q _13580_/A _12787_/A _12787_/B VPWR VGND sg13cmos5l_a22oi_1
X_12012_ _12012_/Y _11986_/D _11975_/C _12018_/B VPWR VGND sg13cmos5l_a21oi_1
X_10273_ _10273_/Y _12745_/A VPWR VGND sg13cmos5l_inv_1
X_19608__600 _19608_/RESET_B VPWR VGND sg13cmos5l_tiehi
X_16820_ _19501_/D _16820_/A _16823_/B VPWR VGND sg13cmos5l_nor2_1
X_16751_ _16751_/Y _16663_/B _16744_/A _16750_/Y VPWR VGND sg13cmos5l_o21ai_1
XFILLER_93_438 VPWR VGND sg13cmos5l_decap_4
XFILLER_48_62 VPWR VGND sg13cmos5l_decap_4
X_13963_ _13963_/Y _13960_/A _13961_/Y _13962_/Y _19081_/Q VPWR VGND sg13cmos5l_a22oi_1
Xclkbuf_leaf_85_clk clkload17/A clkbuf_4_2_0_clk/X VPWR VGND sg13cmos5l_buf_8
X_15702_ _15703_/A _15597_/Y _15717_/A _15702_/C VPWR VGND sg13cmos5l_nand3b_1
X_19498__719 _19498_/RESET_B VPWR VGND sg13cmos5l_tiehi
X_16682_ _16779_/C _19479_/Q _19030_/Q _19499_/Q VPWR VGND sg13cmos5l_nand3_1
X_19470_ _19470_/Q clkload33/A _19470_/D _19470_/RESET_B VPWR VGND sg13cmos5l_dfrbpq_1
X_12914_ _12914_/Y _12902_/Y _12953_/A _12910_/Y _12960_/A VPWR VGND sg13cmos5l_a22oi_1
XFILLER_62_814 VPWR VGND sg13cmos5l_fill_1
X_13894_ _13897_/B _14072_/A _18990_/Q _13893_/X VPWR VGND sg13cmos5l_a21oi_1
X_12845_ _12846_/B _12838_/B _12824_/Y _12844_/Y VPWR VGND sg13cmos5l_o21ai_1
XFILLER_74_696 VPWR VGND sg13cmos5l_fill_2
X_15633_ _15656_/A _19347_/Q _15633_/B VPWR VGND sg13cmos5l_xnor2_1
X_18421_ _18445_/B _18431_/B _18431_/C VPWR VGND sg13cmos5l_or2_1
X_12776_ _12776_/Y _13284_/B _13284_/A VPWR VGND sg13cmos5l_nand2b_1
X_18352_ _18443_/A _19754_/Q _18450_/B VPWR VGND sg13cmos5l_xnor2_1
X_15564_ _15582_/C _15564_/A _15564_/B VPWR VGND sg13cmos5l_nor2_1
X_11727_ _11727_/X _11727_/A _11727_/B VPWR VGND sg13cmos5l_and2_1
X_17303_ _17303_/Y _17290_/Y _17296_/Y _17301_/Y _17198_/B _17302_/Y VPWR VGND sg13cmos5l_a221oi_1
X_14515_ _14610_/B _14497_/A _14512_/B _14513_/Y VPWR VGND sg13cmos5l_a21oi_1
X_18283_ _19726_/D _18483_/A _18283_/B VPWR VGND sg13cmos5l_nor2_1
X_15495_ _15495_/Y _15495_/A VPWR VGND sg13cmos5l_inv_1
X_11658_ _11658_/Y _11658_/A VPWR VGND sg13cmos5l_inv_1
X_17234_ _17235_/C _17234_/A _17234_/B VPWR VGND sg13cmos5l_or2_1
X_14446_ _14452_/B _19117_/Q _19118_/Q _19115_/Q _19116_/Q VPWR VGND sg13cmos5l_nor4_1
X_17165_ _17204_/A _19529_/Q _17168_/C VPWR VGND sg13cmos5l_xnor2_1
X_11589_ _11590_/B _11589_/A _11589_/B VPWR VGND sg13cmos5l_xnor2_1
X_19769__740 _19769_/RESET_B VPWR VGND sg13cmos5l_tiehi
X_10609_ _10610_/B _10609_/A _10609_/B VPWR VGND sg13cmos5l_xnor2_1
X_14377_ _19142_/D _14377_/A _14377_/B VPWR VGND sg13cmos5l_nor2_1
X_13328_ _13328_/Y _13328_/A _13328_/B VPWR VGND sg13cmos5l_nand2_1
X_16116_ _16125_/C _16116_/A _16136_/B VPWR VGND sg13cmos5l_or2_1
X_17096_ _17096_/Y _19576_/Q _10361_/Y _17093_/Y _17094_/Y _17095_/Y VPWR VGND sg13cmos5l_a221oi_1
XFILLER_97_711 VPWR VGND sg13cmos5l_fill_2
X_13259_ _13259_/Y _13259_/A _13259_/B VPWR VGND sg13cmos5l_nand2_1
Xhold3009 _11263_/A _18678_/Q VPWR VGND sg13cmos5l_dlygate4sd3_1
X_16047_ _16047_/Y _16047_/A _19360_/Q _16052_/C VPWR VGND sg13cmos5l_nor3_1
Xhold2319 _18767_/D _11951_/Y VPWR VGND sg13cmos5l_dlygate4sd3_1
Xhold2308 _10272_/A _18853_/Q VPWR VGND sg13cmos5l_dlygate4sd3_1
X_19806_ _19806_/Q clkload27/A _19806_/D _19806_/RESET_B VPWR VGND sg13cmos5l_dfrbpq_1
X_17998_ _17998_/Y _09972_/Y fanout84/X _17997_/Y VPWR VGND sg13cmos5l_a21oi_1
X_19737_ _19737_/Q clkload23/A _19737_/D _19737_/RESET_B VPWR VGND sg13cmos5l_dfrbpq_1
X_16949_ _17051_/A _19544_/Q _16966_/B VPWR VGND sg13cmos5l_xnor2_1
Xclkbuf_leaf_76_clk _19302_/CLK clkbuf_4_8_0_clk/X VPWR VGND sg13cmos5l_buf_8
X_19668_ _19668_/Q clkload12/A _19668_/D _19668_/RESET_B VPWR VGND sg13cmos5l_dfrbpq_1
XFILLER_52_324 VPWR VGND sg13cmos5l_fill_2
X_18619_ _18619_/Q clkload45/A _18619_/D _18619_/RESET_B VPWR VGND sg13cmos5l_dfrbpq_1
X_19599_ _19599_/Q clkload12/A _19599_/D _19599_/RESET_B VPWR VGND sg13cmos5l_dfrbpq_1
XFILLER_100_37 VPWR VGND sg13cmos5l_fill_2
X_19750__917 _19750_/RESET_B VPWR VGND sg13cmos5l_tiehi
X_18866__1403 _18866_/RESET_B VPWR VGND sg13cmos5l_tiehi
XFILLER_88_755 VPWR VGND sg13cmos5l_fill_2
Xhold2831 _11032_/A _18627_/Q VPWR VGND sg13cmos5l_dlygate4sd3_1
Xhold2820 _14052_/B _14051_/Y VPWR VGND sg13cmos5l_dlygate4sd3_1
Xhold2842 _17058_/A _19545_/Q VPWR VGND sg13cmos5l_dlygate4sd3_1
Xhold2853 _11500_/A _18710_/Q VPWR VGND sg13cmos5l_dlygate4sd3_1
Xhold2875 hold2875/X _19617_/Q VPWR VGND sg13cmos5l_dlygate4sd3_1
Xhold2864 _14211_/A _19136_/Q VPWR VGND sg13cmos5l_dlygate4sd3_1
Xhold2886 _18194_/C _18193_/Y VPWR VGND sg13cmos5l_dlygate4sd3_1
Xclkbuf_leaf_67_clk clkload50/A clkbuf_4_10_0_clk/X VPWR VGND sg13cmos5l_buf_8
Xhold2897 _15409_/A _19299_/Q VPWR VGND sg13cmos5l_dlygate4sd3_1
XFILLER_56_663 VPWR VGND sg13cmos5l_fill_1
XFILLER_55_140 VPWR VGND sg13cmos5l_fill_1
X_10960_ _10960_/X _10960_/A _10960_/B VPWR VGND sg13cmos5l_xor2_1
XFILLER_56_696 VPWR VGND sg13cmos5l_fill_2
X_10891_ _10891_/X _10886_/A _10886_/B _10567_/B VPWR VGND sg13cmos5l_a21o_1
X_12630_ _12630_/Y _12630_/A _12663_/A VPWR VGND sg13cmos5l_nor2_1
XFILLER_54_1013 VPWR VGND sg13cmos5l_decap_8
XFILLER_52_880 VPWR VGND sg13cmos5l_fill_2
X_12561_ _12561_/Y _12561_/A _12575_/B VPWR VGND sg13cmos5l_nor2_1
XFILLER_15_1019 VPWR VGND sg13cmos5l_decap_8
X_19717__1457 _19717_/RESET_B VPWR VGND sg13cmos5l_tiehi
X_12492_ _12492_/Y _12492_/A _18814_/Q _12498_/C VPWR VGND sg13cmos5l_nor3_1
X_11512_ _11513_/B _11512_/A _11512_/B VPWR VGND sg13cmos5l_xor2_1
X_15280_ _15303_/B _19247_/Q _15280_/B VPWR VGND sg13cmos5l_xor2_1
X_14300_ _14375_/B _14307_/S _14297_/X _14299_/Y VPWR VGND sg13cmos5l_a21o_1
X_11443_ _11449_/B _18658_/Q _11444_/B VPWR VGND sg13cmos5l_nor2b_1
X_14231_ _14232_/B _14231_/A _14231_/B VPWR VGND sg13cmos5l_xor2_1
XFILLER_50_63 VPWR VGND sg13cmos5l_fill_2
X_14162_ _14162_/Y _14162_/A _14163_/B VPWR VGND sg13cmos5l_nor2b_1
X_11374_ _11374_/Y _18642_/Q _11374_/B VPWR VGND sg13cmos5l_nand2_1
X_13113_ _13130_/B _13103_/Y _13107_/Y _13111_/Y VPWR VGND sg13cmos5l_a21o_1
XFILLER_4_921 VPWR VGND sg13cmos5l_fill_2
X_18970_ _18970_/Q _18975_/CLK _18970_/D _18970_/RESET_B VPWR VGND sg13cmos5l_dfrbpq_1
X_10325_ _18508_/A _10325_/A VPWR VGND sg13cmos5l_inv_1
X_14093_ _14103_/B _14084_/Y _14091_/Y _14092_/Y VPWR VGND sg13cmos5l_o21ai_1
XFILLER_106_882 VPWR VGND sg13cmos5l_fill_1
X_13044_ _13044_/Y _13044_/A VPWR VGND sg13cmos5l_inv_1
X_17921_ _19659_/D _17937_/B _17921_/B VPWR VGND sg13cmos5l_nor2_1
X_10256_ _13321_/A _13829_/A VPWR VGND sg13cmos5l_inv_1
XFILLER_61_1028 VPWR VGND sg13cmos5l_fill_1
XFILLER_61_1006 VPWR VGND sg13cmos5l_decap_4
XFILLER_59_83 VPWR VGND sg13cmos5l_decap_4
X_17852_ _17852_/Y _17938_/B VPWR VGND sg13cmos5l_inv_1
X_16803_ _16804_/B _16776_/X _16809_/S _16825_/A VPWR VGND sg13cmos5l_a21oi_1
X_10187_ _18471_/A _18138_/A VPWR VGND sg13cmos5l_inv_1
X_17783_ _17879_/A _17613_/A _17766_/A _17758_/X _17762_/Y VPWR VGND sg13cmos5l_a22oi_1
Xclkbuf_leaf_58_clk clkload46/A clkbuf_4_9_0_clk/X VPWR VGND sg13cmos5l_buf_8
X_14995_ _14995_/Y _14995_/A _14995_/B _14995_/C VPWR VGND sg13cmos5l_nand3_1
X_16734_ _16736_/B _19491_/Q _16746_/A VPWR VGND sg13cmos5l_nor2_1
X_19522_ _19522_/Q clkload28/A _19522_/D _19522_/RESET_B VPWR VGND sg13cmos5l_dfrbpq_1
XFILLER_75_983 VPWR VGND sg13cmos5l_decap_8
X_13946_ _13946_/Y _13946_/A VPWR VGND sg13cmos5l_inv_1
Xclkbuf_4_11_0_clk clkload2/A clkbuf_0_clk/X VPWR VGND sg13cmos5l_buf_8
X_16665_ _16666_/B _13713_/Y _16650_/X _16659_/S _16664_/Y VPWR VGND sg13cmos5l_a22oi_1
X_19453_ _19453_/Q clkload6/A _19453_/D _19453_/RESET_B VPWR VGND sg13cmos5l_dfrbpq_1
XFILLER_90_986 VPWR VGND sg13cmos5l_fill_2
XFILLER_90_964 VPWR VGND sg13cmos5l_fill_1
XFILLER_62_677 VPWR VGND sg13cmos5l_fill_1
X_13877_ _19070_/D _14436_/A _13877_/B VPWR VGND sg13cmos5l_and2_1
X_15616_ _15676_/A _16016_/A _15616_/B VPWR VGND sg13cmos5l_xnor2_1
X_18404_ _18406_/A _18414_/B _18414_/C _10564_/B VPWR VGND sg13cmos5l_a21o_1
X_12828_ _12931_/A _12828_/A _12849_/B _12833_/C VPWR VGND sg13cmos5l_nand3_1
X_16596_ _16596_/Y _16596_/A VPWR VGND sg13cmos5l_inv_1
X_19384_ _19384_/Q clkload19/A _19384_/D _19384_/RESET_B VPWR VGND sg13cmos5l_dfrbpq_1
XFILLER_91_70 VPWR VGND sg13cmos5l_fill_2
X_12759_ _12765_/A _12764_/A _12764_/B _12753_/A _13041_/A _12758_/Y VPWR VGND sg13cmos5l_a221oi_1
X_15547_ _15547_/Y _15544_/A _15578_/A _15582_/A _15553_/A VPWR VGND sg13cmos5l_a22oi_1
XFILLER_15_582 VPWR VGND sg13cmos5l_fill_1
XFILLER_30_541 VPWR VGND sg13cmos5l_fill_2
X_18335_ _18335_/Y _18316_/X _18318_/Y _18150_/Y VPWR VGND sg13cmos5l_a21oi_1
X_18266_ _18266_/Y _18266_/A VPWR VGND sg13cmos5l_inv_1
X_15478_ _15479_/B _16016_/A _19276_/Q VPWR VGND sg13cmos5l_nand2_1
X_17217_ _17339_/A _17217_/A _17234_/B VPWR VGND sg13cmos5l_xnor2_1
X_14429_ _19149_/D _14412_/Y hold2298/X _14639_/B VPWR VGND sg13cmos5l_a21oi_1
X_18197_ _18197_/Y _18204_/A _18204_/B VPWR VGND sg13cmos5l_nand2_1
X_17148_ _17148_/Y hold2038/X fanout70/X _17152_/A VPWR VGND sg13cmos5l_o21ai_1
X_17079_ _19540_/D _17079_/A _17079_/B VPWR VGND sg13cmos5l_and2_1
X_18854__1418 _18854_/RESET_B VPWR VGND sg13cmos5l_tiehi
X_09970_ _09970_/Y _09970_/A VPWR VGND sg13cmos5l_inv_1
XFILLER_41_0 VPWR VGND sg13cmos5l_decap_4
Xhold2127 _12350_/A _18828_/Q VPWR VGND sg13cmos5l_dlygate4sd3_1
Xhold2116 _11896_/A _18705_/Q VPWR VGND sg13cmos5l_dlygate4sd3_1
Xhold2105 _13329_/A _19000_/Q VPWR VGND sg13cmos5l_dlygate4sd3_1
XFILLER_97_596 VPWR VGND sg13cmos5l_fill_1
XFILLER_85_714 VPWR VGND sg13cmos5l_fill_1
XFILLER_58_939 VPWR VGND sg13cmos5l_fill_1
Xhold2138 _18979_/D _13346_/Y VPWR VGND sg13cmos5l_dlygate4sd3_1
Xhold2149 _19188_/D _14695_/Y VPWR VGND sg13cmos5l_dlygate4sd3_1
Xclkbuf_leaf_49_clk clkload64/A clkbuf_4_14_0_clk/X VPWR VGND sg13cmos5l_buf_8
XFILLER_72_408 VPWR VGND sg13cmos5l_fill_2
XFILLER_81_975 VPWR VGND sg13cmos5l_fill_1
X_18800__1475 _18800_/RESET_B VPWR VGND sg13cmos5l_tiehi
XFILLER_81_986 VPWR VGND sg13cmos5l_fill_2
X_19557__657 _19557_/RESET_B VPWR VGND sg13cmos5l_tiehi
XFILLER_53_688 VPWR VGND sg13cmos5l_decap_8
XFILLER_33_390 VPWR VGND sg13cmos5l_fill_2
X_19170__1078 _19170_/RESET_B VPWR VGND sg13cmos5l_tiehi
X_19488__729 _19488_/RESET_B VPWR VGND sg13cmos5l_tiehi
XFILLER_20_66 VPWR VGND sg13cmos5l_fill_2
XFILLER_106_178 VPWR VGND sg13cmos5l_decap_8
X_11090_ _18637_/D _11090_/A _11090_/B VPWR VGND sg13cmos5l_and2_1
X_10110_ _15459_/A _10110_/A VPWR VGND sg13cmos5l_inv_1
X_10041_ _12461_/A _10041_/A VPWR VGND sg13cmos5l_inv_1
XFILLER_49_906 VPWR VGND sg13cmos5l_fill_1
XFILLER_29_20 VPWR VGND sg13cmos5l_fill_1
Xhold2650 _10031_/A _18745_/Q VPWR VGND sg13cmos5l_dlygate4sd3_1
Xhold2683 hold2683/X _18571_/Q VPWR VGND sg13cmos5l_dlygate4sd3_1
Xhold2672 hold2672/X _19812_/Q VPWR VGND sg13cmos5l_dlygate4sd3_1
Xhold2661 _15055_/B _15054_/Y VPWR VGND sg13cmos5l_dlygate4sd3_1
X_11992_ _11992_/Y _11992_/A _11992_/B VPWR VGND sg13cmos5l_nor2_1
X_13800_ _13801_/C _13800_/A _13791_/Y VPWR VGND sg13cmos5l_nor2b_1
XFILLER_91_728 VPWR VGND sg13cmos5l_fill_2
Xhold1960 hold1960/X _19026_/Q VPWR VGND sg13cmos5l_dlygate4sd3_1
Xhold2694 _10394_/B _19808_/Q VPWR VGND sg13cmos5l_dlygate4sd3_1
XFILLER_57_972 VPWR VGND sg13cmos5l_decap_4
Xhold1971 _09998_/A _19067_/Q VPWR VGND sg13cmos5l_dlygate4sd3_1
X_14780_ _14780_/Y _19220_/Q _14781_/B _14779_/Y VPWR VGND sg13cmos5l_a21oi_1
XFILLER_90_238 VPWR VGND sg13cmos5l_fill_1
Xhold1982 _13647_/A _18583_/Q VPWR VGND sg13cmos5l_dlygate4sd3_1
X_13731_ _13731_/Y _19027_/Q _18582_/Q VPWR VGND sg13cmos5l_nand2_1
Xhold1993 _09969_/A _19729_/Q VPWR VGND sg13cmos5l_dlygate4sd3_1
X_10943_ _10950_/B _18633_/Q _18634_/Q _18635_/Q _18636_/Q VPWR VGND sg13cmos5l_nor4_1
XFILLER_28_173 VPWR VGND sg13cmos5l_fill_2
X_13662_ _13662_/Y _19054_/Q _19053_/Q _19038_/Q VPWR VGND sg13cmos5l_nand3b_1
X_10874_ _18605_/D _10016_/Y fanout76/X _10873_/Y VPWR VGND sg13cmos5l_a21oi_1
X_16450_ _16452_/D _16457_/C _16457_/D _16222_/B VPWR VGND sg13cmos5l_a21o_1
X_12613_ _12613_/Y _18870_/Q _18885_/Q VPWR VGND sg13cmos5l_nand2_1
X_13593_ _13593_/Y _13590_/Y _13591_/Y _13592_/Y VPWR VGND sg13cmos5l_o21ai_1
X_15401_ _15401_/Y _15403_/A _15466_/B _15398_/Y VPWR VGND sg13cmos5l_a21oi_1
X_16381_ _16383_/B _19466_/Q _19468_/Q _19467_/Q _16396_/A VPWR VGND sg13cmos5l_nor4_1
X_12544_ _12561_/A _18821_/Q _18822_/Q VPWR VGND sg13cmos5l_xor2_1
X_15332_ _15332_/Y _15418_/B _15427_/B _15332_/C VPWR VGND sg13cmos5l_nand3_1
X_18120_ _18152_/A _19718_/Q _18120_/B VPWR VGND sg13cmos5l_xor2_1
XFILLER_61_84 VPWR VGND sg13cmos5l_fill_2
X_18051_ _18051_/Y _18026_/D _18012_/C _18057_/B VPWR VGND sg13cmos5l_a21oi_1
X_17002_ _17011_/D _19553_/Q _17002_/B VPWR VGND sg13cmos5l_xnor2_1
X_12475_ _12475_/Y _18873_/Q _12492_/A _12498_/B _18874_/Q VPWR VGND sg13cmos5l_a22oi_1
X_15263_ _15263_/Y _15263_/A _15303_/A VPWR VGND sg13cmos5l_nand2_1
X_11426_ _11429_/B _18655_/Q _18656_/Q _18653_/Q _18654_/Q VPWR VGND sg13cmos5l_nor4_1
X_15194_ _19268_/D _15194_/A _15194_/B VPWR VGND sg13cmos5l_and2_1
X_14214_ _14334_/B _14214_/A _14229_/B VPWR VGND sg13cmos5l_nand2_1
X_11357_ _18674_/D _11357_/A _11358_/A VPWR VGND sg13cmos5l_nor2_1
XFILLER_6_79 VPWR VGND sg13cmos5l_decap_4
X_14145_ _19114_/D _14636_/A _14218_/B VPWR VGND sg13cmos5l_and2_1
X_10308_ _11393_/B _10308_/A VPWR VGND sg13cmos5l_inv_1
X_18953_ _18953_/Q clkload65/A _18953_/D _18953_/RESET_B VPWR VGND sg13cmos5l_dfrbpq_1
X_14076_ _19093_/D _14076_/A _14076_/B VPWR VGND sg13cmos5l_nor2_1
XFILLER_4_795 VPWR VGND sg13cmos5l_decap_8
XFILLER_3_250 VPWR VGND sg13cmos5l_fill_1
X_13027_ _18931_/D _13027_/A _13027_/B VPWR VGND sg13cmos5l_nor2_1
X_11288_ _11288_/Y _11280_/A _11280_/B _11359_/B VPWR VGND sg13cmos5l_a21oi_1
X_17904_ _17904_/Y _17904_/A _17904_/B VPWR VGND sg13cmos5l_nand2_1
X_18884_ _18884_/Q clkload70/A _18884_/D _18884_/RESET_B VPWR VGND sg13cmos5l_dfrbpq_1
XFILLER_6_1028 VPWR VGND sg13cmos5l_fill_1
X_10239_ _10239_/Y _14679_/B VPWR VGND sg13cmos5l_inv_1
XFILLER_55_909 VPWR VGND sg13cmos5l_fill_1
X_17835_ _17865_/A _19676_/Q _17837_/A VPWR VGND sg13cmos5l_xnor2_1
X_17766_ _17766_/X _17766_/A _17780_/B VPWR VGND sg13cmos5l_or2_1
X_16717_ _16742_/B _19505_/Q _19506_/Q hold3049/X VPWR VGND sg13cmos5l_o21ai_1
X_19505_ _19505_/Q _19546_/CLK _19505_/D _19505_/RESET_B VPWR VGND sg13cmos5l_dfrbpq_1
XFILLER_48_994 VPWR VGND sg13cmos5l_fill_1
XFILLER_48_983 VPWR VGND sg13cmos5l_fill_1
XFILLER_47_471 VPWR VGND sg13cmos5l_fill_2
X_14978_ _19240_/D _14978_/A _15030_/B VPWR VGND sg13cmos5l_and2_1
X_17697_ _17697_/Y _18222_/A _19664_/Q _17709_/C VPWR VGND sg13cmos5l_nor3_1
X_13929_ _13929_/Y _13938_/A _13929_/B VPWR VGND sg13cmos5l_nand2_1
X_16648_ _16648_/Y _16648_/A _16664_/A VPWR VGND sg13cmos5l_nand2_1
XFILLER_62_463 VPWR VGND sg13cmos5l_fill_2
XFILLER_50_603 VPWR VGND sg13cmos5l_fill_2
X_19436_ _19436_/Q clkload9/A _19436_/D _19436_/RESET_B VPWR VGND sg13cmos5l_dfrbpq_1
X_16579_ _16579_/Y _16722_/A _17085_/A _16593_/C VPWR VGND sg13cmos5l_nand3_1
X_19367_ _19367_/Q clkload8/A _19367_/D _19367_/RESET_B VPWR VGND sg13cmos5l_dfrbpq_1
XFILLER_22_349 VPWR VGND sg13cmos5l_fill_2
XFILLER_89_0 VPWR VGND sg13cmos5l_fill_1
X_18318_ _18318_/Y _18315_/A _18315_/B _18341_/B _18319_/A VPWR VGND sg13cmos5l_a22oi_1
X_19298_ _19298_/Q clkload44/A _19298_/D _19298_/RESET_B VPWR VGND sg13cmos5l_dfrbpq_1
X_18249_ _18249_/Y _19748_/Q _18236_/A VPWR VGND sg13cmos5l_nor2b_1
XFILLER_103_126 VPWR VGND sg13cmos5l_fill_2
XFILLER_97_371 VPWR VGND sg13cmos5l_fill_2
XFILLER_44_1023 VPWR VGND sg13cmos5l_decap_4
XFILLER_57_268 VPWR VGND sg13cmos5l_fill_1
XFILLER_54_920 VPWR VGND sg13cmos5l_fill_2
XFILLER_39_994 VPWR VGND sg13cmos5l_fill_1
XFILLER_38_482 VPWR VGND sg13cmos5l_fill_1
XFILLER_54_964 VPWR VGND sg13cmos5l_fill_1
XFILLER_25_121 VPWR VGND sg13cmos5l_fill_1
XFILLER_26_633 VPWR VGND sg13cmos5l_fill_2
XFILLER_41_636 VPWR VGND sg13cmos5l_fill_2
X_10590_ _10592_/B _10590_/A _10590_/B VPWR VGND sg13cmos5l_nor2_1
X_12260_ _18819_/D _12528_/A _12260_/B VPWR VGND sg13cmos5l_and2_1
X_12191_ _18796_/D _12191_/A _12201_/A VPWR VGND sg13cmos5l_nor2_1
X_11211_ _18658_/D _11363_/A _11329_/A VPWR VGND sg13cmos5l_nor2_1
X_11142_ _11142_/Y _11393_/B _11130_/Y _11141_/Y VPWR VGND sg13cmos5l_a21oi_1
Xoutput10 uio_out[0] _21225_/X VPWR VGND sg13cmos5l_buf_1
XFILLER_103_671 VPWR VGND sg13cmos5l_fill_1
X_11073_ _11073_/Y _11059_/B _11063_/Y _11090_/A VPWR VGND sg13cmos5l_o21ai_1
XFILLER_1_776 VPWR VGND sg13cmos5l_fill_2
X_15950_ _15950_/Y _15961_/A _16020_/B VPWR VGND sg13cmos5l_nor2_1
XFILLER_103_682 VPWR VGND sg13cmos5l_fill_1
X_10024_ _11894_/A _11533_/B VPWR VGND sg13cmos5l_inv_1
X_14901_ _14902_/B _14889_/A _14886_/Y _14901_/S VPWR VGND sg13cmos5l_mux2_1
X_15881_ _15990_/A _19386_/Q _15884_/B _15880_/Y VPWR VGND sg13cmos5l_a21oi_1
X_17620_ _17620_/Y _17620_/A _17658_/A VPWR VGND sg13cmos5l_nor2_1
X_14832_ _14832_/Y _14995_/A _15004_/A VPWR VGND sg13cmos5l_nand2_1
Xhold2480 _10096_/A _19168_/Q VPWR VGND sg13cmos5l_dlygate4sd3_1
Xhold2491 _10231_/A _19186_/Q VPWR VGND sg13cmos5l_dlygate4sd3_1
XFILLER_36_408 VPWR VGND sg13cmos5l_fill_2
X_11975_ _11975_/Y _11975_/A _11986_/D _11975_/C VPWR VGND sg13cmos5l_nand3_1
X_17551_ _17551_/X _17601_/B _17552_/B _17543_/Y VPWR VGND sg13cmos5l_a21o_1
XFILLER_16_132 VPWR VGND sg13cmos5l_fill_1
X_19403__830 _19403_/RESET_B VPWR VGND sg13cmos5l_tiehi
X_14763_ _14763_/Y _14761_/Y _14762_/Y _14760_/Y VPWR VGND sg13cmos5l_a21oi_1
X_13714_ _13714_/Y _13714_/A _13714_/B _13714_/C VPWR VGND sg13cmos5l_nor3_1
X_17482_ _17585_/B _17470_/Y _17472_/Y _17480_/X VPWR VGND sg13cmos5l_o21ai_1
X_10926_ _11028_/A _10926_/A _10926_/B VPWR VGND sg13cmos5l_nand2_1
X_14694_ _14694_/Y _14663_/Y _14690_/S _14909_/B VPWR VGND sg13cmos5l_o21ai_1
X_16502_ _16532_/A hold2756/X _16500_/B _16501_/Y VPWR VGND sg13cmos5l_a21oi_1
X_13645_ _19029_/D _16624_/A _13645_/B VPWR VGND sg13cmos5l_and2_1
X_10857_ _10858_/B _18603_/Q _10855_/Y _11107_/B VPWR VGND sg13cmos5l_o21ai_1
X_16433_ _16434_/C _16433_/A _16433_/B VPWR VGND sg13cmos5l_nor2_1
X_19221_ _19221_/Q clkload51/A _19221_/D _19221_/RESET_B VPWR VGND sg13cmos5l_dfrbpq_1
XFILLER_60_978 VPWR VGND sg13cmos5l_decap_4
XFILLER_31_157 VPWR VGND sg13cmos5l_decap_4
X_19152_ _19152_/Q clkload52/A _19152_/D _19152_/RESET_B VPWR VGND sg13cmos5l_dfrbpq_1
X_10788_ _18591_/D _18558_/A _10788_/B VPWR VGND sg13cmos5l_nor2_1
X_13576_ _19006_/D _13576_/A _13578_/B VPWR VGND sg13cmos5l_nor2_1
X_18103_ _18129_/B _19705_/Q _18104_/B VPWR VGND sg13cmos5l_xnor2_1
X_16364_ _16364_/X _16334_/Y _09984_/Y _16370_/B VPWR VGND sg13cmos5l_mux2_1
X_12527_ _18860_/D _12527_/A _12527_/B VPWR VGND sg13cmos5l_and2_1
X_19083_ _19083_/Q _19092_/CLK _19083_/D _19083_/RESET_B VPWR VGND sg13cmos5l_dfrbpq_1
X_19334__902 _19334_/RESET_B VPWR VGND sg13cmos5l_tiehi
X_16295_ _16295_/Y _16271_/X fanout34/X _16308_/B VPWR VGND sg13cmos5l_o21ai_1
X_15315_ _15333_/A _19301_/Q _15433_/B VPWR VGND sg13cmos5l_or2_1
X_12458_ _18838_/D _12458_/A _12460_/B VPWR VGND sg13cmos5l_nor2_1
X_18894__1375 _18894_/RESET_B VPWR VGND sg13cmos5l_tiehi
X_19067__1190 _19067_/RESET_B VPWR VGND sg13cmos5l_tiehi
X_18034_ _18034_/Y _18057_/B VPWR VGND sg13cmos5l_inv_1
X_15246_ _15246_/Y _15497_/B _15238_/B _15245_/Y VPWR VGND sg13cmos5l_a21oi_1
X_11409_ _11409_/Y _11387_/A _11412_/S _11408_/Y VPWR VGND sg13cmos5l_a21oi_1
X_12389_ _12417_/C _18817_/Q _18778_/Q _18837_/Q VPWR VGND sg13cmos5l_nand3_1
X_15177_ _15177_/Y _15164_/B _15173_/S _15194_/A VPWR VGND sg13cmos5l_o21ai_1
X_14128_ _14128_/Y _14396_/A _14131_/S _14127_/Y VPWR VGND sg13cmos5l_a21oi_1
X_19547__667 _19547_/RESET_B VPWR VGND sg13cmos5l_tiehi
X_18936_ _18936_/Q clkload46/A _18936_/D _18936_/RESET_B VPWR VGND sg13cmos5l_dfrbpq_1
X_14059_ _19080_/D hold2584/X _14062_/S _14058_/Y VPWR VGND sg13cmos5l_a21oi_1
X_18867_ _18867_/Q _18931_/CLK _18867_/D _18867_/RESET_B VPWR VGND sg13cmos5l_dfrbpq_1
X_17818_ _17821_/B _19661_/Q _19662_/Q _19659_/Q _19660_/Q VPWR VGND sg13cmos5l_nor4_1
X_19143__1108 _19143_/RESET_B VPWR VGND sg13cmos5l_tiehi
X_18798_ _18798_/Q clkload60/A _18798_/D _18798_/RESET_B VPWR VGND sg13cmos5l_dfrbpq_1
XFILLER_67_588 VPWR VGND sg13cmos5l_fill_2
XFILLER_82_547 VPWR VGND sg13cmos5l_fill_2
X_17749_ _17749_/Y _19616_/Q _19609_/Q _17771_/A VPWR VGND sg13cmos5l_o21ai_1
XFILLER_51_923 VPWR VGND sg13cmos5l_fill_1
X_19419_ _19419_/Q clkload8/A _19419_/D _19419_/RESET_B VPWR VGND sg13cmos5l_dfrbpq_1
X_19437__458 _19437_/D VPWR VGND sg13cmos5l_tielo
XFILLER_11_1022 VPWR VGND sg13cmos5l_decap_8
Xheichips26_digital_project_1800 uio_oe[3] VPWR VGND sg13cmos5l_tiehi
XFILLER_104_479 VPWR VGND sg13cmos5l_fill_2
Xheichips26_digital_project_1811 uio_oe[14] VPWR VGND sg13cmos5l_tiehi
XFILLER_58_511 VPWR VGND sg13cmos5l_fill_1
X_18946__1317 _18946_/RESET_B VPWR VGND sg13cmos5l_tiehi
X_19119__1132 _19119_/RESET_B VPWR VGND sg13cmos5l_tiehi
X_11760_ _11773_/A _11760_/A _11760_/B VPWR VGND sg13cmos5l_nor2_1
XFILLER_26_441 VPWR VGND sg13cmos5l_fill_1
X_10711_ _10711_/Y _18572_/Q _10711_/B VPWR VGND sg13cmos5l_nand2b_1
XFILLER_41_422 VPWR VGND sg13cmos5l_fill_1
X_11691_ _18735_/D _11691_/A _11691_/B VPWR VGND sg13cmos5l_and2_1
X_13430_ _13430_/Y _13428_/Y _13429_/Y _13427_/Y VPWR VGND sg13cmos5l_a21oi_1
X_10642_ _19798_/D _18246_/B _10642_/B VPWR VGND sg13cmos5l_nor2_1
X_13361_ _13376_/B _18949_/Q _18950_/Q _18947_/Q _18948_/Q VPWR VGND sg13cmos5l_nor4_1
X_10573_ _10573_/Y _10573_/A _10590_/B VPWR VGND sg13cmos5l_nor2_1
X_12312_ _18826_/D _12452_/A _12374_/A VPWR VGND sg13cmos5l_nor2_1
X_13292_ _18969_/D _13292_/A _13292_/B VPWR VGND sg13cmos5l_nor2_1
X_18624__535 _18624_/D VPWR VGND sg13cmos5l_tielo
X_15100_ _15102_/B _15108_/A _15108_/B _15099_/Y VPWR VGND sg13cmos5l_o21ai_1
X_16080_ _19405_/D _09979_/Y fanout66/X _16079_/Y VPWR VGND sg13cmos5l_a21oi_1
X_12243_ _12243_/Y _12218_/A _12241_/S _12468_/A VPWR VGND sg13cmos5l_o21ai_1
XFILLER_6_868 VPWR VGND sg13cmos5l_fill_2
X_15031_ _15031_/Y _19235_/Q _19196_/Q VPWR VGND sg13cmos5l_xnor2_1
X_12174_ _12174_/Y _12174_/A _12174_/B VPWR VGND sg13cmos5l_nor2_1
X_16982_ _16989_/C _19534_/Q _16982_/B VPWR VGND sg13cmos5l_xnor2_1
X_11125_ _11125_/Y _11125_/A VPWR VGND sg13cmos5l_inv_1
X_19770_ _19770_/Q clkload21/A _19770_/D _19770_/RESET_B VPWR VGND sg13cmos5l_dfrbpq_1
XFILLER_1_551 VPWR VGND sg13cmos5l_fill_2
X_19236__1008 _19236_/RESET_B VPWR VGND sg13cmos5l_tiehi
X_18721_ _18721_/Q _18902_/CLK _18721_/D _18721_/RESET_B VPWR VGND sg13cmos5l_dfrbpq_1
XFILLER_49_522 VPWR VGND sg13cmos5l_fill_1
X_11056_ _11057_/B _11056_/A _11056_/B VPWR VGND sg13cmos5l_or2_1
X_15933_ _15933_/Y _15933_/A _16019_/B VPWR VGND sg13cmos5l_nor2_1
X_19698__1724 _19698_/RESET_B VPWR VGND sg13cmos5l_tiehi
X_10007_ _10007_/Y _10007_/A VPWR VGND sg13cmos5l_inv_1
XFILLER_64_514 VPWR VGND sg13cmos5l_fill_1
X_18652_ _18652_/Q clkload55/A _18652_/D _18652_/RESET_B VPWR VGND sg13cmos5l_dfrbpq_1
XFILLER_37_728 VPWR VGND sg13cmos5l_fill_2
X_15864_ _19372_/D _15864_/A _15959_/A VPWR VGND sg13cmos5l_and2_1
X_18583_ _18583_/Q _18594_/CLK _18583_/D _18583_/RESET_B VPWR VGND sg13cmos5l_dfrbpq_1
X_17603_ _17677_/B _17610_/S _17600_/X _17602_/Y VPWR VGND sg13cmos5l_a21o_1
X_14815_ _15000_/A _19211_/Q _14815_/B VPWR VGND sg13cmos5l_xnor2_1
X_15795_ _19356_/D _16022_/A _15795_/B VPWR VGND sg13cmos5l_nor2_1
X_17534_ _17534_/X _19634_/Q _17562_/D VPWR VGND sg13cmos5l_xor2_1
X_14746_ _14746_/X _14743_/A _14744_/Y _14755_/S VPWR VGND sg13cmos5l_mux2_1
X_11958_ _11958_/Y _12210_/B _11958_/B VPWR VGND sg13cmos5l_nand2_1
X_11889_ _18748_/D hold2812/X _11890_/S _11888_/Y VPWR VGND sg13cmos5l_a21oi_1
X_17465_ _17465_/Y _17467_/A _17467_/B _17464_/Y VPWR VGND sg13cmos5l_a21oi_1
X_10909_ _10909_/Y _10929_/S _10908_/Y VPWR VGND sg13cmos5l_nor2b_1
X_19204_ _19204_/Q _19304_/CLK _19204_/D _19204_/RESET_B VPWR VGND sg13cmos5l_dfrbpq_1
X_14677_ _14677_/Y _19189_/Q _14676_/Y _14672_/Y VPWR VGND sg13cmos5l_a21oi_1
X_18817__1456 _18817_/RESET_B VPWR VGND sg13cmos5l_tiehi
X_13628_ _13628_/Y _13606_/A _13632_/S _13801_/A VPWR VGND sg13cmos5l_a21oi_1
X_17396_ _17396_/X _17696_/A _17396_/B VPWR VGND sg13cmos5l_and2_1
X_16416_ _16416_/Y _16452_/A _16452_/B VPWR VGND sg13cmos5l_nand2_1
XFILLER_34_1022 VPWR VGND sg13cmos5l_decap_8
X_13559_ _13559_/Y _13559_/A _13559_/B VPWR VGND sg13cmos5l_nor2_1
X_19135_ _19135_/Q clkload52/A _19135_/D _19135_/RESET_B VPWR VGND sg13cmos5l_dfrbpq_1
X_16347_ _16347_/Y _16347_/A VPWR VGND sg13cmos5l_inv_1
X_19066_ _19066_/Q _19136_/CLK _19066_/D _19066_/RESET_B VPWR VGND sg13cmos5l_dfrbpq_1
X_18017_ _18017_/Y _17831_/A _18014_/Y _18015_/Y _18016_/Y VPWR VGND sg13cmos5l_a22oi_1
X_16278_ _16278_/Y _16278_/A _16278_/B _16278_/C VPWR VGND sg13cmos5l_nor3_1
X_15229_ _15229_/Y _15492_/A _15223_/A _15228_/A _15497_/B _15224_/Y VPWR VGND sg13cmos5l_a221oi_1
X_18684__1609 _18684_/RESET_B VPWR VGND sg13cmos5l_tiehi
Xfanout107 _12299_/B _12306_/B VPWR VGND sg13cmos5l_buf_1
Xfanout118 _17473_/A _17283_/B VPWR VGND sg13cmos5l_buf_1
Xfanout129 _15282_/A _15119_/B VPWR VGND sg13cmos5l_buf_1
XFILLER_101_416 VPWR VGND sg13cmos5l_decap_4
X_18919_ _18919_/Q _19003_/CLK _18919_/D _18919_/RESET_B VPWR VGND sg13cmos5l_dfrbpq_1
X_19269__973 _19269_/RESET_B VPWR VGND sg13cmos5l_tiehi
XFILLER_55_503 VPWR VGND sg13cmos5l_decap_4
XFILLER_83_889 VPWR VGND sg13cmos5l_fill_1
XFILLER_55_569 VPWR VGND sg13cmos5l_fill_2
X_19107__1147 _19107_/RESET_B VPWR VGND sg13cmos5l_tiehi
X_18942__1323 _18942_/RESET_B VPWR VGND sg13cmos5l_tiehi
XFILLER_70_539 VPWR VGND sg13cmos5l_fill_1
XFILLER_24_923 VPWR VGND sg13cmos5l_fill_1
X_18630__1666 _18630_/RESET_B VPWR VGND sg13cmos5l_tiehi
XFILLER_24_989 VPWR VGND sg13cmos5l_decap_8
X_19276__966 _19276_/RESET_B VPWR VGND sg13cmos5l_tiehi
XFILLER_2_326 VPWR VGND sg13cmos5l_decap_4
X_21226_ _21226_/X _21226_/A VPWR VGND sg13cmos5l_buf_1
XFILLER_105_777 VPWR VGND sg13cmos5l_decap_4
XFILLER_58_330 VPWR VGND sg13cmos5l_fill_1
X_12930_ _13023_/B _12931_/C _12931_/D VPWR VGND sg13cmos5l_and2_1
XFILLER_73_300 VPWR VGND sg13cmos5l_fill_2
XFILLER_59_897 VPWR VGND sg13cmos5l_fill_2
XFILLER_58_363 VPWR VGND sg13cmos5l_fill_1
X_12861_ _12984_/A _18924_/Q _12875_/B VPWR VGND sg13cmos5l_xnor2_1
XFILLER_46_558 VPWR VGND sg13cmos5l_fill_1
X_19324__912 _19324_/RESET_B VPWR VGND sg13cmos5l_tiehi
X_11812_ _11827_/C _18765_/Q _11812_/B VPWR VGND sg13cmos5l_xor2_1
X_14600_ _14600_/Y _14644_/B _14611_/B _14599_/Y VPWR VGND sg13cmos5l_o21ai_1
X_12792_ _12792_/Y _10006_/Y fanout95/X _12791_/Y VPWR VGND sg13cmos5l_a21oi_1
X_15580_ _15688_/A _15388_/Y _15564_/A _15579_/Y VPWR VGND sg13cmos5l_o21ai_1
X_11743_ _11744_/B _11565_/A _11742_/C _11742_/Y VPWR VGND sg13cmos5l_a21oi_1
X_14531_ _14545_/A _19182_/Q _14537_/A VPWR VGND sg13cmos5l_xnor2_1
XFILLER_15_989 VPWR VGND sg13cmos5l_fill_1
X_19400__833 _19400_/RESET_B VPWR VGND sg13cmos5l_tiehi
XFILLER_105_1009 VPWR VGND sg13cmos5l_decap_8
X_11674_ _11674_/Y _11649_/A _11672_/S _11680_/B1 VPWR VGND sg13cmos5l_o21ai_1
X_17250_ _17250_/Y _17267_/D _17249_/B _17442_/A VPWR VGND sg13cmos5l_a21oi_1
XFILLER_53_96 VPWR VGND sg13cmos5l_fill_1
X_14462_ _14462_/Y _14266_/A _14489_/A _14460_/Y VPWR VGND sg13cmos5l_o21ai_1
X_19537__677 _19537_/RESET_B VPWR VGND sg13cmos5l_tiehi
X_17181_ _17181_/Y hold2961/X _17199_/B VPWR VGND sg13cmos5l_nand2b_1
X_13413_ _13413_/Y _13413_/A _13420_/B VPWR VGND sg13cmos5l_nand2_1
X_16201_ _16201_/Y _16432_/A _16249_/A VPWR VGND sg13cmos5l_nor2_1
X_10625_ _10625_/Y _10632_/A _10623_/Y _10624_/Y VPWR VGND sg13cmos5l_o21ai_1
XFILLER_6_610 VPWR VGND sg13cmos5l_fill_1
X_16132_ _16134_/B _15931_/Y _16117_/Y _16131_/Y VPWR VGND sg13cmos5l_a21o_1
X_14393_ _14393_/Y _19166_/Q _14910_/A VPWR VGND sg13cmos5l_nand2_1
X_18813__1462 _18813_/RESET_B VPWR VGND sg13cmos5l_tiehi
X_13344_ _18978_/D _13578_/B _13344_/B VPWR VGND sg13cmos5l_nor2_1
XFILLER_6_643 VPWR VGND sg13cmos5l_fill_1
XFILLER_6_632 VPWR VGND sg13cmos5l_fill_1
XFILLER_5_131 VPWR VGND sg13cmos5l_fill_1
X_10556_ _10556_/Y _10506_/A _10506_/B _10555_/Y VPWR VGND sg13cmos5l_a21oi_1
X_13275_ _18955_/D hold2571/X _13276_/S _13274_/Y VPWR VGND sg13cmos5l_a21oi_1
XFILLER_5_142 VPWR VGND sg13cmos5l_decap_8
X_19331__905 _19331_/RESET_B VPWR VGND sg13cmos5l_tiehi
X_16063_ _16063_/X _16044_/Y _10201_/Y _16063_/S VPWR VGND sg13cmos5l_mux2_1
X_10487_ _10487_/Y _10573_/A VPWR VGND sg13cmos5l_inv_1
X_12226_ _12227_/B _12231_/C _12224_/Y _12225_/Y VPWR VGND sg13cmos5l_a21o_1
X_15014_ _19242_/D _15192_/A _15014_/B VPWR VGND sg13cmos5l_nor2_1
X_12157_ _12158_/C _12157_/A _12157_/B VPWR VGND sg13cmos5l_nor2_1
XFILLER_97_948 VPWR VGND sg13cmos5l_fill_1
X_11108_ _11108_/Y _11108_/A _11625_/A VPWR VGND sg13cmos5l_nand2_1
XFILLER_2_882 VPWR VGND sg13cmos5l_fill_1
X_19183__1065 _19183_/RESET_B VPWR VGND sg13cmos5l_tiehi
XFILLER_38_6 VPWR VGND sg13cmos5l_fill_1
X_12088_ _12097_/A _18806_/Q _12088_/B VPWR VGND sg13cmos5l_xor2_1
X_16965_ _16965_/Y _17043_/B _17060_/A _16965_/C VPWR VGND sg13cmos5l_nand3_1
X_19753_ _19753_/Q _19756_/CLK _19753_/D _19753_/RESET_B VPWR VGND sg13cmos5l_dfrbpq_1
X_16896_ _16897_/C _19483_/Q _19484_/Q _19485_/Q VPWR VGND sg13cmos5l_o21ai_1
X_18704_ _18704_/Q clkload56/A _18704_/D _18704_/RESET_B VPWR VGND sg13cmos5l_dfrbpq_1
X_11039_ _11040_/A _11013_/A _11013_/B _11058_/A VPWR VGND sg13cmos5l_o21ai_1
X_19684_ _19684_/Q clkload20/A _19684_/D _19684_/RESET_B VPWR VGND sg13cmos5l_dfrbpq_1
XFILLER_37_525 VPWR VGND sg13cmos5l_fill_2
X_15916_ _15923_/B _16313_/A _15918_/B VPWR VGND sg13cmos5l_nand2_1
X_18635_ _18635_/Q clkload47/A _18635_/D _18635_/RESET_B VPWR VGND sg13cmos5l_dfrbpq_1
X_15847_ _15847_/Y _15847_/A _15856_/B VPWR VGND sg13cmos5l_nor2_1
X_18566_ _18566_/Q _19814_/CLK _18566_/D _18566_/RESET_B VPWR VGND sg13cmos5l_dfrbpq_1
X_15778_ _15778_/Y _19356_/Q _15763_/Y _15777_/Y _19357_/Q _15773_/Y VPWR VGND sg13cmos5l_a221oi_1
X_17517_ _17637_/C _17516_/A _17629_/A _17529_/A VPWR VGND sg13cmos5l_o21ai_1
X_18497_ _18497_/Y _18498_/B _18493_/X _18496_/Y VPWR VGND sg13cmos5l_a21oi_1
X_14729_ _14733_/B _19162_/Q _14730_/B VPWR VGND sg13cmos5l_nor2b_1
X_17448_ _17457_/B _19569_/Q _19570_/Q _19567_/Q _19568_/Q VPWR VGND sg13cmos5l_nor4_1
X_17379_ _17379_/Y _19618_/Q _17379_/B VPWR VGND sg13cmos5l_nand2_1
X_19118_ _19118_/Q clkload49/A _19118_/D _19118_/RESET_B VPWR VGND sg13cmos5l_dfrbpq_1
X_19049_ _19049_/Q clkload30/A _19049_/D _19049_/RESET_B VPWR VGND sg13cmos5l_dfrbpq_1
XFILLER_0_808 VPWR VGND sg13cmos5l_decap_4
XFILLER_102_736 VPWR VGND sg13cmos5l_fill_1
XFILLER_87_447 VPWR VGND sg13cmos5l_fill_2
XFILLER_68_650 VPWR VGND sg13cmos5l_fill_1
X_18986__1274 _18986_/RESET_B VPWR VGND sg13cmos5l_tiehi
XFILLER_96_981 VPWR VGND sg13cmos5l_fill_2
XFILLER_68_661 VPWR VGND sg13cmos5l_fill_2
XFILLER_24_720 VPWR VGND sg13cmos5l_fill_2
XFILLER_8_908 VPWR VGND sg13cmos5l_fill_1
XFILLER_11_447 VPWR VGND sg13cmos5l_fill_1
X_10410_ _10411_/B _10400_/A _10405_/Y _10652_/B VPWR VGND sg13cmos5l_a21oi_1
X_11390_ _11391_/B _11388_/Y _11390_/B VPWR VGND sg13cmos5l_nand2b_1
X_10341_ _18263_/B _10341_/A VPWR VGND sg13cmos5l_inv_1
X_10272_ _12760_/A _10272_/A VPWR VGND sg13cmos5l_inv_1
X_13060_ _13060_/Y _13323_/A _13053_/B _13059_/A _10265_/Y _13055_/Y VPWR VGND sg13cmos5l_a221oi_1
X_12011_ _12014_/A _11821_/Y _12023_/B VPWR VGND sg13cmos5l_nand2b_1
X_16750_ _16750_/Y _16666_/B _16827_/B VPWR VGND sg13cmos5l_nand2b_1
X_13962_ _13962_/Y _19096_/Q _19095_/Q _19080_/Q VPWR VGND sg13cmos5l_nand3b_1
X_12913_ _12960_/A _13108_/A VPWR VGND sg13cmos5l_inv_1
XFILLER_46_322 VPWR VGND sg13cmos5l_fill_2
X_15701_ _15702_/C _15701_/A _15701_/B _15701_/C VPWR VGND sg13cmos5l_nand3_1
X_16681_ _16779_/B _19498_/Q _16693_/B VPWR VGND sg13cmos5l_nand2_1
XFILLER_73_130 VPWR VGND sg13cmos5l_fill_2
X_13893_ _13893_/X _18996_/Q _18989_/Q VPWR VGND sg13cmos5l_or2_1
XFILLER_47_889 VPWR VGND sg13cmos5l_fill_1
X_18420_ _18431_/C _18449_/A _18483_/B VPWR VGND sg13cmos5l_nor2_1
X_12844_ _12844_/Y _12844_/A _12850_/B VPWR VGND sg13cmos5l_nor2_1
XFILLER_64_40 VPWR VGND sg13cmos5l_fill_1
X_15632_ _15821_/A _19333_/Q _19334_/Q VPWR VGND sg13cmos5l_xnor2_1
X_12775_ _13028_/A _13337_/A _13284_/B VPWR VGND sg13cmos5l_nor2_1
X_15563_ _15570_/C _15564_/B VPWR VGND sg13cmos5l_inv_1
X_18351_ _18351_/Y _18351_/A _18450_/B VPWR VGND sg13cmos5l_nand2_1
X_11726_ _18737_/D _11891_/A _11726_/B VPWR VGND sg13cmos5l_nor2_1
X_17302_ _17302_/Y _17290_/A _17290_/B _17290_/C _17290_/D VPWR VGND sg13cmos5l_a22oi_1
X_18282_ _18283_/B _18266_/Y _18513_/B _18282_/S VPWR VGND sg13cmos5l_mux2_1
X_14514_ _14618_/A _14497_/A _14512_/B _14513_/Y VPWR VGND sg13cmos5l_a21o_1
X_17233_ _17347_/A _17325_/A _17325_/B VPWR VGND sg13cmos5l_nor2_1
X_15494_ _15495_/A _15498_/C _15492_/Y _15493_/Y VPWR VGND sg13cmos5l_a21o_1
X_11657_ _11658_/A _11655_/Y _11657_/B VPWR VGND sg13cmos5l_nand2b_1
X_19259__983 _19259_/RESET_B VPWR VGND sg13cmos5l_tiehi
X_14445_ _14445_/Y _14638_/A _14442_/X _14443_/X _14474_/A VPWR VGND sg13cmos5l_a22oi_1
X_17164_ _17164_/Y _17015_/B _17163_/X _17161_/X VPWR VGND sg13cmos5l_o21ai_1
X_11588_ _11589_/B _11588_/A _11588_/B VPWR VGND sg13cmos5l_xor2_1
X_10608_ _10609_/B _19795_/Q _10608_/B VPWR VGND sg13cmos5l_xor2_1
X_14376_ _19141_/D _14376_/A _14376_/B VPWR VGND sg13cmos5l_nor2_1
X_17095_ _17095_/Y _17670_/A _19515_/Q VPWR VGND sg13cmos5l_nor2_1
X_13327_ _13327_/Y _18978_/Q _13312_/Y _13326_/Y _18979_/Q _13322_/Y VPWR VGND sg13cmos5l_a221oi_1
X_16115_ _16117_/B _16116_/A _16136_/B VPWR VGND sg13cmos5l_nor2_1
X_10539_ _10539_/Y _10567_/B _10528_/X _10536_/Y _10537_/X VPWR VGND sg13cmos5l_a22oi_1
XFILLER_7_996 VPWR VGND sg13cmos5l_fill_1
XFILLER_6_484 VPWR VGND sg13cmos5l_decap_8
X_16046_ _16046_/Y _16329_/A _16037_/A _16041_/A _16335_/A _16045_/Y VPWR VGND sg13cmos5l_a221oi_1
X_13258_ _13267_/A _13258_/A _13265_/A _13258_/C VPWR VGND sg13cmos5l_or3_1
X_12209_ _12219_/B _12205_/Y _12207_/Y _12208_/Y VPWR VGND sg13cmos5l_o21ai_1
Xhold2309 _18853_/D _12516_/Y VPWR VGND sg13cmos5l_dlygate4sd3_1
X_13189_ _13189_/Y _13199_/S _13157_/Y VPWR VGND sg13cmos5l_nor2b_1
X_17997_ _17997_/Y _19687_/Q fanout84/X _18005_/A VPWR VGND sg13cmos5l_o21ai_1
X_19805_ _19805_/Q _19805_/CLK _19805_/D _19805_/RESET_B VPWR VGND sg13cmos5l_dfrbpq_1
X_16948_ _16948_/Y _19546_/Q _16966_/B VPWR VGND sg13cmos5l_nor2_1
XFILLER_78_981 VPWR VGND sg13cmos5l_decap_8
X_19736_ _19736_/Q clkload23/A _19736_/D _19736_/RESET_B VPWR VGND sg13cmos5l_dfrbpq_1
XFILLER_65_631 VPWR VGND sg13cmos5l_fill_1
XFILLER_37_311 VPWR VGND sg13cmos5l_fill_1
X_19266__976 _19266_/RESET_B VPWR VGND sg13cmos5l_tiehi
X_18974__1289 _18974_/RESET_B VPWR VGND sg13cmos5l_tiehi
XFILLER_64_141 VPWR VGND sg13cmos5l_fill_1
X_16879_ _16879_/Y _16865_/B fanout29/X _17079_/B VPWR VGND sg13cmos5l_o21ai_1
X_19667_ _19667_/Q clkload11/A _19667_/D _19667_/RESET_B VPWR VGND sg13cmos5l_dfrbpq_1
XFILLER_38_889 VPWR VGND sg13cmos5l_fill_1
XFILLER_52_314 VPWR VGND sg13cmos5l_fill_1
X_18618_ _18618_/Q clkload45/A _18618_/D _18618_/RESET_B VPWR VGND sg13cmos5l_dfrbpq_1
X_19598_ _19598_/Q clkload12/A _19598_/D _19598_/RESET_B VPWR VGND sg13cmos5l_dfrbpq_1
X_18549_ _18549_/Y _10600_/X _10633_/A _10642_/B VPWR VGND sg13cmos5l_a21oi_1
XFILLER_21_723 VPWR VGND sg13cmos5l_fill_2
X_19273__969 _19273_/RESET_B VPWR VGND sg13cmos5l_tiehi
Xclkload70 clkload70/Y clkload70/A VPWR VGND sg13cmos5l_inv_2
Xhold2810 _11754_/A _18755_/Q VPWR VGND sg13cmos5l_dlygate4sd3_1
Xhold2832 _11033_/B _11032_/X VPWR VGND sg13cmos5l_dlygate4sd3_1
Xhold2821 hold2821/X _14056_/B VPWR VGND sg13cmos5l_dlygate4sd3_1
Xhold2843 _17060_/B _17059_/Y VPWR VGND sg13cmos5l_dlygate4sd3_1
Xhold2854 _12041_/A _18796_/Q VPWR VGND sg13cmos5l_dlygate4sd3_1
XFILLER_88_789 VPWR VGND sg13cmos5l_fill_2
Xhold2865 hold2865/X _18619_/Q VPWR VGND sg13cmos5l_dlygate4sd3_1
X_19527__687 _19527_/RESET_B VPWR VGND sg13cmos5l_tiehi
Xhold2876 _11503_/A _18715_/Q VPWR VGND sg13cmos5l_dlygate4sd3_1
Xhold2887 hold2887/X _18204_/A VPWR VGND sg13cmos5l_dlygate4sd3_1
Xhold2898 hold2898/X _19349_/Q VPWR VGND sg13cmos5l_dlygate4sd3_1
XFILLER_84_973 VPWR VGND sg13cmos5l_decap_8
XFILLER_71_601 VPWR VGND sg13cmos5l_fill_1
X_19497__720 _19497_/RESET_B VPWR VGND sg13cmos5l_tiehi
X_10890_ _10890_/Y _10526_/B _10887_/Y _10888_/Y _10889_/Y VPWR VGND sg13cmos5l_a22oi_1
X_19755__829 _19755_/RESET_B VPWR VGND sg13cmos5l_tiehi
XFILLER_70_144 VPWR VGND sg13cmos5l_decap_8
XFILLER_70_155 VPWR VGND sg13cmos5l_fill_1
X_12560_ _12560_/Y _12551_/X _12553_/Y _12353_/Y VPWR VGND sg13cmos5l_a21oi_1
XFILLER_12_745 VPWR VGND sg13cmos5l_fill_2
X_11511_ _11511_/X _18722_/Q _11511_/B VPWR VGND sg13cmos5l_xor2_1
X_12491_ _12491_/Y _10273_/Y _12482_/Y _12486_/A _10274_/Y _12490_/Y VPWR VGND sg13cmos5l_a221oi_1
X_11442_ _11442_/Y _11439_/Y _11440_/Y _11441_/Y VPWR VGND sg13cmos5l_o21ai_1
X_19802__1754 _19802_/RESET_B VPWR VGND sg13cmos5l_tiehi
X_14230_ _14231_/B _14230_/A _14334_/B VPWR VGND sg13cmos5l_nand2_1
X_11373_ _11374_/B _11364_/Y _11371_/Y _11372_/Y VPWR VGND sg13cmos5l_o21ai_1
X_14161_ _14163_/B _13970_/Y _14195_/A _14199_/A _14164_/A VPWR VGND sg13cmos5l_a22oi_1
X_13112_ _13115_/A _13103_/Y _13107_/Y _13111_/Y VPWR VGND sg13cmos5l_a21oi_1
X_10324_ _10849_/B _10324_/A VPWR VGND sg13cmos5l_inv_1
XFILLER_4_966 VPWR VGND sg13cmos5l_fill_2
X_14092_ _14092_/Y _19128_/Q _14098_/B _19065_/Q _14642_/A VPWR VGND sg13cmos5l_a22oi_1
XFILLER_79_712 VPWR VGND sg13cmos5l_fill_1
X_13043_ _13044_/A _13056_/C _13042_/Y _13041_/Y VPWR VGND sg13cmos5l_a21o_1
X_17920_ _17921_/B _17891_/X _17889_/Y _17928_/S VPWR VGND sg13cmos5l_mux2_1
X_10255_ _13836_/A _10255_/A VPWR VGND sg13cmos5l_inv_1
X_10186_ _18477_/A _10186_/A VPWR VGND sg13cmos5l_inv_1
X_17851_ _17938_/B _17847_/Y _17850_/Y _17871_/S VPWR VGND sg13cmos5l_mux2_1
X_16802_ _16802_/X _16692_/Y _16693_/X _16809_/S VPWR VGND sg13cmos5l_a21o_1
X_19102__1152 _19102_/RESET_B VPWR VGND sg13cmos5l_tiehi
Xfanout290 _13025_/A _13020_/B VPWR VGND sg13cmos5l_buf_1
XFILLER_47_620 VPWR VGND sg13cmos5l_decap_4
X_17782_ _19655_/D _17943_/A _17904_/A VPWR VGND sg13cmos5l_and2_1
X_14994_ _14994_/Y _15183_/A _14991_/X _15011_/A _14993_/X VPWR VGND sg13cmos5l_a22oi_1
X_16733_ _16824_/B _16732_/Y hold2688/X _16753_/A VPWR VGND sg13cmos5l_mux2_1
X_19521_ _19521_/Q clkload33/A _19521_/D _19521_/RESET_B VPWR VGND sg13cmos5l_dfrbpq_1
X_13945_ _13946_/A _14051_/A _13945_/B VPWR VGND sg13cmos5l_or2_1
X_16664_ _16664_/Y _16664_/A _16633_/Y VPWR VGND sg13cmos5l_nor2b_1
X_13876_ _19069_/D _09996_/Y fanout74/X _13875_/Y VPWR VGND sg13cmos5l_a21oi_1
X_19452_ _19452_/Q clkload6/A _19452_/D _19452_/RESET_B VPWR VGND sg13cmos5l_dfrbpq_1
X_12827_ _12827_/Y hold2958/X _12827_/B VPWR VGND sg13cmos5l_nand2b_1
X_15615_ _15615_/Y _19338_/Q _15616_/B VPWR VGND sg13cmos5l_xnor2_1
X_19383_ _19383_/Q _19738_/CLK _19383_/D _19383_/RESET_B VPWR VGND sg13cmos5l_dfrbpq_1
X_18403_ _18403_/Y _18428_/A _18479_/B _18478_/B _18431_/A VPWR VGND sg13cmos5l_a22oi_1
X_16595_ _16596_/A _16593_/C _16594_/Y _16593_/Y VPWR VGND sg13cmos5l_a21o_1
X_18334_ _19737_/D _18480_/A _18334_/B VPWR VGND sg13cmos5l_nor2_1
X_12758_ _12758_/Y _18893_/Q _12753_/Y _12757_/Y VPWR VGND sg13cmos5l_a21oi_1
X_18959__1304 _18959_/RESET_B VPWR VGND sg13cmos5l_tiehi
X_15546_ _15582_/A _19287_/Q _15546_/B VPWR VGND sg13cmos5l_xnor2_1
X_12689_ _12690_/A _12593_/B _12704_/A _12689_/C VPWR VGND sg13cmos5l_nand3b_1
X_11709_ _11713_/C _10036_/Y _11705_/B _10035_/Y VPWR VGND sg13cmos5l_a21oi_1
X_19771__697 _19771_/RESET_B VPWR VGND sg13cmos5l_tiehi
X_18265_ _18266_/A _18264_/C _18263_/Y _18264_/Y VPWR VGND sg13cmos5l_a21o_1
X_15477_ _15477_/X _15477_/A _15482_/C VPWR VGND sg13cmos5l_and2_1
X_17216_ _17325_/A _17216_/A _17234_/B VPWR VGND sg13cmos5l_and2_1
X_14428_ _14428_/Y _14679_/A _14428_/B VPWR VGND sg13cmos5l_nand2_1
X_18196_ _18204_/B _18232_/B _18195_/B _18195_/Y VPWR VGND sg13cmos5l_o21ai_1
X_17147_ _19562_/D _09974_/Y fanout70/X _17146_/Y VPWR VGND sg13cmos5l_a21oi_1
XFILLER_6_270 VPWR VGND sg13cmos5l_fill_2
X_14359_ _19125_/D _14319_/A _14349_/X _14358_/Y VPWR VGND sg13cmos5l_a21oi_1
X_17078_ _19539_/D _18540_/A _17078_/B VPWR VGND sg13cmos5l_and2_1
XFILLER_69_200 VPWR VGND sg13cmos5l_fill_2
X_16029_ _16029_/Y _19419_/Q _16047_/A _16052_/B _19420_/Q VPWR VGND sg13cmos5l_a22oi_1
Xhold2106 _16817_/A _19038_/Q VPWR VGND sg13cmos5l_dlygate4sd3_1
Xhold2117 _12483_/A _18809_/Q VPWR VGND sg13cmos5l_dlygate4sd3_1
XFILLER_69_244 VPWR VGND sg13cmos5l_fill_2
XFILLER_69_222 VPWR VGND sg13cmos5l_fill_2
Xhold2128 _10033_/A _18749_/Q VPWR VGND sg13cmos5l_dlygate4sd3_1
XFILLER_58_929 VPWR VGND sg13cmos5l_fill_1
Xhold2139 _16553_/A _19419_/Q VPWR VGND sg13cmos5l_dlygate4sd3_1
X_18905__1361 _18905_/RESET_B VPWR VGND sg13cmos5l_tiehi
X_18565__1742 _18565_/RESET_B VPWR VGND sg13cmos5l_tiehi
XFILLER_66_951 VPWR VGND sg13cmos5l_decap_8
XFILLER_37_130 VPWR VGND sg13cmos5l_fill_1
X_19719_ _19719_/Q clkload10/A _19719_/D _19719_/RESET_B VPWR VGND sg13cmos5l_dfrbpq_1
XFILLER_38_686 VPWR VGND sg13cmos5l_fill_1
XFILLER_20_12 VPWR VGND sg13cmos5l_fill_2
XFILLER_106_135 VPWR VGND sg13cmos5l_decap_4
XFILLER_105_6 VPWR VGND sg13cmos5l_fill_1
X_10040_ _12458_/A _10040_/A VPWR VGND sg13cmos5l_inv_1
XFILLER_88_531 VPWR VGND sg13cmos5l_fill_2
XFILLER_102_363 VPWR VGND sg13cmos5l_fill_2
Xhold2640 _10368_/A _19472_/Q VPWR VGND sg13cmos5l_dlygate4sd3_1
X_19605__604 _19605_/RESET_B VPWR VGND sg13cmos5l_tiehi
XFILLER_102_374 VPWR VGND sg13cmos5l_fill_1
Xhold2673 _10432_/B _10739_/A VPWR VGND sg13cmos5l_dlygate4sd3_1
Xhold2651 _17234_/A _19582_/Q VPWR VGND sg13cmos5l_dlygate4sd3_1
XFILLER_48_439 VPWR VGND sg13cmos5l_fill_2
Xhold2662 _10240_/A _19105_/Q VPWR VGND sg13cmos5l_dlygate4sd3_1
XFILLER_29_65 VPWR VGND sg13cmos5l_fill_2
X_11991_ _11991_/X _11992_/A _11992_/B _11989_/Y VPWR VGND sg13cmos5l_a21o_1
XFILLER_91_718 VPWR VGND sg13cmos5l_fill_1
Xhold2695 hold2695/X _19547_/Q VPWR VGND sg13cmos5l_dlygate4sd3_1
Xhold1950 _10691_/B _10690_/Y VPWR VGND sg13cmos5l_dlygate4sd3_1
Xhold1972 _10015_/A _18606_/Q VPWR VGND sg13cmos5l_dlygate4sd3_1
Xhold1961 hold1961/X _19688_/Q VPWR VGND sg13cmos5l_dlygate4sd3_1
X_19249__993 _19249_/RESET_B VPWR VGND sg13cmos5l_tiehi
Xhold2684 _14857_/A _19215_/Q VPWR VGND sg13cmos5l_dlygate4sd3_1
X_13730_ _13730_/X _13814_/B _13648_/A _13780_/B VPWR VGND sg13cmos5l_mux2_1
Xhold1983 hold1983/X _18817_/Q VPWR VGND sg13cmos5l_dlygate4sd3_1
Xhold1994 _09971_/A _19646_/Q VPWR VGND sg13cmos5l_dlygate4sd3_1
X_10942_ _10942_/X _11159_/A _10977_/A _10977_/B VPWR VGND sg13cmos5l_and3_1
XFILLER_17_815 VPWR VGND sg13cmos5l_fill_2
XFILLER_72_954 VPWR VGND sg13cmos5l_fill_2
XFILLER_71_420 VPWR VGND sg13cmos5l_fill_1
XFILLER_45_42 VPWR VGND sg13cmos5l_decap_8
XFILLER_16_358 VPWR VGND sg13cmos5l_fill_2
X_13661_ _13661_/Y _19038_/Q _19053_/Q VPWR VGND sg13cmos5l_nand2_1
X_10873_ _10873_/Y hold1979/X fanout75/X _15735_/A VPWR VGND sg13cmos5l_o21ai_1
X_15400_ _15400_/Y _15466_/B VPWR VGND sg13cmos5l_inv_1
X_12612_ _12647_/A _18885_/Q _12612_/B VPWR VGND sg13cmos5l_xnor2_1
X_13592_ _13592_/Y _16819_/A _18572_/Q _18571_/Q _16818_/A VPWR VGND sg13cmos5l_a22oi_1
X_16380_ _16407_/B _19467_/Q _16398_/B VPWR VGND sg13cmos5l_nor2b_1
X_12543_ _12543_/X _18829_/Q _12543_/B VPWR VGND sg13cmos5l_or2_1
XFILLER_61_52 VPWR VGND sg13cmos5l_fill_2
X_15331_ _15332_/C _15331_/A _15331_/B VPWR VGND sg13cmos5l_or2_1
X_18050_ _18054_/A _18050_/A _18056_/B VPWR VGND sg13cmos5l_nand2_1
X_15262_ _15262_/X _19245_/Q _15262_/B VPWR VGND sg13cmos5l_xor2_1
X_12474_ _12474_/Y _12470_/Y _12473_/Y _12472_/Y VPWR VGND sg13cmos5l_o21ai_1
X_17001_ _17011_/C _16998_/Y _17000_/Y _16980_/Y VPWR VGND sg13cmos5l_o21ai_1
X_14213_ _14230_/A _14214_/A _14229_/B VPWR VGND sg13cmos5l_or2_1
X_18643__1653 _18643_/RESET_B VPWR VGND sg13cmos5l_tiehi
X_11425_ _11434_/B _18655_/Q _18653_/Q _18654_/Q VPWR VGND sg13cmos5l_or3_1
X_15193_ _19267_/D _15194_/A _15193_/B VPWR VGND sg13cmos5l_and2_1
X_19256__986 _19256_/RESET_B VPWR VGND sg13cmos5l_tiehi
X_11356_ _18673_/D _11356_/A _11358_/A VPWR VGND sg13cmos5l_nor2_1
XFILLER_4_752 VPWR VGND sg13cmos5l_fill_2
XFILLER_4_741 VPWR VGND sg13cmos5l_decap_8
X_14144_ _19113_/D _14436_/A _14144_/B VPWR VGND sg13cmos5l_and2_1
X_10307_ _11378_/B _18646_/Q VPWR VGND sg13cmos5l_inv_1
X_18952_ _18952_/Q _18975_/CLK _18952_/D _18952_/RESET_B VPWR VGND sg13cmos5l_dfrbpq_1
X_14075_ _19092_/D _14075_/A _14076_/B VPWR VGND sg13cmos5l_nor2_1
X_13026_ _18930_/D _13028_/A _13026_/B VPWR VGND sg13cmos5l_and2_1
X_11287_ _11360_/B _11295_/B _11285_/Y _11286_/Y VPWR VGND sg13cmos5l_a21oi_1
X_17903_ _17914_/A _17799_/Y _17912_/A _17903_/C VPWR VGND sg13cmos5l_nand3b_1
X_18883_ _18883_/Q clkload70/A _18883_/D _18883_/RESET_B VPWR VGND sg13cmos5l_dfrbpq_1
XFILLER_79_553 VPWR VGND sg13cmos5l_fill_2
X_10238_ _14679_/A _19150_/Q VPWR VGND sg13cmos5l_inv_1
X_10169_ _17936_/A _10169_/A VPWR VGND sg13cmos5l_inv_1
X_17834_ _18022_/A _18224_/A _17834_/B VPWR VGND sg13cmos5l_xnor2_1
XFILLER_39_439 VPWR VGND sg13cmos5l_fill_1
X_17765_ _17765_/X _17765_/A _17765_/B VPWR VGND sg13cmos5l_or2_1
X_14977_ _19239_/D _15528_/A _14977_/B VPWR VGND sg13cmos5l_and2_1
X_19504_ _19504_/Q clkload32/A _19504_/D _19504_/RESET_B VPWR VGND sg13cmos5l_dfrbpq_1
X_16716_ _16906_/A _17082_/A _16716_/B VPWR VGND sg13cmos5l_xnor2_1
XFILLER_63_932 VPWR VGND sg13cmos5l_fill_2
X_13928_ _19078_/D _14080_/A _13928_/B VPWR VGND sg13cmos5l_nor2_1
XFILLER_35_612 VPWR VGND sg13cmos5l_fill_1
XFILLER_74_291 VPWR VGND sg13cmos5l_decap_8
XFILLER_62_420 VPWR VGND sg13cmos5l_fill_2
X_17696_ _17696_/Y _17696_/A _19602_/Q VPWR VGND sg13cmos5l_nor2_1
X_19263__979 _19263_/RESET_B VPWR VGND sg13cmos5l_tiehi
X_16647_ _16651_/B _16664_/A VPWR VGND sg13cmos5l_inv_1
XFILLER_63_976 VPWR VGND sg13cmos5l_decap_8
X_19435_ _19435_/Q clkload9/A _19435_/D _19435_/RESET_B VPWR VGND sg13cmos5l_dfrbpq_1
X_13859_ _13859_/X _13832_/Y _10250_/Y _13859_/S VPWR VGND sg13cmos5l_mux2_1
XFILLER_34_166 VPWR VGND sg13cmos5l_fill_1
X_16578_ _16578_/Y _19019_/Q _16578_/B VPWR VGND sg13cmos5l_nand2_1
XFILLER_37_1020 VPWR VGND sg13cmos5l_decap_8
X_19366_ _19366_/Q clkload19/A _19366_/D _19366_/RESET_B VPWR VGND sg13cmos5l_dfrbpq_1
XFILLER_34_188 VPWR VGND sg13cmos5l_decap_4
X_18760__1518 _18760_/RESET_B VPWR VGND sg13cmos5l_tiehi
X_15529_ _15550_/D _19285_/Q _19283_/Q _19284_/Q VPWR VGND sg13cmos5l_or3_1
X_18317_ _18341_/B _19699_/Q _18317_/B VPWR VGND sg13cmos5l_xor2_1
X_19297_ _19297_/Q _19805_/CLK _19297_/D _19297_/RESET_B VPWR VGND sg13cmos5l_dfrbpq_1
X_18248_ _18248_/Y _18248_/A _19686_/Q VPWR VGND sg13cmos5l_nor2_1
X_18179_ _18181_/A _18168_/X _18170_/A _18229_/B VPWR VGND sg13cmos5l_a21oi_1
X_19487__730 _19487_/RESET_B VPWR VGND sg13cmos5l_tiehi
XFILLER_89_306 VPWR VGND sg13cmos5l_fill_1
XFILLER_103_116 VPWR VGND sg13cmos5l_fill_2
XFILLER_89_339 VPWR VGND sg13cmos5l_fill_2
XFILLER_54_954 VPWR VGND sg13cmos5l_fill_1
XFILLER_54_943 VPWR VGND sg13cmos5l_fill_1
XFILLER_14_807 VPWR VGND sg13cmos5l_fill_2
X_19494__723 _19494_/RESET_B VPWR VGND sg13cmos5l_tiehi
XFILLER_90_1022 VPWR VGND sg13cmos5l_fill_1
XFILLER_80_272 VPWR VGND sg13cmos5l_fill_2
XFILLER_53_486 VPWR VGND sg13cmos5l_fill_1
XFILLER_13_328 VPWR VGND sg13cmos5l_fill_1
XFILLER_40_147 VPWR VGND sg13cmos5l_fill_1
X_18736__1542 _18736_/RESET_B VPWR VGND sg13cmos5l_tiehi
XFILLER_5_527 VPWR VGND sg13cmos5l_fill_1
Xclkbuf_4_10_0_clk clkbuf_4_10_0_clk/X clkbuf_0_clk/X VPWR VGND sg13cmos5l_buf_8
X_12190_ _18795_/D _12190_/A _12201_/A VPWR VGND sg13cmos5l_nor2_1
X_11210_ _11302_/A _11329_/A VPWR VGND sg13cmos5l_inv_1
XFILLER_5_549 VPWR VGND sg13cmos5l_fill_1
X_11141_ _11141_/Y _11125_/A _11133_/S _11351_/B VPWR VGND sg13cmos5l_o21ai_1
Xoutput11 uio_out[1] _21226_/X VPWR VGND sg13cmos5l_buf_1
XFILLER_103_661 VPWR VGND sg13cmos5l_fill_1
X_11072_ _18621_/D _11030_/A _11063_/Y _11071_/Y VPWR VGND sg13cmos5l_a21oi_1
X_10023_ _11895_/A _10023_/A VPWR VGND sg13cmos5l_inv_1
X_14900_ _19210_/D _14887_/A _14901_/S _14899_/Y VPWR VGND sg13cmos5l_a21oi_1
X_15880_ _15880_/Y _15982_/B _15982_/C _15982_/A VPWR VGND sg13cmos5l_a21oi_1
Xhold2481 _10329_/A _19722_/Q VPWR VGND sg13cmos5l_dlygate4sd3_1
X_14831_ _14831_/Y _14742_/B _14911_/B _14912_/B _14746_/X VPWR VGND sg13cmos5l_a22oi_1
Xhold2470 hold2470/X _15436_/A VPWR VGND sg13cmos5l_dlygate4sd3_1
XFILLER_91_537 VPWR VGND sg13cmos5l_fill_2
X_17550_ _17550_/Y _17601_/B _17552_/B _17543_/Y VPWR VGND sg13cmos5l_a21oi_1
XFILLER_56_63 VPWR VGND sg13cmos5l_fill_2
Xhold2492 _14691_/B _14690_/X VPWR VGND sg13cmos5l_dlygate4sd3_1
X_11974_ _11975_/C _18737_/Q _18738_/Q _18739_/Q VPWR VGND sg13cmos5l_o21ai_1
XFILLER_57_792 VPWR VGND sg13cmos5l_fill_2
XFILLER_45_965 VPWR VGND sg13cmos5l_fill_2
X_16501_ _16501_/Y _16501_/A _16501_/B _16530_/B VPWR VGND sg13cmos5l_nor3_1
X_14762_ _14762_/Y _19194_/Q _19155_/Q VPWR VGND sg13cmos5l_xnor2_1
XFILLER_29_483 VPWR VGND sg13cmos5l_fill_2
X_13713_ _13713_/Y _13713_/A _16651_/A VPWR VGND sg13cmos5l_nor2_1
X_19026__1233 _19026_/RESET_B VPWR VGND sg13cmos5l_tiehi
X_17481_ _17585_/A _17285_/B _17494_/B _17481_/C VPWR VGND sg13cmos5l_nand3b_1
XFILLER_60_913 VPWR VGND sg13cmos5l_decap_8
X_18999__1261 _18999_/RESET_B VPWR VGND sg13cmos5l_tiehi
X_10925_ _10926_/B _10917_/B _10907_/B _10924_/Y VPWR VGND sg13cmos5l_o21ai_1
X_14693_ _19187_/D _14935_/A _14690_/S _14692_/Y VPWR VGND sg13cmos5l_a21oi_1
X_13644_ _19028_/D _16889_/A _13644_/B VPWR VGND sg13cmos5l_and2_1
X_10856_ _10858_/A _10848_/Y _10852_/Y _10855_/Y _18603_/Q _10853_/Y VPWR VGND sg13cmos5l_a221oi_1
X_16432_ _16434_/B _16432_/A _16469_/A VPWR VGND sg13cmos5l_nor2_1
X_19220_ _19220_/Q _19220_/CLK _19220_/D _19220_/RESET_B VPWR VGND sg13cmos5l_dfrbpq_1
XFILLER_72_95 VPWR VGND sg13cmos5l_fill_2
X_16363_ _16363_/Y _09985_/Y _16370_/B _16362_/Y VPWR VGND sg13cmos5l_a21oi_1
X_19151_ _19151_/Q _19805_/CLK _19151_/D _19151_/RESET_B VPWR VGND sg13cmos5l_dfrbpq_1
X_10787_ _10788_/B _10052_/Y _10784_/Y _13705_/A _10784_/B VPWR VGND sg13cmos5l_a22oi_1
X_13575_ _19005_/D _13575_/A _13578_/B VPWR VGND sg13cmos5l_nor2_1
X_15314_ _15426_/A _19302_/Q _15433_/B VPWR VGND sg13cmos5l_xnor2_1
X_18102_ _18128_/B _18476_/A _18104_/B VPWR VGND sg13cmos5l_nand2_1
X_12526_ _18859_/D _10005_/Y fanout78/X _12525_/Y VPWR VGND sg13cmos5l_a21oi_1
X_19082_ _19082_/Q _19092_/CLK _19082_/D _19082_/RESET_B VPWR VGND sg13cmos5l_dfrbpq_1
XFILLER_8_332 VPWR VGND sg13cmos5l_decap_8
X_16294_ _16305_/S _16168_/A _16168_/B _16285_/Y _16292_/Y _16293_/Y VPWR VGND sg13cmos5l_a221oi_1
X_12457_ _18837_/D _12457_/A _12460_/B VPWR VGND sg13cmos5l_nor2_1
X_15245_ _15245_/Y _15228_/A _15238_/B _15465_/A VPWR VGND sg13cmos5l_o21ai_1
X_18033_ _18061_/B _19657_/Q _18033_/B VPWR VGND sg13cmos5l_xor2_1
X_11408_ _11408_/Y _11387_/B _11412_/S _11630_/A VPWR VGND sg13cmos5l_o21ai_1
X_15176_ _19251_/D _15134_/A _15173_/S _15175_/Y VPWR VGND sg13cmos5l_a21oi_1
X_12388_ _12417_/B _12414_/A _12414_/B VPWR VGND sg13cmos5l_nand2_1
X_14127_ _14127_/Y _14102_/B _14131_/S _14375_/A VPWR VGND sg13cmos5l_o21ai_1
X_11339_ _18660_/D hold2624/X _11342_/S _11338_/Y VPWR VGND sg13cmos5l_a21oi_1
XFILLER_67_501 VPWR VGND sg13cmos5l_fill_1
X_18935_ _18935_/Q clkload46/A _18935_/D _18935_/RESET_B VPWR VGND sg13cmos5l_dfrbpq_1
X_14058_ _14058_/Y _14033_/Y _14062_/S _13925_/A VPWR VGND sg13cmos5l_o21ai_1
X_18866_ _18866_/Q clkload71/A _18866_/D _18866_/RESET_B VPWR VGND sg13cmos5l_dfrbpq_1
X_13009_ _18915_/D _13020_/B _13009_/B _13009_/C VPWR VGND sg13cmos5l_nor3_1
XFILLER_39_214 VPWR VGND sg13cmos5l_fill_1
X_17817_ _17823_/B _19661_/Q _17831_/A _19660_/Q VPWR VGND sg13cmos5l_nor3_1
X_19151__1100 _19151_/RESET_B VPWR VGND sg13cmos5l_tiehi
X_18797_ _18797_/Q clkload60/A _18797_/D _18797_/RESET_B VPWR VGND sg13cmos5l_dfrbpq_1
XFILLER_48_770 VPWR VGND sg13cmos5l_fill_2
X_17748_ _17771_/A _19609_/Q _19610_/Q VPWR VGND sg13cmos5l_xor2_1
XFILLER_36_954 VPWR VGND sg13cmos5l_fill_2
X_17679_ _19636_/D _17679_/A _17679_/B VPWR VGND sg13cmos5l_nor2_1
XFILLER_74_1028 VPWR VGND sg13cmos5l_fill_1
X_19418_ _19418_/Q clkload5/A _19418_/D _19418_/RESET_B VPWR VGND sg13cmos5l_dfrbpq_1
XFILLER_50_456 VPWR VGND sg13cmos5l_fill_2
X_19349_ _19349_/Q clkload17/A _19349_/D _19349_/RESET_B VPWR VGND sg13cmos5l_dfrbpq_1
XFILLER_30_191 VPWR VGND sg13cmos5l_fill_2
XFILLER_11_1012 VPWR VGND sg13cmos5l_decap_4
X_18724__1557 _18724_/RESET_B VPWR VGND sg13cmos5l_tiehi
Xheichips26_digital_project_1801 uio_oe[4] VPWR VGND sg13cmos5l_tiehi
Xheichips26_digital_project_1812 uio_oe[15] VPWR VGND sg13cmos5l_tiehi
X_19734__1144 _19734_/RESET_B VPWR VGND sg13cmos5l_tiehi
XFILLER_54_740 VPWR VGND sg13cmos5l_decap_4
X_19246__996 _19246_/RESET_B VPWR VGND sg13cmos5l_tiehi
X_10710_ _10710_/Y _13813_/A _13810_/A VPWR VGND sg13cmos5l_nand2b_1
X_11690_ _18734_/D _12188_/A _11690_/B VPWR VGND sg13cmos5l_and2_1
X_10641_ _19797_/D _10641_/A _10646_/B VPWR VGND sg13cmos5l_and2_1
X_13360_ _13381_/D _18949_/Q _18947_/Q _18948_/Q VPWR VGND sg13cmos5l_or3_1
X_10572_ _10572_/Y _10589_/A _10572_/B VPWR VGND sg13cmos5l_nor2_1
X_12311_ _12374_/A _12137_/A _12094_/Y _12280_/X _12294_/B VPWR VGND sg13cmos5l_a22oi_1
X_13291_ _18968_/D _13291_/A _13291_/B VPWR VGND sg13cmos5l_nor2_1
X_12242_ _18808_/D _12460_/B _12242_/B VPWR VGND sg13cmos5l_nor2_1
X_15030_ _15030_/Y _15030_/A _15030_/B VPWR VGND sg13cmos5l_nand2_1
X_12173_ _12173_/Y _12174_/A _12174_/B _12172_/Y VPWR VGND sg13cmos5l_a21oi_1
X_19253__989 _19253_/RESET_B VPWR VGND sg13cmos5l_tiehi
X_16981_ _17011_/B _19547_/Q _19548_/Q _19549_/Q VPWR VGND sg13cmos5l_o21ai_1
X_11124_ _11125_/A _11123_/C _11122_/Y _11123_/Y VPWR VGND sg13cmos5l_a21o_1
X_18720_ _18720_/Q clkload57/A _18720_/D _18720_/RESET_B VPWR VGND sg13cmos5l_dfrbpq_1
X_11055_ _11076_/A _10999_/A _11036_/B _10995_/Y VPWR VGND sg13cmos5l_a21oi_1
X_15932_ _16019_/B _15895_/X _15931_/Y _15952_/A VPWR VGND sg13cmos5l_mux2_1
X_10006_ _10006_/Y _10006_/A VPWR VGND sg13cmos5l_inv_1
XFILLER_97_1028 VPWR VGND sg13cmos5l_fill_1
XFILLER_97_1006 VPWR VGND sg13cmos5l_fill_2
XFILLER_76_375 VPWR VGND sg13cmos5l_fill_1
XFILLER_76_353 VPWR VGND sg13cmos5l_fill_1
X_18651_ _18651_/Q _18733_/CLK _18651_/D _18651_/RESET_B VPWR VGND sg13cmos5l_dfrbpq_1
XFILLER_49_589 VPWR VGND sg13cmos5l_fill_1
X_15863_ _15959_/A _15829_/Y _15856_/B _15681_/Y VPWR VGND sg13cmos5l_o21ai_1
X_18582_ _18582_/Q _18594_/CLK _18582_/D _18582_/RESET_B VPWR VGND sg13cmos5l_dfrbpq_1
X_17602_ _17602_/Y _17587_/A _17579_/X _17601_/Y VPWR VGND sg13cmos5l_a21oi_1
X_14814_ _14819_/B _15187_/A _14815_/B VPWR VGND sg13cmos5l_and2_1
X_15794_ _15794_/X _15763_/Y _10205_/Y _15798_/S VPWR VGND sg13cmos5l_mux2_1
X_11957_ _11957_/Y _12230_/B fanout55/X _11956_/Y VPWR VGND sg13cmos5l_a21oi_1
X_17533_ _17557_/B _19631_/Q _19632_/Q _19633_/Q _19634_/Q VPWR VGND sg13cmos5l_nor4_1
XFILLER_45_762 VPWR VGND sg13cmos5l_fill_2
X_14745_ _14747_/B _14755_/S _14744_/Y _14743_/X VPWR VGND sg13cmos5l_a21oi_1
XFILLER_18_965 VPWR VGND sg13cmos5l_fill_1
XFILLER_72_592 VPWR VGND sg13cmos5l_fill_1
X_17464_ _17464_/Y _17464_/A _17495_/A VPWR VGND sg13cmos5l_nor2_1
XFILLER_45_795 VPWR VGND sg13cmos5l_fill_1
X_10908_ _10908_/Y _10908_/A _10928_/B VPWR VGND sg13cmos5l_nor2_1
X_11888_ _11888_/Y _11876_/B _11890_/S _11904_/A VPWR VGND sg13cmos5l_o21ai_1
X_19203_ _19203_/Q clkload51/A _19203_/D _19203_/RESET_B VPWR VGND sg13cmos5l_dfrbpq_1
X_14676_ _14676_/Y _14676_/A VPWR VGND sg13cmos5l_inv_1
X_16415_ _16452_/B _16415_/A _16467_/B VPWR VGND sg13cmos5l_nand2_1
XFILLER_33_968 VPWR VGND sg13cmos5l_fill_1
X_13627_ _13629_/A _13627_/A _13632_/S VPWR VGND sg13cmos5l_nor2_1
X_10839_ _10839_/Y _18618_/Q _11357_/A VPWR VGND sg13cmos5l_nand2_1
X_17395_ _17395_/X _17696_/A _17396_/B VPWR VGND sg13cmos5l_or2_1
X_19395__462 _19395_/D VPWR VGND sg13cmos5l_tielo
X_19553__661 _19553_/RESET_B VPWR VGND sg13cmos5l_tiehi
X_13558_ _13558_/Y _13559_/A _13559_/B _13557_/Y VPWR VGND sg13cmos5l_a21oi_1
XFILLER_9_630 VPWR VGND sg13cmos5l_fill_1
XFILLER_13_692 VPWR VGND sg13cmos5l_fill_2
X_16346_ _16347_/A _16350_/C _16344_/Y _16345_/Y VPWR VGND sg13cmos5l_a21o_1
X_19134_ _19134_/Q clkload52/A _19134_/D _19134_/RESET_B VPWR VGND sg13cmos5l_dfrbpq_1
X_12509_ _12509_/X _12489_/Y _10275_/Y _12509_/S VPWR VGND sg13cmos5l_mux2_1
XFILLER_8_162 VPWR VGND sg13cmos5l_fill_1
XFILLER_8_140 VPWR VGND sg13cmos5l_fill_1
X_16277_ _16278_/C _16277_/A _16277_/B VPWR VGND sg13cmos5l_nor2_1
X_19065_ _19065_/Q _19136_/CLK _19065_/D _19065_/RESET_B VPWR VGND sg13cmos5l_dfrbpq_1
X_13489_ _13489_/Y _13482_/Y _13484_/Y _13907_/A VPWR VGND sg13cmos5l_o21ai_1
X_18016_ _18016_/Y _19658_/Q _19651_/Q VPWR VGND sg13cmos5l_nor2_1
X_15228_ _15228_/Y _15228_/A VPWR VGND sg13cmos5l_inv_1
X_15159_ _15159_/Y _15134_/Y _15153_/Y _15158_/Y VPWR VGND sg13cmos5l_o21ai_1
X_19195__1051 _19195_/RESET_B VPWR VGND sg13cmos5l_tiehi
X_19484__733 _19484_/RESET_B VPWR VGND sg13cmos5l_tiehi
XFILLER_102_907 VPWR VGND sg13cmos5l_fill_2
Xfanout108 _11560_/B _11565_/B VPWR VGND sg13cmos5l_buf_1
Xfanout119 _17316_/B _17310_/B VPWR VGND sg13cmos5l_buf_1
X_18918_ _18918_/Q _19003_/CLK _18918_/D _18918_/RESET_B VPWR VGND sg13cmos5l_dfrbpq_1
X_18849_ _18849_/Q clkload70/A _18849_/D _18849_/RESET_B VPWR VGND sg13cmos5l_dfrbpq_1
X_19560__654 _19560_/RESET_B VPWR VGND sg13cmos5l_tiehi
XFILLER_94_194 VPWR VGND sg13cmos5l_fill_1
XFILLER_55_559 VPWR VGND sg13cmos5l_fill_1
X_19491__726 _19491_/RESET_B VPWR VGND sg13cmos5l_tiehi
XFILLER_23_467 VPWR VGND sg13cmos5l_fill_1
XFILLER_23_478 VPWR VGND sg13cmos5l_fill_2
XFILLER_3_839 VPWR VGND sg13cmos5l_fill_2
X_21225_ _21225_/X _21225_/A VPWR VGND sg13cmos5l_buf_1
XFILLER_104_255 VPWR VGND sg13cmos5l_decap_8
X_19058__1199 _19058_/RESET_B VPWR VGND sg13cmos5l_tiehi
X_12860_ _12881_/A _12860_/A _12875_/B VPWR VGND sg13cmos5l_nor2_1
XFILLER_74_835 VPWR VGND sg13cmos5l_fill_2
XFILLER_46_548 VPWR VGND sg13cmos5l_fill_2
XFILLER_2_1010 VPWR VGND sg13cmos5l_decap_8
X_11811_ _11820_/D _18765_/Q _11812_/B VPWR VGND sg13cmos5l_xnor2_1
X_12791_ _12791_/Y _18900_/Q fanout95/X _12528_/A VPWR VGND sg13cmos5l_o21ai_1
X_14530_ _14530_/Y _14577_/A _14716_/A VPWR VGND sg13cmos5l_nor2_1
X_11742_ _11742_/Y _11742_/A _11742_/B _11742_/C VPWR VGND sg13cmos5l_nor3_1
XFILLER_53_31 VPWR VGND sg13cmos5l_decap_8
X_11673_ _18724_/D _11673_/A _11673_/B VPWR VGND sg13cmos5l_nor2_1
X_14461_ _14461_/Y _14460_/B _14453_/Y _14463_/B _14463_/A VPWR VGND sg13cmos5l_a22oi_1
X_17180_ _17200_/S _17194_/B _17194_/C VPWR VGND sg13cmos5l_nand2_1
X_13412_ _18991_/D _13585_/A _13412_/B VPWR VGND sg13cmos5l_nor2_1
X_10624_ _10624_/Y _10465_/X _10624_/B VPWR VGND sg13cmos5l_nand2b_1
X_16200_ _16200_/Y _16181_/Y _16191_/X _16198_/Y VPWR VGND sg13cmos5l_o21ai_1
X_14392_ _14392_/Y _14392_/A _14392_/B _14392_/C VPWR VGND sg13cmos5l_nand3_1
X_13343_ _13343_/X _13312_/Y _10254_/Y _13347_/S VPWR VGND sg13cmos5l_mux2_1
X_16131_ _16131_/Y _16140_/B _16125_/C _16130_/Y VPWR VGND sg13cmos5l_a21oi_1
X_10555_ _10555_/Y _10555_/A _10579_/A VPWR VGND sg13cmos5l_nand2_1
X_13274_ _13274_/Y _13243_/Y _13276_/S _13297_/A VPWR VGND sg13cmos5l_o21ai_1
X_16062_ _16314_/B _16549_/B _16081_/A VPWR VGND sg13cmos5l_nand2b_1
X_10486_ _10573_/A _19738_/Q _10493_/A VPWR VGND sg13cmos5l_xor2_1
X_12225_ _12225_/Y _12726_/A _18834_/Q _12231_/C VPWR VGND sg13cmos5l_nor3_1
X_15013_ _15139_/A _15025_/S _15011_/Y _15010_/Y VPWR VGND sg13cmos5l_a21o_1
XFILLER_5_176 VPWR VGND sg13cmos5l_decap_8
X_12156_ _12158_/B _12156_/A _12156_/B VPWR VGND sg13cmos5l_nor2_1
X_11107_ _11107_/Y _18600_/Q _11107_/B _11107_/C VPWR VGND sg13cmos5l_nand3_1
X_12087_ _12136_/A _12087_/A _12088_/B VPWR VGND sg13cmos5l_xnor2_1
X_16964_ _16965_/C _16964_/A _17058_/B VPWR VGND sg13cmos5l_or2_1
XFILLER_49_342 VPWR VGND sg13cmos5l_fill_2
X_19752_ _19752_/Q _19756_/CLK _19752_/D _19752_/RESET_B VPWR VGND sg13cmos5l_dfrbpq_1
X_16895_ _16895_/Y _16933_/A _16895_/B VPWR VGND sg13cmos5l_nand2b_1
X_18703_ _18703_/Q clkload56/A _18703_/D _18703_/RESET_B VPWR VGND sg13cmos5l_dfrbpq_1
XFILLER_49_375 VPWR VGND sg13cmos5l_fill_2
X_11038_ _11038_/Y _11037_/A _11037_/B _11034_/A VPWR VGND sg13cmos5l_o21ai_1
X_19683_ _19683_/Q clkload20/A _19683_/D _19683_/RESET_B VPWR VGND sg13cmos5l_dfrbpq_1
X_15915_ _15915_/X _15915_/A _15915_/B _15915_/C VPWR VGND sg13cmos5l_or3_1
XFILLER_92_621 VPWR VGND sg13cmos5l_fill_2
X_18634_ _18634_/Q clkload47/A _18634_/D _18634_/RESET_B VPWR VGND sg13cmos5l_dfrbpq_1
X_15846_ _15944_/A _15846_/A _15846_/B VPWR VGND sg13cmos5l_nand2_1
XFILLER_80_827 VPWR VGND sg13cmos5l_fill_1
XFILLER_18_762 VPWR VGND sg13cmos5l_fill_1
X_12989_ _12990_/B _12959_/Y _12963_/Y _12962_/A VPWR VGND sg13cmos5l_a21oi_1
X_18565_ _18565_/Q clkload27/A _18565_/D _18565_/RESET_B VPWR VGND sg13cmos5l_dfrbpq_1
X_15777_ _15777_/Y _15777_/A VPWR VGND sg13cmos5l_inv_1
XFILLER_17_272 VPWR VGND sg13cmos5l_fill_1
XFILLER_91_197 VPWR VGND sg13cmos5l_fill_2
X_17516_ _17530_/A _17516_/A _17629_/A VPWR VGND sg13cmos5l_nor2_1
X_18496_ _18496_/Y _18496_/A _19790_/Q _18514_/C VPWR VGND sg13cmos5l_nor3_1
X_14728_ _14728_/Y _14724_/X _14726_/Y _14727_/Y VPWR VGND sg13cmos5l_o21ai_1
X_19743__1009 _19743_/RESET_B VPWR VGND sg13cmos5l_tiehi
X_17447_ _17447_/X _17447_/A _17447_/B VPWR VGND sg13cmos5l_and2_1
X_14659_ _14660_/B _14650_/Y _14657_/Y _14658_/Y VPWR VGND sg13cmos5l_o21ai_1
X_18590__1709 _18590_/RESET_B VPWR VGND sg13cmos5l_tiehi
XFILLER_60_595 VPWR VGND sg13cmos5l_fill_2
X_17378_ _17378_/Y _17936_/A _19559_/Q VPWR VGND sg13cmos5l_nor2_1
X_19117_ _19117_/Q clkload50/A _19117_/D _19117_/RESET_B VPWR VGND sg13cmos5l_dfrbpq_1
X_16329_ _16329_/Y _16329_/A _19402_/Q VPWR VGND sg13cmos5l_nor2_1
X_19048_ _19048_/Q clkload29/A _19048_/D _19048_/RESET_B VPWR VGND sg13cmos5l_dfrbpq_1
XFILLER_102_748 VPWR VGND sg13cmos5l_fill_2
XFILLER_68_640 VPWR VGND sg13cmos5l_fill_2
X_19013__1247 _19013_/RESET_B VPWR VGND sg13cmos5l_tiehi
X_19243__999 _19243_/RESET_B VPWR VGND sg13cmos5l_tiehi
XFILLER_51_584 VPWR VGND sg13cmos5l_fill_2
X_10340_ _10340_/Y _19685_/Q VPWR VGND sg13cmos5l_inv_1
X_18773__1505 _18773_/RESET_B VPWR VGND sg13cmos5l_tiehi
X_10271_ _13056_/B _10271_/A VPWR VGND sg13cmos5l_inv_1
X_12010_ _18780_/D _12200_/A _12010_/B VPWR VGND sg13cmos5l_nor2_1
XFILLER_2_124 VPWR VGND sg13cmos5l_fill_1
XFILLER_19_515 VPWR VGND sg13cmos5l_fill_1
X_13961_ _13961_/Y _19080_/Q _19095_/Q VPWR VGND sg13cmos5l_nand2_1
X_16680_ _16779_/A _19500_/Q _16693_/B VPWR VGND sg13cmos5l_xnor2_1
X_19543__671 _19543_/RESET_B VPWR VGND sg13cmos5l_tiehi
X_12912_ _13108_/A _18917_/Q _12912_/B VPWR VGND sg13cmos5l_xor2_1
X_15700_ _15700_/X _15607_/Y _15699_/Y _15697_/Y VPWR VGND sg13cmos5l_a21o_1
X_13892_ _13897_/A _13891_/A _13891_/B _13506_/A VPWR VGND sg13cmos5l_a21oi_1
XFILLER_34_507 VPWR VGND sg13cmos5l_fill_2
X_12843_ _12846_/A _12843_/A _12849_/B VPWR VGND sg13cmos5l_nand2_1
X_15631_ _15631_/X _15640_/B _15631_/B VPWR VGND sg13cmos5l_and2_1
X_18691__1600 _18691_/RESET_B VPWR VGND sg13cmos5l_tiehi
X_12774_ _12785_/S _12774_/A _12774_/B VPWR VGND sg13cmos5l_nor2_1
XFILLER_64_74 VPWR VGND sg13cmos5l_fill_2
X_15562_ _15564_/B _15562_/A _15582_/B VPWR VGND sg13cmos5l_nor2_1
X_18350_ _18350_/Y _18351_/A _18450_/B VPWR VGND sg13cmos5l_nor2_1
X_11725_ _11725_/Y _11725_/A _11725_/B VPWR VGND sg13cmos5l_nand2_1
X_17301_ _17301_/Y _17304_/C _17304_/D VPWR VGND sg13cmos5l_nand2_1
X_18281_ _18281_/Y _18508_/A _18282_/S _18280_/Y VPWR VGND sg13cmos5l_a21oi_1
X_15493_ _15493_/Y _16013_/A _19338_/Q _15498_/C VPWR VGND sg13cmos5l_nor3_1
X_14513_ _14513_/Y _14513_/A _14513_/B _14616_/B VPWR VGND sg13cmos5l_nor3_1
X_19814__1751 _19814_/RESET_B VPWR VGND sg13cmos5l_tiehi
X_17232_ _17325_/B _17232_/A _17232_/B _17345_/B VPWR VGND sg13cmos5l_nor3_1
X_14444_ _14474_/A _19115_/Q _19116_/Q VPWR VGND sg13cmos5l_xor2_1
X_11656_ _11657_/B _18747_/Q _12195_/A _11661_/C VPWR VGND sg13cmos5l_nand3_1
Xfanout90 fanout90/X fanout92/X VPWR VGND sg13cmos5l_buf_1
X_17163_ _17163_/X _19528_/Q _17163_/B VPWR VGND sg13cmos5l_xor2_1
X_11587_ _11587_/Y _11579_/Y _11581_/Y _11584_/Y _11585_/X _11586_/Y VPWR VGND sg13cmos5l_a221oi_1
X_10607_ _10607_/X _10607_/A _10607_/B _10607_/C VPWR VGND sg13cmos5l_or3_1
X_14375_ _19140_/D _14375_/A _14375_/B VPWR VGND sg13cmos5l_and2_1
X_19550__664 _19550_/RESET_B VPWR VGND sg13cmos5l_tiehi
X_17094_ _17094_/Y _17669_/A _19514_/Q _19513_/Q _17668_/A VPWR VGND sg13cmos5l_a22oi_1
X_13326_ _13326_/Y _13326_/A VPWR VGND sg13cmos5l_inv_1
XFILLER_6_430 VPWR VGND sg13cmos5l_fill_1
X_16114_ _16140_/B _16102_/Y _16109_/X _16112_/Y VPWR VGND sg13cmos5l_o21ai_1
X_10538_ _10538_/Y _19802_/Q _10538_/B VPWR VGND sg13cmos5l_xnor2_1
X_13257_ _13258_/C _13257_/A _13257_/B _13257_/C VPWR VGND sg13cmos5l_and3_1
X_16045_ _16045_/Y _19397_/Q _16041_/Y _16044_/Y _19396_/Q VPWR VGND sg13cmos5l_a22oi_1
X_12208_ _12208_/Y _18834_/Q _12210_/B _18771_/Q _12728_/A VPWR VGND sg13cmos5l_a22oi_1
X_10469_ _10484_/B _19745_/Q _19744_/Q _10497_/A VPWR VGND sg13cmos5l_nor3_1
X_13188_ _13407_/A _13365_/A _13202_/B VPWR VGND sg13cmos5l_and2_1
XFILLER_36_4 VPWR VGND sg13cmos5l_fill_2
X_12139_ _12167_/A _12138_/A _12139_/B VPWR VGND sg13cmos5l_nand2b_1
X_17996_ _17996_/Y _17979_/Y hold2265/X _18067_/A VPWR VGND sg13cmos5l_a21oi_1
X_19804_ _19804_/Q _19805_/CLK _19804_/D _19804_/RESET_B VPWR VGND sg13cmos5l_dfrbpq_1
X_19481__736 _19481_/RESET_B VPWR VGND sg13cmos5l_tiehi
X_16947_ _16947_/Y _16945_/Y _16946_/Y _16944_/Y VPWR VGND sg13cmos5l_a21oi_1
X_19735_ _19735_/Q clkload23/A _19735_/D _19735_/RESET_B VPWR VGND sg13cmos5l_dfrbpq_1
XFILLER_93_941 VPWR VGND sg13cmos5l_fill_1
X_16878_ _16878_/Y _17116_/A fanout29/X _16877_/Y VPWR VGND sg13cmos5l_a21oi_1
X_19666_ _19666_/Q clkload25/A _19666_/D _19666_/RESET_B VPWR VGND sg13cmos5l_dfrbpq_1
X_18982__1281 _18982_/RESET_B VPWR VGND sg13cmos5l_tiehi
X_18617_ _18617_/Q clkload45/A _18617_/D _18617_/RESET_B VPWR VGND sg13cmos5l_dfrbpq_1
X_19597_ _19597_/Q clkload12/A _19597_/D _19597_/RESET_B VPWR VGND sg13cmos5l_dfrbpq_1
X_15829_ _15829_/Y _19330_/Q _15830_/B VPWR VGND sg13cmos5l_xnor2_1
X_18548_ _18550_/A _10602_/A hold2667/X _10633_/A VPWR VGND sg13cmos5l_a21oi_1
XFILLER_61_893 VPWR VGND sg13cmos5l_fill_2
X_18479_ _19758_/D _18483_/A _18479_/B VPWR VGND sg13cmos5l_nor2_1
X_19231__1014 _19231_/RESET_B VPWR VGND sg13cmos5l_tiehi
Xclkload71 clkload71/Y clkload71/A VPWR VGND sg13cmos5l_inv_2
Xclkload60 clkload60/Y clkload60/A VPWR VGND sg13cmos5l_inv_2
X_19693__1741 _19693_/RESET_B VPWR VGND sg13cmos5l_tiehi
Xhold2811 _11866_/C _11865_/Y VPWR VGND sg13cmos5l_dlygate4sd3_1
Xhold2800 _13495_/A _18997_/Q VPWR VGND sg13cmos5l_dlygate4sd3_1
Xhold2822 _19085_/D _14069_/Y VPWR VGND sg13cmos5l_dlygate4sd3_1
Xhold2866 _12087_/A _18806_/Q VPWR VGND sg13cmos5l_dlygate4sd3_1
Xhold2855 hold2855/X _12156_/A VPWR VGND sg13cmos5l_dlygate4sd3_1
Xhold2833 _10773_/A _18595_/Q VPWR VGND sg13cmos5l_dlygate4sd3_1
Xhold2844 hold2844/X _17064_/B VPWR VGND sg13cmos5l_dlygate4sd3_1
Xhold2877 _11505_/B _11504_/Y VPWR VGND sg13cmos5l_dlygate4sd3_1
Xhold2888 _19704_/D _18217_/Y VPWR VGND sg13cmos5l_dlygate4sd3_1
Xhold2899 _14215_/A _19132_/Q VPWR VGND sg13cmos5l_dlygate4sd3_1
XFILLER_71_624 VPWR VGND sg13cmos5l_fill_1
XFILLER_18_89 VPWR VGND sg13cmos5l_fill_2
X_19321__916 _19321_/RESET_B VPWR VGND sg13cmos5l_tiehi
XFILLER_52_882 VPWR VGND sg13cmos5l_fill_1
X_11510_ _11513_/A _18722_/Q _11511_/B VPWR VGND sg13cmos5l_xnor2_1
XFILLER_51_370 VPWR VGND sg13cmos5l_fill_1
X_12490_ _12490_/Y _18851_/Q _12486_/Y _12489_/Y _18850_/Q VPWR VGND sg13cmos5l_a22oi_1
XFILLER_11_256 VPWR VGND sg13cmos5l_fill_1
X_11441_ _11441_/Y _11266_/A _11429_/X _11469_/A _11261_/Y VPWR VGND sg13cmos5l_a22oi_1
X_11372_ _11372_/Y _18708_/Q _11378_/B _18645_/Q _11898_/A VPWR VGND sg13cmos5l_a22oi_1
X_14160_ _14199_/A _19077_/Q _14160_/B VPWR VGND sg13cmos5l_xnor2_1
X_13111_ _13111_/Y _12960_/B _13122_/B _13108_/Y VPWR VGND sg13cmos5l_o21ai_1
X_10323_ _10854_/A _19770_/Q VPWR VGND sg13cmos5l_inv_1
X_14091_ _14091_/Y _14641_/A _19064_/Q _14090_/Y VPWR VGND sg13cmos5l_a21oi_1
X_13042_ _13042_/Y _13575_/A _18960_/Q VPWR VGND sg13cmos5l_nor2_1
X_10254_ _10254_/Y _10254_/A VPWR VGND sg13cmos5l_inv_1
X_10185_ _18476_/A _10185_/A VPWR VGND sg13cmos5l_inv_1
X_17850_ _17850_/Y hold2825/X _17870_/B VPWR VGND sg13cmos5l_nand2b_1
X_16801_ _16812_/A _16765_/Y _16799_/Y _16800_/X VPWR VGND sg13cmos5l_a21o_1
XFILLER_67_919 VPWR VGND sg13cmos5l_fill_1
Xfanout291 _13020_/B _12776_/Y VPWR VGND sg13cmos5l_buf_1
X_19520_ _19520_/Q clkload28/A _19520_/D _19520_/RESET_B VPWR VGND sg13cmos5l_dfrbpq_1
Xfanout280 _13578_/B _13586_/A VPWR VGND sg13cmos5l_buf_1
X_17781_ _17904_/A _17606_/X _17780_/Y _17781_/S VPWR VGND sg13cmos5l_mux2_1
X_14993_ _14993_/X _19206_/Q _19199_/Q VPWR VGND sg13cmos5l_or2_1
X_16732_ _16732_/Y _17079_/A _16916_/A VPWR VGND sg13cmos5l_nand2_1
X_13944_ _13945_/B _19093_/Q _14050_/B VPWR VGND sg13cmos5l_nor2_1
X_16663_ _19485_/D _16825_/A _16663_/B VPWR VGND sg13cmos5l_nor2_1
XFILLER_61_101 VPWR VGND sg13cmos5l_fill_1
X_13875_ _13875_/Y _13439_/A fanout80/X _13573_/A VPWR VGND sg13cmos5l_o21ai_1
XFILLER_19_389 VPWR VGND sg13cmos5l_fill_1
X_19451_ _19451_/Q _19679_/CLK _19451_/D _19451_/RESET_B VPWR VGND sg13cmos5l_dfrbpq_1
XFILLER_34_315 VPWR VGND sg13cmos5l_fill_1
X_12826_ _12826_/Y _12849_/B _12833_/C VPWR VGND sg13cmos5l_nand2_1
XFILLER_62_668 VPWR VGND sg13cmos5l_fill_2
X_19441__786 _19441_/RESET_B VPWR VGND sg13cmos5l_tiehi
X_15614_ _15616_/B _16015_/A _15623_/B VPWR VGND sg13cmos5l_and2_1
X_19382_ _19382_/Q clkload19/A _19382_/D _19382_/RESET_B VPWR VGND sg13cmos5l_dfrbpq_1
X_18402_ _18478_/B hold2741/X _10555_/Y _18402_/S VPWR VGND sg13cmos5l_mux2_1
X_16594_ _16594_/Y _17083_/A _19496_/Q VPWR VGND sg13cmos5l_nor2_1
XFILLER_90_988 VPWR VGND sg13cmos5l_fill_1
XFILLER_43_871 VPWR VGND sg13cmos5l_fill_1
X_18333_ _18333_/X _18320_/X _18330_/Y _18331_/Y VPWR VGND sg13cmos5l_a21o_1
XFILLER_98_6 VPWR VGND sg13cmos5l_fill_2
X_12757_ _12757_/Y _12757_/A _12757_/B VPWR VGND sg13cmos5l_nor2_1
X_15545_ _15552_/B _19287_/Q _15546_/B VPWR VGND sg13cmos5l_nor2b_1
X_12688_ _12689_/C _12688_/A _12688_/B _12688_/C VPWR VGND sg13cmos5l_nand3_1
X_11708_ _11715_/B _18700_/Q _18699_/Q _18698_/Q _11708_/D VPWR VGND sg13cmos5l_nor4_1
X_18264_ _18264_/Y _18264_/A _19748_/Q _18264_/C VPWR VGND sg13cmos5l_nor3_1
X_15476_ _15482_/C _15472_/Y _15474_/Y _15475_/Y VPWR VGND sg13cmos5l_o21ai_1
X_11639_ _11639_/Y _12193_/A _18686_/Q _11637_/Y _11638_/Y VPWR VGND sg13cmos5l_a22oi_1
X_17215_ _17232_/A _19588_/Q _17234_/B VPWR VGND sg13cmos5l_nor2_1
X_14427_ _19148_/D _10239_/Y _14424_/S _14426_/Y VPWR VGND sg13cmos5l_a21oi_1
X_18195_ _18195_/Y _18195_/A _18195_/B VPWR VGND sg13cmos5l_nand2_1
X_17146_ _17146_/Y hold2060/X fanout70/X _17152_/A VPWR VGND sg13cmos5l_o21ai_1
X_14358_ _14358_/Y _14319_/B _14349_/X _14374_/A VPWR VGND sg13cmos5l_o21ai_1
X_13309_ _13329_/C _19002_/Q _13328_/A _13318_/B VPWR VGND sg13cmos5l_o21ai_1
X_17077_ _17077_/Y hold2844/X _17065_/Y _17076_/Y VPWR VGND sg13cmos5l_a21oi_1
X_19272__970 _19272_/RESET_B VPWR VGND sg13cmos5l_tiehi
X_14289_ _14478_/A _14303_/A _14441_/A VPWR VGND sg13cmos5l_nand2_1
X_16028_ _16028_/Y _16024_/Y _16027_/Y _16026_/Y VPWR VGND sg13cmos5l_o21ai_1
Xhold2107 _19498_/D _16817_/X VPWR VGND sg13cmos5l_dlygate4sd3_1
X_18880__1389 _18880_/RESET_B VPWR VGND sg13cmos5l_tiehi
Xhold2118 _18809_/D _12244_/Y VPWR VGND sg13cmos5l_dlygate4sd3_1
XFILLER_58_908 VPWR VGND sg13cmos5l_fill_1
X_19681__1778 _19681_/RESET_B VPWR VGND sg13cmos5l_tiehi
Xhold2129 _13349_/B _18981_/Q VPWR VGND sg13cmos5l_dlygate4sd3_1
X_17979_ _17979_/Y _19705_/Q _18477_/A _17962_/B _19643_/Q VPWR VGND sg13cmos5l_a22oi_1
X_19718_ _19718_/Q clkload14/A _19718_/D _19718_/RESET_B VPWR VGND sg13cmos5l_dfrbpq_1
XFILLER_93_793 VPWR VGND sg13cmos5l_fill_1
X_19649_ _19649_/Q clkload35/A _19649_/D _19649_/RESET_B VPWR VGND sg13cmos5l_dfrbpq_1
XFILLER_81_988 VPWR VGND sg13cmos5l_fill_1
XFILLER_21_510 VPWR VGND sg13cmos5l_fill_1
XFILLER_33_392 VPWR VGND sg13cmos5l_fill_1
X_19533__681 _19533_/RESET_B VPWR VGND sg13cmos5l_tiehi
Xhold2630 _10105_/A _19212_/Q VPWR VGND sg13cmos5l_dlygate4sd3_1
Xhold2641 _16609_/B _16608_/X VPWR VGND sg13cmos5l_dlygate4sd3_1
Xhold2674 _10816_/B _10443_/B VPWR VGND sg13cmos5l_dlygate4sd3_1
Xhold2652 hold2652/X _17235_/Y VPWR VGND sg13cmos5l_dlygate4sd3_1
Xhold2663 _14132_/B _14131_/X VPWR VGND sg13cmos5l_dlygate4sd3_1
X_11990_ _11990_/Y _11992_/A _11992_/B _11989_/Y VPWR VGND sg13cmos5l_a21oi_1
Xhold1951 _09975_/A _19561_/Q VPWR VGND sg13cmos5l_dlygate4sd3_1
Xhold1940 _09972_/A _19645_/Q VPWR VGND sg13cmos5l_dlygate4sd3_1
Xhold2696 _15655_/A _19333_/Q VPWR VGND sg13cmos5l_dlygate4sd3_1
Xhold2685 hold2685/X _14860_/Y VPWR VGND sg13cmos5l_dlygate4sd3_1
XFILLER_29_654 VPWR VGND sg13cmos5l_fill_2
Xhold1962 _09995_/A _19151_/Q VPWR VGND sg13cmos5l_dlygate4sd3_1
Xhold1984 _10007_/A _18857_/Q VPWR VGND sg13cmos5l_dlygate4sd3_1
Xhold1995 _13212_/A _18943_/Q VPWR VGND sg13cmos5l_dlygate4sd3_1
Xhold1973 _18648_/D _11148_/Y VPWR VGND sg13cmos5l_dlygate4sd3_1
XFILLER_57_996 VPWR VGND sg13cmos5l_fill_2
X_10941_ _10941_/Y _10938_/Y _10939_/Y _10940_/Y _10945_/C VPWR VGND sg13cmos5l_a22oi_1
X_13660_ _13696_/A _19053_/Q _13660_/B VPWR VGND sg13cmos5l_xnor2_1
X_19540__674 _19540_/RESET_B VPWR VGND sg13cmos5l_tiehi
X_12611_ _12611_/Y _12652_/A _12652_/B _12651_/A VPWR VGND sg13cmos5l_a21oi_1
X_10872_ _10872_/Y _10855_/Y hold2394/X _11085_/B VPWR VGND sg13cmos5l_a21oi_1
X_13591_ _13591_/Y _18570_/Q _19038_/Q VPWR VGND sg13cmos5l_nor2b_1
X_12542_ _12543_/B _18828_/Q _18821_/Q _18822_/Q VPWR VGND sg13cmos5l_nor3_1
XFILLER_61_31 VPWR VGND sg13cmos5l_fill_1
XFILLER_12_543 VPWR VGND sg13cmos5l_fill_2
X_15330_ _15427_/B _15435_/A VPWR VGND sg13cmos5l_inv_1
X_12473_ _12473_/Y _13018_/A _18810_/Q _18809_/Q _13017_/A _12471_/Y VPWR VGND sg13cmos5l_a221oi_1
XFILLER_61_64 VPWR VGND sg13cmos5l_fill_2
XFILLER_40_874 VPWR VGND sg13cmos5l_fill_2
X_15261_ _15303_/A _19245_/Q _15262_/B VPWR VGND sg13cmos5l_xnor2_1
XFILLER_12_576 VPWR VGND sg13cmos5l_fill_2
X_17000_ _17000_/Y _16974_/B _16979_/X _16999_/Y VPWR VGND sg13cmos5l_o21ai_1
X_11424_ _18694_/D _13807_/A _11424_/B VPWR VGND sg13cmos5l_and2_1
X_14212_ _14334_/A _19134_/Q _14226_/B VPWR VGND sg13cmos5l_xnor2_1
X_15192_ _19266_/D _15192_/A _15192_/B VPWR VGND sg13cmos5l_nor2_1
X_11355_ _18672_/D _11355_/A _11355_/B VPWR VGND sg13cmos5l_nor2_1
X_14143_ _19112_/D _14436_/A _14143_/B VPWR VGND sg13cmos5l_and2_1
X_10306_ _11382_/A _10306_/A VPWR VGND sg13cmos5l_inv_1
X_18951_ _18951_/Q _18975_/CLK _18951_/D _18951_/RESET_B VPWR VGND sg13cmos5l_dfrbpq_1
X_11286_ _11286_/Y _11286_/A _11295_/B VPWR VGND sg13cmos5l_nor2_1
X_14074_ _19091_/D _14074_/A _14076_/B VPWR VGND sg13cmos5l_nor2_1
XFILLER_3_263 VPWR VGND sg13cmos5l_fill_1
XFILLER_105_180 VPWR VGND sg13cmos5l_fill_1
X_13025_ _18929_/D _13025_/A _13025_/B VPWR VGND sg13cmos5l_nor2_1
X_17902_ _17903_/C _17902_/A _17902_/B _17902_/C VPWR VGND sg13cmos5l_nand3_1
X_10237_ _14668_/A _10237_/A VPWR VGND sg13cmos5l_inv_1
X_18882_ _18882_/Q clkload70/A _18882_/D _18882_/RESET_B VPWR VGND sg13cmos5l_dfrbpq_1
XFILLER_6_1019 VPWR VGND sg13cmos5l_decap_8
XFILLER_79_598 VPWR VGND sg13cmos5l_fill_2
X_10168_ _17932_/A _17751_/A VPWR VGND sg13cmos5l_inv_1
X_17833_ _18010_/B _19661_/Q _17834_/B VPWR VGND sg13cmos5l_xnor2_1
XFILLER_0_992 VPWR VGND sg13cmos5l_decap_8
X_17764_ _17765_/B _17573_/B _17758_/X _17763_/Y VPWR VGND sg13cmos5l_o21ai_1
X_10099_ _14910_/A _10099_/A VPWR VGND sg13cmos5l_inv_1
X_14976_ _19238_/D _15528_/A _14976_/B VPWR VGND sg13cmos5l_and2_1
X_19503_ _19503_/Q clkload32/A _19503_/D _19503_/RESET_B VPWR VGND sg13cmos5l_dfrbpq_1
X_16715_ _16895_/B _19493_/Q _16716_/B VPWR VGND sg13cmos5l_xnor2_1
X_18865__1404 _18865_/RESET_B VPWR VGND sg13cmos5l_tiehi
X_13927_ _14020_/A _13927_/A VPWR VGND sg13cmos5l_inv_1
X_17695_ _17706_/B _17709_/C _17694_/Y _17693_/Y VPWR VGND sg13cmos5l_o21ai_1
X_19434_ _19434_/Q clkload9/A _19434_/D _19434_/RESET_B VPWR VGND sg13cmos5l_dfrbpq_1
X_16646_ _16664_/A _19037_/Q _16646_/B VPWR VGND sg13cmos5l_xor2_1
X_13858_ _13858_/Y _14364_/B _14364_/A VPWR VGND sg13cmos5l_nand2b_1
X_13789_ _13805_/C _13777_/Y _13782_/Y _13788_/Y VPWR VGND sg13cmos5l_a21o_1
X_12809_ _12809_/Y _12621_/X _12844_/A _12803_/X VPWR VGND sg13cmos5l_o21ai_1
X_16577_ _16577_/Y _16577_/A VPWR VGND sg13cmos5l_inv_1
X_19365_ _19365_/Q clkload7/A _19365_/D _19365_/RESET_B VPWR VGND sg13cmos5l_dfrbpq_1
X_18568__1736 _18568_/RESET_B VPWR VGND sg13cmos5l_tiehi
X_15528_ _19324_/D _15528_/A _15528_/B VPWR VGND sg13cmos5l_and2_1
X_19296_ _19296_/Q clkload16/A _19296_/D _19296_/RESET_B VPWR VGND sg13cmos5l_dfrbpq_1
X_18316_ _18316_/X _18300_/Y _18312_/Y _18315_/Y VPWR VGND sg13cmos5l_a21o_1
X_18247_ _18261_/B _18264_/C _18246_/Y _18243_/Y VPWR VGND sg13cmos5l_o21ai_1
X_15459_ _15459_/Y _15459_/A _15466_/A VPWR VGND sg13cmos5l_nor2_1
X_18975__502 _18975_/D VPWR VGND sg13cmos5l_tielo
X_18178_ _18178_/Y _18178_/A VPWR VGND sg13cmos5l_inv_1
X_17129_ _17136_/S _17129_/A _17129_/B VPWR VGND sg13cmos5l_nor2_1
XFILLER_89_318 VPWR VGND sg13cmos5l_fill_1
XFILLER_58_705 VPWR VGND sg13cmos5l_fill_1
XFILLER_97_373 VPWR VGND sg13cmos5l_fill_1
XFILLER_58_738 VPWR VGND sg13cmos5l_decap_4
XFILLER_100_846 VPWR VGND sg13cmos5l_fill_2
XFILLER_85_557 VPWR VGND sg13cmos5l_fill_2
XFILLER_81_796 VPWR VGND sg13cmos5l_fill_1
XFILLER_41_638 VPWR VGND sg13cmos5l_fill_1
X_11140_ _11140_/Y _11388_/A _11133_/S _11139_/Y VPWR VGND sg13cmos5l_a21oi_1
Xoutput12 uio_out[2] _21227_/X VPWR VGND sg13cmos5l_buf_1
X_11071_ _11071_/Y _11030_/B _11063_/Y _11090_/A VPWR VGND sg13cmos5l_o21ai_1
X_10022_ _11897_/A _10022_/A VPWR VGND sg13cmos5l_inv_1
XFILLER_56_20 VPWR VGND sg13cmos5l_fill_1
Xhold2460 _11351_/A _18618_/Q VPWR VGND sg13cmos5l_dlygate4sd3_1
Xhold2482 _18275_/B _18274_/X VPWR VGND sg13cmos5l_dlygate4sd3_1
X_14830_ _14912_/B _14827_/Y _14806_/Y _14843_/S VPWR VGND sg13cmos5l_mux2_1
Xhold2471 _15617_/A _19332_/Q VPWR VGND sg13cmos5l_dlygate4sd3_1
XFILLER_91_527 VPWR VGND sg13cmos5l_fill_2
XFILLER_56_53 VPWR VGND sg13cmos5l_fill_2
Xhold2493 _10213_/A _19312_/Q VPWR VGND sg13cmos5l_dlygate4sd3_1
X_11973_ _11986_/D _18739_/Q _18737_/Q _18738_/Q VPWR VGND sg13cmos5l_or3_1
XFILLER_84_590 VPWR VGND sg13cmos5l_fill_1
X_16500_ _16530_/B _19461_/Q _16500_/B VPWR VGND sg13cmos5l_and2_1
X_14761_ _14761_/Y _19193_/Q _19154_/Q VPWR VGND sg13cmos5l_xnor2_1
X_13712_ _13712_/Y _13700_/Y _13705_/Y _13710_/Y _13650_/A _13706_/Y VPWR VGND sg13cmos5l_a221oi_1
X_18853__1419 _18853_/RESET_B VPWR VGND sg13cmos5l_tiehi
X_17480_ _17480_/X _17480_/A _17495_/B VPWR VGND sg13cmos5l_or2_1
XFILLER_44_454 VPWR VGND sg13cmos5l_fill_1
X_10924_ _10924_/Y _10924_/A _10928_/B VPWR VGND sg13cmos5l_nor2_1
X_19262__980 _19262_/RESET_B VPWR VGND sg13cmos5l_tiehi
X_14692_ _14692_/Y _14667_/A _14690_/S _14909_/B VPWR VGND sg13cmos5l_o21ai_1
X_13643_ _13643_/Y _09999_/Y fanout86/X _13642_/Y VPWR VGND sg13cmos5l_a21oi_1
X_10855_ _10855_/Y _18623_/Q _11357_/A _10854_/A _10854_/B VPWR VGND sg13cmos5l_a22oi_1
X_16431_ _16469_/A _19413_/Q _16431_/B VPWR VGND sg13cmos5l_xnor2_1
X_13574_ _19004_/D _13574_/A _13583_/A VPWR VGND sg13cmos5l_and2_1
X_16362_ _16362_/Y _16338_/A _16370_/B _16561_/A VPWR VGND sg13cmos5l_o21ai_1
X_19150_ _19150_/Q clkload42/A _19150_/D _19150_/RESET_B VPWR VGND sg13cmos5l_dfrbpq_1
X_10786_ _13648_/A _13647_/A _10804_/A VPWR VGND sg13cmos5l_nand2_1
X_12525_ _12525_/Y hold1983/X fanout78/X _12797_/A VPWR VGND sg13cmos5l_o21ai_1
X_18101_ _18104_/B _18475_/A _18107_/B VPWR VGND sg13cmos5l_and2_1
XFILLER_8_300 VPWR VGND sg13cmos5l_fill_1
XFILLER_9_823 VPWR VGND sg13cmos5l_fill_1
X_15313_ _15313_/Y _15313_/A _15433_/B VPWR VGND sg13cmos5l_nand2_1
X_19081_ _19081_/Q clkload53/A _19081_/D _19081_/RESET_B VPWR VGND sg13cmos5l_dfrbpq_1
X_16293_ _16293_/Y _16293_/A _16293_/B VPWR VGND sg13cmos5l_nor2_1
X_12456_ _18836_/D _12456_/A _12460_/B VPWR VGND sg13cmos5l_nor2_1
X_18032_ _18032_/Y _18032_/A _18032_/B VPWR VGND sg13cmos5l_nor2_1
X_15244_ _15244_/Y _15492_/A _15238_/B _15243_/Y VPWR VGND sg13cmos5l_a21oi_1
X_12387_ _12417_/A _18838_/Q _12414_/B VPWR VGND sg13cmos5l_xnor2_1
X_11407_ _18683_/D _11629_/A _11407_/B VPWR VGND sg13cmos5l_nor2_1
X_15175_ _15175_/Y _15134_/B _15173_/S _15194_/A VPWR VGND sg13cmos5l_o21ai_1
XFILLER_99_616 VPWR VGND sg13cmos5l_fill_1
X_11338_ _11338_/Y _11313_/B _11342_/S _11351_/B VPWR VGND sg13cmos5l_o21ai_1
X_14126_ _14126_/Y _14106_/A _14131_/S _14125_/Y VPWR VGND sg13cmos5l_a21oi_1
X_11269_ _11274_/A _18680_/Q _11269_/B VPWR VGND sg13cmos5l_xnor2_1
X_18934_ _18934_/Q clkload58/A _18934_/D _18934_/RESET_B VPWR VGND sg13cmos5l_dfrbpq_1
X_14057_ _14057_/Y _13933_/Y _13946_/Y _14047_/Y _14055_/Y _14056_/X VPWR VGND sg13cmos5l_a221oi_1
X_18865_ _18865_/Q clkload71/A _18865_/D _18865_/RESET_B VPWR VGND sg13cmos5l_dfrbpq_1
X_13008_ _13009_/C _13008_/A _13007_/A VPWR VGND sg13cmos5l_nor2b_1
X_17816_ _17834_/B _17831_/A _19660_/Q VPWR VGND sg13cmos5l_nor2_1
XFILLER_95_888 VPWR VGND sg13cmos5l_fill_2
X_18796_ _18796_/Q clkload60/A _18796_/D _18796_/RESET_B VPWR VGND sg13cmos5l_dfrbpq_1
XFILLER_82_527 VPWR VGND sg13cmos5l_decap_4
X_17747_ _17747_/Y _17757_/D _17746_/B _17592_/A VPWR VGND sg13cmos5l_a21oi_1
X_14959_ _19228_/D _15192_/A _14959_/B VPWR VGND sg13cmos5l_nor2_1
X_19523__691 _19523_/RESET_B VPWR VGND sg13cmos5l_tiehi
X_17678_ _19635_/D _17678_/A _17678_/B VPWR VGND sg13cmos5l_nor2_1
X_16629_ _16629_/Y _19036_/Q _16629_/B VPWR VGND sg13cmos5l_xnor2_1
X_18829__1443 _18829_/RESET_B VPWR VGND sg13cmos5l_tiehi
X_19417_ _19417_/Q clkload9/A _19417_/D _19417_/RESET_B VPWR VGND sg13cmos5l_dfrbpq_1
XFILLER_35_498 VPWR VGND sg13cmos5l_decap_8
XFILLER_94_0 VPWR VGND sg13cmos5l_fill_2
X_19476__454 _19476_/D VPWR VGND sg13cmos5l_tielo
X_19348_ _19348_/Q clkload17/A _19348_/D _19348_/RESET_B VPWR VGND sg13cmos5l_dfrbpq_1
X_19279_ _19279_/Q _19302_/CLK _19279_/D _19279_/RESET_B VPWR VGND sg13cmos5l_dfrbpq_1
X_19199__1046 _19199_/RESET_B VPWR VGND sg13cmos5l_tiehi
X_19530__684 _19530_/RESET_B VPWR VGND sg13cmos5l_tiehi
Xheichips26_digital_project_1802 uio_oe[5] VPWR VGND sg13cmos5l_tiehi
XFILLER_54_796 VPWR VGND sg13cmos5l_fill_1
XFILLER_53_295 VPWR VGND sg13cmos5l_fill_2
X_10640_ _19796_/D _18264_/A _10642_/B VPWR VGND sg13cmos5l_nor2_1
XFILLER_42_22 VPWR VGND sg13cmos5l_decap_8
XFILLER_22_693 VPWR VGND sg13cmos5l_fill_1
X_10571_ _10571_/Y _10554_/Y _10562_/Y _18544_/A _10569_/Y _10570_/Y VPWR VGND sg13cmos5l_a221oi_1
X_12310_ _18825_/D _12452_/A _12310_/B VPWR VGND sg13cmos5l_nor2_1
X_13290_ _18967_/D _13290_/A _13290_/B VPWR VGND sg13cmos5l_and2_1
X_12241_ _12242_/B _12221_/Y _12487_/A _12241_/S VPWR VGND sg13cmos5l_mux2_1
XFILLER_6_848 VPWR VGND sg13cmos5l_fill_2
X_12172_ _12172_/Y _12172_/A _12172_/B VPWR VGND sg13cmos5l_nor2_1
X_16980_ _16980_/Y _16974_/B _16979_/X _16972_/Y VPWR VGND sg13cmos5l_a21oi_1
X_11123_ _11123_/Y _18666_/Q _11623_/A _11123_/C VPWR VGND sg13cmos5l_nor3_1
XFILLER_1_553 VPWR VGND sg13cmos5l_fill_1
X_11054_ _11054_/Y _11030_/Y _11048_/Y _11053_/Y VPWR VGND sg13cmos5l_o21ai_1
X_15931_ _15931_/Y _16090_/A _16116_/A VPWR VGND sg13cmos5l_nand2_1
X_10005_ _10005_/Y _10005_/A VPWR VGND sg13cmos5l_inv_1
XFILLER_76_321 VPWR VGND sg13cmos5l_fill_1
X_18650_ _18650_/Q _18733_/CLK _18650_/D _18650_/RESET_B VPWR VGND sg13cmos5l_dfrbpq_1
XFILLER_91_302 VPWR VGND sg13cmos5l_fill_2
Xhold2290 _10157_/A _19578_/Q VPWR VGND sg13cmos5l_dlygate4sd3_1
X_17601_ _17601_/Y _17607_/B _17601_/B VPWR VGND sg13cmos5l_nand2b_1
X_15862_ _19371_/D _16022_/A _15862_/B VPWR VGND sg13cmos5l_nor2_1
X_18581_ _18581_/Q _18594_/CLK _18581_/D _18581_/RESET_B VPWR VGND sg13cmos5l_dfrbpq_1
XFILLER_76_398 VPWR VGND sg13cmos5l_fill_2
X_14813_ _14816_/A _19226_/Q _14813_/B VPWR VGND sg13cmos5l_xor2_1
X_15793_ _15793_/Y _15768_/A _15798_/S _15792_/Y VPWR VGND sg13cmos5l_a21oi_1
XFILLER_36_229 VPWR VGND sg13cmos5l_fill_1
X_11956_ _11956_/Y _11941_/B fanout55/X _12199_/A VPWR VGND sg13cmos5l_o21ai_1
X_17532_ _17562_/D _19631_/Q _19632_/Q _19633_/Q VPWR VGND sg13cmos5l_or3_1
X_14744_ _14744_/Y _14757_/B _14722_/Y VPWR VGND sg13cmos5l_nor2b_1
XFILLER_83_73 VPWR VGND sg13cmos5l_fill_1
X_17463_ _17467_/B _19572_/Q _17463_/B VPWR VGND sg13cmos5l_xor2_1
X_10907_ _10929_/S _10917_/B _10907_/B VPWR VGND sg13cmos5l_nor2_1
X_11887_ _11887_/Y _11846_/A _11879_/Y _11886_/Y VPWR VGND sg13cmos5l_a21oi_1
X_19202_ _19202_/Q clkload51/A _19202_/D _19202_/RESET_B VPWR VGND sg13cmos5l_dfrbpq_1
X_14675_ _14676_/A _14673_/Y _14675_/B VPWR VGND sg13cmos5l_nand2b_1
X_16414_ _16452_/A _19463_/Q _16414_/B _16467_/B VPWR VGND sg13cmos5l_or3_1
X_13626_ _19018_/D _13801_/A _13626_/B VPWR VGND sg13cmos5l_nor2_1
X_10838_ _10838_/Y _19764_/Q _10854_/A _10838_/C VPWR VGND sg13cmos5l_nand3_1
X_17394_ _17396_/B _17408_/C _17392_/Y _17393_/Y VPWR VGND sg13cmos5l_o21ai_1
X_10769_ _10769_/Y _10804_/B _10769_/B VPWR VGND sg13cmos5l_nor2_1
X_13557_ _13557_/Y _13557_/A _13557_/B VPWR VGND sg13cmos5l_nor2_1
X_16345_ _16345_/Y _16345_/A _19454_/Q _16350_/C VPWR VGND sg13cmos5l_nor3_1
X_19133_ _19133_/Q clkload52/A _19133_/D _19133_/RESET_B VPWR VGND sg13cmos5l_dfrbpq_1
X_12508_ _12729_/B _13015_/B _12797_/A VPWR VGND sg13cmos5l_nand2b_1
X_13488_ _13513_/B _14077_/A _13488_/B VPWR VGND sg13cmos5l_xnor2_1
X_16276_ _16278_/B _16276_/A _16276_/B VPWR VGND sg13cmos5l_nor2_1
X_19064_ _19064_/Q _19136_/CLK _19064_/D _19064_/RESET_B VPWR VGND sg13cmos5l_dfrbpq_1
X_12439_ _12453_/C _12426_/Y _12431_/X _12438_/Y VPWR VGND sg13cmos5l_o21ai_1
XFILLER_8_174 VPWR VGND sg13cmos5l_fill_1
X_15227_ _15228_/A _15225_/C _15226_/Y _15225_/Y VPWR VGND sg13cmos5l_a21o_1
X_18015_ _18015_/Y _17831_/A _19652_/Q VPWR VGND sg13cmos5l_nand2b_1
X_15158_ _15158_/Y _15164_/A _15164_/B VPWR VGND sg13cmos5l_nand2_1
X_15089_ _15278_/A _15459_/A _15089_/B VPWR VGND sg13cmos5l_xnor2_1
X_14109_ _14109_/Y _14640_/A _19128_/Q VPWR VGND sg13cmos5l_nor2_1
Xfanout109 _18157_/B _18319_/A VPWR VGND sg13cmos5l_buf_1
X_18917_ _18917_/Q clkload64/A _18917_/D _18917_/RESET_B VPWR VGND sg13cmos5l_dfrbpq_1
XFILLER_41_1028 VPWR VGND sg13cmos5l_fill_1
X_18848_ _18848_/Q clkload70/A _18848_/D _18848_/RESET_B VPWR VGND sg13cmos5l_dfrbpq_1
X_18779_ _18779_/Q clkload61/A _18779_/D _18779_/RESET_B VPWR VGND sg13cmos5l_dfrbpq_1
XFILLER_55_527 VPWR VGND sg13cmos5l_decap_8
Xclkbuf_leaf_30_clk _18750_/CLK clkload1/A VPWR VGND sg13cmos5l_buf_8
X_19252__990 _19252_/RESET_B VPWR VGND sg13cmos5l_tiehi
XFILLER_85_140 VPWR VGND sg13cmos5l_fill_1
XFILLER_85_173 VPWR VGND sg13cmos5l_fill_1
X_19066__1191 _19066_/RESET_B VPWR VGND sg13cmos5l_tiehi
X_11810_ _11820_/C _11797_/X _11804_/Y _11808_/Y VPWR VGND sg13cmos5l_a21o_1
X_12790_ _18899_/D _10007_/Y fanout96/X _12789_/Y VPWR VGND sg13cmos5l_a21oi_1
X_18893__1376 _18893_/RESET_B VPWR VGND sg13cmos5l_tiehi
X_11741_ _18740_/D _11891_/A _11741_/B VPWR VGND sg13cmos5l_nor2_1
XFILLER_54_571 VPWR VGND sg13cmos5l_fill_2
XFILLER_42_711 VPWR VGND sg13cmos5l_fill_1
XFILLER_81_390 VPWR VGND sg13cmos5l_fill_2
XFILLER_14_435 VPWR VGND sg13cmos5l_fill_2
X_11672_ _11673_/B _11652_/Y _10294_/Y _11672_/S VPWR VGND sg13cmos5l_mux2_1
X_18606__1692 _18606_/RESET_B VPWR VGND sg13cmos5l_tiehi
X_19205__480 _19205_/D VPWR VGND sg13cmos5l_tielo
XFILLER_14_468 VPWR VGND sg13cmos5l_decap_8
X_14460_ _14460_/Y _14486_/A _14460_/B VPWR VGND sg13cmos5l_nand2b_1
XFILLER_30_939 VPWR VGND sg13cmos5l_fill_2
X_13411_ _13411_/Y _13412_/B VPWR VGND sg13cmos5l_inv_1
X_14391_ _14391_/Y _14392_/B _14387_/X _14390_/Y VPWR VGND sg13cmos5l_a21oi_1
X_10623_ _10623_/Y _10610_/A _10623_/B VPWR VGND sg13cmos5l_nand2b_1
Xclkbuf_leaf_21_clk clkload28/A clkbuf_4_4_0_clk/X VPWR VGND sg13cmos5l_buf_8
X_13342_ _13342_/Y _13836_/A _13347_/S _13341_/Y VPWR VGND sg13cmos5l_a21oi_1
X_16130_ _16130_/Y _16104_/D _16090_/C _16136_/B VPWR VGND sg13cmos5l_a21oi_1
X_10554_ _10554_/Y _18543_/A _10644_/A VPWR VGND sg13cmos5l_nand2b_1
XFILLER_6_623 VPWR VGND sg13cmos5l_decap_8
XFILLER_5_100 VPWR VGND sg13cmos5l_fill_1
X_19142__1109 _19142_/RESET_B VPWR VGND sg13cmos5l_tiehi
X_13273_ _18954_/D _13292_/A _13273_/B VPWR VGND sg13cmos5l_nor2_1
XFILLER_6_678 VPWR VGND sg13cmos5l_fill_2
X_16061_ _16061_/Y _18272_/A _16549_/B VPWR VGND sg13cmos5l_nor2_1
X_10485_ _10485_/X _10501_/A _18387_/A VPWR VGND sg13cmos5l_and2_1
X_12224_ _12224_/Y _12224_/A _18772_/Q VPWR VGND sg13cmos5l_nor2_1
X_15012_ _15014_/B _15025_/S _15011_/Y _15010_/Y VPWR VGND sg13cmos5l_a21oi_1
X_12155_ _12156_/B _12198_/B _12015_/Y _12162_/B VPWR VGND sg13cmos5l_mux2_1
XFILLER_69_608 VPWR VGND sg13cmos5l_fill_2
XFILLER_96_427 VPWR VGND sg13cmos5l_fill_2
XFILLER_69_619 VPWR VGND sg13cmos5l_fill_2
XFILLER_68_107 VPWR VGND sg13cmos5l_decap_4
X_11106_ _11106_/Y _11107_/B _11102_/X _11105_/Y VPWR VGND sg13cmos5l_a21oi_1
X_19751_ _19751_/Q _19756_/CLK _19751_/D _19751_/RESET_B VPWR VGND sg13cmos5l_dfrbpq_1
X_12086_ _12096_/B _18804_/Q _18806_/Q _18805_/Q _12086_/D VPWR VGND sg13cmos5l_nor4_1
X_16963_ _17060_/A _19546_/Q _17058_/B _16961_/A _16962_/Y VPWR VGND sg13cmos5l_a22oi_1
X_18702_ _18702_/Q clkload56/A _18702_/D _18702_/RESET_B VPWR VGND sg13cmos5l_dfrbpq_1
Xclkbuf_leaf_88_clk clkload7/A clkbuf_4_0_0_clk/X VPWR VGND sg13cmos5l_buf_8
X_16894_ _16933_/A _19486_/Q _16908_/D VPWR VGND sg13cmos5l_xor2_1
X_11037_ _11037_/Y _11037_/A _11037_/B VPWR VGND sg13cmos5l_nor2_1
X_19682_ _19682_/Q clkload20/A _19682_/D _19682_/RESET_B VPWR VGND sg13cmos5l_dfrbpq_1
X_15914_ _15915_/C _15914_/A _16107_/A VPWR VGND sg13cmos5l_nor2_1
X_18633_ _18633_/Q clkload47/A _18633_/D _18633_/RESET_B VPWR VGND sg13cmos5l_dfrbpq_1
X_15845_ _19367_/D _16022_/A _15845_/B VPWR VGND sg13cmos5l_nor2_1
X_18564_ _18564_/Q clkload26/A _18564_/D _18564_/RESET_B VPWR VGND sg13cmos5l_dfrbpq_1
X_12988_ _12988_/Y _12988_/A _13010_/A VPWR VGND sg13cmos5l_nand2_1
X_17515_ _17629_/A _17628_/B _17628_/C _17628_/A VPWR VGND sg13cmos5l_a21oi_1
X_15776_ _15777_/A _15779_/C _15775_/Y _15774_/Y VPWR VGND sg13cmos5l_a21o_1
X_11939_ _11941_/B _11938_/C _11937_/Y _11938_/Y VPWR VGND sg13cmos5l_a21o_1
X_18495_ _18514_/C _18498_/C _18495_/B VPWR VGND sg13cmos5l_and2_1
X_14727_ _14727_/Y _14528_/Y _14715_/X _14717_/Y _14572_/A VPWR VGND sg13cmos5l_a22oi_1
X_17446_ _17447_/B _17443_/X _17480_/A _17445_/X _17668_/A VPWR VGND sg13cmos5l_a22oi_1
X_14658_ _14658_/Y _19212_/Q _14679_/A _19149_/Q _15187_/A VPWR VGND sg13cmos5l_a22oi_1
X_13609_ _13609_/Y _19018_/Q _13609_/B _13609_/C VPWR VGND sg13cmos5l_nand3_1
X_17377_ _19594_/D _17377_/A _17377_/B VPWR VGND sg13cmos5l_nor2_1
Xclkbuf_leaf_12_clk clkload34/A clkbuf_4_6_0_clk/X VPWR VGND sg13cmos5l_buf_8
XFILLER_9_450 VPWR VGND sg13cmos5l_fill_1
X_14589_ _14589_/Y _14589_/A _14605_/S VPWR VGND sg13cmos5l_nor2_1
X_16328_ _16339_/B _16324_/Y _16326_/Y _16327_/Y VPWR VGND sg13cmos5l_o21ai_1
X_19116_ _19116_/Q clkload49/A _19116_/D _19116_/RESET_B VPWR VGND sg13cmos5l_dfrbpq_1
X_19047_ _19047_/Q clkload29/A _19047_/D _19047_/RESET_B VPWR VGND sg13cmos5l_dfrbpq_1
X_18945__1318 _18945_/RESET_B VPWR VGND sg13cmos5l_tiehi
X_16259_ _16260_/B _16282_/A _16319_/B _16320_/B _16261_/A VPWR VGND sg13cmos5l_a22oi_1
X_19118__1133 _19118_/RESET_B VPWR VGND sg13cmos5l_tiehi
XFILLER_99_276 VPWR VGND sg13cmos5l_fill_1
XFILLER_101_237 VPWR VGND sg13cmos5l_fill_2
XFILLER_87_449 VPWR VGND sg13cmos5l_fill_1
Xclkbuf_leaf_79_clk _19790_/CLK clkbuf_4_9_0_clk/X VPWR VGND sg13cmos5l_buf_8
XFILLER_96_983 VPWR VGND sg13cmos5l_fill_1
XFILLER_82_198 VPWR VGND sg13cmos5l_fill_1
XFILLER_23_210 VPWR VGND sg13cmos5l_fill_2
XFILLER_51_574 VPWR VGND sg13cmos5l_fill_1
XFILLER_12_917 VPWR VGND sg13cmos5l_fill_2
XFILLER_87_1028 VPWR VGND sg13cmos5l_fill_1
X_19489__453 _19489_/D VPWR VGND sg13cmos5l_tielo
X_10270_ _12787_/A _18898_/Q VPWR VGND sg13cmos5l_inv_1
XFILLER_3_637 VPWR VGND sg13cmos5l_fill_2
XFILLER_2_147 VPWR VGND sg13cmos5l_fill_1
XFILLER_105_598 VPWR VGND sg13cmos5l_fill_1
XFILLER_48_76 VPWR VGND sg13cmos5l_fill_2
X_13960_ _13960_/Y _13960_/A VPWR VGND sg13cmos5l_inv_1
XFILLER_101_771 VPWR VGND sg13cmos5l_fill_2
XFILLER_86_471 VPWR VGND sg13cmos5l_fill_2
X_12911_ _12918_/B _18917_/Q _12912_/B VPWR VGND sg13cmos5l_nor2b_1
XFILLER_74_644 VPWR VGND sg13cmos5l_fill_2
X_13891_ _13891_/X _13891_/A _13891_/B VPWR VGND sg13cmos5l_and2_1
X_15630_ _15631_/B _19347_/Q _19348_/Q hold2898/X VPWR VGND sg13cmos5l_o21ai_1
X_12842_ _18907_/D _13025_/A _12977_/A VPWR VGND sg13cmos5l_nor2_1
XFILLER_64_31 VPWR VGND sg13cmos5l_fill_1
X_12773_ _12774_/B _12787_/B _12771_/Y _12787_/A VPWR VGND sg13cmos5l_o21ai_1
X_15561_ _15570_/B _15548_/Y _15555_/X _15559_/Y VPWR VGND sg13cmos5l_o21ai_1
X_11724_ _11726_/B _11725_/A _11725_/B VPWR VGND sg13cmos5l_and2_1
XFILLER_70_850 VPWR VGND sg13cmos5l_fill_1
X_17300_ _17304_/D _17284_/A _17284_/B _17299_/Y VPWR VGND sg13cmos5l_o21ai_1
X_18280_ _18280_/Y _18260_/B _18282_/S _18482_/A VPWR VGND sg13cmos5l_o21ai_1
X_14512_ _14616_/B _19177_/Q _14512_/B VPWR VGND sg13cmos5l_and2_1
X_15492_ _15492_/Y _15492_/A _19276_/Q VPWR VGND sg13cmos5l_nor2_1
X_11655_ _11655_/Y _11655_/A _18688_/Q _11661_/C VPWR VGND sg13cmos5l_nor3_1
X_17231_ _17345_/B _19587_/Q _17234_/B VPWR VGND sg13cmos5l_and2_1
X_14443_ _14443_/X _19122_/Q _19115_/Q VPWR VGND sg13cmos5l_or2_1
Xfanout80 fanout80/X fanout81/X VPWR VGND sg13cmos5l_buf_1
Xfanout91 fanout91/X fanout92/X VPWR VGND sg13cmos5l_buf_1
X_17162_ _17168_/C _19527_/Q _19528_/Q _19525_/Q _19526_/Q VPWR VGND sg13cmos5l_nor4_1
X_11586_ _11586_/Y _11586_/A _11578_/X VPWR VGND sg13cmos5l_nor2b_1
XFILLER_7_932 VPWR VGND sg13cmos5l_fill_2
X_14374_ _19139_/D _14374_/A _14374_/B VPWR VGND sg13cmos5l_and2_1
X_10606_ _10607_/C _10606_/A _10606_/B VPWR VGND sg13cmos5l_nor2_1
X_17093_ _17093_/Y _17667_/A _19512_/Q _17092_/Y VPWR VGND sg13cmos5l_o21ai_1
X_13325_ _13326_/A _13329_/C _13324_/Y _13323_/Y VPWR VGND sg13cmos5l_a21o_1
XFILLER_7_976 VPWR VGND sg13cmos5l_fill_2
XFILLER_7_965 VPWR VGND sg13cmos5l_decap_8
X_16113_ _16117_/A _16103_/Y _16108_/Y _16136_/B _16116_/A _16110_/Y VPWR VGND sg13cmos5l_a221oi_1
X_10537_ _10537_/X _19802_/Q _10538_/B VPWR VGND sg13cmos5l_xor2_1
X_13256_ _13256_/Y _13237_/A _13237_/B _13249_/X _13254_/Y _13255_/Y VPWR VGND sg13cmos5l_a221oi_1
X_10468_ _10606_/A _10610_/A _10468_/B VPWR VGND sg13cmos5l_nor2_1
X_16044_ _16044_/Y _16033_/B _16042_/Y _16043_/Y _16052_/C VPWR VGND sg13cmos5l_a22oi_1
X_12207_ _12207_/Y _12727_/A _18770_/Q _12206_/Y VPWR VGND sg13cmos5l_o21ai_1
XFILLER_6_497 VPWR VGND sg13cmos5l_decap_8
X_19106__1148 _19106_/RESET_B VPWR VGND sg13cmos5l_tiehi
X_10399_ _10400_/B _10680_/D VPWR VGND sg13cmos5l_inv_1
XFILLER_69_427 VPWR VGND sg13cmos5l_fill_2
X_13187_ _13187_/X _13119_/X _13292_/B _13186_/Y VPWR VGND sg13cmos5l_a21o_1
X_12138_ _12201_/B _12138_/A _12139_/B VPWR VGND sg13cmos5l_nor2b_1
XFILLER_96_213 VPWR VGND sg13cmos5l_fill_1
X_17995_ _17995_/Y _18243_/B _17995_/B VPWR VGND sg13cmos5l_nand2_1
X_19803_ _19803_/Q _19805_/CLK _19803_/D _19803_/RESET_B VPWR VGND sg13cmos5l_dfrbpq_1
X_12069_ _12069_/Y _12086_/D _12069_/B _12267_/A VPWR VGND sg13cmos5l_nand3_1
X_16946_ _16946_/Y _19520_/Q _19481_/Q VPWR VGND sg13cmos5l_xnor2_1
X_19734_ _19734_/Q clkload20/A _19734_/D _19734_/RESET_B VPWR VGND sg13cmos5l_dfrbpq_1
Xclkbuf_leaf_1_clk clkload6/A clkbuf_4_0_0_clk/X VPWR VGND sg13cmos5l_buf_8
X_19665_ _19665_/Q clkload35/A _19665_/D _19665_/RESET_B VPWR VGND sg13cmos5l_dfrbpq_1
X_16877_ _16877_/Y _16857_/A fanout29/X _17079_/B VPWR VGND sg13cmos5l_o21ai_1
X_18616_ _18616_/Q clkload45/A _18616_/D _18616_/RESET_B VPWR VGND sg13cmos5l_dfrbpq_1
XFILLER_38_858 VPWR VGND sg13cmos5l_fill_1
XFILLER_92_485 VPWR VGND sg13cmos5l_fill_2
X_19596_ _19596_/Q clkload12/A _19596_/D _19596_/RESET_B VPWR VGND sg13cmos5l_dfrbpq_1
XFILLER_46_880 VPWR VGND sg13cmos5l_fill_1
X_15828_ _15835_/B _19330_/Q _19329_/Q _19328_/Q _15828_/D VPWR VGND sg13cmos5l_nor4_1
X_15759_ _15759_/Y _15759_/A _15769_/B VPWR VGND sg13cmos5l_nand2_1
X_18547_ _19782_/D _18547_/A _18547_/B VPWR VGND sg13cmos5l_nor2_1
X_18659__1634 _18659_/RESET_B VPWR VGND sg13cmos5l_tiehi
X_18478_ _19757_/D _18483_/A _18478_/B VPWR VGND sg13cmos5l_nor2_1
XFILLER_33_552 VPWR VGND sg13cmos5l_fill_2
XFILLER_61_883 VPWR VGND sg13cmos5l_fill_2
X_17429_ _17429_/Y _17693_/B _17429_/B VPWR VGND sg13cmos5l_nand2_1
X_18898__509 _18898_/D VPWR VGND sg13cmos5l_tielo
Xclkload61 clkload61/Y clkload61/A VPWR VGND sg13cmos5l_inv_1
Xclkload50 clkload50/Y clkload50/A VPWR VGND sg13cmos5l_inv_1
XFILLER_102_513 VPWR VGND sg13cmos5l_fill_1
X_18909__1357 _18909_/RESET_B VPWR VGND sg13cmos5l_tiehi
XFILLER_102_535 VPWR VGND sg13cmos5l_decap_4
Xhold2801 _12636_/A _18890_/Q VPWR VGND sg13cmos5l_dlygate4sd3_1
Xhold2812 hold2812/X _11876_/A VPWR VGND sg13cmos5l_dlygate4sd3_1
Xhold2823 _15939_/A _19389_/Q VPWR VGND sg13cmos5l_dlygate4sd3_1
XFILLER_102_568 VPWR VGND sg13cmos5l_fill_1
Xhold2856 _18788_/D _12181_/Y VPWR VGND sg13cmos5l_dlygate4sd3_1
Xhold2845 _19537_/D _17077_/Y VPWR VGND sg13cmos5l_dlygate4sd3_1
Xhold2834 _13967_/A _19098_/Q VPWR VGND sg13cmos5l_dlygate4sd3_1
Xhold2889 _13245_/A _18962_/Q VPWR VGND sg13cmos5l_dlygate4sd3_1
Xhold2867 _13485_/A _19016_/Q VPWR VGND sg13cmos5l_dlygate4sd3_1
Xhold2878 hold2878/X _19375_/Q VPWR VGND sg13cmos5l_dlygate4sd3_1
XFILLER_18_46 VPWR VGND sg13cmos5l_fill_2
X_18812__1463 _18812_/RESET_B VPWR VGND sg13cmos5l_tiehi
XFILLER_83_474 VPWR VGND sg13cmos5l_fill_1
XFILLER_16_519 VPWR VGND sg13cmos5l_decap_4
XFILLER_54_1027 VPWR VGND sg13cmos5l_fill_2
XFILLER_34_67 VPWR VGND sg13cmos5l_fill_1
X_19182__1066 _19182_/RESET_B VPWR VGND sg13cmos5l_tiehi
XFILLER_8_718 VPWR VGND sg13cmos5l_decap_8
XFILLER_8_729 VPWR VGND sg13cmos5l_fill_1
X_11440_ _11440_/Y _11261_/Y _11469_/A _11434_/Y VPWR VGND sg13cmos5l_o21ai_1
Xclkload0 clkload0/X clkload0/A VPWR VGND sg13cmos5l_buf_8
X_11371_ _11371_/Y _11897_/A _18644_/Q _11369_/Y _11370_/Y VPWR VGND sg13cmos5l_a22oi_1
X_13110_ _13136_/B _18911_/Q _13110_/B VPWR VGND sg13cmos5l_xnor2_1
X_10322_ _10322_/Y _10322_/A VPWR VGND sg13cmos5l_inv_1
X_14090_ _14090_/Y _19125_/Q _14108_/A _14114_/B _19126_/Q _14089_/Y VPWR VGND sg13cmos5l_a221oi_1
X_13041_ _13041_/Y _13041_/A _18898_/Q _13056_/C VPWR VGND sg13cmos5l_nor3_1
XFILLER_4_968 VPWR VGND sg13cmos5l_fill_1
X_10253_ _10253_/Y _13842_/A VPWR VGND sg13cmos5l_inv_1
XFILLER_106_896 VPWR VGND sg13cmos5l_fill_2
XFILLER_59_64 VPWR VGND sg13cmos5l_decap_8
X_10184_ _18472_/A _10184_/A VPWR VGND sg13cmos5l_inv_1
X_16800_ _16800_/X _16800_/A _16800_/B VPWR VGND sg13cmos5l_and2_1
XFILLER_94_728 VPWR VGND sg13cmos5l_fill_2
X_17780_ _17780_/Y _17780_/A _17780_/B VPWR VGND sg13cmos5l_nor2_1
X_16731_ _16731_/Y _16728_/Y _16730_/Y _16707_/Y VPWR VGND sg13cmos5l_a21oi_1
Xfanout292 _13019_/B _13028_/A VPWR VGND sg13cmos5l_buf_1
Xfanout281 _13585_/A _13586_/A VPWR VGND sg13cmos5l_buf_1
Xfanout270 _14080_/A _14083_/A VPWR VGND sg13cmos5l_buf_1
X_14992_ _15011_/A _19199_/Q _19200_/Q VPWR VGND sg13cmos5l_xor2_1
X_19732__1187 _19732_/RESET_B VPWR VGND sg13cmos5l_tiehi
X_13943_ _14051_/A _19092_/Q _14050_/B _13942_/Y VPWR VGND sg13cmos5l_a21oi_1
XFILLER_47_655 VPWR VGND sg13cmos5l_decap_4
X_16662_ _16663_/B _13707_/X _16650_/X _16661_/Y VPWR VGND sg13cmos5l_a21oi_1
XFILLER_47_677 VPWR VGND sg13cmos5l_fill_2
X_13874_ _19068_/D _09997_/Y fanout74/X _13873_/Y VPWR VGND sg13cmos5l_a21oi_1
X_19450_ _19450_/Q _19679_/CLK _19450_/D _19450_/RESET_B VPWR VGND sg13cmos5l_dfrbpq_1
X_16593_ _16593_/Y _19024_/Q _16593_/B _16593_/C VPWR VGND sg13cmos5l_nor3_1
X_12825_ _12833_/C _12825_/A _12827_/B VPWR VGND sg13cmos5l_nand2_1
X_15613_ _15623_/B _19335_/Q _19336_/Q _19333_/Q _19334_/Q VPWR VGND sg13cmos5l_nor4_1
X_19381_ _19381_/Q _19738_/CLK _19381_/D _19381_/RESET_B VPWR VGND sg13cmos5l_dfrbpq_1
XFILLER_28_891 VPWR VGND sg13cmos5l_fill_1
X_18401_ _18479_/B _10511_/A _18402_/S _18399_/Y VPWR VGND sg13cmos5l_a21o_1
XFILLER_91_51 VPWR VGND sg13cmos5l_fill_1
X_15544_ _15544_/X _15544_/A _15578_/A VPWR VGND sg13cmos5l_and2_1
X_18332_ _18334_/B _18340_/B _18330_/Y _18331_/Y VPWR VGND sg13cmos5l_a21oi_1
X_12756_ _12757_/B _12767_/C _12755_/Y _12754_/Y VPWR VGND sg13cmos5l_o21ai_1
XFILLER_42_360 VPWR VGND sg13cmos5l_fill_2
X_12687_ _12687_/X _12603_/Y _12686_/Y _12684_/Y VPWR VGND sg13cmos5l_a21o_1
X_11707_ _11707_/Y _11703_/Y _11704_/Y _11706_/Y VPWR VGND sg13cmos5l_o21ai_1
X_18263_ _18263_/Y _19686_/Q _18263_/B VPWR VGND sg13cmos5l_nor2_1
X_15475_ _15475_/Y _19338_/Q _15482_/B _19275_/Q _16015_/A VPWR VGND sg13cmos5l_a22oi_1
X_11638_ _11638_/Y _18747_/Q _11655_/A _11661_/B _18748_/Q VPWR VGND sg13cmos5l_a22oi_1
X_17214_ _17214_/Y _17212_/Y _17213_/Y _17211_/Y VPWR VGND sg13cmos5l_a21oi_1
X_18647__1649 _18647_/RESET_B VPWR VGND sg13cmos5l_tiehi
X_18194_ _18204_/A _18081_/Y _18202_/A _18194_/C VPWR VGND sg13cmos5l_nand3b_1
X_19158__1090 _19158_/RESET_B VPWR VGND sg13cmos5l_tiehi
X_14426_ _14426_/Y _14410_/A _14424_/S _14637_/B VPWR VGND sg13cmos5l_o21ai_1
XFILLER_30_599 VPWR VGND sg13cmos5l_fill_1
X_17145_ _17145_/Y _09975_/Y fanout69/X _17144_/Y VPWR VGND sg13cmos5l_a21oi_1
X_14357_ _19124_/D hold2774/X _14349_/X _14356_/Y VPWR VGND sg13cmos5l_a21oi_1
X_11569_ _11569_/Y _11477_/B _11630_/B _11568_/Y VPWR VGND sg13cmos5l_o21ai_1
X_13308_ _13308_/Y _13308_/A _13318_/B VPWR VGND sg13cmos5l_nand2_1
X_17076_ _17076_/Y _17064_/A _17065_/Y _16939_/A VPWR VGND sg13cmos5l_o21ai_1
XFILLER_6_272 VPWR VGND sg13cmos5l_fill_1
X_14288_ _14288_/Y _14288_/A _14288_/B _14288_/C _14288_/D VPWR VGND sg13cmos5l_nand4_1
X_13239_ _13239_/X _13239_/A _13239_/B VPWR VGND sg13cmos5l_xor2_1
X_16027_ _16027_/Y _16552_/A _19356_/Q _19355_/Q _16551_/A _16025_/Y VPWR VGND sg13cmos5l_a221oi_1
Xhold2108 _10041_/A _18791_/Q VPWR VGND sg13cmos5l_dlygate4sd3_1
Xhold2119 _10067_/A _18958_/Q VPWR VGND sg13cmos5l_dlygate4sd3_1
X_17978_ _17978_/Y _18257_/A _17972_/B _17977_/A _18263_/B _17973_/Y VPWR VGND sg13cmos5l_a221oi_1
XFILLER_38_600 VPWR VGND sg13cmos5l_fill_2
X_16929_ _16931_/B _17013_/A _17013_/B VPWR VGND sg13cmos5l_and2_1
X_19717_ _19717_/Q clkload10/A _19717_/D _19717_/RESET_B VPWR VGND sg13cmos5l_dfrbpq_1
X_19696__1735 _19696_/RESET_B VPWR VGND sg13cmos5l_tiehi
XFILLER_66_975 VPWR VGND sg13cmos5l_decap_4
X_19648_ _19648_/Q _19756_/CLK _19648_/D _19648_/RESET_B VPWR VGND sg13cmos5l_dfrbpq_1
XFILLER_37_165 VPWR VGND sg13cmos5l_decap_8
XFILLER_80_411 VPWR VGND sg13cmos5l_fill_2
XFILLER_65_485 VPWR VGND sg13cmos5l_fill_1
X_19579_ _19579_/Q clkload34/A _19579_/D _19579_/RESET_B VPWR VGND sg13cmos5l_dfrbpq_1
XFILLER_52_135 VPWR VGND sg13cmos5l_fill_1
XFILLER_33_382 VPWR VGND sg13cmos5l_decap_4
XFILLER_102_354 VPWR VGND sg13cmos5l_fill_1
Xhold2620 _10302_/A _18686_/Q VPWR VGND sg13cmos5l_dlygate4sd3_1
Xhold2631 _13450_/A _19004_/Q VPWR VGND sg13cmos5l_dlygate4sd3_1
XFILLER_102_365 VPWR VGND sg13cmos5l_fill_1
Xhold2642 _10319_/A _19767_/Q VPWR VGND sg13cmos5l_dlygate4sd3_1
Xhold2653 _18088_/A _19708_/Q VPWR VGND sg13cmos5l_dlygate4sd3_1
Xhold2664 _10089_/A _19086_/Q VPWR VGND sg13cmos5l_dlygate4sd3_1
Xhold1930 _10418_/A _19807_/Q VPWR VGND sg13cmos5l_dlygate4sd3_1
Xhold1952 _19561_/D _17145_/Y VPWR VGND sg13cmos5l_dlygate4sd3_1
Xhold2686 hold2686/X _18675_/Q VPWR VGND sg13cmos5l_dlygate4sd3_1
Xhold1941 _19687_/D _17998_/Y VPWR VGND sg13cmos5l_dlygate4sd3_1
Xhold2697 _10331_/A _19790_/Q VPWR VGND sg13cmos5l_dlygate4sd3_1
Xhold2675 _10184_/A _19701_/Q VPWR VGND sg13cmos5l_dlygate4sd3_1
XFILLER_29_633 VPWR VGND sg13cmos5l_fill_2
XFILLER_29_644 VPWR VGND sg13cmos5l_fill_1
Xhold1963 _19193_/D _14703_/Y VPWR VGND sg13cmos5l_dlygate4sd3_1
Xhold1974 _10005_/A _18859_/Q VPWR VGND sg13cmos5l_dlygate4sd3_1
Xhold1985 _18857_/D _12522_/Y VPWR VGND sg13cmos5l_dlygate4sd3_1
Xhold1996 _18985_/D _13356_/Y VPWR VGND sg13cmos5l_dlygate4sd3_1
XFILLER_71_400 VPWR VGND sg13cmos5l_fill_1
X_10940_ _10940_/Y _18634_/Q _18633_/Q _18618_/Q VPWR VGND sg13cmos5l_nand3b_1
XFILLER_45_11 VPWR VGND sg13cmos5l_decap_4
XFILLER_44_625 VPWR VGND sg13cmos5l_decap_4
XFILLER_43_124 VPWR VGND sg13cmos5l_fill_2
X_12610_ _12651_/A _18872_/Q _12625_/D VPWR VGND sg13cmos5l_xnor2_1
X_10871_ _10871_/Y _11107_/B _10871_/B VPWR VGND sg13cmos5l_nand2_1
X_13590_ _13590_/Y _16818_/A _18571_/Q VPWR VGND sg13cmos5l_nor2_1
X_12541_ _12541_/Y _12546_/B _12546_/C _12546_/A VPWR VGND sg13cmos5l_a21oi_1
XFILLER_52_691 VPWR VGND sg13cmos5l_decap_8
X_12472_ _12472_/Y _18873_/Q _18811_/Q VPWR VGND sg13cmos5l_nand2b_1
X_15260_ _15277_/B _19245_/Q _15262_/B VPWR VGND sg13cmos5l_nor2b_1
XFILLER_8_526 VPWR VGND sg13cmos5l_decap_4
X_11423_ _18693_/D _11423_/A _11423_/B VPWR VGND sg13cmos5l_and2_1
X_14211_ _14227_/A _14211_/A _14229_/B VPWR VGND sg13cmos5l_nor2_1
X_15191_ _19265_/D _15191_/A _15191_/B VPWR VGND sg13cmos5l_nor2_1
X_11354_ _18671_/D _11354_/A _11355_/B VPWR VGND sg13cmos5l_nor2_1
X_14142_ _19111_/D _09996_/Y fanout91/X _14141_/Y VPWR VGND sg13cmos5l_a21oi_1
X_10305_ _10305_/Y _11378_/A VPWR VGND sg13cmos5l_inv_1
X_18950_ _18950_/Q _18975_/CLK _18950_/D _18950_/RESET_B VPWR VGND sg13cmos5l_dfrbpq_1
X_11285_ _11285_/Y _11452_/A _11434_/A VPWR VGND sg13cmos5l_nand2_1
X_14073_ _19090_/D _14073_/A _14076_/B VPWR VGND sg13cmos5l_nor2_1
XFILLER_4_765 VPWR VGND sg13cmos5l_decap_4
X_18881_ _18881_/Q clkload69/A _18881_/D _18881_/RESET_B VPWR VGND sg13cmos5l_dfrbpq_1
X_13024_ _18928_/D _13027_/A _13024_/B VPWR VGND sg13cmos5l_nor2_1
X_17901_ _17901_/Y _17884_/A _17884_/B _17894_/X _17899_/Y _17900_/Y VPWR VGND sg13cmos5l_a221oi_1
XFILLER_3_286 VPWR VGND sg13cmos5l_fill_1
X_10236_ _10236_/Y _14664_/A VPWR VGND sg13cmos5l_inv_1
X_17832_ _17832_/Y _18222_/A _17830_/X _17831_/Y _17829_/X VPWR VGND sg13cmos5l_a22oi_1
XFILLER_66_205 VPWR VGND sg13cmos5l_fill_1
X_19580__444 _19580_/D VPWR VGND sg13cmos5l_tielo
X_10167_ _17933_/A _10167_/A VPWR VGND sg13cmos5l_inv_1
X_17763_ _17763_/Y _17766_/A _17780_/B VPWR VGND sg13cmos5l_nand2_1
X_10098_ _14906_/A _10098_/A VPWR VGND sg13cmos5l_inv_1
X_14975_ _14975_/Y _09990_/Y fanout72/X _14974_/Y VPWR VGND sg13cmos5l_a21oi_1
X_19502_ _19502_/Q clkload32/A _19502_/D _19502_/RESET_B VPWR VGND sg13cmos5l_dfrbpq_1
X_16714_ _16714_/Y _16714_/A VPWR VGND sg13cmos5l_inv_1
X_13926_ _13927_/A _13482_/Y _13907_/A _13902_/B hold2814/X VPWR VGND sg13cmos5l_a22oi_1
X_17694_ _17694_/Y _19660_/Q _18227_/A VPWR VGND sg13cmos5l_nand2_1
XFILLER_35_603 VPWR VGND sg13cmos5l_decap_8
X_16645_ _16650_/A _13688_/A _16629_/Y _16632_/Y _16644_/Y VPWR VGND sg13cmos5l_a22oi_1
X_18699__1591 _18699_/RESET_B VPWR VGND sg13cmos5l_tiehi
X_19433_ _19433_/Q clkload9/A _19433_/D _19433_/RESET_B VPWR VGND sg13cmos5l_dfrbpq_1
XFILLER_34_124 VPWR VGND sg13cmos5l_fill_2
X_18561__1750 _18561_/RESET_B VPWR VGND sg13cmos5l_tiehi
X_13857_ _13857_/Y _15234_/A _14364_/B VPWR VGND sg13cmos5l_nor2_1
XFILLER_34_157 VPWR VGND sg13cmos5l_decap_8
X_13788_ _13788_/Y _13782_/A _13802_/A _13787_/Y VPWR VGND sg13cmos5l_o21ai_1
X_12808_ _12808_/Y _12651_/A _12839_/A _12806_/X _12832_/A _12805_/Y VPWR VGND sg13cmos5l_a221oi_1
X_16576_ _16577_/A _19024_/Q _16573_/Y _16575_/Y VPWR VGND sg13cmos5l_o21ai_1
X_19364_ _19364_/Q clkload10/A _19364_/D _19364_/RESET_B VPWR VGND sg13cmos5l_dfrbpq_1
XFILLER_96_4 VPWR VGND sg13cmos5l_fill_1
X_12739_ _12739_/Y _13287_/A _18852_/Q VPWR VGND sg13cmos5l_nor2_1
X_19295_ _19295_/Q clkload16/A _19295_/D _19295_/RESET_B VPWR VGND sg13cmos5l_dfrbpq_1
X_15527_ _19323_/D _15528_/A _15527_/B VPWR VGND sg13cmos5l_and2_1
XFILLER_30_330 VPWR VGND sg13cmos5l_fill_2
X_18315_ _18315_/Y _18315_/A _18315_/B VPWR VGND sg13cmos5l_nor2_1
X_18246_ _18246_/Y _19744_/Q _18246_/B VPWR VGND sg13cmos5l_nand2_1
X_15458_ _19302_/D _15458_/A _15458_/B VPWR VGND sg13cmos5l_nor2_1
X_14409_ _14410_/A _14408_/C _14407_/Y _14408_/Y VPWR VGND sg13cmos5l_a21o_1
X_18177_ _18178_/A _18202_/A _18177_/B VPWR VGND sg13cmos5l_nand2_1
X_15389_ _15389_/X _15389_/A _15389_/B _15389_/C VPWR VGND sg13cmos5l_and3_1
X_17128_ _17129_/B _19559_/Q _17126_/Y _17392_/B VPWR VGND sg13cmos5l_o21ai_1
X_17059_ _17059_/Y _17059_/A _17059_/B VPWR VGND sg13cmos5l_xnor2_1
XFILLER_103_118 VPWR VGND sg13cmos5l_fill_1
XFILLER_100_814 VPWR VGND sg13cmos5l_fill_2
XFILLER_85_514 VPWR VGND sg13cmos5l_fill_2
X_19716__1459 _19716_/RESET_B VPWR VGND sg13cmos5l_tiehi
XFILLER_38_441 VPWR VGND sg13cmos5l_fill_1
X_19801__1755 _19801_/RESET_B VPWR VGND sg13cmos5l_tiehi
XFILLER_40_116 VPWR VGND sg13cmos5l_fill_2
XFILLER_40_105 VPWR VGND sg13cmos5l_fill_2
XFILLER_34_680 VPWR VGND sg13cmos5l_fill_1
X_19101__1153 _19101_/RESET_B VPWR VGND sg13cmos5l_tiehi
XFILLER_22_897 VPWR VGND sg13cmos5l_fill_1
XFILLER_31_57 VPWR VGND sg13cmos5l_fill_2
Xoutput13 uo_out[0] _19438_/Q VPWR VGND sg13cmos5l_buf_1
X_11070_ _18620_/D _11091_/A _11070_/B VPWR VGND sg13cmos5l_nor2_1
XFILLER_88_352 VPWR VGND sg13cmos5l_fill_2
X_10021_ _11356_/A _10021_/A VPWR VGND sg13cmos5l_inv_1
X_18958__1305 _18958_/RESET_B VPWR VGND sg13cmos5l_tiehi
XFILLER_102_184 VPWR VGND sg13cmos5l_fill_2
Xhold2450 _10087_/A _19082_/Q VPWR VGND sg13cmos5l_dlygate4sd3_1
Xhold2461 _10185_/A _19705_/Q VPWR VGND sg13cmos5l_dlygate4sd3_1
Xhold2472 _14365_/A _19080_/Q VPWR VGND sg13cmos5l_dlygate4sd3_1
Xhold2483 _10079_/A _19041_/Q VPWR VGND sg13cmos5l_dlygate4sd3_1
XFILLER_56_65 VPWR VGND sg13cmos5l_fill_1
X_14760_ _14760_/Y _19195_/Q _14760_/B VPWR VGND sg13cmos5l_nand2_1
Xhold2494 _15509_/B _15508_/X VPWR VGND sg13cmos5l_dlygate4sd3_1
X_11972_ _11972_/Y _12190_/A _11969_/X _12005_/A _11971_/X VPWR VGND sg13cmos5l_a22oi_1
X_13711_ _13816_/B _13716_/B _13716_/C VPWR VGND sg13cmos5l_and2_1
X_10923_ _10926_/A _10917_/B _10923_/B VPWR VGND sg13cmos5l_nand2b_1
X_14691_ _19186_/D _14902_/A _14691_/B VPWR VGND sg13cmos5l_nor2_1
X_19128__487 _19128_/D VPWR VGND sg13cmos5l_tielo
X_13642_ _13642_/Y _19027_/Q fanout86/X _16624_/A VPWR VGND sg13cmos5l_o21ai_1
XFILLER_72_797 VPWR VGND sg13cmos5l_fill_2
XFILLER_72_53 VPWR VGND sg13cmos5l_fill_1
X_10854_ _10854_/Y _10854_/A _10854_/B VPWR VGND sg13cmos5l_nand2_1
X_16430_ _16437_/B _19413_/Q _16431_/B VPWR VGND sg13cmos5l_nor2b_1
XFILLER_72_75 VPWR VGND sg13cmos5l_fill_1
X_13573_ _19003_/D _13573_/A _13573_/B VPWR VGND sg13cmos5l_and2_1
X_16361_ _16361_/Y _16555_/B _16361_/B VPWR VGND sg13cmos5l_nor2_1
X_10785_ _13705_/A _13647_/A _10804_/A VPWR VGND sg13cmos5l_and2_1
X_12524_ _18858_/D _10006_/Y fanout77/X _12523_/Y VPWR VGND sg13cmos5l_a21oi_1
X_19080_ _19080_/Q clkload53/A _19080_/D _19080_/RESET_B VPWR VGND sg13cmos5l_dfrbpq_1
X_18100_ _18107_/B _19703_/Q _19702_/Q _19701_/Q VPWR VGND sg13cmos5l_nor3_1
X_15312_ _15312_/Y _15313_/A _15433_/B VPWR VGND sg13cmos5l_nor2_1
X_18904__1362 _18904_/RESET_B VPWR VGND sg13cmos5l_tiehi
X_18031_ _18031_/X _18032_/A _18032_/B _18029_/Y VPWR VGND sg13cmos5l_a21o_1
X_16292_ _16292_/Y _16293_/A _16293_/B _16291_/Y VPWR VGND sg13cmos5l_a21oi_1
X_12455_ _18835_/D _12527_/A _12455_/B VPWR VGND sg13cmos5l_and2_1
X_15243_ _15243_/Y _15223_/A _15238_/B _15465_/A VPWR VGND sg13cmos5l_o21ai_1
X_12386_ _12391_/A _18838_/Q _12414_/B VPWR VGND sg13cmos5l_and2_1
X_11406_ _11407_/B _11381_/Y _10299_/Y _11412_/S VPWR VGND sg13cmos5l_mux2_1
X_15174_ _19250_/D _15191_/A _15174_/B VPWR VGND sg13cmos5l_nor2_1
X_11337_ _11337_/Y _11232_/A _11232_/B _11328_/Y _11335_/Y _11336_/X VPWR VGND sg13cmos5l_a221oi_1
X_14125_ _14125_/Y _14106_/B _14131_/S _14375_/A VPWR VGND sg13cmos5l_o21ai_1
X_18579__1721 _18579_/RESET_B VPWR VGND sg13cmos5l_tiehi
X_18933_ _18933_/Q _18975_/CLK _18933_/D _18933_/RESET_B VPWR VGND sg13cmos5l_dfrbpq_1
X_11268_ _11273_/B _18679_/Q _18680_/Q _18678_/Q _11268_/D VPWR VGND sg13cmos5l_nor4_1
X_14056_ _14056_/X _14056_/A _14056_/B VPWR VGND sg13cmos5l_and2_1
X_18864_ _18864_/Q clkload71/A _18864_/D _18864_/RESET_B VPWR VGND sg13cmos5l_dfrbpq_1
X_13007_ _13009_/B _13007_/A _12981_/A VPWR VGND sg13cmos5l_nor2b_1
X_11199_ _11199_/Y _11199_/A _11199_/B VPWR VGND sg13cmos5l_nand2_1
X_10219_ _15218_/A _15477_/A VPWR VGND sg13cmos5l_inv_1
X_18795_ _18795_/Q clkload60/A _18795_/D _18795_/RESET_B VPWR VGND sg13cmos5l_dfrbpq_1
X_17815_ _17815_/Y _19678_/Q _17815_/B VPWR VGND sg13cmos5l_xnor2_1
X_17746_ _17774_/A _17757_/D _17746_/B VPWR VGND sg13cmos5l_and2_1
X_14958_ _14958_/X _14931_/Y _10225_/Y _14958_/S VPWR VGND sg13cmos5l_mux2_1
XFILLER_63_764 VPWR VGND sg13cmos5l_fill_1
X_17677_ _19634_/D _17677_/A _17677_/B VPWR VGND sg13cmos5l_and2_1
X_13909_ _13909_/Y _13909_/A _13923_/B VPWR VGND sg13cmos5l_nor2_1
X_14889_ _14889_/Y _14889_/A _14889_/B VPWR VGND sg13cmos5l_nor2_1
XFILLER_35_444 VPWR VGND sg13cmos5l_fill_2
X_16628_ _16646_/B _19036_/Q _19035_/Q _19034_/Q _16641_/B VPWR VGND sg13cmos5l_nor4_1
X_19416_ _19416_/Q clkload8/A _19416_/D _19416_/RESET_B VPWR VGND sg13cmos5l_dfrbpq_1
X_19347_ _19347_/Q clkload17/A _19347_/D _19347_/RESET_B VPWR VGND sg13cmos5l_dfrbpq_1
X_16559_ _16559_/Y hold2734/X _16465_/B _16562_/A VPWR VGND sg13cmos5l_a21oi_1
X_19278_ _19278_/Q _19805_/CLK _19278_/D _19278_/RESET_B VPWR VGND sg13cmos5l_dfrbpq_1
X_18229_ _19716_/D _18233_/A _18229_/B VPWR VGND sg13cmos5l_nor2_1
XFILLER_7_92 VPWR VGND sg13cmos5l_decap_8
XFILLER_104_449 VPWR VGND sg13cmos5l_fill_2
Xheichips26_digital_project_1803 uio_oe[6] VPWR VGND sg13cmos5l_tiehi
XFILLER_46_709 VPWR VGND sg13cmos5l_fill_1
X_19602__609 _19602_/RESET_B VPWR VGND sg13cmos5l_tiehi
XFILLER_38_260 VPWR VGND sg13cmos5l_fill_2
X_18642__1654 _18642_/RESET_B VPWR VGND sg13cmos5l_tiehi
XFILLER_27_967 VPWR VGND sg13cmos5l_fill_1
XFILLER_81_561 VPWR VGND sg13cmos5l_fill_1
XFILLER_42_12 VPWR VGND sg13cmos5l_fill_2
XFILLER_22_650 VPWR VGND sg13cmos5l_fill_2
XFILLER_21_171 VPWR VGND sg13cmos5l_fill_1
X_10570_ _10570_/Y _10511_/Y _10512_/Y _10644_/A VPWR VGND sg13cmos5l_a21oi_1
X_12240_ _12240_/Y _12722_/B _12797_/A VPWR VGND sg13cmos5l_nand2b_1
X_19029__1228 _19029_/RESET_B VPWR VGND sg13cmos5l_tiehi
X_19531__449 _19531_/D VPWR VGND sg13cmos5l_tielo
X_12171_ _12174_/B _12171_/A VPWR VGND sg13cmos5l_inv_1
X_11122_ _11122_/Y _18604_/Q _11122_/B VPWR VGND sg13cmos5l_nor2_1
XFILLER_103_460 VPWR VGND sg13cmos5l_fill_1
X_11053_ _11053_/Y _11059_/A _11059_/B VPWR VGND sg13cmos5l_nand2_1
X_15930_ _15952_/A _15939_/B _15939_/C VPWR VGND sg13cmos5l_nand2_1
X_10004_ _10004_/Y _10004_/A VPWR VGND sg13cmos5l_inv_1
X_15861_ _15862_/B _15678_/B _15846_/B _15841_/X _15860_/Y VPWR VGND sg13cmos5l_a22oi_1
XFILLER_97_1008 VPWR VGND sg13cmos5l_fill_1
Xhold2291 _11108_/A _18662_/Q VPWR VGND sg13cmos5l_dlygate4sd3_1
X_17600_ _17600_/X _17755_/A _17766_/A VPWR VGND sg13cmos5l_and2_1
X_14812_ _14822_/B _19226_/Q _14813_/B VPWR VGND sg13cmos5l_nor2b_1
Xhold2280 _15247_/B _19275_/Q VPWR VGND sg13cmos5l_dlygate4sd3_1
X_18580_ _18580_/Q _18594_/CLK _18580_/D _18580_/RESET_B VPWR VGND sg13cmos5l_dfrbpq_1
XFILLER_64_539 VPWR VGND sg13cmos5l_fill_2
XFILLER_64_528 VPWR VGND sg13cmos5l_fill_2
X_15792_ _15792_/Y _15768_/B _15798_/S _15864_/A VPWR VGND sg13cmos5l_o21ai_1
X_11955_ _11955_/Y _12224_/A _11945_/Y _11954_/Y VPWR VGND sg13cmos5l_a21oi_1
X_17531_ _17620_/A _17638_/B _17531_/B VPWR VGND sg13cmos5l_nand2_1
X_14743_ _14743_/X _14743_/A _14743_/B VPWR VGND sg13cmos5l_and2_1
X_17462_ _17499_/A _17462_/A _17463_/B VPWR VGND sg13cmos5l_xnor2_1
X_10906_ _10907_/B _10906_/A _10928_/B VPWR VGND sg13cmos5l_nor2_1
XFILLER_17_466 VPWR VGND sg13cmos5l_fill_1
X_14674_ _14675_/B _15185_/A _15188_/A _14680_/C VPWR VGND sg13cmos5l_nand3_1
X_11886_ _11886_/Y _11846_/B _11890_/S _11904_/A VPWR VGND sg13cmos5l_o21ai_1
X_13625_ _13626_/B _13609_/C _10376_/Y _13632_/S VPWR VGND sg13cmos5l_mux2_1
X_19201_ _19201_/Q clkload51/A _19201_/D _19201_/RESET_B VPWR VGND sg13cmos5l_dfrbpq_1
X_16413_ _16413_/Y _16467_/B _16417_/B VPWR VGND sg13cmos5l_nand2b_1
X_10837_ _10837_/Y _10837_/A VPWR VGND sg13cmos5l_inv_1
X_17393_ _17393_/Y _19617_/Q _17937_/A _17408_/C VPWR VGND sg13cmos5l_nand3_1
XFILLER_41_970 VPWR VGND sg13cmos5l_fill_1
X_19132_ _19132_/Q clkload52/A _19132_/D _19132_/RESET_B VPWR VGND sg13cmos5l_dfrbpq_1
X_10768_ _10768_/Y _13808_/A _10766_/Y _10767_/Y VPWR VGND sg13cmos5l_a21oi_1
X_13556_ _13559_/B _13556_/A VPWR VGND sg13cmos5l_inv_1
XFILLER_8_120 VPWR VGND sg13cmos5l_fill_2
X_16344_ _16344_/Y _16344_/A _19402_/Q VPWR VGND sg13cmos5l_nor2_1
X_12507_ _12734_/A _13337_/A _13015_/B VPWR VGND sg13cmos5l_nor2_1
X_13487_ _13907_/A _19002_/Q _13488_/B VPWR VGND sg13cmos5l_xnor2_1
X_16275_ _16276_/B _16317_/B _16133_/Y _16282_/B VPWR VGND sg13cmos5l_mux2_1
XFILLER_9_665 VPWR VGND sg13cmos5l_fill_2
X_19063_ _19063_/Q _19136_/CLK _19063_/D _19063_/RESET_B VPWR VGND sg13cmos5l_dfrbpq_1
X_12438_ _12438_/Y _12440_/A _12453_/B _12437_/Y VPWR VGND sg13cmos5l_a21oi_1
X_10699_ _10778_/B _13811_/A _10774_/B VPWR VGND sg13cmos5l_nor2b_1
XFILLER_8_197 VPWR VGND sg13cmos5l_fill_1
X_15226_ _15226_/Y _15740_/A _19296_/Q VPWR VGND sg13cmos5l_nor2_1
X_18014_ _18014_/Y _19651_/Q _19652_/Q VPWR VGND sg13cmos5l_xnor2_1
XFILLER_59_4 VPWR VGND sg13cmos5l_fill_1
X_12369_ _12369_/Y _12368_/B _12574_/A _12368_/Y VPWR VGND sg13cmos5l_a21oi_1
X_15157_ _15164_/B _15026_/B _15156_/B _15156_/Y VPWR VGND sg13cmos5l_o21ai_1
X_15088_ _15093_/B _19253_/Q _15089_/B VPWR VGND sg13cmos5l_xnor2_1
X_14108_ _14108_/Y _14108_/A _19066_/Q _14114_/C VPWR VGND sg13cmos5l_nor3_1
XFILLER_86_119 VPWR VGND sg13cmos5l_fill_1
X_18916_ _18916_/Q clkload64/A _18916_/D _18916_/RESET_B VPWR VGND sg13cmos5l_dfrbpq_1
X_14039_ _14041_/B _13919_/B _14080_/B _14045_/S VPWR VGND sg13cmos5l_mux2_1
X_18847_ _18847_/Q clkload70/A _18847_/D _18847_/RESET_B VPWR VGND sg13cmos5l_dfrbpq_1
X_18735__1543 _18735_/RESET_B VPWR VGND sg13cmos5l_tiehi
XFILLER_55_517 VPWR VGND sg13cmos5l_fill_2
X_18778_ _18778_/Q clkload62/A _18778_/D _18778_/RESET_B VPWR VGND sg13cmos5l_dfrbpq_1
X_17729_ _17729_/Y _17962_/B _17729_/B VPWR VGND sg13cmos5l_nand2_1
X_19317__922 _19317_/RESET_B VPWR VGND sg13cmos5l_tiehi
X_18998__1262 _18998_/RESET_B VPWR VGND sg13cmos5l_tiehi
XFILLER_101_953 VPWR VGND sg13cmos5l_decap_8
XFILLER_100_463 VPWR VGND sg13cmos5l_fill_1
XFILLER_46_539 VPWR VGND sg13cmos5l_fill_1
XFILLER_37_56 VPWR VGND sg13cmos5l_decap_4
X_11740_ _11844_/A _11740_/A _11740_/B VPWR VGND sg13cmos5l_nand2_1
X_11671_ _11673_/A _12188_/B _12188_/A VPWR VGND sg13cmos5l_nand2b_1
X_13410_ _13412_/B _13410_/A _13410_/B VPWR VGND sg13cmos5l_and2_1
X_14390_ _14390_/Y _19170_/Q _14904_/A _14408_/C VPWR VGND sg13cmos5l_nor3_1
X_10622_ _10623_/B _10622_/A _10622_/B VPWR VGND sg13cmos5l_xnor2_1
X_13341_ _13341_/Y _13317_/B _13347_/S _13569_/B1 VPWR VGND sg13cmos5l_o21ai_1
X_10553_ _10644_/A _10531_/Y _10520_/Y _10585_/S VPWR VGND sg13cmos5l_mux2_1
X_19101__490 _19101_/D VPWR VGND sg13cmos5l_tielo
X_16060_ _16060_/Y _16060_/A _16060_/B VPWR VGND sg13cmos5l_nor2_1
X_19150__1101 _19150_/RESET_B VPWR VGND sg13cmos5l_tiehi
X_13272_ _13273_/B _13211_/X _13247_/Y _13276_/S VPWR VGND sg13cmos5l_mux2_1
X_10484_ _18387_/A _18264_/A _10484_/B VPWR VGND sg13cmos5l_xnor2_1
X_15011_ _15011_/Y _15011_/A _15011_/B VPWR VGND sg13cmos5l_nor2_1
X_12223_ _12229_/A _12228_/A _12228_/B _12218_/A _10281_/Y _12222_/Y VPWR VGND sg13cmos5l_a221oi_1
X_12154_ _12156_/A _12045_/B _12170_/A _12154_/C VPWR VGND sg13cmos5l_nand3b_1
XFILLER_64_1018 VPWR VGND sg13cmos5l_decap_8
X_11105_ _11105_/Y _11619_/A _18666_/Q _11123_/C VPWR VGND sg13cmos5l_nor3_1
X_19750_ _19750_/Q _19756_/CLK _19750_/D _19750_/RESET_B VPWR VGND sg13cmos5l_dfrbpq_1
X_12085_ _12085_/Y _12130_/A _12281_/B VPWR VGND sg13cmos5l_nand2b_1
X_16962_ _16962_/Y _19545_/Q _16966_/B _16948_/Y VPWR VGND sg13cmos5l_a21oi_1
X_18701_ _18701_/Q clkload59/A _18701_/D _18701_/RESET_B VPWR VGND sg13cmos5l_dfrbpq_1
X_16893_ _16905_/B _19485_/Q _19486_/Q _19483_/Q _19484_/Q VPWR VGND sg13cmos5l_nor4_1
XFILLER_76_141 VPWR VGND sg13cmos5l_fill_1
X_11036_ _11037_/B _11036_/A _11036_/B _11036_/C VPWR VGND sg13cmos5l_and3_1
X_19681_ _19681_/Q clkload20/A _19681_/D _19681_/RESET_B VPWR VGND sg13cmos5l_dfrbpq_1
X_15913_ _16107_/A _16312_/A _15913_/B VPWR VGND sg13cmos5l_xnor2_1
XFILLER_94_51 VPWR VGND sg13cmos5l_fill_2
X_18632_ _18632_/Q _19790_/CLK _18632_/D _18632_/RESET_B VPWR VGND sg13cmos5l_dfrbpq_1
X_15844_ _15845_/B _15844_/A _15844_/B VPWR VGND sg13cmos5l_and2_1
X_18723__1558 _18723_/RESET_B VPWR VGND sg13cmos5l_tiehi
X_18563_ _18563_/Q clkload27/A _18563_/D _18563_/RESET_B VPWR VGND sg13cmos5l_dfrbpq_1
X_15775_ _15775_/Y _16311_/A _19380_/Q VPWR VGND sg13cmos5l_nor2_1
X_12987_ _13010_/A _13027_/B _12986_/B _12986_/Y VPWR VGND sg13cmos5l_o21ai_1
X_17514_ _17628_/C _19605_/Q _19566_/Q _19625_/Q VPWR VGND sg13cmos5l_nand3_1
X_14726_ _14726_/Y _14572_/A _14717_/Y _14725_/Y VPWR VGND sg13cmos5l_o21ai_1
X_11938_ _11938_/Y _12460_/A _18792_/Q _11938_/C VPWR VGND sg13cmos5l_nor3_1
X_18494_ _18495_/B _19728_/Q _18499_/B VPWR VGND sg13cmos5l_nand2_1
X_11869_ _11869_/Y _11876_/A _11876_/B VPWR VGND sg13cmos5l_nand2_1
X_17445_ _17445_/X _19574_/Q _19567_/Q _19568_/Q VPWR VGND sg13cmos5l_or3_1
XFILLER_60_575 VPWR VGND sg13cmos5l_fill_2
X_14657_ _14657_/Y _15186_/A _19148_/Q _14655_/Y _14656_/Y VPWR VGND sg13cmos5l_a22oi_1
X_13608_ _13609_/C _10720_/Y _13598_/B _13616_/S _13607_/Y VPWR VGND sg13cmos5l_a22oi_1
X_17376_ _19593_/D _17377_/A _17376_/B VPWR VGND sg13cmos5l_nor2_1
X_14588_ _14605_/S _14599_/B _14599_/C VPWR VGND sg13cmos5l_nand2_1
XFILLER_14_970 VPWR VGND sg13cmos5l_fill_2
X_13539_ _13540_/C _13539_/A _13539_/B _13539_/C VPWR VGND sg13cmos5l_nand3_1
X_16327_ _16327_/Y _19454_/Q _16073_/A _19401_/Q _16404_/A VPWR VGND sg13cmos5l_a22oi_1
X_19115_ _19115_/Q clkload54/A _19115_/D _19115_/RESET_B VPWR VGND sg13cmos5l_dfrbpq_1
X_19046_ _19046_/Q clkload29/A _19046_/D _19046_/RESET_B VPWR VGND sg13cmos5l_dfrbpq_1
X_18953__1310 _18953_/RESET_B VPWR VGND sg13cmos5l_tiehi
X_16258_ _16258_/Y _16320_/B VPWR VGND sg13cmos5l_inv_1
X_16189_ _16189_/Y _16551_/A _16229_/A _16188_/Y _16186_/X VPWR VGND sg13cmos5l_a22oi_1
X_15209_ _15209_/Y _15209_/A VPWR VGND sg13cmos5l_inv_1
XFILLER_101_216 VPWR VGND sg13cmos5l_fill_1
XFILLER_67_130 VPWR VGND sg13cmos5l_fill_2
XFILLER_67_174 VPWR VGND sg13cmos5l_fill_2
XFILLER_67_152 VPWR VGND sg13cmos5l_fill_2
XFILLER_55_325 VPWR VGND sg13cmos5l_fill_1
XFILLER_64_881 VPWR VGND sg13cmos5l_fill_1
XFILLER_20_984 VPWR VGND sg13cmos5l_fill_2
XFILLER_59_620 VPWR VGND sg13cmos5l_fill_1
X_18816__1458 _18816_/RESET_B VPWR VGND sg13cmos5l_tiehi
XFILLER_59_642 VPWR VGND sg13cmos5l_fill_1
X_12910_ _12910_/Y _12916_/B _12919_/B VPWR VGND sg13cmos5l_nand2b_1
XFILLER_74_612 VPWR VGND sg13cmos5l_fill_2
X_13890_ _13891_/B _18989_/Q _18990_/Q _18991_/Q VPWR VGND sg13cmos5l_o21ai_1
X_12841_ _12841_/X _12826_/Y _12839_/Y _12838_/Y VPWR VGND sg13cmos5l_a21o_1
XFILLER_34_509 VPWR VGND sg13cmos5l_fill_1
X_12772_ _12774_/A _10271_/A _12769_/Y _12771_/Y _12787_/B _12770_/Y VPWR VGND sg13cmos5l_a221oi_1
XFILLER_64_76 VPWR VGND sg13cmos5l_fill_1
X_15560_ _15564_/A _15549_/Y _15554_/Y _15582_/B _15562_/A _15556_/Y VPWR VGND sg13cmos5l_a221oi_1
X_19398__835 _19398_/RESET_B VPWR VGND sg13cmos5l_tiehi
X_11723_ _11725_/B _11721_/A _11721_/B _11722_/Y VPWR VGND sg13cmos5l_o21ai_1
X_15491_ _15491_/Y _15750_/B _15485_/A _15489_/A _10212_/Y _15490_/Y VPWR VGND sg13cmos5l_a221oi_1
X_14511_ _14513_/B _14617_/A _14616_/A VPWR VGND sg13cmos5l_nor2_1
X_11654_ _11654_/Y _10292_/Y _11645_/Y _11649_/A _11926_/A _11653_/Y VPWR VGND sg13cmos5l_a221oi_1
X_17230_ _17232_/B _17346_/A _17345_/A VPWR VGND sg13cmos5l_nor2_1
X_14442_ _14442_/X _19122_/Q _19115_/Q _19116_/Q VPWR VGND sg13cmos5l_or3_1
Xfanout70 fanout70/X fanout71/X VPWR VGND sg13cmos5l_buf_1
XFILLER_80_75 VPWR VGND sg13cmos5l_fill_2
X_17161_ _17161_/X _17163_/B _17155_/B _16989_/C VPWR VGND sg13cmos5l_a21o_1
Xfanout81 fanout81/X fanout82/X VPWR VGND sg13cmos5l_buf_1
X_10605_ _10607_/B _10605_/A _10605_/B VPWR VGND sg13cmos5l_nor2_1
XFILLER_7_900 VPWR VGND sg13cmos5l_decap_8
Xfanout92 fanout92/X fanout93/X VPWR VGND sg13cmos5l_buf_1
XFILLER_80_86 VPWR VGND sg13cmos5l_fill_2
X_11585_ _11585_/X _11628_/B _11467_/B _11597_/S VPWR VGND sg13cmos5l_mux2_1
XFILLER_7_911 VPWR VGND sg13cmos5l_fill_1
X_16112_ _16112_/Y _15924_/A _16105_/Y _16136_/B _16116_/A VPWR VGND sg13cmos5l_a22oi_1
X_14373_ _19138_/D _14377_/A _14373_/B VPWR VGND sg13cmos5l_nor2_1
XFILLER_31_1028 VPWR VGND sg13cmos5l_fill_1
X_17092_ _17092_/Y _19513_/Q _19575_/Q VPWR VGND sg13cmos5l_nand2b_1
X_13324_ _13324_/Y _14074_/A _19002_/Q VPWR VGND sg13cmos5l_nor2_1
X_10536_ _10536_/Y _18509_/A _10536_/B VPWR VGND sg13cmos5l_xnor2_1
X_13255_ _13255_/Y _13255_/A _13255_/B VPWR VGND sg13cmos5l_nor2_1
X_10467_ _10468_/B _10467_/A _10467_/B VPWR VGND sg13cmos5l_xnor2_1
XFILLER_7_988 VPWR VGND sg13cmos5l_fill_1
X_16043_ _16043_/Y _19422_/Q _19416_/Q VPWR VGND sg13cmos5l_nor2b_1
X_12206_ _12206_/Y _18771_/Q _18833_/Q VPWR VGND sg13cmos5l_nand2b_1
X_19728__430 _19728_/D VPWR VGND sg13cmos5l_tielo
X_10398_ _10680_/D input8/X _10398_/B VPWR VGND sg13cmos5l_nand2_1
X_18941__1325 _18941_/RESET_B VPWR VGND sg13cmos5l_tiehi
X_13186_ _13186_/Y _13124_/A _13124_/B _13199_/S _13183_/X _13184_/Y VPWR VGND sg13cmos5l_a221oi_1
X_19802_ _19802_/Q _19805_/CLK _19802_/D _19802_/RESET_B VPWR VGND sg13cmos5l_dfrbpq_1
X_12137_ _12139_/B _12137_/A _12137_/B VPWR VGND sg13cmos5l_nand2_1
X_17994_ _19684_/D _18067_/A _17994_/B VPWR VGND sg13cmos5l_nor2_1
X_12068_ _12267_/A _12110_/A _18788_/Q VPWR VGND sg13cmos5l_xnor2_1
X_16945_ _16945_/Y _19519_/Q _19480_/Q VPWR VGND sg13cmos5l_xnor2_1
X_19733_ _19733_/Q clkload34/A _19733_/D _19733_/RESET_B VPWR VGND sg13cmos5l_dfrbpq_1
X_11019_ _11057_/A _18630_/Q _11022_/B _11018_/Y VPWR VGND sg13cmos5l_a21oi_1
X_19664_ _19664_/Q clkload12/A _19664_/D _19664_/RESET_B VPWR VGND sg13cmos5l_dfrbpq_1
X_16876_ _16876_/Y _10361_/Y _16868_/Y _16875_/Y VPWR VGND sg13cmos5l_a21oi_1
X_18615_ _18615_/Q clkload45/A _18615_/D _18615_/RESET_B VPWR VGND sg13cmos5l_dfrbpq_1
X_19307__932 _19307_/RESET_B VPWR VGND sg13cmos5l_tiehi
X_19595_ _19595_/Q clkload37/A _19595_/D _19595_/RESET_B VPWR VGND sg13cmos5l_dfrbpq_1
X_19659__546 _19659_/RESET_B VPWR VGND sg13cmos5l_tiehi
X_15827_ _15827_/Y _15826_/A _15827_/B VPWR VGND sg13cmos5l_nand2b_1
X_15758_ _15769_/B _15749_/Y _15756_/Y _15757_/Y VPWR VGND sg13cmos5l_o21ai_1
X_18546_ _19781_/D _18546_/A _18547_/B VPWR VGND sg13cmos5l_nor2_1
X_15689_ _15690_/B _15746_/B _15710_/B _15688_/Y VPWR VGND sg13cmos5l_a21oi_1
X_14709_ _19197_/D _14978_/A _14709_/B VPWR VGND sg13cmos5l_and2_1
X_18477_ _19756_/D _18477_/A _18480_/A VPWR VGND sg13cmos5l_nor2_1
X_17428_ _17428_/Y _17708_/B _17416_/Y _17427_/Y VPWR VGND sg13cmos5l_a21oi_1
XFILLER_21_759 VPWR VGND sg13cmos5l_fill_1
X_17359_ _19577_/D hold2954/X fanout26/X _17358_/Y VPWR VGND sg13cmos5l_a21oi_1
Xclkload62 clkload62/Y clkload62/A VPWR VGND sg13cmos5l_inv_1
Xclkload40 clkload40/Y clkload40/A VPWR VGND sg13cmos5l_inv_1
X_19029_ _19029_/Q clkload28/A _19029_/D _19029_/RESET_B VPWR VGND sg13cmos5l_dfrbpq_1
Xclkload51 clkload51/Y clkload51/A VPWR VGND sg13cmos5l_inv_1
X_19314__925 _19314_/RESET_B VPWR VGND sg13cmos5l_tiehi
Xhold2802 _17622_/A _19625_/Q VPWR VGND sg13cmos5l_dlygate4sd3_1
Xhold2813 _13903_/A _18995_/Q VPWR VGND sg13cmos5l_dlygate4sd3_1
Xhold2857 _11548_/A _18703_/Q VPWR VGND sg13cmos5l_dlygate4sd3_1
XFILLER_69_962 VPWR VGND sg13cmos5l_decap_8
Xhold2846 _13435_/A _19007_/Q VPWR VGND sg13cmos5l_dlygate4sd3_1
Xhold2835 _14081_/B _14007_/B VPWR VGND sg13cmos5l_dlygate4sd3_1
Xhold2824 _16017_/B _15942_/Y VPWR VGND sg13cmos5l_dlygate4sd3_1
Xhold2868 _13684_/A _19058_/Q VPWR VGND sg13cmos5l_dlygate4sd3_1
Xhold2879 _13437_/A _19006_/Q VPWR VGND sg13cmos5l_dlygate4sd3_1
XFILLER_56_656 VPWR VGND sg13cmos5l_decap_8
XFILLER_56_689 VPWR VGND sg13cmos5l_decap_8
XFILLER_93_1000 VPWR VGND sg13cmos5l_fill_2
XFILLER_71_637 VPWR VGND sg13cmos5l_fill_2
XFILLER_24_520 VPWR VGND sg13cmos5l_fill_1
Xclkload1 clkload1/X clkload1/A VPWR VGND sg13cmos5l_buf_8
XFILLER_7_207 VPWR VGND sg13cmos5l_decap_8
X_11370_ _11370_/Y _18705_/Q _11388_/A _11393_/B _18706_/Q VPWR VGND sg13cmos5l_a22oi_1
X_10321_ _10321_/Y _10321_/A VPWR VGND sg13cmos5l_inv_1
XFILLER_4_914 VPWR VGND sg13cmos5l_decap_8
XFILLER_3_402 VPWR VGND sg13cmos5l_fill_1
X_13040_ _13054_/B _18898_/Q _13037_/Y _13039_/Y VPWR VGND sg13cmos5l_o21ai_1
XFILLER_59_32 VPWR VGND sg13cmos5l_decap_8
X_10252_ _14114_/B _10252_/A VPWR VGND sg13cmos5l_inv_1
X_10183_ _18473_/A _17960_/A VPWR VGND sg13cmos5l_inv_1
X_14991_ _14991_/X _19206_/Q _19199_/Q _19200_/Q VPWR VGND sg13cmos5l_or3_1
X_16730_ _16730_/Y _16746_/A _16730_/B VPWR VGND sg13cmos5l_nor2_1
Xfanout282 _13586_/A _13338_/Y VPWR VGND sg13cmos5l_buf_1
XFILLER_59_450 VPWR VGND sg13cmos5l_fill_1
X_13942_ _13942_/Y _14043_/B _14043_/C _14043_/A VPWR VGND sg13cmos5l_a21oi_1
XFILLER_47_601 VPWR VGND sg13cmos5l_fill_1
Xfanout271 _14076_/B _13858_/Y VPWR VGND sg13cmos5l_buf_1
Xfanout260 _14916_/A _14909_/B VPWR VGND sg13cmos5l_buf_1
XFILLER_19_303 VPWR VGND sg13cmos5l_fill_1
Xfanout293 _12728_/B _12729_/B VPWR VGND sg13cmos5l_buf_1
X_16661_ _16661_/Y _16641_/B _16641_/C _16650_/X _16648_/A _16664_/A VPWR VGND sg13cmos5l_a221oi_1
XFILLER_75_976 VPWR VGND sg13cmos5l_decap_8
X_13873_ _13873_/Y hold2029/X fanout80/X _14070_/A VPWR VGND sg13cmos5l_o21ai_1
X_12824_ _12824_/Y _12824_/A _12850_/B VPWR VGND sg13cmos5l_nor2_1
X_16592_ _16592_/Y _19472_/Q _16577_/Y _16591_/Y _19473_/Q _16587_/Y VPWR VGND sg13cmos5l_a221oi_1
XFILLER_62_626 VPWR VGND sg13cmos5l_fill_1
X_15612_ _15626_/B _19335_/Q _19333_/Q _19334_/Q VPWR VGND sg13cmos5l_nor3_1
X_19380_ _19380_/Q clkload7/A _19380_/D _19380_/RESET_B VPWR VGND sg13cmos5l_dfrbpq_1
X_18400_ _18400_/Y _10511_/A _18402_/S _18399_/Y VPWR VGND sg13cmos5l_a21oi_1
X_12755_ _12755_/Y _13291_/A _18912_/Q VPWR VGND sg13cmos5l_nand2_1
X_15543_ _15543_/Y _15544_/A _15578_/A _15540_/X VPWR VGND sg13cmos5l_o21ai_1
X_18331_ _18331_/Y _18316_/X _18318_/Y _18144_/Y VPWR VGND sg13cmos5l_a21oi_1
X_11706_ _11706_/Y _11559_/B _11737_/A _11742_/A _11711_/A VPWR VGND sg13cmos5l_a22oi_1
X_18262_ _18262_/Y _18262_/A _18262_/B _18262_/C VPWR VGND sg13cmos5l_nor3_1
X_12686_ _12686_/Y _12645_/X _12697_/B _12685_/Y VPWR VGND sg13cmos5l_a21oi_1
X_18708__527 _18708_/D VPWR VGND sg13cmos5l_tielo
X_15474_ _15474_/Y _16015_/A _19275_/Q _15473_/Y VPWR VGND sg13cmos5l_o21ai_1
XFILLER_30_534 VPWR VGND sg13cmos5l_decap_8
X_11637_ _11637_/Y _11633_/Y _11636_/Y _11635_/Y VPWR VGND sg13cmos5l_o21ai_1
X_17213_ _17213_/Y _19562_/Q _19523_/Q VPWR VGND sg13cmos5l_xnor2_1
X_18985__1276 _18985_/RESET_B VPWR VGND sg13cmos5l_tiehi
X_19012__1248 _19012_/RESET_B VPWR VGND sg13cmos5l_tiehi
X_18193_ _18193_/Y _18193_/A _18193_/B _18193_/C VPWR VGND sg13cmos5l_nand3_1
X_14425_ _19147_/D _14639_/B _14425_/B VPWR VGND sg13cmos5l_nor2_1
X_17144_ _17144_/Y _19519_/Q fanout69/X _16889_/A VPWR VGND sg13cmos5l_o21ai_1
X_11568_ _11568_/Y _11478_/Y _11631_/B VPWR VGND sg13cmos5l_nand2b_1
X_14356_ _14356_/Y _14323_/B _14349_/X _14374_/A VPWR VGND sg13cmos5l_o21ai_1
X_17075_ _19536_/D hold2874/X _17070_/S _17074_/Y VPWR VGND sg13cmos5l_a21oi_1
X_13307_ _13318_/B _13298_/Y _13305_/Y _13306_/Y VPWR VGND sg13cmos5l_o21ai_1
X_10519_ _10575_/A _18499_/B _10519_/B VPWR VGND sg13cmos5l_xnor2_1
X_11499_ _11596_/B _11497_/Y _11498_/X _11485_/Y VPWR VGND sg13cmos5l_o21ai_1
X_16026_ _16026_/Y _19419_/Q _19357_/Q VPWR VGND sg13cmos5l_nand2b_1
X_14287_ _14373_/B _14288_/C _14288_/D VPWR VGND sg13cmos5l_and2_1
X_13238_ _13239_/B _18962_/Q _13263_/B _13212_/Y VPWR VGND sg13cmos5l_a21oi_1
XFILLER_41_4 VPWR VGND sg13cmos5l_fill_1
Xhold2109 _10150_/A _19535_/Q VPWR VGND sg13cmos5l_dlygate4sd3_1
X_13169_ _13179_/B _18974_/Q _13170_/B VPWR VGND sg13cmos5l_nand2b_1
XFILLER_97_545 VPWR VGND sg13cmos5l_decap_4
X_17977_ _17977_/Y _17977_/A VPWR VGND sg13cmos5l_inv_1
X_19242__1000 _19242_/RESET_B VPWR VGND sg13cmos5l_tiehi
X_19716_ _19716_/Q clkload10/A _19716_/D _19716_/RESET_B VPWR VGND sg13cmos5l_dfrbpq_1
X_16928_ _17013_/B _16932_/B _16918_/B _16927_/Y VPWR VGND sg13cmos5l_a21o_1
XFILLER_66_965 VPWR VGND sg13cmos5l_fill_2
XFILLER_65_420 VPWR VGND sg13cmos5l_fill_2
XFILLER_81_924 VPWR VGND sg13cmos5l_fill_1
X_16859_ _16859_/Y _10361_/Y _16843_/Y _16858_/Y VPWR VGND sg13cmos5l_o21ai_1
X_19647_ _19647_/Q clkload13/A _19647_/D _19647_/RESET_B VPWR VGND sg13cmos5l_dfrbpq_1
XFILLER_37_155 VPWR VGND sg13cmos5l_decap_4
XFILLER_26_829 VPWR VGND sg13cmos5l_fill_2
X_19578_ _19578_/Q clkload34/A _19578_/D _19578_/RESET_B VPWR VGND sg13cmos5l_dfrbpq_1
X_18772__1506 _18772_/RESET_B VPWR VGND sg13cmos5l_tiehi
X_18529_ _19767_/D _18529_/A _18529_/B VPWR VGND sg13cmos5l_nor2_1
XFILLER_80_478 VPWR VGND sg13cmos5l_fill_1
XFILLER_61_670 VPWR VGND sg13cmos5l_fill_1
XFILLER_60_191 VPWR VGND sg13cmos5l_fill_2
XFILLER_60_180 VPWR VGND sg13cmos5l_fill_2
X_19787__652 _19787_/RESET_B VPWR VGND sg13cmos5l_tiehi
XFILLER_103_834 VPWR VGND sg13cmos5l_fill_2
XFILLER_103_812 VPWR VGND sg13cmos5l_decap_4
X_19388__845 _19388_/RESET_B VPWR VGND sg13cmos5l_tiehi
Xhold2621 _11769_/A _18752_/Q VPWR VGND sg13cmos5l_dlygate4sd3_1
Xhold2610 _10341_/A _19684_/Q VPWR VGND sg13cmos5l_dlygate4sd3_1
Xhold1920 _17439_/B _19566_/Q VPWR VGND sg13cmos5l_dlygate4sd3_1
Xhold2632 hold2632/X _13451_/Y VPWR VGND sg13cmos5l_dlygate4sd3_1
Xhold2654 hold2654/X _18090_/Y VPWR VGND sg13cmos5l_dlygate4sd3_1
Xhold2665 _15887_/A _19382_/Q VPWR VGND sg13cmos5l_dlygate4sd3_1
Xhold2643 _15606_/A _19340_/Q VPWR VGND sg13cmos5l_dlygate4sd3_1
Xhold1931 _12722_/B _18835_/Q VPWR VGND sg13cmos5l_dlygate4sd3_1
Xhold1942 _09974_/A _19562_/Q VPWR VGND sg13cmos5l_dlygate4sd3_1
Xhold2698 _13533_/A _19005_/Q VPWR VGND sg13cmos5l_dlygate4sd3_1
XFILLER_57_965 VPWR VGND sg13cmos5l_fill_2
Xhold2676 _10355_/A _19556_/Q VPWR VGND sg13cmos5l_dlygate4sd3_1
Xhold2687 _10102_/A _19207_/Q VPWR VGND sg13cmos5l_dlygate4sd3_1
Xhold1953 _09989_/A _19319_/Q VPWR VGND sg13cmos5l_dlygate4sd3_1
XFILLER_29_656 VPWR VGND sg13cmos5l_fill_1
Xhold1975 _18901_/D _12794_/Y VPWR VGND sg13cmos5l_dlygate4sd3_1
Xhold1986 _10004_/A _18941_/Q VPWR VGND sg13cmos5l_dlygate4sd3_1
XFILLER_57_976 VPWR VGND sg13cmos5l_fill_1
Xhold1997 _14218_/A _19111_/Q VPWR VGND sg13cmos5l_dlygate4sd3_1
Xhold1964 hold1964/X _19109_/Q VPWR VGND sg13cmos5l_dlygate4sd3_1
X_10870_ _10870_/Y _11122_/B _10858_/Y _10869_/Y VPWR VGND sg13cmos5l_a21oi_1
XFILLER_56_497 VPWR VGND sg13cmos5l_fill_1
XFILLER_45_78 VPWR VGND sg13cmos5l_fill_2
X_18748__1530 _18748_/RESET_B VPWR VGND sg13cmos5l_tiehi
X_19395__838 _19395_/RESET_B VPWR VGND sg13cmos5l_tiehi
XFILLER_12_512 VPWR VGND sg13cmos5l_fill_2
XFILLER_31_309 VPWR VGND sg13cmos5l_decap_4
X_12540_ _12546_/C _18821_/Q _18822_/Q _18823_/Q VPWR VGND sg13cmos5l_o21ai_1
XFILLER_24_394 VPWR VGND sg13cmos5l_fill_1
X_12471_ _12471_/Y _12625_/D _10281_/Y _12487_/A _18870_/Q VPWR VGND sg13cmos5l_a22oi_1
XFILLER_61_77 VPWR VGND sg13cmos5l_fill_2
X_11422_ _18692_/D _11423_/A _11422_/B VPWR VGND sg13cmos5l_and2_1
X_15190_ _19264_/D _15191_/A _15190_/B VPWR VGND sg13cmos5l_nor2_1
XFILLER_8_549 VPWR VGND sg13cmos5l_fill_2
X_14210_ _14210_/Y _14208_/Y _14209_/Y _14207_/Y VPWR VGND sg13cmos5l_a21oi_1
X_14141_ _14141_/Y _14218_/A fanout91/X _14636_/A VPWR VGND sg13cmos5l_o21ai_1
X_11353_ _18670_/D _11353_/A _11355_/B VPWR VGND sg13cmos5l_nor2_1
X_18981__1282 _18981_/RESET_B VPWR VGND sg13cmos5l_tiehi
X_10304_ _11120_/A _10304_/A VPWR VGND sg13cmos5l_inv_1
X_11284_ _11284_/Y _11188_/A _11188_/B _11358_/B VPWR VGND sg13cmos5l_o21ai_1
X_19649__556 _19649_/RESET_B VPWR VGND sg13cmos5l_tiehi
X_14072_ _19089_/D _14072_/A _14076_/B VPWR VGND sg13cmos5l_nor2_1
XFILLER_4_777 VPWR VGND sg13cmos5l_fill_1
X_18880_ _18880_/Q clkload69/A _18880_/D _18880_/RESET_B VPWR VGND sg13cmos5l_dfrbpq_1
X_13023_ _18927_/D _13027_/A _13023_/B VPWR VGND sg13cmos5l_nor2_1
XFILLER_79_512 VPWR VGND sg13cmos5l_fill_1
X_17900_ _17900_/Y _17900_/A _17900_/B VPWR VGND sg13cmos5l_nor2_1
X_10235_ _10235_/Y _10235_/A VPWR VGND sg13cmos5l_inv_1
X_17831_ _17831_/Y _17831_/A _19674_/Q VPWR VGND sg13cmos5l_nand2_1
XFILLER_79_589 VPWR VGND sg13cmos5l_decap_4
X_10166_ _11355_/A _10166_/A VPWR VGND sg13cmos5l_inv_1
X_17762_ _17762_/Y _17780_/B VPWR VGND sg13cmos5l_inv_1
X_10097_ _14907_/A _10097_/A VPWR VGND sg13cmos5l_inv_1
X_14974_ _14974_/Y _19195_/Q fanout72/X _14978_/A VPWR VGND sg13cmos5l_o21ai_1
X_19501_ _19501_/Q clkload32/A _19501_/D _19501_/RESET_B VPWR VGND sg13cmos5l_dfrbpq_1
X_16713_ _16714_/A _16713_/A _16742_/A VPWR VGND sg13cmos5l_xnor2_1
X_17693_ _17693_/Y _19598_/Q _17693_/B _17693_/C VPWR VGND sg13cmos5l_nand3_1
X_13925_ _19077_/D _13925_/A _14013_/A VPWR VGND sg13cmos5l_and2_1
X_19230__1015 _19230_/RESET_B VPWR VGND sg13cmos5l_tiehi
X_16644_ _16644_/Y _16640_/Y _16642_/Y _16643_/Y VPWR VGND sg13cmos5l_o21ai_1
XFILLER_63_924 VPWR VGND sg13cmos5l_fill_2
X_19432_ _19432_/Q clkload9/A _19432_/D _19432_/RESET_B VPWR VGND sg13cmos5l_dfrbpq_1
XFILLER_19_177 VPWR VGND sg13cmos5l_fill_2
XFILLER_19_188 VPWR VGND sg13cmos5l_fill_2
X_13856_ _13856_/Y _13856_/A _13856_/B VPWR VGND sg13cmos5l_nor2_1
XFILLER_34_114 VPWR VGND sg13cmos5l_fill_2
X_12807_ _12832_/A _18863_/Q _18864_/Q VPWR VGND sg13cmos5l_xor2_1
X_19304__935 _19304_/RESET_B VPWR VGND sg13cmos5l_tiehi
X_13787_ _13787_/Y _13790_/A _13805_/B VPWR VGND sg13cmos5l_nand2_1
X_16575_ _16575_/Y _19492_/Q _17085_/A _16593_/C VPWR VGND sg13cmos5l_nand3_1
X_10999_ _11000_/A _10999_/A _11091_/B VPWR VGND sg13cmos5l_nor2_1
XFILLER_43_670 VPWR VGND sg13cmos5l_fill_1
X_19656__549 _19656_/RESET_B VPWR VGND sg13cmos5l_tiehi
X_19363_ _19363_/Q clkload15/A _19363_/D _19363_/RESET_B VPWR VGND sg13cmos5l_dfrbpq_1
X_12738_ _12738_/Y _13287_/A _18852_/Q _18851_/Q _13286_/A VPWR VGND sg13cmos5l_a22oi_1
X_19294_ _19294_/Q clkload43/A _19294_/D _19294_/RESET_B VPWR VGND sg13cmos5l_dfrbpq_1
X_15526_ _19322_/D _16307_/A _15526_/B VPWR VGND sg13cmos5l_and2_1
X_18314_ _18315_/B _19698_/Q _18314_/B VPWR VGND sg13cmos5l_xnor2_1
X_12669_ _12669_/Y _12577_/B _12734_/B _12668_/Y VPWR VGND sg13cmos5l_o21ai_1
X_18245_ _18264_/C _18252_/B _18245_/B VPWR VGND sg13cmos5l_and2_1
X_15457_ _19301_/D _15457_/A _15458_/B VPWR VGND sg13cmos5l_nor2_1
XFILLER_30_342 VPWR VGND sg13cmos5l_fill_2
X_14408_ _14408_/Y _14908_/A _19170_/Q _14408_/C VPWR VGND sg13cmos5l_nor3_1
X_18176_ _18177_/B _18176_/A _18176_/B VPWR VGND sg13cmos5l_xor2_1
X_15388_ _15388_/Y _15544_/A _15394_/B VPWR VGND sg13cmos5l_nand2_1
X_17127_ _17129_/A _10359_/A _17124_/Y _17126_/Y _19559_/Q _17125_/Y VPWR VGND sg13cmos5l_a221oi_1
X_14339_ _14340_/A _14315_/A _14314_/Y _14312_/Y VPWR VGND sg13cmos5l_a21oi_1
X_17058_ _17059_/B _17058_/A _17058_/B VPWR VGND sg13cmos5l_xor2_1
X_19311__928 _19311_/RESET_B VPWR VGND sg13cmos5l_tiehi
X_16009_ _19381_/D _16307_/A _16009_/B VPWR VGND sg13cmos5l_and2_1
XFILLER_44_1027 VPWR VGND sg13cmos5l_fill_2
XFILLER_44_1016 VPWR VGND sg13cmos5l_decap_8
XFILLER_97_386 VPWR VGND sg13cmos5l_decap_4
XFILLER_38_431 VPWR VGND sg13cmos5l_fill_2
XFILLER_65_272 VPWR VGND sg13cmos5l_fill_1
XFILLER_38_497 VPWR VGND sg13cmos5l_fill_2
XFILLER_31_14 VPWR VGND sg13cmos5l_decap_4
Xoutput14 uo_out[1] _19439_/Q VPWR VGND sg13cmos5l_buf_1
XFILLER_103_620 VPWR VGND sg13cmos5l_decap_4
X_10020_ _11354_/A _10020_/A VPWR VGND sg13cmos5l_inv_1
XFILLER_0_235 VPWR VGND sg13cmos5l_fill_2
Xhold2440 _17931_/A _19616_/Q VPWR VGND sg13cmos5l_dlygate4sd3_1
Xhold2462 _11143_/B _18645_/Q VPWR VGND sg13cmos5l_dlygate4sd3_1
Xhold2451 _10167_/A _19618_/Q VPWR VGND sg13cmos5l_dlygate4sd3_1
XFILLER_56_11 VPWR VGND sg13cmos5l_decap_8
XFILLER_48_239 VPWR VGND sg13cmos5l_fill_2
Xhold2473 _10101_/A _19210_/Q VPWR VGND sg13cmos5l_dlygate4sd3_1
X_11971_ _11971_/X _18744_/Q _18737_/Q VPWR VGND sg13cmos5l_or2_1
Xhold2484 _10037_/A _18789_/Q VPWR VGND sg13cmos5l_dlygate4sd3_1
XFILLER_63_209 VPWR VGND sg13cmos5l_fill_2
XFILLER_56_55 VPWR VGND sg13cmos5l_fill_1
Xhold2495 _17691_/A _19664_/Q VPWR VGND sg13cmos5l_dlygate4sd3_1
X_13710_ _13710_/Y _13716_/B _13716_/C VPWR VGND sg13cmos5l_nand2_1
X_10922_ _18613_/D _11089_/A _10922_/B VPWR VGND sg13cmos5l_nor2_1
X_14690_ _14690_/X _14670_/Y _10231_/Y _14690_/S VPWR VGND sg13cmos5l_mux2_1
X_13641_ _19026_/D _10000_/Y fanout86/X _13640_/Y VPWR VGND sg13cmos5l_a21oi_1
XFILLER_71_253 VPWR VGND sg13cmos5l_fill_1
X_10853_ _10853_/Y _11122_/B _10853_/B VPWR VGND sg13cmos5l_nor2_1
XFILLER_60_927 VPWR VGND sg13cmos5l_decap_4
XFILLER_32_618 VPWR VGND sg13cmos5l_fill_2
X_10784_ _10784_/Y _10784_/A _10784_/B VPWR VGND sg13cmos5l_nor2_1
X_13572_ _19001_/D _13578_/B _13572_/B VPWR VGND sg13cmos5l_nor2_1
X_16360_ _16360_/X _16341_/Y _09986_/Y _16370_/B VPWR VGND sg13cmos5l_mux2_1
X_12523_ _12523_/Y hold1958/X fanout77/X _12528_/A VPWR VGND sg13cmos5l_o21ai_1
X_19680__1779 _19680_/RESET_B VPWR VGND sg13cmos5l_tiehi
X_16291_ _16291_/Y _16291_/A _16291_/B VPWR VGND sg13cmos5l_nor2_1
X_15311_ _15311_/Y _15309_/Y _15310_/Y _15308_/Y VPWR VGND sg13cmos5l_a21oi_1
X_19024__497 _19024_/D VPWR VGND sg13cmos5l_tielo
X_18030_ _18030_/Y _18032_/A _18032_/B _18029_/Y VPWR VGND sg13cmos5l_a21oi_1
X_15242_ _19272_/D _15466_/A _15242_/B VPWR VGND sg13cmos5l_nor2_1
X_12454_ _18833_/D _12440_/A _12453_/Y _12452_/A VPWR VGND sg13cmos5l_a21oi_1
X_18564__1744 _18564_/RESET_B VPWR VGND sg13cmos5l_tiehi
X_12385_ _12427_/B _18839_/Q _12414_/B VPWR VGND sg13cmos5l_nand2_1
X_11405_ _18682_/D _11629_/A _11405_/B VPWR VGND sg13cmos5l_nor2_1
X_15173_ _15174_/B _15152_/B _15149_/A _15173_/S VPWR VGND sg13cmos5l_mux2_1
XFILLER_67_1027 VPWR VGND sg13cmos5l_fill_2
X_11336_ _11336_/X _11336_/A _11336_/B VPWR VGND sg13cmos5l_and2_1
X_14124_ _14376_/A _14636_/B _14636_/A VPWR VGND sg13cmos5l_nand2b_1
X_18932_ _18932_/Q clkload64/A _18932_/D _18932_/RESET_B VPWR VGND sg13cmos5l_dfrbpq_1
X_14055_ _14055_/Y _14055_/A _14055_/B VPWR VGND sg13cmos5l_nor2_1
X_13006_ _18914_/D _12978_/Y _13007_/A _13005_/Y VPWR VGND sg13cmos5l_a21oi_1
X_11267_ _11267_/Y _11290_/B _11263_/X _11265_/Y _11260_/Y _11266_/Y VPWR VGND sg13cmos5l_a221oi_1
X_18863_ _18863_/Q clkload71/A _18863_/D _18863_/RESET_B VPWR VGND sg13cmos5l_dfrbpq_1
X_11198_ _11201_/A _11198_/A _11198_/B VPWR VGND sg13cmos5l_nor2_1
X_10218_ _15486_/A _10218_/A VPWR VGND sg13cmos5l_inv_1
X_10149_ _17085_/A _10149_/A VPWR VGND sg13cmos5l_inv_1
X_18794_ _18794_/Q clkload60/A _18794_/D _18794_/RESET_B VPWR VGND sg13cmos5l_dfrbpq_1
X_17814_ _17843_/B _19676_/Q _19678_/Q _19677_/Q _17837_/A VPWR VGND sg13cmos5l_nor4_1
X_17745_ _17746_/B _19609_/Q _19610_/Q _19611_/Q VPWR VGND sg13cmos5l_o21ai_1
XFILLER_63_710 VPWR VGND sg13cmos5l_decap_8
X_14957_ _14957_/Y _15453_/B _15453_/A VPWR VGND sg13cmos5l_nand2b_1
XFILLER_90_551 VPWR VGND sg13cmos5l_fill_1
X_17676_ _19633_/D _17678_/A _17676_/B VPWR VGND sg13cmos5l_nor2_1
X_13908_ _13924_/S _13906_/A _13906_/B _13907_/Y VPWR VGND sg13cmos5l_a21o_1
X_14888_ _14888_/Y _14889_/A _14889_/B _14887_/Y VPWR VGND sg13cmos5l_a21oi_1
X_16627_ _16629_/B _19035_/Q _16631_/B VPWR VGND sg13cmos5l_nand2b_1
XFILLER_63_776 VPWR VGND sg13cmos5l_fill_1
X_19415_ _19415_/Q clkload5/A _19415_/D _19415_/RESET_B VPWR VGND sg13cmos5l_dfrbpq_1
X_13839_ _13839_/Y _13839_/A VPWR VGND sg13cmos5l_inv_1
XFILLER_94_2 VPWR VGND sg13cmos5l_fill_1
X_19378__855 _19378_/RESET_B VPWR VGND sg13cmos5l_tiehi
X_19346_ _19346_/Q clkload16/A _19346_/D _19346_/RESET_B VPWR VGND sg13cmos5l_dfrbpq_1
X_16558_ _16558_/Y _16448_/A _16448_/B _16562_/A VPWR VGND sg13cmos5l_a21oi_1
X_15509_ _19312_/D _15586_/A _15509_/B VPWR VGND sg13cmos5l_nor2_1
X_16489_ _16494_/A _19458_/Q _16508_/B VPWR VGND sg13cmos5l_and2_1
X_19277_ _19277_/Q clkload48/A _19277_/D _19277_/RESET_B VPWR VGND sg13cmos5l_dfrbpq_1
X_18228_ _19715_/D _18233_/A _18228_/B VPWR VGND sg13cmos5l_nor2_1
XFILLER_7_82 VPWR VGND sg13cmos5l_decap_4
X_18159_ _18159_/Y _18159_/A _18159_/B VPWR VGND sg13cmos5l_nor2_1
Xheichips26_digital_project_1804 uio_oe[7] VPWR VGND sg13cmos5l_tiehi
X_19385__848 _19385_/RESET_B VPWR VGND sg13cmos5l_tiehi
XFILLER_54_754 VPWR VGND sg13cmos5l_fill_1
XFILLER_53_220 VPWR VGND sg13cmos5l_fill_1
X_19086__491 _19086_/D VPWR VGND sg13cmos5l_tielo
X_19037__1220 _19037_/RESET_B VPWR VGND sg13cmos5l_tiehi
X_18864__1405 _18864_/RESET_B VPWR VGND sg13cmos5l_tiehi
X_12170_ _12171_/A _12170_/A _12170_/B VPWR VGND sg13cmos5l_nand2_1
X_11121_ _11121_/Y _11121_/A _11121_/B _11121_/C VPWR VGND sg13cmos5l_nor3_1
XFILLER_104_973 VPWR VGND sg13cmos5l_fill_1
XFILLER_104_962 VPWR VGND sg13cmos5l_decap_8
X_11052_ _11059_/B _10930_/B _11051_/B _11051_/Y VPWR VGND sg13cmos5l_o21ai_1
XFILLER_103_472 VPWR VGND sg13cmos5l_decap_4
X_10003_ _10003_/Y _10003_/A VPWR VGND sg13cmos5l_inv_1
XFILLER_49_537 VPWR VGND sg13cmos5l_fill_2
X_15860_ _15860_/Y _15860_/A _15860_/B VPWR VGND sg13cmos5l_nor2_1
Xhold2270 _19643_/D _17730_/Y VPWR VGND sg13cmos5l_dlygate4sd3_1
X_14811_ _14811_/Y _14795_/A _14842_/A _14808_/X _14809_/Y _14810_/Y VPWR VGND sg13cmos5l_a221oi_1
Xhold2281 hold2281/X _15247_/Y VPWR VGND sg13cmos5l_dlygate4sd3_1
XFILLER_91_304 VPWR VGND sg13cmos5l_fill_1
XFILLER_57_581 VPWR VGND sg13cmos5l_fill_1
X_15791_ _15791_/Y _16042_/A _15798_/S _15790_/Y VPWR VGND sg13cmos5l_a21oi_1
Xhold2292 _10249_/A _19061_/Q VPWR VGND sg13cmos5l_dlygate4sd3_1
X_11954_ _11954_/Y _11934_/X _11945_/Y _12199_/A VPWR VGND sg13cmos5l_o21ai_1
X_17530_ _17531_/B _17530_/A _17530_/B VPWR VGND sg13cmos5l_xor2_1
X_14742_ _19199_/D _14916_/A _14742_/B VPWR VGND sg13cmos5l_and2_1
X_11885_ _18746_/D _11905_/A _11885_/B VPWR VGND sg13cmos5l_nor2_1
X_17461_ _17468_/B _19572_/Q _19571_/Q _19570_/Q _17461_/D VPWR VGND sg13cmos5l_nor4_1
X_10905_ _10917_/B _10897_/Y _10902_/Y _10928_/B _10906_/A _10904_/Y VPWR VGND sg13cmos5l_a221oi_1
X_14673_ _14673_/Y _14673_/A _19150_/Q _14680_/C VPWR VGND sg13cmos5l_nor3_1
XFILLER_32_415 VPWR VGND sg13cmos5l_fill_2
X_13624_ _13624_/Y _19045_/Q _17152_/A VPWR VGND sg13cmos5l_nand2b_1
X_19477__743 _19477_/RESET_B VPWR VGND sg13cmos5l_tiehi
X_10836_ _10837_/A _10850_/C _10835_/Y _10834_/Y VPWR VGND sg13cmos5l_o21ai_1
X_19200_ _19200_/Q clkload51/A _19200_/D _19200_/RESET_B VPWR VGND sg13cmos5l_dfrbpq_1
X_19301__938 _19301_/RESET_B VPWR VGND sg13cmos5l_tiehi
X_16412_ _16463_/B _16403_/X _16408_/Y _16411_/Y _16406_/A _16410_/Y VPWR VGND sg13cmos5l_a221oi_1
XFILLER_32_437 VPWR VGND sg13cmos5l_fill_2
X_17392_ _17392_/Y _19555_/Q _17392_/B VPWR VGND sg13cmos5l_nand2_1
XFILLER_41_960 VPWR VGND sg13cmos5l_fill_1
XFILLER_9_600 VPWR VGND sg13cmos5l_decap_8
XFILLER_34_1015 VPWR VGND sg13cmos5l_decap_8
X_19131_ _19131_/Q clkload47/A _19131_/D _19131_/RESET_B VPWR VGND sg13cmos5l_dfrbpq_1
X_10767_ _10767_/Y _18591_/Q _10767_/B VPWR VGND sg13cmos5l_xnor2_1
X_13555_ _13556_/A _13555_/A _13555_/B VPWR VGND sg13cmos5l_nand2_1
X_16343_ _16343_/Y _09984_/Y _16334_/A _16338_/A _09985_/Y _16342_/Y VPWR VGND sg13cmos5l_a221oi_1
X_10698_ _10774_/B _18586_/Q _13808_/A _18585_/Q VPWR VGND sg13cmos5l_nor3_1
X_12506_ _12506_/Y _12506_/A _12506_/B VPWR VGND sg13cmos5l_nor2_1
X_13486_ _13486_/Y _13518_/A _13899_/A _13482_/Y _13484_/Y VPWR VGND sg13cmos5l_a22oi_1
X_16274_ _16276_/A _16161_/B _16289_/A _16274_/C VPWR VGND sg13cmos5l_nand3b_1
X_19062_ _19062_/Q _19136_/CLK _19062_/D _19062_/RESET_B VPWR VGND sg13cmos5l_dfrbpq_1
X_12437_ _12437_/Y _12437_/A _12450_/A VPWR VGND sg13cmos5l_nor2_1
X_15225_ _15225_/Y _19234_/Q _15225_/B _15225_/C VPWR VGND sg13cmos5l_nor3_1
X_18013_ _18013_/X _18026_/D _18012_/C _18012_/A VPWR VGND sg13cmos5l_a21o_1
X_15156_ _15156_/Y _15193_/B _15156_/B VPWR VGND sg13cmos5l_nand2_1
X_12368_ _12368_/Y _12368_/A _12368_/B VPWR VGND sg13cmos5l_nor2_1
X_14107_ _14107_/Y _10241_/Y _14097_/Y _14101_/X _14106_/X _14102_/X VPWR VGND sg13cmos5l_a221oi_1
X_12299_ _12301_/A _12299_/A _12299_/B VPWR VGND sg13cmos5l_and2_1
X_11319_ _11321_/B _11360_/B _11325_/B _11318_/Y VPWR VGND sg13cmos5l_o21ai_1
X_15087_ _15091_/B _15459_/A _15089_/B VPWR VGND sg13cmos5l_nand2_1
X_18915_ _18915_/Q clkload64/A _18915_/D _18915_/RESET_B VPWR VGND sg13cmos5l_dfrbpq_1
X_14038_ _14041_/A _14038_/A VPWR VGND sg13cmos5l_inv_1
X_18846_ _18846_/Q clkload70/A _18846_/D _18846_/RESET_B VPWR VGND sg13cmos5l_dfrbpq_1
XFILLER_55_507 VPWR VGND sg13cmos5l_fill_1
XFILLER_103_19 VPWR VGND sg13cmos5l_fill_2
X_18777_ _18777_/Q clkload57/A _18777_/D _18777_/RESET_B VPWR VGND sg13cmos5l_dfrbpq_1
X_19601__610 _19601_/RESET_B VPWR VGND sg13cmos5l_tiehi
X_15989_ _15990_/B _15989_/A _15989_/B VPWR VGND sg13cmos5l_or2_1
X_17728_ _17728_/Y _17974_/B _17719_/S _17727_/Y VPWR VGND sg13cmos5l_a21oi_1
X_17659_ _17660_/C _17659_/A _17620_/A VPWR VGND sg13cmos5l_nor2b_1
XFILLER_91_893 VPWR VGND sg13cmos5l_fill_2
XFILLER_23_459 VPWR VGND sg13cmos5l_fill_1
X_19329_ _19329_/Q clkload17/A _19329_/D _19329_/RESET_B VPWR VGND sg13cmos5l_dfrbpq_1
X_19025__1235 _19025_/RESET_B VPWR VGND sg13cmos5l_tiehi
XFILLER_99_982 VPWR VGND sg13cmos5l_fill_2
XFILLER_101_932 VPWR VGND sg13cmos5l_decap_8
X_19762__783 _19762_/RESET_B VPWR VGND sg13cmos5l_tiehi
XFILLER_100_475 VPWR VGND sg13cmos5l_fill_2
XFILLER_86_698 VPWR VGND sg13cmos5l_fill_1
XFILLER_37_35 VPWR VGND sg13cmos5l_fill_1
XFILLER_85_197 VPWR VGND sg13cmos5l_fill_2
XFILLER_2_1024 VPWR VGND sg13cmos5l_decap_4
XFILLER_54_573 VPWR VGND sg13cmos5l_fill_1
X_11670_ _11670_/Y _13337_/A _12188_/B VPWR VGND sg13cmos5l_nor2_1
XFILLER_53_56 VPWR VGND sg13cmos5l_fill_2
XFILLER_23_960 VPWR VGND sg13cmos5l_fill_1
X_10621_ _10622_/B _10621_/A _10621_/B VPWR VGND sg13cmos5l_xor2_1
X_13340_ _13340_/Y _13321_/A _13347_/S _13339_/Y VPWR VGND sg13cmos5l_a21oi_1
X_10552_ _10585_/S _10552_/A _10552_/B VPWR VGND sg13cmos5l_nand2_1
X_13271_ _13276_/S _13216_/Y _13228_/Y _13262_/Y _13268_/Y _13270_/Y VPWR VGND sg13cmos5l_a221oi_1
X_19437__793 _19437_/RESET_B VPWR VGND sg13cmos5l_tiehi
X_12222_ _12222_/Y _18809_/Q _12218_/Y _12221_/Y _18808_/Q VPWR VGND sg13cmos5l_a22oi_1
X_15010_ _15010_/Y _14999_/Y _15003_/Y _14827_/Y VPWR VGND sg13cmos5l_a21oi_1
X_10483_ _10501_/A _10483_/A _10483_/B VPWR VGND sg13cmos5l_xnor2_1
X_12153_ _12154_/C _12153_/A _12153_/B _12153_/C VPWR VGND sg13cmos5l_nand3_1
X_12084_ _12084_/Y _12083_/A _12084_/B VPWR VGND sg13cmos5l_nand2b_1
X_18828__1444 _18828_/RESET_B VPWR VGND sg13cmos5l_tiehi
X_16961_ _16961_/Y _16961_/A VPWR VGND sg13cmos5l_inv_1
X_11104_ _11123_/C _11107_/C _11104_/B VPWR VGND sg13cmos5l_and2_1
X_18700_ _18700_/Q clkload56/A _18700_/D _18700_/RESET_B VPWR VGND sg13cmos5l_dfrbpq_1
X_11035_ _11037_/A _11036_/B _11036_/C _11087_/B VPWR VGND sg13cmos5l_a21oi_1
X_19368__865 _19368_/RESET_B VPWR VGND sg13cmos5l_tiehi
X_15912_ _15918_/B _19377_/Q _19378_/Q _15912_/C _19376_/Q VPWR VGND sg13cmos5l_nor4_1
X_16892_ _16908_/D _19485_/Q _19483_/Q _19484_/Q VPWR VGND sg13cmos5l_or3_1
X_19680_ _19680_/Q clkload20/A _19680_/D _19680_/RESET_B VPWR VGND sg13cmos5l_dfrbpq_1
X_18631_ _18631_/Q _19790_/CLK _18631_/D _18631_/RESET_B VPWR VGND sg13cmos5l_dfrbpq_1
X_15843_ _15844_/B _15851_/B _15841_/B _15842_/Y VPWR VGND sg13cmos5l_o21ai_1
X_12986_ _12986_/Y _12986_/A _12986_/B VPWR VGND sg13cmos5l_nand2_1
X_18562_ _18562_/Q clkload27/A _18562_/D _18562_/RESET_B VPWR VGND sg13cmos5l_dfrbpq_1
X_15774_ _15774_/Y _15774_/A _19318_/Q _15779_/C VPWR VGND sg13cmos5l_nor3_1
X_19198__1047 _19198_/RESET_B VPWR VGND sg13cmos5l_tiehi
XFILLER_80_819 VPWR VGND sg13cmos5l_fill_2
X_18731__1550 _18731_/RESET_B VPWR VGND sg13cmos5l_tiehi
X_17513_ _17628_/B _17526_/A _17526_/B VPWR VGND sg13cmos5l_nand2_1
X_14725_ _14725_/Y _14725_/A _14725_/B _14725_/C VPWR VGND sg13cmos5l_nand3_1
X_11937_ _11937_/Y _18730_/Q _11937_/B VPWR VGND sg13cmos5l_nor2_1
X_18493_ _18493_/X _19722_/Q _18498_/C VPWR VGND sg13cmos5l_and2_1
X_11868_ _11876_/B _11744_/B _11867_/B _11867_/Y VPWR VGND sg13cmos5l_o21ai_1
X_19520__696 _19520_/RESET_B VPWR VGND sg13cmos5l_tiehi
X_17444_ _17480_/A _19567_/Q _19568_/Q VPWR VGND sg13cmos5l_xor2_1
X_14656_ _14656_/Y _19209_/Q _14673_/A _10239_/Y _19210_/Q VPWR VGND sg13cmos5l_a22oi_1
X_11799_ _11992_/A _18749_/Q _11800_/B VPWR VGND sg13cmos5l_xnor2_1
X_13607_ _13607_/Y _13607_/A _19038_/Q VPWR VGND sg13cmos5l_nor2b_1
X_17375_ _19592_/D _17375_/A _17375_/B VPWR VGND sg13cmos5l_and2_1
X_10819_ _10819_/Y _10945_/C _10321_/Y _10817_/Y VPWR VGND sg13cmos5l_o21ai_1
X_14587_ _14611_/B _14599_/B _14599_/C VPWR VGND sg13cmos5l_and2_1
XFILLER_32_267 VPWR VGND sg13cmos5l_fill_2
X_13538_ _13544_/A _13543_/A _13543_/B _13537_/X _13451_/Y VPWR VGND sg13cmos5l_a22oi_1
X_19375__858 _19375_/RESET_B VPWR VGND sg13cmos5l_tiehi
X_16326_ _16326_/Y _16404_/A _19401_/Q _16325_/Y VPWR VGND sg13cmos5l_o21ai_1
X_19114_ _19114_/Q clkload52/A _19114_/D _19114_/RESET_B VPWR VGND sg13cmos5l_dfrbpq_1
X_19045_ _19045_/Q clkload38/A _19045_/D _19045_/RESET_B VPWR VGND sg13cmos5l_dfrbpq_1
X_13469_ _13513_/A _18999_/Q _13470_/B VPWR VGND sg13cmos5l_xnor2_1
X_16257_ _16320_/B _16257_/A _16257_/B VPWR VGND sg13cmos5l_nor2_1
XFILLER_9_496 VPWR VGND sg13cmos5l_decap_4
X_16188_ _16188_/Y _16227_/A _19432_/Q VPWR VGND sg13cmos5l_nand2_1
X_15208_ _15209_/A _19234_/Q _15205_/Y _15207_/Y VPWR VGND sg13cmos5l_o21ai_1
X_15139_ _15139_/Y _15139_/A _15142_/B _15142_/C VPWR VGND sg13cmos5l_nor3_1
X_19037__496 _19037_/D VPWR VGND sg13cmos5l_tielo
X_18829_ _18829_/Q clkload69/A _18829_/D _18829_/RESET_B VPWR VGND sg13cmos5l_dfrbpq_1
XFILLER_82_134 VPWR VGND sg13cmos5l_fill_2
XFILLER_12_919 VPWR VGND sg13cmos5l_fill_1
XFILLER_24_757 VPWR VGND sg13cmos5l_fill_1
XFILLER_51_598 VPWR VGND sg13cmos5l_fill_1
X_19069__1186 _19069_/RESET_B VPWR VGND sg13cmos5l_tiehi
X_18609__1687 _18609_/RESET_B VPWR VGND sg13cmos5l_tiehi
XFILLER_3_639 VPWR VGND sg13cmos5l_fill_1
XFILLER_59_610 VPWR VGND sg13cmos5l_fill_1
XFILLER_48_12 VPWR VGND sg13cmos5l_fill_1
X_19467__753 _19467_/RESET_B VPWR VGND sg13cmos5l_tiehi
XFILLER_86_451 VPWR VGND sg13cmos5l_fill_2
XFILLER_48_45 VPWR VGND sg13cmos5l_decap_8
XFILLER_24_1025 VPWR VGND sg13cmos5l_decap_4
X_12840_ _12977_/A _12826_/Y _12839_/Y _12838_/Y VPWR VGND sg13cmos5l_a21oi_1
X_12771_ _12771_/Y _13290_/A _13291_/A _12754_/B _12519_/B VPWR VGND sg13cmos5l_a22oi_1
X_11722_ _11722_/Y _11722_/A _11742_/B VPWR VGND sg13cmos5l_nor2_1
XFILLER_42_532 VPWR VGND sg13cmos5l_fill_2
X_15490_ _15490_/Y _19312_/Q _15481_/Y _15489_/Y _19313_/Q VPWR VGND sg13cmos5l_a22oi_1
X_14510_ _14616_/A _19177_/Q _14512_/B VPWR VGND sg13cmos5l_nor2_1
X_19194__1053 _19194_/RESET_B VPWR VGND sg13cmos5l_tiehi
X_11653_ _11653_/Y _18725_/Q _11649_/Y _11652_/Y _18724_/Q VPWR VGND sg13cmos5l_a22oi_1
XFILLER_80_32 VPWR VGND sg13cmos5l_fill_2
XFILLER_42_587 VPWR VGND sg13cmos5l_fill_2
XFILLER_14_289 VPWR VGND sg13cmos5l_fill_2
X_14441_ _14441_/Y _14441_/A _14457_/D _14441_/C VPWR VGND sg13cmos5l_nand3_1
XFILLER_30_738 VPWR VGND sg13cmos5l_fill_2
Xfanout82 fanout82/X _10739_/X VPWR VGND sg13cmos5l_buf_1
Xfanout71 fanout71/X fanout82/X VPWR VGND sg13cmos5l_buf_1
X_19474__746 _19474_/RESET_B VPWR VGND sg13cmos5l_tiehi
X_17160_ _17160_/Y _16989_/C _17155_/X _17159_/Y VPWR VGND sg13cmos5l_a21oi_1
Xfanout60 _10633_/A _10627_/Y VPWR VGND sg13cmos5l_buf_1
X_14372_ _19137_/D _14377_/A _14372_/B VPWR VGND sg13cmos5l_nor2_1
X_10604_ _10605_/B _10645_/A _18544_/A _10616_/B VPWR VGND sg13cmos5l_mux2_1
X_11584_ _11584_/Y _11593_/B VPWR VGND sg13cmos5l_inv_1
Xfanout93 fanout93/X fanout98/X VPWR VGND sg13cmos5l_buf_1
X_13323_ _13323_/Y _13323_/A _18940_/Q _13329_/C VPWR VGND sg13cmos5l_nor3_1
X_16111_ _16141_/B _19373_/Q _16111_/B VPWR VGND sg13cmos5l_xor2_1
X_17091_ _19552_/D _17091_/A _17091_/B VPWR VGND sg13cmos5l_nor2_1
X_10535_ _10575_/B _10535_/A _10536_/B VPWR VGND sg13cmos5l_xnor2_1
XFILLER_10_473 VPWR VGND sg13cmos5l_decap_4
X_13254_ _13254_/Y _13241_/Y _13244_/X _13255_/A _13255_/B VPWR VGND sg13cmos5l_a22oi_1
X_10466_ _10467_/B _19792_/Q _10447_/Y _10444_/Y VPWR VGND sg13cmos5l_a21oi_1
XFILLER_6_466 VPWR VGND sg13cmos5l_fill_2
X_16042_ _16042_/Y _16042_/A _19360_/Q VPWR VGND sg13cmos5l_nor2_1
X_12205_ _12205_/Y _12726_/A _18769_/Q _18770_/Q _12727_/A _12204_/Y VPWR VGND sg13cmos5l_a221oi_1
X_13185_ _13293_/B _13199_/S _13183_/X _13184_/Y VPWR VGND sg13cmos5l_a21o_1
X_12136_ _12138_/A _12136_/A _12136_/B VPWR VGND sg13cmos5l_nor2_1
X_10397_ _10397_/X _10397_/A _19809_/Q VPWR VGND sg13cmos5l_or2_1
X_19801_ _19801_/Q _19805_/CLK _19801_/D _19801_/RESET_B VPWR VGND sg13cmos5l_dfrbpq_1
X_17993_ _17993_/X _17977_/Y _18263_/B _17993_/S VPWR VGND sg13cmos5l_mux2_1
X_12067_ _12069_/B _18801_/Q _18802_/Q _18803_/Q VPWR VGND sg13cmos5l_o21ai_1
X_16944_ _16944_/Y _19521_/Q _19482_/Q VPWR VGND sg13cmos5l_nand2_1
XFILLER_78_974 VPWR VGND sg13cmos5l_decap_8
X_19732_ _19732_/Q clkload35/A _19732_/D _19732_/RESET_B VPWR VGND sg13cmos5l_dfrbpq_1
XFILLER_78_996 VPWR VGND sg13cmos5l_decap_4
X_16875_ _16875_/Y _16843_/Y _16868_/Y _17079_/B VPWR VGND sg13cmos5l_o21ai_1
X_11018_ _11018_/Y _11049_/B _11049_/C _11049_/A VPWR VGND sg13cmos5l_a21oi_1
X_19663_ _19663_/Q clkload12/A _19663_/D _19663_/RESET_B VPWR VGND sg13cmos5l_dfrbpq_1
XFILLER_92_421 VPWR VGND sg13cmos5l_fill_2
X_18614_ _18614_/Q clkload47/A _18614_/D _18614_/RESET_B VPWR VGND sg13cmos5l_dfrbpq_1
X_15826_ _15826_/Y _15826_/A _15827_/B VPWR VGND sg13cmos5l_nor2b_1
X_19594_ _19594_/Q clkload37/A _19594_/D _19594_/RESET_B VPWR VGND sg13cmos5l_dfrbpq_1
XFILLER_37_359 VPWR VGND sg13cmos5l_fill_2
X_12969_ _12969_/Y _12993_/A _12969_/B VPWR VGND sg13cmos5l_nor2_1
X_15757_ _15757_/Y _19380_/Q _15764_/B _19317_/Q _16313_/A VPWR VGND sg13cmos5l_a22oi_1
XFILLER_18_584 VPWR VGND sg13cmos5l_fill_1
X_18545_ _19780_/D _18545_/A _18547_/B VPWR VGND sg13cmos5l_nor2_1
X_15688_ _15688_/Y _15688_/A _15710_/B VPWR VGND sg13cmos5l_nor2_1
X_14708_ _19196_/D _14708_/A _14708_/B VPWR VGND sg13cmos5l_and2_1
X_18476_ _19755_/D _18476_/A _18480_/A VPWR VGND sg13cmos5l_nor2_1
X_17427_ _17427_/Y _17411_/A _17416_/Y _17672_/B VPWR VGND sg13cmos5l_o21ai_1
X_14639_ _19174_/D _14639_/A _14639_/B VPWR VGND sg13cmos5l_nor2_1
X_17358_ _17358_/Y _17322_/B fanout26/X _17375_/A VPWR VGND sg13cmos5l_o21ai_1
X_17289_ _17289_/Y _17373_/B VPWR VGND sg13cmos5l_inv_1
X_16309_ _19425_/D _16309_/A _16312_/B VPWR VGND sg13cmos5l_nor2_1
Xclkload30 clkload30/Y clkload30/A VPWR VGND sg13cmos5l_inv_4
Xclkload41 clkload41/Y clkload41/A VPWR VGND sg13cmos5l_inv_2
X_19028_ _19028_/Q clkload29/A _19028_/D _19028_/RESET_B VPWR VGND sg13cmos5l_dfrbpq_1
X_18892__1377 _18892_/RESET_B VPWR VGND sg13cmos5l_tiehi
XFILLER_62_0 VPWR VGND sg13cmos5l_fill_1
Xclkload52 clkload52/Y clkload52/A VPWR VGND sg13cmos5l_inv_2
X_19065__1192 _19065_/RESET_B VPWR VGND sg13cmos5l_tiehi
Xclkload63 clkload63/Y clkload63/A VPWR VGND sg13cmos5l_inv_2
Xhold2814 hold2814/X _13903_/Y VPWR VGND sg13cmos5l_dlygate4sd3_1
Xhold2803 _14764_/A _19220_/Q VPWR VGND sg13cmos5l_dlygate4sd3_1
Xhold2847 _13547_/C _13546_/Y VPWR VGND sg13cmos5l_dlygate4sd3_1
Xhold2825 hold2825/X _19673_/Q VPWR VGND sg13cmos5l_dlygate4sd3_1
Xhold2836 _15965_/A _19383_/Q VPWR VGND sg13cmos5l_dlygate4sd3_1
Xhold2869 hold2869/X _13684_/X VPWR VGND sg13cmos5l_dlygate4sd3_1
Xhold2858 _11627_/B _11551_/Y VPWR VGND sg13cmos5l_dlygate4sd3_1
XFILLER_84_966 VPWR VGND sg13cmos5l_decap_8
XFILLER_84_999 VPWR VGND sg13cmos5l_fill_2
XFILLER_83_454 VPWR VGND sg13cmos5l_fill_1
XFILLER_36_370 VPWR VGND sg13cmos5l_fill_2
XFILLER_70_137 VPWR VGND sg13cmos5l_decap_8
XFILLER_52_852 VPWR VGND sg13cmos5l_fill_1
XFILLER_34_36 VPWR VGND sg13cmos5l_decap_4
Xclkload2 clkload2/X clkload2/A VPWR VGND sg13cmos5l_buf_8
X_10320_ _10320_/Y _10828_/A VPWR VGND sg13cmos5l_inv_1
X_19434__796 _19434_/RESET_B VPWR VGND sg13cmos5l_tiehi
X_10251_ _14098_/B _19066_/Q VPWR VGND sg13cmos5l_inv_1
X_19669__1790 _19669_/RESET_B VPWR VGND sg13cmos5l_tiehi
XFILLER_106_898 VPWR VGND sg13cmos5l_fill_1
XFILLER_79_727 VPWR VGND sg13cmos5l_fill_1
X_10182_ _18475_/A _10182_/A VPWR VGND sg13cmos5l_inv_1
X_14990_ _14990_/Y _14995_/B _14995_/C _14995_/A VPWR VGND sg13cmos5l_a21oi_1
Xfanout250 _15466_/A _15235_/Y VPWR VGND sg13cmos5l_buf_1
Xfanout283 _13569_/B1 _13583_/A VPWR VGND sg13cmos5l_buf_1
Xfanout272 _14083_/A _13858_/Y VPWR VGND sg13cmos5l_buf_1
X_13941_ _14043_/C _19091_/Q _13951_/B _13952_/A VPWR VGND sg13cmos5l_o21ai_1
Xfanout261 _14909_/B _14688_/Y VPWR VGND sg13cmos5l_buf_1
Xfanout294 _12732_/A _12735_/A VPWR VGND sg13cmos5l_buf_1
XFILLER_47_624 VPWR VGND sg13cmos5l_fill_1
X_19365__868 _19365_/RESET_B VPWR VGND sg13cmos5l_tiehi
X_16660_ _19484_/D _16825_/A _16660_/B VPWR VGND sg13cmos5l_nor2_1
XFILLER_75_999 VPWR VGND sg13cmos5l_fill_2
XFILLER_75_76 VPWR VGND sg13cmos5l_fill_2
X_13872_ _19067_/D _09998_/Y fanout74/X _13871_/Y VPWR VGND sg13cmos5l_a21oi_1
X_19117__1134 _19117_/RESET_B VPWR VGND sg13cmos5l_tiehi
XFILLER_34_307 VPWR VGND sg13cmos5l_fill_1
X_12823_ _12849_/B _12813_/Y _12817_/Y _12821_/Y VPWR VGND sg13cmos5l_a21o_1
X_16591_ _16591_/Y _16591_/A VPWR VGND sg13cmos5l_inv_1
X_18944__1319 _18944_/RESET_B VPWR VGND sg13cmos5l_tiehi
X_15611_ _15639_/B _19333_/Q _19334_/Q VPWR VGND sg13cmos5l_nor2_1
X_12754_ _12754_/Y _18850_/Q _12754_/B _12754_/C VPWR VGND sg13cmos5l_nand3_1
X_15542_ _15542_/Y _15542_/A _15542_/B VPWR VGND sg13cmos5l_nor2_1
X_18330_ _18330_/Y _18309_/B _18309_/C _18341_/B VPWR VGND sg13cmos5l_a21oi_1
X_11705_ _11742_/A _18699_/Q _11705_/B VPWR VGND sg13cmos5l_xnor2_1
X_19729__1277 _19729_/RESET_B VPWR VGND sg13cmos5l_tiehi
X_18261_ _18262_/C _18261_/A _18261_/B VPWR VGND sg13cmos5l_nor2_1
X_12685_ _12685_/Y _12685_/A _12685_/B _12685_/C VPWR VGND sg13cmos5l_nor3_1
X_17212_ _17212_/Y _19561_/Q _19522_/Q VPWR VGND sg13cmos5l_xnor2_1
X_15473_ _15473_/Y _19336_/Q _15497_/B VPWR VGND sg13cmos5l_nand2_1
X_19020__1240 _19020_/RESET_B VPWR VGND sg13cmos5l_tiehi
X_11636_ _11636_/Y _12191_/A _18684_/Q _18683_/Q _12190_/A _11634_/Y VPWR VGND sg13cmos5l_a221oi_1
X_18192_ _18192_/Y _18174_/A _18174_/B _18185_/Y _18190_/Y _18191_/Y VPWR VGND sg13cmos5l_a221oi_1
X_14424_ _14425_/B _14405_/Y _14673_/A _14424_/S VPWR VGND sg13cmos5l_mux2_1
XFILLER_30_579 VPWR VGND sg13cmos5l_fill_1
X_11567_ _11567_/Y _11591_/A _11562_/Y _11630_/B _11477_/B VPWR VGND sg13cmos5l_a22oi_1
X_17143_ _19559_/D _17126_/Y hold2333/X _17137_/A VPWR VGND sg13cmos5l_a21oi_1
XFILLER_7_731 VPWR VGND sg13cmos5l_decap_8
X_14355_ _19123_/D _14328_/B _14350_/Y _14354_/Y VPWR VGND sg13cmos5l_a21oi_1
X_17074_ _17074_/Y _17062_/B _17070_/S _16939_/A VPWR VGND sg13cmos5l_o21ai_1
X_18604__537 _18604_/D VPWR VGND sg13cmos5l_tielo
X_13306_ _13306_/Y _19002_/Q _13328_/A _18939_/Q _14076_/A VPWR VGND sg13cmos5l_a22oi_1
X_10518_ _10906_/A _19790_/Q _10519_/B VPWR VGND sg13cmos5l_xnor2_1
X_14286_ _14288_/D _14277_/A _14277_/B _14285_/Y VPWR VGND sg13cmos5l_o21ai_1
X_13237_ _13237_/Y _13237_/A _13237_/B VPWR VGND sg13cmos5l_nor2_1
X_11498_ _11498_/X _18715_/Q _11503_/B _11484_/Y VPWR VGND sg13cmos5l_a21o_1
X_16025_ _16025_/Y _16227_/A _15768_/A _16042_/A _19416_/Q VPWR VGND sg13cmos5l_a22oi_1
X_10449_ _10449_/Y _19798_/Q _10621_/B VPWR VGND sg13cmos5l_nand2_1
X_13168_ _13168_/Y _13151_/A _13384_/A _13155_/Y _13166_/Y _13167_/Y VPWR VGND sg13cmos5l_a221oi_1
XFILLER_34_4 VPWR VGND sg13cmos5l_fill_1
X_12119_ _12119_/Y _12086_/D _12069_/B _12137_/B _12111_/A _12136_/B VPWR VGND sg13cmos5l_a221oi_1
X_13099_ _13099_/Y _12947_/A _13131_/A _13096_/X VPWR VGND sg13cmos5l_o21ai_1
X_17976_ _17977_/A _17975_/C _17974_/Y _17975_/Y VPWR VGND sg13cmos5l_a21o_1
X_16927_ _16927_/Y _16927_/A VPWR VGND sg13cmos5l_inv_1
XFILLER_38_602 VPWR VGND sg13cmos5l_fill_1
X_19715_ _19715_/Q clkload10/A _19715_/D _19715_/RESET_B VPWR VGND sg13cmos5l_dfrbpq_1
XFILLER_66_944 VPWR VGND sg13cmos5l_decap_8
XFILLER_65_410 VPWR VGND sg13cmos5l_fill_1
XFILLER_37_101 VPWR VGND sg13cmos5l_fill_1
XFILLER_66_988 VPWR VGND sg13cmos5l_fill_2
X_16858_ _16858_/Y _19515_/Q _16857_/Y _16853_/Y VPWR VGND sg13cmos5l_a21oi_1
X_19646_ _19646_/Q clkload35/A _19646_/D _19646_/RESET_B VPWR VGND sg13cmos5l_dfrbpq_1
XFILLER_53_605 VPWR VGND sg13cmos5l_fill_1
XFILLER_37_145 VPWR VGND sg13cmos5l_fill_2
X_16789_ _16789_/Y _16795_/B _16787_/Y VPWR VGND sg13cmos5l_nor2b_1
XFILLER_92_284 VPWR VGND sg13cmos5l_fill_2
X_19577_ _19577_/Q clkload36/A _19577_/D _19577_/RESET_B VPWR VGND sg13cmos5l_dfrbpq_1
X_15809_ _19365_/D _16081_/A _15809_/B VPWR VGND sg13cmos5l_and2_1
X_18528_ _18529_/B _18511_/Y _10844_/A _18530_/S VPWR VGND sg13cmos5l_mux2_1
XFILLER_61_693 VPWR VGND sg13cmos5l_fill_2
X_18459_ _19742_/D _18368_/Y _18462_/S _18458_/Y VPWR VGND sg13cmos5l_a21oi_1
X_19457__763 _19457_/RESET_B VPWR VGND sg13cmos5l_tiehi
XFILLER_106_139 VPWR VGND sg13cmos5l_fill_2
XFILLER_20_38 VPWR VGND sg13cmos5l_fill_2
X_18690__1602 _18690_/RESET_B VPWR VGND sg13cmos5l_tiehi
Xhold2622 hold2622/X _11771_/Y VPWR VGND sg13cmos5l_dlygate4sd3_1
Xhold2600 _18425_/A _19751_/Q VPWR VGND sg13cmos5l_dlygate4sd3_1
Xhold2611 _17994_/B _17993_/X VPWR VGND sg13cmos5l_dlygate4sd3_1
Xhold2644 _12345_/A _18849_/Q VPWR VGND sg13cmos5l_dlygate4sd3_1
Xhold1910 _12188_/B _18751_/Q VPWR VGND sg13cmos5l_dlygate4sd3_1
Xhold2655 _10124_/A _19338_/Q VPWR VGND sg13cmos5l_dlygate4sd3_1
X_19464__756 _19464_/RESET_B VPWR VGND sg13cmos5l_tiehi
Xhold2677 _10081_/A _19039_/Q VPWR VGND sg13cmos5l_dlygate4sd3_1
Xhold2688 hold2688/X _19505_/Q VPWR VGND sg13cmos5l_dlygate4sd3_1
Xhold1921 _10006_/A _18858_/Q VPWR VGND sg13cmos5l_dlygate4sd3_1
Xhold1943 _19604_/D _17434_/Y VPWR VGND sg13cmos5l_dlygate4sd3_1
Xhold1932 _17930_/B _19623_/Q VPWR VGND sg13cmos5l_dlygate4sd3_1
Xhold2699 _13534_/C _13533_/Y VPWR VGND sg13cmos5l_dlygate4sd3_1
Xhold2666 _10598_/A _19792_/Q VPWR VGND sg13cmos5l_dlygate4sd3_1
Xhold1954 _19361_/D _15803_/Y VPWR VGND sg13cmos5l_dlygate4sd3_1
Xhold1976 _10793_/B _18577_/Q VPWR VGND sg13cmos5l_dlygate4sd3_1
Xhold1987 _18983_/D _13352_/Y VPWR VGND sg13cmos5l_dlygate4sd3_1
Xhold1965 _10013_/A _18689_/Q VPWR VGND sg13cmos5l_dlygate4sd3_1
XFILLER_72_947 VPWR VGND sg13cmos5l_decap_8
Xhold1998 _09991_/A _19236_/Q VPWR VGND sg13cmos5l_dlygate4sd3_1
XFILLER_71_479 VPWR VGND sg13cmos5l_fill_2
X_19105__1149 _19105_/RESET_B VPWR VGND sg13cmos5l_tiehi
X_18666__531 _18666_/D VPWR VGND sg13cmos5l_tielo
X_12470_ _12470_/Y _13018_/A _18810_/Q VPWR VGND sg13cmos5l_nor2_1
X_19471__749 _19471_/RESET_B VPWR VGND sg13cmos5l_tiehi
X_11421_ _11421_/Y _10011_/Y fanout81/X _11420_/Y VPWR VGND sg13cmos5l_a21oi_1
X_11352_ _18669_/D _11352_/A _11358_/A VPWR VGND sg13cmos5l_nor2_1
X_14140_ _19110_/D _09997_/Y fanout91/X _14139_/Y VPWR VGND sg13cmos5l_a21oi_1
X_10303_ _11388_/A _10303_/A VPWR VGND sg13cmos5l_inv_1
XFILLER_4_734 VPWR VGND sg13cmos5l_decap_8
XFILLER_3_211 VPWR VGND sg13cmos5l_decap_8
X_11283_ _11283_/Y _11358_/B VPWR VGND sg13cmos5l_inv_1
X_14071_ _19088_/D _14071_/A _14071_/B VPWR VGND sg13cmos5l_and2_1
XFILLER_106_684 VPWR VGND sg13cmos5l_fill_2
X_13022_ _18926_/D _13022_/A _13027_/A VPWR VGND sg13cmos5l_nor2_1
XFILLER_4_789 VPWR VGND sg13cmos5l_fill_2
X_10234_ _14673_/A _10234_/A VPWR VGND sg13cmos5l_inv_1
X_18658__1635 _18658_/RESET_B VPWR VGND sg13cmos5l_tiehi
X_10165_ _17935_/A _10165_/A VPWR VGND sg13cmos5l_inv_1
X_17830_ _17830_/X _19673_/Q _19674_/Q VPWR VGND sg13cmos5l_xor2_1
XFILLER_94_516 VPWR VGND sg13cmos5l_fill_1
X_19500_ _19500_/Q clkload32/A _19500_/D _19500_/RESET_B VPWR VGND sg13cmos5l_dfrbpq_1
X_17761_ _17780_/B _19615_/Q _17761_/B VPWR VGND sg13cmos5l_xor2_1
X_10096_ _14908_/A _10096_/A VPWR VGND sg13cmos5l_inv_1
X_14973_ _14973_/Y _09991_/Y fanout72/X _14972_/Y VPWR VGND sg13cmos5l_a21oi_1
X_16712_ _16712_/Y _16910_/A _16712_/B VPWR VGND sg13cmos5l_nor2_1
X_13924_ _14013_/A _13517_/X _13923_/Y _13924_/S VPWR VGND sg13cmos5l_mux2_1
X_17692_ _17692_/Y _17693_/B _17688_/X _17691_/Y VPWR VGND sg13cmos5l_a21oi_1
X_16643_ _16643_/Y _13675_/Y _16631_/X _16633_/Y _13713_/A VPWR VGND sg13cmos5l_a22oi_1
XFILLER_74_284 VPWR VGND sg13cmos5l_decap_8
X_19431_ _19431_/Q clkload9/A _19431_/D _19431_/RESET_B VPWR VGND sg13cmos5l_dfrbpq_1
X_13855_ _13856_/B _19065_/Q _13853_/Y _14098_/B VPWR VGND sg13cmos5l_o21ai_1
X_12806_ _12806_/X _18870_/Q _18863_/Q VPWR VGND sg13cmos5l_or2_1
X_19692__1743 _19692_/RESET_B VPWR VGND sg13cmos5l_tiehi
X_19362_ _19362_/Q _19738_/CLK _19362_/D _19362_/RESET_B VPWR VGND sg13cmos5l_dfrbpq_1
XFILLER_34_126 VPWR VGND sg13cmos5l_fill_1
X_16574_ _16593_/C _19496_/Q _16578_/B _16583_/B VPWR VGND sg13cmos5l_o21ai_1
X_13786_ _13805_/B _13786_/A _13786_/B VPWR VGND sg13cmos5l_and2_1
X_10998_ _11036_/B _10987_/Y _10993_/Y _10997_/Y VPWR VGND sg13cmos5l_a21o_1
X_18313_ _18317_/B _19698_/Q _18314_/B VPWR VGND sg13cmos5l_nor2b_1
X_12737_ _12737_/Y _13285_/A _18850_/Q _12736_/Y VPWR VGND sg13cmos5l_o21ai_1
X_18908__1358 _18908_/RESET_B VPWR VGND sg13cmos5l_tiehi
X_19293_ _19293_/Q clkload43/A _19293_/D _19293_/RESET_B VPWR VGND sg13cmos5l_dfrbpq_1
X_15525_ _15525_/Y _09987_/Y fanout75/X _15524_/Y VPWR VGND sg13cmos5l_a21oi_1
X_12668_ _12668_/Y _12672_/A _12735_/B VPWR VGND sg13cmos5l_nand2_1
X_18244_ _18245_/B _18246_/B _19686_/Q VPWR VGND sg13cmos5l_nand2_1
X_15456_ _19300_/D _15456_/A _15458_/B VPWR VGND sg13cmos5l_nor2_1
XFILLER_30_332 VPWR VGND sg13cmos5l_fill_1
X_11619_ _18710_/D _11619_/A _11625_/B VPWR VGND sg13cmos5l_nor2_1
X_18175_ _18176_/B _18088_/A _18071_/Y _18068_/Y VPWR VGND sg13cmos5l_a21oi_1
X_14407_ _14407_/Y _19108_/Q _14407_/B VPWR VGND sg13cmos5l_nor2_1
X_12599_ _12702_/B _18883_/Q _12599_/B VPWR VGND sg13cmos5l_and2_1
X_17126_ _17126_/Y _17672_/A _17673_/A _17110_/B _16881_/B VPWR VGND sg13cmos5l_a22oi_1
XFILLER_7_550 VPWR VGND sg13cmos5l_decap_4
X_15387_ _15387_/Y _15292_/B _15380_/Y _15385_/Y _15297_/B VPWR VGND sg13cmos5l_a22oi_1
X_14338_ _14338_/X _14345_/A _14345_/B VPWR VGND sg13cmos5l_and2_1
X_17057_ _17064_/A _17025_/A _17040_/B _17091_/B VPWR VGND sg13cmos5l_o21ai_1
X_18811__1464 _18811_/RESET_B VPWR VGND sg13cmos5l_tiehi
X_14269_ _14269_/Y _14310_/A _14266_/A _14267_/Y VPWR VGND sg13cmos5l_o21ai_1
X_16008_ _19379_/D hold2574/X _15996_/Y _16007_/Y VPWR VGND sg13cmos5l_a21oi_1
XFILLER_98_866 VPWR VGND sg13cmos5l_fill_2
XFILLER_44_1006 VPWR VGND sg13cmos5l_fill_2
XFILLER_97_354 VPWR VGND sg13cmos5l_decap_4
XFILLER_25_0 VPWR VGND sg13cmos5l_fill_2
X_17959_ _17959_/Y _17959_/A _17962_/B _17962_/C VPWR VGND sg13cmos5l_nand3_1
X_19181__1067 _19181_/RESET_B VPWR VGND sg13cmos5l_tiehi
X_19629_ _19629_/Q clkload24/A _19629_/D _19629_/RESET_B VPWR VGND sg13cmos5l_dfrbpq_1
XFILLER_19_690 VPWR VGND sg13cmos5l_fill_1
XFILLER_40_107 VPWR VGND sg13cmos5l_fill_1
XFILLER_80_287 VPWR VGND sg13cmos5l_fill_2
XFILLER_40_118 VPWR VGND sg13cmos5l_fill_1
Xclkbuf_leaf_60_clk clkload52/A clkload2/A VPWR VGND sg13cmos5l_buf_8
XFILLER_31_59 VPWR VGND sg13cmos5l_fill_1
Xoutput15 uo_out[2] _19440_/Q VPWR VGND sg13cmos5l_buf_1
XFILLER_89_833 VPWR VGND sg13cmos5l_fill_2
X_19431__799 _19431_/RESET_B VPWR VGND sg13cmos5l_tiehi
XFILLER_89_844 VPWR VGND sg13cmos5l_fill_1
XFILLER_88_354 VPWR VGND sg13cmos5l_fill_1
Xhold2430 _10203_/A _19400_/Q VPWR VGND sg13cmos5l_dlygate4sd3_1
Xhold2452 _10048_/A _18833_/Q VPWR VGND sg13cmos5l_dlygate4sd3_1
Xhold2463 hold2463/X _11143_/Y VPWR VGND sg13cmos5l_dlygate4sd3_1
X_19157__1091 _19157_/RESET_B VPWR VGND sg13cmos5l_tiehi
Xhold2441 _10107_/A _19252_/Q VPWR VGND sg13cmos5l_dlygate4sd3_1
X_11970_ _12005_/A _18737_/Q _18738_/Q VPWR VGND sg13cmos5l_xor2_1
Xhold2474 _10061_/A _18918_/Q VPWR VGND sg13cmos5l_dlygate4sd3_1
Xhold2496 _10021_/A _18623_/Q VPWR VGND sg13cmos5l_dlygate4sd3_1
Xhold2485 _16339_/A _19396_/Q VPWR VGND sg13cmos5l_dlygate4sd3_1
X_10921_ _10921_/Y _10982_/A _10982_/B VPWR VGND sg13cmos5l_nand2_1
X_13640_ _13640_/Y hold1960/X fanout86/X _10750_/A VPWR VGND sg13cmos5l_o21ai_1
X_10852_ _10852_/Y _11116_/A _10846_/X _10853_/B _11122_/B VPWR VGND sg13cmos5l_a22oi_1
X_10783_ _10784_/B _10755_/Y _13649_/B _10782_/Y VPWR VGND sg13cmos5l_a21oi_1
XFILLER_71_298 VPWR VGND sg13cmos5l_fill_2
X_13571_ _13572_/B _13559_/A _13556_/A _13571_/S VPWR VGND sg13cmos5l_mux2_1
XFILLER_40_630 VPWR VGND sg13cmos5l_fill_1
X_19655__550 _19655_/RESET_B VPWR VGND sg13cmos5l_tiehi
X_12522_ _12522_/Y _10007_/Y fanout78/X _12521_/Y VPWR VGND sg13cmos5l_a21oi_1
Xclkbuf_leaf_51_clk clkload65/A clkbuf_4_14_0_clk/X VPWR VGND sg13cmos5l_buf_8
XFILLER_40_652 VPWR VGND sg13cmos5l_decap_8
X_16290_ _16293_/B _16290_/A VPWR VGND sg13cmos5l_inv_1
X_15310_ _15310_/Y _19278_/Q _19239_/Q VPWR VGND sg13cmos5l_xnor2_1
X_15241_ _15241_/X _15209_/Y _10217_/Y _15241_/S VPWR VGND sg13cmos5l_mux2_1
X_12453_ _12453_/Y _12453_/A _12453_/B _12453_/C VPWR VGND sg13cmos5l_nand3_1
XFILLER_8_369 VPWR VGND sg13cmos5l_fill_1
X_12384_ _12402_/A _18839_/Q _12414_/B VPWR VGND sg13cmos5l_or2_1
X_11404_ _11404_/X _11384_/Y _11650_/A _11412_/S VPWR VGND sg13cmos5l_mux2_1
X_15172_ _19249_/D hold2595/X _15173_/S _15171_/Y VPWR VGND sg13cmos5l_a21oi_1
X_11335_ _11335_/Y _11335_/A _11335_/B VPWR VGND sg13cmos5l_nor2_1
X_14123_ _14123_/Y _15234_/A _14636_/B VPWR VGND sg13cmos5l_nor2_1
X_18931_ _18931_/Q _18931_/CLK _18931_/D _18931_/RESET_B VPWR VGND sg13cmos5l_dfrbpq_1
X_11266_ _11266_/Y _11266_/A _11295_/A VPWR VGND sg13cmos5l_nor2_1
X_14054_ _14055_/B _14054_/A _14054_/B VPWR VGND sg13cmos5l_nor2_1
XFILLER_106_481 VPWR VGND sg13cmos5l_fill_2
XFILLER_97_74 VPWR VGND sg13cmos5l_fill_1
X_13005_ _13005_/Y _12976_/Y _13007_/A _13019_/B VPWR VGND sg13cmos5l_o21ai_1
X_10217_ _10217_/Y _10217_/A VPWR VGND sg13cmos5l_inv_1
X_18862_ _18862_/Q clkload68/A _18862_/D _18862_/RESET_B VPWR VGND sg13cmos5l_dfrbpq_1
X_11197_ _18655_/D _11358_/A _11318_/A VPWR VGND sg13cmos5l_nor2_1
X_19662__543 _19662_/RESET_B VPWR VGND sg13cmos5l_tiehi
X_10148_ _17084_/A _10148_/A VPWR VGND sg13cmos5l_inv_1
X_18793_ _18793_/Q _18902_/CLK _18793_/D _18793_/RESET_B VPWR VGND sg13cmos5l_dfrbpq_1
XFILLER_79_398 VPWR VGND sg13cmos5l_fill_2
X_17813_ _17815_/B _19677_/Q _17824_/B VPWR VGND sg13cmos5l_nand2b_1
X_10079_ _16820_/A _10079_/A VPWR VGND sg13cmos5l_inv_1
X_17744_ _17744_/Y _17759_/A _17780_/A VPWR VGND sg13cmos5l_nand2_1
XFILLER_48_763 VPWR VGND sg13cmos5l_fill_2
X_14956_ _14956_/Y _15234_/A _15453_/B VPWR VGND sg13cmos5l_nor2_1
X_13907_ _13907_/Y _13907_/A _13923_/B VPWR VGND sg13cmos5l_nor2_1
XFILLER_36_947 VPWR VGND sg13cmos5l_decap_8
X_17675_ _19632_/D _17678_/A _17675_/B VPWR VGND sg13cmos5l_nor2_1
X_14887_ _14887_/Y _14887_/A _14887_/B VPWR VGND sg13cmos5l_nor2_1
X_19414_ _19414_/Q clkload5/A _19414_/D _19414_/RESET_B VPWR VGND sg13cmos5l_dfrbpq_1
X_16626_ _16631_/B _19033_/Q _19034_/Q _19031_/Q _19032_/Q VPWR VGND sg13cmos5l_nor4_1
X_13838_ _13839_/A _13836_/Y _13837_/Y _13849_/C VPWR VGND sg13cmos5l_mux2_1
X_13769_ _13770_/B _13786_/A _13769_/B VPWR VGND sg13cmos5l_nand2_1
X_19345_ _19345_/Q clkload16/A _19345_/D _19345_/RESET_B VPWR VGND sg13cmos5l_dfrbpq_1
X_16557_ _16557_/Y _16452_/A _16452_/B _16562_/A VPWR VGND sg13cmos5l_a21oi_1
Xclkbuf_leaf_42_clk clkload62/A clkload3/A VPWR VGND sg13cmos5l_buf_8
X_15508_ _15508_/X _15481_/Y _10213_/Y _15516_/S VPWR VGND sg13cmos5l_mux2_1
X_19276_ _19276_/Q _19738_/CLK _19276_/D _19276_/RESET_B VPWR VGND sg13cmos5l_dfrbpq_1
X_18227_ _19714_/D _18227_/A _18227_/B VPWR VGND sg13cmos5l_nor2_1
X_16488_ _16524_/B _16488_/A _16500_/B VPWR VGND sg13cmos5l_nand2_1
X_19709__1599 _19709_/RESET_B VPWR VGND sg13cmos5l_tiehi
X_15439_ _15439_/Y _15439_/A _15451_/A VPWR VGND sg13cmos5l_nor2_1
X_19454__766 _19454_/RESET_B VPWR VGND sg13cmos5l_tiehi
XFILLER_11_1016 VPWR VGND sg13cmos5l_fill_2
X_18158_ _18158_/Y _18125_/Y _18130_/Y _18340_/A VPWR VGND sg13cmos5l_a21oi_1
X_17109_ _17109_/Y _17109_/A VPWR VGND sg13cmos5l_inv_1
X_18089_ _18089_/X _18186_/B _18202_/A _18090_/C VPWR VGND sg13cmos5l_and3_1
XFILLER_104_429 VPWR VGND sg13cmos5l_fill_2
X_18739__1539 _18739_/RESET_B VPWR VGND sg13cmos5l_tiehi
XFILLER_98_630 VPWR VGND sg13cmos5l_fill_1
Xheichips26_digital_project_1805 uio_oe[8] VPWR VGND sg13cmos5l_tiehi
X_18617__536 _18617_/D VPWR VGND sg13cmos5l_tielo
X_19461__759 _19461_/RESET_B VPWR VGND sg13cmos5l_tiehi
XFILLER_54_744 VPWR VGND sg13cmos5l_fill_2
XFILLER_54_733 VPWR VGND sg13cmos5l_decap_8
XFILLER_14_619 VPWR VGND sg13cmos5l_fill_2
Xclkbuf_leaf_33_clk clkload38/A clkbuf_4_6_0_clk/X VPWR VGND sg13cmos5l_buf_8
XFILLER_50_972 VPWR VGND sg13cmos5l_fill_2
X_18698__1592 _18698_/RESET_B VPWR VGND sg13cmos5l_tiehi
X_11120_ _11121_/C _11120_/A _11120_/B VPWR VGND sg13cmos5l_nor2_1
X_11051_ _11051_/Y _11090_/B _11051_/B VPWR VGND sg13cmos5l_nand2_1
X_10002_ _10002_/Y _13212_/A VPWR VGND sg13cmos5l_inv_1
X_18567__1738 _18567_/RESET_B VPWR VGND sg13cmos5l_tiehi
Xhold2271 _10321_/A _19765_/Q VPWR VGND sg13cmos5l_dlygate4sd3_1
X_14810_ _14810_/Y _14810_/A _14997_/A VPWR VGND sg13cmos5l_nor2_1
Xhold2282 _19275_/D _15248_/Y VPWR VGND sg13cmos5l_dlygate4sd3_1
Xhold2260 _10228_/A _19189_/Q VPWR VGND sg13cmos5l_dlygate4sd3_1
X_15790_ _15790_/Y _15772_/B _15798_/S _15864_/A VPWR VGND sg13cmos5l_o21ai_1
Xhold2293 _19061_/D _13862_/Y VPWR VGND sg13cmos5l_dlygate4sd3_1
X_11953_ _11953_/Y _10286_/Y fanout55/X _11952_/Y VPWR VGND sg13cmos5l_a21oi_1
X_14741_ _14742_/B _14743_/B _14740_/X _14736_/X VPWR VGND sg13cmos5l_o21ai_1
XFILLER_29_284 VPWR VGND sg13cmos5l_fill_1
X_11884_ _11885_/B _11863_/B _11860_/A _11890_/S VPWR VGND sg13cmos5l_mux2_1
X_17460_ _17460_/Y _17447_/X _17453_/Y _17458_/Y VPWR VGND sg13cmos5l_o21ai_1
X_10904_ _10904_/Y _10904_/A _10904_/B VPWR VGND sg13cmos5l_nor2_1
X_14672_ _14672_/Y _10229_/Y _14663_/Y _14667_/A _14935_/A _14671_/Y VPWR VGND sg13cmos5l_a221oi_1
X_13623_ _13623_/Y _17417_/A _19045_/Q VPWR VGND sg13cmos5l_nor2_1
X_10835_ _10835_/Y _10945_/C _11357_/A VPWR VGND sg13cmos5l_nand2_1
X_17391_ _17402_/B _19560_/Q _17388_/Y _17390_/Y VPWR VGND sg13cmos5l_o21ai_1
XFILLER_26_980 VPWR VGND sg13cmos5l_decap_4
X_16411_ _16411_/Y _16414_/B _16411_/B VPWR VGND sg13cmos5l_nor2_1
Xclkbuf_leaf_24_clk clkload30/A clkbuf_4_5_0_clk/X VPWR VGND sg13cmos5l_buf_8
XFILLER_60_769 VPWR VGND sg13cmos5l_fill_1
X_16342_ _16342_/Y _19439_/Q _16338_/Y _16341_/Y _19438_/Q VPWR VGND sg13cmos5l_a22oi_1
X_19130_ _19130_/Q clkload52/A _19130_/D _19130_/RESET_B VPWR VGND sg13cmos5l_dfrbpq_1
X_10766_ _10766_/Y _18591_/Q _18583_/Q VPWR VGND sg13cmos5l_nand2_1
X_13554_ _13555_/B _13554_/A _13554_/B VPWR VGND sg13cmos5l_xor2_1
XFILLER_8_100 VPWR VGND sg13cmos5l_decap_4
XFILLER_9_612 VPWR VGND sg13cmos5l_fill_2
X_10697_ _10697_/Y _13587_/B _10716_/A VPWR VGND sg13cmos5l_nand2_1
X_12505_ _12506_/B _18855_/Q _12502_/Y _12754_/B VPWR VGND sg13cmos5l_o21ai_1
X_13485_ _13485_/X _13485_/A _13485_/B VPWR VGND sg13cmos5l_xor2_1
XFILLER_8_133 VPWR VGND sg13cmos5l_decap_8
XFILLER_9_667 VPWR VGND sg13cmos5l_fill_1
X_16273_ _16273_/Y _16273_/A _16273_/B _16273_/C VPWR VGND sg13cmos5l_nand3_1
X_19061_ _19061_/Q _19136_/CLK _19061_/D _19061_/RESET_B VPWR VGND sg13cmos5l_dfrbpq_1
X_12436_ _12453_/B _12436_/A _12436_/B VPWR VGND sg13cmos5l_and2_1
X_15224_ _15224_/Y _19272_/Q _15209_/Y _15223_/Y _19273_/Q _15219_/Y VPWR VGND sg13cmos5l_a221oi_1
X_18012_ _18012_/X _18012_/A _18026_/D _18012_/C VPWR VGND sg13cmos5l_and3_1
X_15155_ _15164_/A _15045_/Y _15155_/B _15155_/C VPWR VGND sg13cmos5l_nand3b_1
X_19800__1756 _19800_/RESET_B VPWR VGND sg13cmos5l_tiehi
X_12367_ _12574_/A _12334_/A _12554_/A VPWR VGND sg13cmos5l_nand2b_1
X_14106_ _14106_/X _14106_/A _14106_/B VPWR VGND sg13cmos5l_or2_1
X_12298_ _18822_/D _12460_/B _12298_/B VPWR VGND sg13cmos5l_nor2_1
X_11318_ _11318_/Y _11318_/A _11325_/B VPWR VGND sg13cmos5l_nand2_1
XFILLER_4_394 VPWR VGND sg13cmos5l_decap_4
X_15086_ _15093_/A _19268_/Q _15086_/B VPWR VGND sg13cmos5l_xor2_1
X_18914_ _18914_/Q clkload64/A _18914_/D _18914_/RESET_B VPWR VGND sg13cmos5l_dfrbpq_1
X_11249_ _11269_/B _18679_/Q _11250_/B VPWR VGND sg13cmos5l_nor2b_1
X_14037_ _14038_/A _13939_/Y _14052_/A _14037_/C VPWR VGND sg13cmos5l_nand3b_1
X_18845_ _18845_/Q clkload70/A _18845_/D _18845_/RESET_B VPWR VGND sg13cmos5l_dfrbpq_1
X_19100__1154 _19100_/RESET_B VPWR VGND sg13cmos5l_tiehi
X_18776_ _18776_/Q _18902_/CLK _18776_/D _18776_/RESET_B VPWR VGND sg13cmos5l_dfrbpq_1
X_15988_ _15995_/A _15959_/A _16022_/B VPWR VGND sg13cmos5l_nand2b_1
XFILLER_82_349 VPWR VGND sg13cmos5l_fill_2
X_17727_ _17727_/Y _17711_/A _17719_/S _17770_/A VPWR VGND sg13cmos5l_o21ai_1
X_14939_ _14939_/Y _19228_/Q _14931_/Y _14938_/Y _19229_/Q VPWR VGND sg13cmos5l_a22oi_1
X_17658_ _17660_/B _17658_/A _17659_/A VPWR VGND sg13cmos5l_nor2b_1
X_16609_ _19472_/D _16609_/A _16609_/B VPWR VGND sg13cmos5l_nor2_1
XFILLER_92_0 VPWR VGND sg13cmos5l_fill_2
Xclkbuf_leaf_15_clk clkload37/A clkbuf_4_6_0_clk/X VPWR VGND sg13cmos5l_buf_8
X_17589_ _17591_/D _17593_/A _17580_/B hold2707/X VPWR VGND sg13cmos5l_o21ai_1
X_19328_ _19328_/Q clkload17/A _19328_/D _19328_/RESET_B VPWR VGND sg13cmos5l_dfrbpq_1
X_18957__1306 _18957_/RESET_B VPWR VGND sg13cmos5l_tiehi
X_19391__842 _19391_/RESET_B VPWR VGND sg13cmos5l_tiehi
X_19259_ _19259_/Q clkload42/A _19259_/D _19259_/RESET_B VPWR VGND sg13cmos5l_dfrbpq_1
X_19812__1582 _19812_/RESET_B VPWR VGND sg13cmos5l_tiehi
X_18653__1640 _18653_/RESET_B VPWR VGND sg13cmos5l_tiehi
XFILLER_105_749 VPWR VGND sg13cmos5l_fill_1
XFILLER_100_421 VPWR VGND sg13cmos5l_fill_2
X_18903__1363 _18903_/RESET_B VPWR VGND sg13cmos5l_tiehi
XFILLER_58_368 VPWR VGND sg13cmos5l_fill_1
XFILLER_27_733 VPWR VGND sg13cmos5l_fill_2
XFILLER_23_950 VPWR VGND sg13cmos5l_fill_2
X_10620_ _10632_/A _18547_/A _10648_/A VPWR VGND sg13cmos5l_nand2_1
XFILLER_50_791 VPWR VGND sg13cmos5l_fill_1
X_19652__553 _19652_/RESET_B VPWR VGND sg13cmos5l_tiehi
X_10551_ _10552_/B _10543_/Y _10548_/Y _10550_/Y VPWR VGND sg13cmos5l_o21ai_1
X_13270_ _13270_/Y _13282_/A _13270_/B VPWR VGND sg13cmos5l_nor2_1
X_10482_ _10482_/Y _10590_/A _10589_/B VPWR VGND sg13cmos5l_nand2b_1
X_12221_ _12221_/Y _12210_/B _12219_/X _12220_/Y VPWR VGND sg13cmos5l_a21oi_1
XFILLER_6_637 VPWR VGND sg13cmos5l_fill_2
X_12152_ _12158_/A _12157_/A _12157_/B _12151_/X _12055_/Y VPWR VGND sg13cmos5l_a22oi_1
XFILLER_78_32 VPWR VGND sg13cmos5l_fill_2
X_12083_ _12083_/Y _12083_/A _12084_/B VPWR VGND sg13cmos5l_nor2b_1
X_16960_ _16961_/A _17059_/A _16960_/B VPWR VGND sg13cmos5l_or2_1
XFILLER_78_65 VPWR VGND sg13cmos5l_fill_1
X_11103_ _11104_/B _18604_/Q _11625_/A VPWR VGND sg13cmos5l_nand2_1
X_11034_ _11034_/Y _11034_/A VPWR VGND sg13cmos5l_inv_1
X_15911_ _15914_/A _19393_/Q _15911_/B VPWR VGND sg13cmos5l_xnor2_1
XFILLER_103_292 VPWR VGND sg13cmos5l_fill_2
X_16891_ _19524_/D _17152_/A _16891_/B VPWR VGND sg13cmos5l_and2_1
X_18630_ _18630_/Q _19790_/CLK _18630_/D _18630_/RESET_B VPWR VGND sg13cmos5l_dfrbpq_1
XFILLER_94_53 VPWR VGND sg13cmos5l_fill_1
X_15842_ _15842_/Y _15842_/A _15856_/B VPWR VGND sg13cmos5l_nor2_1
Xhold2090 _10104_/A _19211_/Q VPWR VGND sg13cmos5l_dlygate4sd3_1
X_12985_ _12988_/A _12871_/Y _12985_/B _12985_/C VPWR VGND sg13cmos5l_nand3b_1
X_18561_ _18561_/Q clkload27/A _18561_/D _18561_/RESET_B VPWR VGND sg13cmos5l_dfrbpq_1
X_15773_ _15773_/Y _10205_/Y _15763_/A _15767_/X _15772_/X _15768_/X VPWR VGND sg13cmos5l_a221oi_1
X_11936_ _11936_/Y _12224_/A _11934_/X _11935_/Y VPWR VGND sg13cmos5l_o21ai_1
X_17512_ _17628_/A _19626_/Q _17526_/B VPWR VGND sg13cmos5l_xnor2_1
X_18492_ _18498_/C _19789_/Q _10332_/Y _18491_/Y VPWR VGND sg13cmos5l_o21ai_1
X_14724_ _14724_/X _14724_/A _14724_/B _14724_/C VPWR VGND sg13cmos5l_and3_1
XFILLER_91_179 VPWR VGND sg13cmos5l_fill_2
X_17443_ _17443_/X _19574_/Q _19567_/Q VPWR VGND sg13cmos5l_or2_1
XFILLER_45_585 VPWR VGND sg13cmos5l_fill_1
XFILLER_45_574 VPWR VGND sg13cmos5l_fill_1
X_11867_ _11867_/Y _11904_/B _11867_/B VPWR VGND sg13cmos5l_nand2_1
X_14655_ _14655_/Y _14651_/Y _14654_/Y _14653_/Y VPWR VGND sg13cmos5l_o21ai_1
X_11798_ _11806_/B _12194_/A _11800_/B VPWR VGND sg13cmos5l_and2_1
X_13606_ _13609_/B _13606_/A _13627_/A VPWR VGND sg13cmos5l_nand2_1
X_17374_ _19591_/D _17304_/C _17304_/D _17370_/B VPWR VGND sg13cmos5l_a21oi_1
X_10818_ _10818_/Y _10945_/C _10321_/Y _10322_/Y _18618_/Q VPWR VGND sg13cmos5l_a22oi_1
XFILLER_14_972 VPWR VGND sg13cmos5l_fill_1
X_14586_ _14599_/C _14586_/A _14649_/B VPWR VGND sg13cmos5l_nand2_1
XFILLER_32_279 VPWR VGND sg13cmos5l_fill_1
X_10749_ _10794_/B input7/X _10795_/C VPWR VGND sg13cmos5l_and2_1
X_13537_ _13537_/X _13504_/Y _13400_/B _13548_/B VPWR VGND sg13cmos5l_mux2_1
XFILLER_43_90 VPWR VGND sg13cmos5l_fill_1
X_16325_ _16325_/Y _19452_/Q _16349_/B VPWR VGND sg13cmos5l_nand2_1
X_19113_ _19113_/Q clkload52/A _19113_/D _19113_/RESET_B VPWR VGND sg13cmos5l_dfrbpq_1
X_19044_ _19044_/Q clkload31/A _19044_/D _19044_/RESET_B VPWR VGND sg13cmos5l_dfrbpq_1
X_16256_ _16257_/B _16256_/A _16256_/B VPWR VGND sg13cmos5l_nor2_1
XFILLER_9_464 VPWR VGND sg13cmos5l_decap_4
X_13468_ _13477_/B _18999_/Q _13476_/C _18998_/Q VPWR VGND sg13cmos5l_nor3_1
X_15207_ _15207_/Y _19292_/Q _15742_/A _15225_/C VPWR VGND sg13cmos5l_nand3_1
X_18779__1496 _18779_/RESET_B VPWR VGND sg13cmos5l_tiehi
X_12419_ _12419_/Y _12419_/A _12419_/B VPWR VGND sg13cmos5l_nor2_1
X_13399_ _13400_/B _13505_/A _13505_/B VPWR VGND sg13cmos5l_and2_1
X_16187_ _16229_/A _19431_/Q _19432_/Q VPWR VGND sg13cmos5l_xor2_1
X_19451__769 _19451_/RESET_B VPWR VGND sg13cmos5l_tiehi
X_18641__1655 _18641_/RESET_B VPWR VGND sg13cmos5l_tiehi
XFILLER_5_692 VPWR VGND sg13cmos5l_decap_4
X_15138_ _15138_/Y _15138_/A VPWR VGND sg13cmos5l_inv_1
X_15069_ _15069_/X _15074_/B _15061_/B _15271_/A VPWR VGND sg13cmos5l_a21o_1
XFILLER_68_622 VPWR VGND sg13cmos5l_fill_1
Xclkbuf_leaf_4_clk _19679_/CLK clkbuf_4_1_0_clk/X VPWR VGND sg13cmos5l_buf_8
XFILLER_96_964 VPWR VGND sg13cmos5l_decap_8
XFILLER_95_441 VPWR VGND sg13cmos5l_fill_1
XFILLER_67_132 VPWR VGND sg13cmos5l_fill_1
X_18828_ _18828_/Q clkload69/A _18828_/D _18828_/RESET_B VPWR VGND sg13cmos5l_dfrbpq_1
X_18759_ _18759_/Q clkload39/A _18759_/D _18759_/RESET_B VPWR VGND sg13cmos5l_dfrbpq_1
XFILLER_67_198 VPWR VGND sg13cmos5l_fill_1
X_19028__1229 _19028_/RESET_B VPWR VGND sg13cmos5l_tiehi
XFILLER_36_585 VPWR VGND sg13cmos5l_fill_1
XFILLER_32_791 VPWR VGND sg13cmos5l_fill_2
XFILLER_104_1025 VPWR VGND sg13cmos5l_decap_4
XFILLER_2_106 VPWR VGND sg13cmos5l_fill_1
XFILLER_2_117 VPWR VGND sg13cmos5l_decap_8
XFILLER_2_128 VPWR VGND sg13cmos5l_decap_4
XFILLER_3_8 VPWR VGND sg13cmos5l_fill_1
XFILLER_74_614 VPWR VGND sg13cmos5l_fill_1
XFILLER_59_699 VPWR VGND sg13cmos5l_decap_8
XFILLER_74_658 VPWR VGND sg13cmos5l_fill_2
X_12770_ _12770_/Y _13050_/A _12763_/B _12769_/A _13056_/B _12765_/Y VPWR VGND sg13cmos5l_a221oi_1
X_11721_ _11742_/C _11721_/A _11721_/B VPWR VGND sg13cmos5l_nor2_1
XFILLER_64_89 VPWR VGND sg13cmos5l_fill_1
X_11652_ _11652_/Y _11642_/B _11650_/Y _11651_/Y _11661_/C VPWR VGND sg13cmos5l_a22oi_1
X_14440_ _14441_/C _19115_/Q _19116_/Q _19117_/Q VPWR VGND sg13cmos5l_o21ai_1
Xfanout61 _11133_/S _11130_/Y VPWR VGND sg13cmos5l_buf_1
Xfanout50 fanout50/X _12785_/S VPWR VGND sg13cmos5l_buf_1
Xfanout72 fanout72/X fanout74/X VPWR VGND sg13cmos5l_buf_1
X_10603_ _10605_/A _10603_/A _10610_/A _10603_/C VPWR VGND sg13cmos5l_nor3_1
Xfanout83 fanout83/X fanout85/X VPWR VGND sg13cmos5l_buf_1
X_14371_ _19136_/D _14371_/A _14371_/B VPWR VGND sg13cmos5l_nor2_1
X_18734__1544 _18734_/RESET_B VPWR VGND sg13cmos5l_tiehi
Xfanout94 fanout94/X fanout98/X VPWR VGND sg13cmos5l_buf_1
X_11583_ _11593_/B _11583_/A _11596_/B _11583_/C VPWR VGND sg13cmos5l_or3_1
X_13322_ _13322_/Y _10254_/Y _13312_/A _13316_/X _13321_/X _13317_/X VPWR VGND sg13cmos5l_a221oi_1
X_16110_ _16110_/Y _16110_/A _16110_/B VPWR VGND sg13cmos5l_nor2_1
X_17090_ _19551_/D _17091_/A _17090_/B VPWR VGND sg13cmos5l_nor2_1
XFILLER_6_423 VPWR VGND sg13cmos5l_fill_2
XFILLER_10_496 VPWR VGND sg13cmos5l_fill_1
X_10534_ _10534_/Y _10567_/B _10528_/X _10533_/Y VPWR VGND sg13cmos5l_o21ai_1
X_13253_ _13255_/B _13196_/A _13294_/B _13253_/S VPWR VGND sg13cmos5l_mux2_1
X_10465_ _10465_/X _10465_/A _10610_/A _10465_/C VPWR VGND sg13cmos5l_or3_1
X_16041_ _16041_/Y _16041_/A VPWR VGND sg13cmos5l_inv_1
X_12204_ _12204_/Y _18831_/Q _12224_/A _10286_/Y _18830_/Q _12203_/Y VPWR VGND sg13cmos5l_a221oi_1
X_10396_ _10673_/B _19810_/Q _19809_/Q VPWR VGND sg13cmos5l_nor2_1
X_13184_ _13184_/Y _13142_/X _13161_/Y _13175_/Y _13178_/Y _13179_/Y VPWR VGND sg13cmos5l_a221oi_1
X_12135_ _12135_/Y _12121_/Y _12128_/X _12134_/Y VPWR VGND sg13cmos5l_o21ai_1
XFILLER_97_706 VPWR VGND sg13cmos5l_fill_1
XFILLER_89_86 VPWR VGND sg13cmos5l_fill_2
X_19800_ _19800_/Q _19805_/CLK _19800_/D _19800_/RESET_B VPWR VGND sg13cmos5l_dfrbpq_1
XFILLER_78_931 VPWR VGND sg13cmos5l_decap_8
XFILLER_78_920 VPWR VGND sg13cmos5l_fill_1
X_17992_ _17992_/Y _18257_/A _17993_/S _17991_/Y VPWR VGND sg13cmos5l_a21oi_1
X_12066_ _12123_/B _18804_/Q _12086_/D VPWR VGND sg13cmos5l_xnor2_1
X_16943_ _19530_/D _17071_/A _17025_/A VPWR VGND sg13cmos5l_nor2_1
X_19731_ _19731_/Q clkload20/A _19731_/D _19731_/RESET_B VPWR VGND sg13cmos5l_dfrbpq_1
XFILLER_2_695 VPWR VGND sg13cmos5l_fill_2
X_16874_ _16874_/Y _16848_/A fanout29/X _16873_/Y VPWR VGND sg13cmos5l_a21oi_1
X_11017_ _11049_/C _11016_/A _11016_/B _11025_/A VPWR VGND sg13cmos5l_o21ai_1
X_19662_ _19662_/Q clkload11/A _19662_/D _19662_/RESET_B VPWR VGND sg13cmos5l_dfrbpq_1
X_19593_ _19593_/Q clkload37/A _19593_/D _19593_/RESET_B VPWR VGND sg13cmos5l_dfrbpq_1
XFILLER_64_124 VPWR VGND sg13cmos5l_fill_2
X_18613_ _18613_/Q clkload45/A _18613_/D _18613_/RESET_B VPWR VGND sg13cmos5l_dfrbpq_1
XFILLER_37_349 VPWR VGND sg13cmos5l_fill_1
XFILLER_38_90 VPWR VGND sg13cmos5l_fill_2
X_15825_ _15827_/B _15642_/A _15856_/A _15860_/A _15831_/A VPWR VGND sg13cmos5l_a22oi_1
X_19381__852 _19381_/RESET_B VPWR VGND sg13cmos5l_tiehi
XFILLER_92_455 VPWR VGND sg13cmos5l_fill_1
X_19811__1581 _19811_/RESET_B VPWR VGND sg13cmos5l_tiehi
XFILLER_64_146 VPWR VGND sg13cmos5l_fill_2
X_12968_ _12969_/B _12968_/A _12968_/B VPWR VGND sg13cmos5l_xnor2_1
X_15756_ _15756_/Y _16312_/A _19316_/Q _15755_/Y VPWR VGND sg13cmos5l_a21oi_1
X_18544_ _19779_/D _18544_/A _18547_/B VPWR VGND sg13cmos5l_nor2_1
X_11919_ _11921_/B _18792_/Q _12456_/A _11938_/C VPWR VGND sg13cmos5l_or3_1
X_12899_ _12899_/Y _12941_/A _12939_/A _12895_/Y _12934_/A _12896_/Y VPWR VGND sg13cmos5l_a221oi_1
X_18475_ _19754_/D _18475_/A _18481_/A VPWR VGND sg13cmos5l_nor2_1
X_15687_ _15710_/B _15698_/B _15698_/C VPWR VGND sg13cmos5l_or2_1
X_14707_ _14707_/Y _09993_/Y fanout90/X _14706_/Y VPWR VGND sg13cmos5l_a21oi_1
X_18997__1263 _18997_/RESET_B VPWR VGND sg13cmos5l_tiehi
X_17426_ _17426_/Y _17702_/A fanout25/X _17425_/Y VPWR VGND sg13cmos5l_a21oi_1
X_14638_ _19173_/D _14638_/A _14639_/B VPWR VGND sg13cmos5l_nor2_1
X_17357_ _19576_/D hold2930/X fanout26/X _17356_/Y VPWR VGND sg13cmos5l_a21oi_1
X_14569_ _14575_/B _14535_/Y _14568_/X _14573_/S VPWR VGND sg13cmos5l_mux2_1
X_16308_ _19424_/D _16308_/A _16308_/B VPWR VGND sg13cmos5l_and2_1
X_17288_ _17373_/B _17290_/C _17290_/D VPWR VGND sg13cmos5l_and2_1
Xclkload20 clkload20/Y clkload20/A VPWR VGND sg13cmos5l_inv_1
Xclkload31 clkload31/Y clkload31/A VPWR VGND sg13cmos5l_inv_2
XFILLER_86_1020 VPWR VGND sg13cmos5l_decap_8
X_19027_ _19027_/Q clkload28/A _19027_/D _19027_/RESET_B VPWR VGND sg13cmos5l_dfrbpq_1
Xclkload53 clkload53/X clkload53/A VPWR VGND sg13cmos5l_buf_8
X_16239_ _16317_/B _16239_/A _16239_/B VPWR VGND sg13cmos5l_and2_1
Xclkload42 clkload42/Y clkload42/A VPWR VGND sg13cmos5l_inv_2
Xclkload64 clkload64/X clkload64/A VPWR VGND sg13cmos5l_buf_8
XFILLER_55_0 VPWR VGND sg13cmos5l_fill_2
Xhold2804 _14885_/A _14780_/Y VPWR VGND sg13cmos5l_dlygate4sd3_1
XFILLER_69_953 VPWR VGND sg13cmos5l_decap_4
Xhold2848 hold2848/X _13557_/A VPWR VGND sg13cmos5l_dlygate4sd3_1
X_18605__1694 _18605_/RESET_B VPWR VGND sg13cmos5l_tiehi
Xhold2815 _13928_/B _13927_/A VPWR VGND sg13cmos5l_dlygate4sd3_1
Xhold2837 _15966_/B _15965_/X VPWR VGND sg13cmos5l_dlygate4sd3_1
Xhold2826 _16488_/A _19459_/Q VPWR VGND sg13cmos5l_dlygate4sd3_1
XFILLER_84_901 VPWR VGND sg13cmos5l_fill_2
Xhold2859 _12879_/A _18920_/Q VPWR VGND sg13cmos5l_dlygate4sd3_1
XFILLER_71_617 VPWR VGND sg13cmos5l_fill_1
XFILLER_56_669 VPWR VGND sg13cmos5l_fill_1
XFILLER_55_135 VPWR VGND sg13cmos5l_fill_1
XFILLER_24_566 VPWR VGND sg13cmos5l_fill_1
Xclkload3 clkload3/X clkload3/A VPWR VGND sg13cmos5l_buf_8
XFILLER_20_794 VPWR VGND sg13cmos5l_fill_1
X_18722__1559 _18722_/RESET_B VPWR VGND sg13cmos5l_tiehi
X_10250_ _10250_/Y _10250_/A VPWR VGND sg13cmos5l_inv_1
X_10181_ _18474_/A _10181_/A VPWR VGND sg13cmos5l_inv_1
Xfanout240 _16016_/B _16022_/A VPWR VGND sg13cmos5l_buf_1
XFILLER_101_560 VPWR VGND sg13cmos5l_decap_8
XFILLER_87_761 VPWR VGND sg13cmos5l_fill_2
XFILLER_75_912 VPWR VGND sg13cmos5l_fill_1
X_13940_ _13952_/A _19090_/Q _13951_/B _13939_/Y VPWR VGND sg13cmos5l_a21o_1
Xfanout273 _14071_/B _13857_/Y VPWR VGND sg13cmos5l_buf_1
Xfanout251 _15465_/A _15234_/Y VPWR VGND sg13cmos5l_buf_1
Xfanout262 _14648_/A _14639_/B VPWR VGND sg13cmos5l_buf_1
XFILLER_101_582 VPWR VGND sg13cmos5l_fill_1
Xfanout295 _12735_/A _12729_/B VPWR VGND sg13cmos5l_buf_1
XFILLER_75_55 VPWR VGND sg13cmos5l_fill_1
Xfanout284 _13583_/A _13337_/Y VPWR VGND sg13cmos5l_buf_1
X_13871_ _13871_/Y hold2007/X fanout80/X _14070_/A VPWR VGND sg13cmos5l_o21ai_1
XFILLER_47_669 VPWR VGND sg13cmos5l_decap_4
X_15610_ _15690_/A _15609_/Y _15717_/A VPWR VGND sg13cmos5l_nand2b_1
X_16590_ _16591_/A _16593_/C _16589_/Y _16588_/Y VPWR VGND sg13cmos5l_a21o_1
X_12822_ _12838_/B _12813_/Y _12817_/Y _12821_/Y VPWR VGND sg13cmos5l_a21oi_1
X_18952__1311 _18952_/RESET_B VPWR VGND sg13cmos5l_tiehi
XFILLER_62_639 VPWR VGND sg13cmos5l_fill_2
X_12753_ _12753_/Y _12753_/A VPWR VGND sg13cmos5l_inv_1
XFILLER_43_853 VPWR VGND sg13cmos5l_fill_2
X_15541_ _15541_/X _15542_/B _15540_/X _15542_/A VPWR VGND sg13cmos5l_a21o_1
X_11704_ _11704_/Y _11559_/B _11737_/A _11698_/X VPWR VGND sg13cmos5l_o21ai_1
XFILLER_70_672 VPWR VGND sg13cmos5l_fill_1
X_18260_ _18262_/B _18508_/A _18260_/B VPWR VGND sg13cmos5l_nor2_1
X_15472_ _15472_/Y _16013_/A _19273_/Q _19274_/Q _16014_/A _15471_/Y VPWR VGND sg13cmos5l_a221oi_1
X_12684_ _12684_/Y _12731_/B _12697_/B _12680_/B _12704_/A _12682_/Y VPWR VGND sg13cmos5l_a221oi_1
X_17211_ _17211_/Y _17223_/A _19524_/Q VPWR VGND sg13cmos5l_nand2_1
X_14423_ _19146_/D _14639_/B _14423_/B VPWR VGND sg13cmos5l_nor2_1
XFILLER_30_547 VPWR VGND sg13cmos5l_decap_4
X_11635_ _11635_/Y _18747_/Q _18685_/Q VPWR VGND sg13cmos5l_nand2b_1
X_18191_ _18191_/Y _18191_/A _18191_/B VPWR VGND sg13cmos5l_nor2_1
X_11566_ _11630_/B _11527_/A _11565_/B _11565_/Y VPWR VGND sg13cmos5l_a21oi_1
X_17142_ _17142_/Y _17392_/B _17142_/B VPWR VGND sg13cmos5l_nand2_1
X_14354_ _14354_/Y _14328_/A _14350_/Y _14374_/A VPWR VGND sg13cmos5l_o21ai_1
X_17073_ _19535_/D _17032_/A _17070_/S _17072_/Y VPWR VGND sg13cmos5l_a21oi_1
X_13305_ _13305_/Y _14075_/A _18938_/Q _13304_/Y VPWR VGND sg13cmos5l_a21oi_1
X_10517_ _10519_/B _19789_/Q _10546_/B VPWR VGND sg13cmos5l_nor2b_1
X_14285_ _14285_/Y _14285_/A _14285_/B VPWR VGND sg13cmos5l_nor2_1
X_13236_ _13237_/B _13295_/B _13253_/S _13235_/Y VPWR VGND sg13cmos5l_a21oi_1
X_11497_ _11497_/Y _11504_/A _11497_/B VPWR VGND sg13cmos5l_nor2_1
X_16024_ _16024_/Y _16552_/A _19356_/Q VPWR VGND sg13cmos5l_nor2_1
X_10448_ _10448_/Y _10448_/A _10621_/B VPWR VGND sg13cmos5l_nor2_1
X_10379_ _10731_/A _10379_/A VPWR VGND sg13cmos5l_inv_1
X_13167_ _13167_/Y _13167_/A _13363_/B VPWR VGND sg13cmos5l_nor2_1
X_12118_ _12299_/A _12267_/A _12137_/B VPWR VGND sg13cmos5l_and2_1
X_13098_ _13131_/A _18908_/Q _13098_/B VPWR VGND sg13cmos5l_xor2_1
X_17975_ _17975_/Y _18475_/A _19706_/Q _17975_/C VPWR VGND sg13cmos5l_nor3_1
XFILLER_2_492 VPWR VGND sg13cmos5l_fill_1
X_16926_ _16927_/A _16908_/D _16897_/C _16940_/B VPWR VGND sg13cmos5l_a21oi_1
X_12049_ _12168_/A _18799_/Q _12051_/B VPWR VGND sg13cmos5l_nor2_1
X_19714_ _19714_/Q clkload14/A _19714_/D _19714_/RESET_B VPWR VGND sg13cmos5l_dfrbpq_1
X_16857_ _16857_/Y _16857_/A VPWR VGND sg13cmos5l_inv_1
XFILLER_65_444 VPWR VGND sg13cmos5l_fill_2
X_19645_ _19645_/Q clkload24/A _19645_/D _19645_/RESET_B VPWR VGND sg13cmos5l_dfrbpq_1
X_16788_ _16795_/B _16666_/B _16827_/B _16788_/S VPWR VGND sg13cmos5l_mux2_1
XFILLER_81_937 VPWR VGND sg13cmos5l_fill_2
X_19576_ _19576_/Q clkload36/A _19576_/D _19576_/RESET_B VPWR VGND sg13cmos5l_dfrbpq_1
XFILLER_37_179 VPWR VGND sg13cmos5l_decap_8
XFILLER_1_85 VPWR VGND sg13cmos5l_fill_2
X_15808_ _19364_/D _16081_/A _15808_/B VPWR VGND sg13cmos5l_and2_1
X_18527_ _18527_/Y _10320_/Y _18530_/S _18526_/Y VPWR VGND sg13cmos5l_a21oi_1
X_15739_ _19343_/D _15739_/A _15742_/B VPWR VGND sg13cmos5l_nor2_1
X_18458_ _18458_/Y _18433_/Y _18462_/S _18482_/A VPWR VGND sg13cmos5l_o21ai_1
X_17409_ _17409_/Y _17935_/A _19622_/Q VPWR VGND sg13cmos5l_nor2_1
X_18389_ _18397_/B _19762_/Q _18391_/B VPWR VGND sg13cmos5l_nor2b_1
XFILLER_103_825 VPWR VGND sg13cmos5l_fill_1
XFILLER_0_418 VPWR VGND sg13cmos5l_decap_4
XFILLER_76_709 VPWR VGND sg13cmos5l_fill_1
Xhold2601 _18426_/B _18425_/X VPWR VGND sg13cmos5l_dlygate4sd3_1
Xhold2612 _10205_/A _19356_/Q VPWR VGND sg13cmos5l_dlygate4sd3_1
Xhold2645 _12410_/A _18837_/Q VPWR VGND sg13cmos5l_dlygate4sd3_1
Xhold1900 _13284_/B _18919_/Q VPWR VGND sg13cmos5l_dlygate4sd3_1
Xhold2623 _11234_/A _18668_/Q VPWR VGND sg13cmos5l_dlygate4sd3_1
Xhold1911 _17666_/B _19581_/Q VPWR VGND sg13cmos5l_dlygate4sd3_1
Xhold2634 _14905_/A _14380_/A VPWR VGND sg13cmos5l_dlygate4sd3_1
Xhold2656 _10218_/A _19271_/Q VPWR VGND sg13cmos5l_dlygate4sd3_1
Xhold1933 _13809_/A _18585_/Q VPWR VGND sg13cmos5l_dlygate4sd3_1
Xhold1922 _18900_/D _12792_/Y VPWR VGND sg13cmos5l_dlygate4sd3_1
Xhold2689 _10078_/A _19002_/Q VPWR VGND sg13cmos5l_dlygate4sd3_1
Xhold2678 _10191_/A _19748_/Q VPWR VGND sg13cmos5l_dlygate4sd3_1
Xhold2667 hold2667/X _10599_/Y VPWR VGND sg13cmos5l_dlygate4sd3_1
Xhold1944 _14903_/B _19171_/Q VPWR VGND sg13cmos5l_dlygate4sd3_1
XFILLER_83_241 VPWR VGND sg13cmos5l_fill_1
Xhold1977 _19025_/D _13639_/Y VPWR VGND sg13cmos5l_dlygate4sd3_1
Xhold1955 _10385_/A _18569_/Q VPWR VGND sg13cmos5l_dlygate4sd3_1
Xhold1966 _18689_/D _11417_/Y VPWR VGND sg13cmos5l_dlygate4sd3_1
XFILLER_57_967 VPWR VGND sg13cmos5l_fill_1
Xhold1988 _09980_/A _19404_/Q VPWR VGND sg13cmos5l_dlygate4sd3_1
XFILLER_44_639 VPWR VGND sg13cmos5l_fill_1
XFILLER_43_105 VPWR VGND sg13cmos5l_fill_2
Xhold1999 _19236_/D _14973_/Y VPWR VGND sg13cmos5l_dlygate4sd3_1
XFILLER_71_436 VPWR VGND sg13cmos5l_fill_2
X_19759__789 _19759_/RESET_B VPWR VGND sg13cmos5l_tiehi
XFILLER_24_352 VPWR VGND sg13cmos5l_fill_1
XFILLER_52_683 VPWR VGND sg13cmos5l_decap_4
X_18940__1326 _18940_/RESET_B VPWR VGND sg13cmos5l_tiehi
XFILLER_61_79 VPWR VGND sg13cmos5l_fill_1
X_11420_ _11420_/Y _18649_/Q fanout76/X _11423_/A VPWR VGND sg13cmos5l_o21ai_1
X_11351_ _18668_/D _11351_/A _11351_/B VPWR VGND sg13cmos5l_and2_1
X_10302_ _11661_/B _10302_/A VPWR VGND sg13cmos5l_inv_1
X_19810__1580 _19810_/RESET_B VPWR VGND sg13cmos5l_tiehi
XFILLER_3_201 VPWR VGND sg13cmos5l_decap_4
X_19371__862 _19371_/RESET_B VPWR VGND sg13cmos5l_tiehi
X_11282_ _11358_/B hold2686/X _11281_/Y _11295_/B VPWR VGND sg13cmos5l_mux2_1
X_14070_ _19087_/D _14070_/A _14070_/B VPWR VGND sg13cmos5l_and2_1
X_13021_ _18925_/D _13021_/A _13027_/A VPWR VGND sg13cmos5l_nor2_1
X_10233_ _14947_/B _10233_/A VPWR VGND sg13cmos5l_inv_1
X_10164_ _17934_/A _10164_/A VPWR VGND sg13cmos5l_inv_1
XFILLER_66_219 VPWR VGND sg13cmos5l_fill_2
X_17760_ _17765_/A _17744_/Y _17756_/X _17758_/X _17573_/B _17759_/Y VPWR VGND sg13cmos5l_a221oi_1
XFILLER_48_945 VPWR VGND sg13cmos5l_fill_2
XFILLER_0_985 VPWR VGND sg13cmos5l_decap_8
X_10095_ _14643_/A _10095_/A VPWR VGND sg13cmos5l_inv_1
X_14972_ _14972_/Y _19194_/Q fanout72/X _14978_/A VPWR VGND sg13cmos5l_o21ai_1
XFILLER_101_390 VPWR VGND sg13cmos5l_fill_2
X_16711_ _16712_/B _19509_/Q _16711_/B VPWR VGND sg13cmos5l_xnor2_1
XFILLER_63_904 VPWR VGND sg13cmos5l_decap_4
X_13923_ _13923_/Y _13923_/A _13923_/B VPWR VGND sg13cmos5l_nor2_1
X_17691_ _17691_/Y _17691_/A _18221_/A _17709_/C VPWR VGND sg13cmos5l_nor3_1
X_16642_ _16642_/Y _13713_/A _16633_/Y _16641_/Y VPWR VGND sg13cmos5l_o21ai_1
XFILLER_90_701 VPWR VGND sg13cmos5l_fill_1
XFILLER_63_926 VPWR VGND sg13cmos5l_fill_1
XFILLER_47_477 VPWR VGND sg13cmos5l_fill_2
X_19430_ _19430_/Q clkload8/A _19430_/D _19430_/RESET_B VPWR VGND sg13cmos5l_dfrbpq_1
X_13854_ _13856_/A _10252_/A _13851_/Y _13853_/Y _19065_/Q _13852_/Y VPWR VGND sg13cmos5l_a221oi_1
X_12805_ _12805_/Y _18871_/Q _12805_/B VPWR VGND sg13cmos5l_nor2_1
X_16573_ _16573_/Y _16573_/A _16583_/B VPWR VGND sg13cmos5l_nand2_1
X_19361_ _19361_/Q clkload15/A _19361_/D _19361_/RESET_B VPWR VGND sg13cmos5l_dfrbpq_1
X_13785_ _13786_/B _13785_/A _13785_/B VPWR VGND sg13cmos5l_xnor2_1
X_10997_ _10997_/Y _10930_/B _11090_/B _10996_/Y VPWR VGND sg13cmos5l_o21ai_1
XFILLER_43_661 VPWR VGND sg13cmos5l_decap_4
X_15524_ _15524_/Y _19279_/Q fanout75/X _15528_/A VPWR VGND sg13cmos5l_o21ai_1
X_18312_ _18312_/Y _18302_/Y _18310_/Y _18311_/Y VPWR VGND sg13cmos5l_o21ai_1
X_18916__1350 _18916_/RESET_B VPWR VGND sg13cmos5l_tiehi
X_12736_ _12736_/Y _18851_/Q _12751_/A VPWR VGND sg13cmos5l_nand2b_1
X_19292_ _19292_/Q clkload43/A _19292_/D _19292_/RESET_B VPWR VGND sg13cmos5l_dfrbpq_1
X_12667_ _12667_/Y _12735_/B VPWR VGND sg13cmos5l_inv_1
X_18243_ _18243_/Y _18243_/A _18243_/B _18252_/B VPWR VGND sg13cmos5l_nand3_1
X_15455_ _19299_/D _15455_/A _15458_/B VPWR VGND sg13cmos5l_nor2_1
XFILLER_30_344 VPWR VGND sg13cmos5l_fill_1
XFILLER_30_355 VPWR VGND sg13cmos5l_decap_4
X_11618_ _18709_/D _12528_/A _11618_/B VPWR VGND sg13cmos5l_and2_1
X_18174_ _18174_/Y _18174_/A _18174_/B VPWR VGND sg13cmos5l_nor2_1
X_15386_ _15463_/B _15395_/S _15384_/Y _15383_/X VPWR VGND sg13cmos5l_a21o_1
X_14406_ _14406_/Y _19146_/Q _14395_/Y _14405_/Y _19147_/Q _14401_/Y VPWR VGND sg13cmos5l_a221oi_1
X_12598_ _12600_/B _12703_/A _12702_/A VPWR VGND sg13cmos5l_nor2_1
X_17125_ _17125_/Y _17403_/A _17119_/A _17124_/A _17408_/B _17120_/Y VPWR VGND sg13cmos5l_a221oi_1
XFILLER_11_580 VPWR VGND sg13cmos5l_fill_1
X_14337_ _14345_/B _14376_/B _14336_/B _14336_/Y VPWR VGND sg13cmos5l_o21ai_1
X_11549_ _11549_/Y _11560_/B _11548_/Y VPWR VGND sg13cmos5l_nor2b_1
X_17056_ _17056_/Y _17032_/Y _17050_/Y _17055_/Y VPWR VGND sg13cmos5l_o21ai_1
X_14268_ _14268_/Y _14460_/B _14258_/Y _14271_/A _14463_/A VPWR VGND sg13cmos5l_a22oi_1
X_13219_ _13250_/A _18964_/Q _13263_/B VPWR VGND sg13cmos5l_xnor2_1
X_16007_ _16007_/Y _15995_/A _15996_/Y _16021_/A VPWR VGND sg13cmos5l_o21ai_1
X_14199_ _14201_/B _14199_/A _14199_/B VPWR VGND sg13cmos5l_nor2_1
X_17958_ _17958_/Y _17962_/B _17954_/X _17957_/Y VPWR VGND sg13cmos5l_a21oi_1
X_16909_ _16940_/A _19488_/Q _16909_/B VPWR VGND sg13cmos5l_xnor2_1
X_17889_ _17889_/Y _17912_/A _17889_/B VPWR VGND sg13cmos5l_nand2_1
XFILLER_18_0 VPWR VGND sg13cmos5l_fill_1
X_19628_ _19628_/Q clkload24/A _19628_/D _19628_/RESET_B VPWR VGND sg13cmos5l_dfrbpq_1
XFILLER_38_499 VPWR VGND sg13cmos5l_fill_1
X_19559_ _19559_/Q clkload25/A _19559_/D _19559_/RESET_B VPWR VGND sg13cmos5l_dfrbpq_1
XFILLER_34_672 VPWR VGND sg13cmos5l_fill_1
XFILLER_33_193 VPWR VGND sg13cmos5l_fill_2
X_19470__750 _19470_/RESET_B VPWR VGND sg13cmos5l_tiehi
XFILLER_88_300 VPWR VGND sg13cmos5l_fill_2
Xoutput16 uo_out[3] _19441_/Q VPWR VGND sg13cmos5l_buf_1
XFILLER_88_366 VPWR VGND sg13cmos5l_fill_1
Xhold2420 _13019_/A _18873_/Q VPWR VGND sg13cmos5l_dlygate4sd3_1
Xhold2431 _19400_/D _16072_/Y VPWR VGND sg13cmos5l_dlygate4sd3_1
Xhold2453 _10145_/A _19493_/Q VPWR VGND sg13cmos5l_dlygate4sd3_1
Xhold2464 _10019_/A _18561_/Q VPWR VGND sg13cmos5l_dlygate4sd3_1
X_19011__1249 _19011_/RESET_B VPWR VGND sg13cmos5l_tiehi
Xhold2442 _10174_/A _19662_/Q VPWR VGND sg13cmos5l_dlygate4sd3_1
Xhold2475 _10071_/A _18959_/Q VPWR VGND sg13cmos5l_dlygate4sd3_1
XFILLER_57_764 VPWR VGND sg13cmos5l_fill_1
Xhold2497 _10119_/A _19335_/Q VPWR VGND sg13cmos5l_dlygate4sd3_1
Xhold2486 _16064_/B _16063_/X VPWR VGND sg13cmos5l_dlygate4sd3_1
XFILLER_84_572 VPWR VGND sg13cmos5l_fill_2
X_10920_ _10922_/B _10982_/A _10982_/B VPWR VGND sg13cmos5l_and2_1
X_10851_ _10853_/B _10850_/C _10849_/Y _10850_/Y VPWR VGND sg13cmos5l_a21o_1
X_10782_ _10782_/Y _10784_/A _10804_/A _10777_/Y _10780_/Y _10781_/Y VPWR VGND sg13cmos5l_a221oi_1
X_13570_ _19000_/D hold2848/X fanout47/X _13569_/Y VPWR VGND sg13cmos5l_a21oi_1
XFILLER_13_834 VPWR VGND sg13cmos5l_fill_2
X_12521_ _12521_/Y _18815_/Q fanout78/X _12529_/A VPWR VGND sg13cmos5l_o21ai_1
X_12452_ _18832_/D _12452_/A _12452_/B _12452_/C VPWR VGND sg13cmos5l_nor3_1
X_19241__1001 _19241_/RESET_B VPWR VGND sg13cmos5l_tiehi
X_15240_ _19271_/D _15240_/A _15239_/Y VPWR VGND sg13cmos5l_nor2b_1
X_11403_ _11631_/A _11892_/B _12188_/A VPWR VGND sg13cmos5l_nand2b_1
X_12383_ _12427_/A _18840_/Q _12414_/B VPWR VGND sg13cmos5l_xnor2_1
X_15171_ _15171_/Y _15140_/Y _15173_/S _15194_/A VPWR VGND sg13cmos5l_o21ai_1
X_19695__1737 _19695_/RESET_B VPWR VGND sg13cmos5l_tiehi
X_11334_ _11335_/B _11334_/A _11334_/B VPWR VGND sg13cmos5l_nor2_1
XFILLER_4_521 VPWR VGND sg13cmos5l_fill_1
X_14122_ _14122_/Y _14122_/A _14122_/B VPWR VGND sg13cmos5l_nor2_1
XFILLER_21_60 VPWR VGND sg13cmos5l_fill_1
XFILLER_21_71 VPWR VGND sg13cmos5l_fill_1
X_18930_ _18930_/Q _18931_/CLK _18930_/D _18930_/RESET_B VPWR VGND sg13cmos5l_dfrbpq_1
X_11265_ _11265_/Y _11253_/Y _11286_/A _11261_/Y _11264_/Y VPWR VGND sg13cmos5l_a22oi_1
X_14053_ _14055_/A _14056_/A _14056_/B VPWR VGND sg13cmos5l_nor2_1
X_18771__1507 _18771_/RESET_B VPWR VGND sg13cmos5l_tiehi
X_13004_ _18913_/D _13004_/A _13004_/B VPWR VGND sg13cmos5l_nor2_1
XFILLER_79_311 VPWR VGND sg13cmos5l_fill_2
X_10216_ _15492_/A _10216_/A VPWR VGND sg13cmos5l_inv_1
XFILLER_79_344 VPWR VGND sg13cmos5l_fill_2
X_18861_ _18861_/Q _19003_/CLK _18861_/D _18861_/RESET_B VPWR VGND sg13cmos5l_dfrbpq_1
X_11196_ _11318_/A _11195_/X _10979_/Y _11205_/A VPWR VGND sg13cmos5l_mux2_1
X_10147_ _17080_/A _10147_/A VPWR VGND sg13cmos5l_inv_1
XFILLER_95_859 VPWR VGND sg13cmos5l_fill_2
X_18792_ _18792_/Q clkload62/A _18792_/D _18792_/RESET_B VPWR VGND sg13cmos5l_dfrbpq_1
XFILLER_94_325 VPWR VGND sg13cmos5l_fill_2
X_17812_ _17824_/B _19673_/Q _19674_/Q _19675_/Q _19676_/Q VPWR VGND sg13cmos5l_nor4_1
X_19447__774 _19447_/RESET_B VPWR VGND sg13cmos5l_tiehi
X_17743_ _17780_/A _17758_/B _17742_/Y VPWR VGND sg13cmos5l_nor2b_1
X_10078_ _14077_/A _10078_/A VPWR VGND sg13cmos5l_inv_1
X_14955_ _14955_/Y _14955_/A _14955_/B VPWR VGND sg13cmos5l_nor2_1
XFILLER_63_701 VPWR VGND sg13cmos5l_decap_4
X_13906_ _13906_/Y _13906_/A _13906_/B VPWR VGND sg13cmos5l_nand2_1
XFILLER_48_786 VPWR VGND sg13cmos5l_fill_2
XFILLER_90_542 VPWR VGND sg13cmos5l_decap_8
XFILLER_75_594 VPWR VGND sg13cmos5l_fill_1
X_17674_ _19631_/D _17591_/C _17591_/D _17678_/A VPWR VGND sg13cmos5l_a21oi_1
XFILLER_62_222 VPWR VGND sg13cmos5l_fill_1
X_19413_ _19413_/Q clkload5/A _19413_/D _19413_/RESET_B VPWR VGND sg13cmos5l_dfrbpq_1
X_14886_ _14886_/Y _14889_/B VPWR VGND sg13cmos5l_inv_1
X_16625_ _16641_/B _19033_/Q _19031_/Q _19032_/Q VPWR VGND sg13cmos5l_or3_1
X_13837_ _13837_/Y _14366_/A _19086_/Q VPWR VGND sg13cmos5l_nor2_1
X_13768_ _13769_/B _13768_/A _13768_/B _13768_/C VPWR VGND sg13cmos5l_nand3_1
XFILLER_15_160 VPWR VGND sg13cmos5l_fill_1
X_19344_ _19344_/Q clkload16/A _19344_/D _19344_/RESET_B VPWR VGND sg13cmos5l_dfrbpq_1
X_16556_ _16556_/Y _16556_/A _16562_/A VPWR VGND sg13cmos5l_nor2_1
X_12719_ _18874_/D hold2555/X _12714_/S _12718_/Y VPWR VGND sg13cmos5l_a21oi_1
Xclkbuf_0_clk clkbuf_0_clk/X clk VPWR VGND sg13cmos5l_buf_8
X_19275_ _19275_/Q clkload15/A _19275_/D _19275_/RESET_B VPWR VGND sg13cmos5l_dfrbpq_1
X_15507_ _15507_/Y _19339_/Q _16307_/A VPWR VGND sg13cmos5l_nand2b_1
X_16487_ _16516_/A _19459_/Q _16500_/B VPWR VGND sg13cmos5l_or2_1
X_13699_ _13699_/Y _13815_/B VPWR VGND sg13cmos5l_inv_1
X_18226_ _19713_/D _18226_/A _18227_/B VPWR VGND sg13cmos5l_nor2_1
X_15438_ _15451_/B _15312_/Y _15327_/Y _15431_/Y _15437_/Y VPWR VGND sg13cmos5l_a22oi_1
XFILLER_50_1022 VPWR VGND sg13cmos5l_decap_8
X_15369_ _15369_/Y _15364_/Y _15365_/Y _15394_/B VPWR VGND sg13cmos5l_o21ai_1
X_18157_ _18340_/A _18300_/A _18157_/B VPWR VGND sg13cmos5l_nand2_1
X_17108_ _17109_/A _17122_/C _17107_/Y _17106_/Y VPWR VGND sg13cmos5l_o21ai_1
X_18088_ _18090_/C _18088_/A _18091_/B VPWR VGND sg13cmos5l_or2_1
X_17039_ _17039_/Y _17087_/B _17047_/S _17034_/X _17060_/A _17037_/Y VPWR VGND sg13cmos5l_a221oi_1
Xheichips26_digital_project_1806 uio_oe[9] VPWR VGND sg13cmos5l_tiehi
X_18747__1531 _18747_/RESET_B VPWR VGND sg13cmos5l_tiehi
XFILLER_97_163 VPWR VGND sg13cmos5l_fill_1
XFILLER_86_848 VPWR VGND sg13cmos5l_fill_1
X_18980__1283 _18980_/RESET_B VPWR VGND sg13cmos5l_tiehi
XFILLER_26_469 VPWR VGND sg13cmos5l_fill_1
XFILLER_50_951 VPWR VGND sg13cmos5l_fill_1
XFILLER_1_513 VPWR VGND sg13cmos5l_fill_2
X_11050_ _11059_/A _11018_/Y _11058_/A _11050_/C VPWR VGND sg13cmos5l_nand3b_1
X_10001_ _10795_/A _10793_/B VPWR VGND sg13cmos5l_inv_1
XFILLER_49_539 VPWR VGND sg13cmos5l_fill_1
XFILLER_49_528 VPWR VGND sg13cmos5l_fill_1
Xhold2272 _16573_/A _19020_/Q VPWR VGND sg13cmos5l_dlygate4sd3_1
XFILLER_76_347 VPWR VGND sg13cmos5l_fill_1
Xhold2250 _10309_/A _18601_/Q VPWR VGND sg13cmos5l_dlygate4sd3_1
Xhold2261 _19189_/D _14697_/Y VPWR VGND sg13cmos5l_dlygate4sd3_1
Xhold2294 _10182_/A _19704_/Q VPWR VGND sg13cmos5l_dlygate4sd3_1
X_14740_ _14740_/X _19157_/Q _14757_/B VPWR VGND sg13cmos5l_or2_1
Xhold2283 _10198_/A _19399_/Q VPWR VGND sg13cmos5l_dlygate4sd3_1
X_11952_ _11952_/Y _11925_/A fanout55/X _12199_/A VPWR VGND sg13cmos5l_o21ai_1
X_11883_ _18745_/D _11905_/A _11883_/B VPWR VGND sg13cmos5l_nor2_1
XFILLER_44_233 VPWR VGND sg13cmos5l_fill_1
X_10903_ _10928_/B _19783_/Q _10903_/B VPWR VGND sg13cmos5l_xor2_1
X_14671_ _14671_/Y _19187_/Q _14667_/Y _14670_/Y _19186_/Q VPWR VGND sg13cmos5l_a22oi_1
X_13622_ _13632_/S _13622_/A _13622_/B VPWR VGND sg13cmos5l_nor2_1
X_10834_ _10834_/Y _19765_/Q _10854_/A _10838_/C VPWR VGND sg13cmos5l_nand3_1
X_17390_ _17390_/Y _19618_/Q _17937_/A _17408_/C VPWR VGND sg13cmos5l_nand3_1
X_16410_ _16410_/Y _16410_/A VPWR VGND sg13cmos5l_inv_1
XFILLER_60_759 VPWR VGND sg13cmos5l_fill_1
X_13553_ _13554_/B _13553_/A _13553_/B VPWR VGND sg13cmos5l_or2_1
X_16341_ _16341_/Y _16073_/A _16339_/X _16340_/Y VPWR VGND sg13cmos5l_a21oi_1
X_10765_ _10765_/Y _10769_/B VPWR VGND sg13cmos5l_inv_1
X_12504_ _12506_/A _12497_/Y _12501_/Y _12502_/Y _18855_/Q _12503_/Y VPWR VGND sg13cmos5l_a221oi_1
X_19060_ _19060_/Q clkload52/A _19060_/D _19060_/RESET_B VPWR VGND sg13cmos5l_dfrbpq_1
X_10696_ _10696_/Y _10734_/A _10716_/A VPWR VGND sg13cmos5l_nor2b_1
X_13484_ _13484_/Y _19016_/Q _13485_/B VPWR VGND sg13cmos5l_xnor2_1
X_16272_ _16278_/A _16277_/A _16277_/B _16271_/X _16171_/Y VPWR VGND sg13cmos5l_a22oi_1
XFILLER_12_174 VPWR VGND sg13cmos5l_fill_2
X_12435_ _12436_/B _12435_/A _12435_/B VPWR VGND sg13cmos5l_xnor2_1
X_18011_ _18012_/C _19651_/Q _19652_/Q _19653_/Q VPWR VGND sg13cmos5l_o21ai_1
XFILLER_8_167 VPWR VGND sg13cmos5l_decap_8
X_15223_ _15223_/Y _15223_/A VPWR VGND sg13cmos5l_inv_1
X_12366_ _12366_/Y _12305_/B _12466_/B _12361_/Y VPWR VGND sg13cmos5l_o21ai_1
X_15154_ _15155_/C _15154_/A _15154_/B _15154_/C VPWR VGND sg13cmos5l_nand3_1
X_11317_ _11321_/A _11317_/A VPWR VGND sg13cmos5l_inv_1
X_19205__1040 _19205_/RESET_B VPWR VGND sg13cmos5l_tiehi
X_14105_ _14106_/B _19066_/Q _14103_/Y _14104_/Y VPWR VGND sg13cmos5l_o21ai_1
X_12297_ _12298_/B _12355_/A _12355_/B VPWR VGND sg13cmos5l_nand2_1
XFILLER_4_362 VPWR VGND sg13cmos5l_fill_2
X_15085_ _15085_/Y _15085_/A _15086_/B VPWR VGND sg13cmos5l_xnor2_1
X_18913_ _18913_/Q clkload64/A _18913_/D _18913_/RESET_B VPWR VGND sg13cmos5l_dfrbpq_1
X_11248_ _11250_/B _18675_/Q _18676_/Q _18677_/Q _18678_/Q VPWR VGND sg13cmos5l_nor4_1
X_14036_ _14037_/C _14036_/A _14036_/B _14036_/C VPWR VGND sg13cmos5l_nand3_1
X_18844_ _18844_/Q clkload70/A _18844_/D _18844_/RESET_B VPWR VGND sg13cmos5l_dfrbpq_1
X_11179_ _11179_/Y _11183_/A _11199_/B VPWR VGND sg13cmos5l_nor2_1
XFILLER_67_358 VPWR VGND sg13cmos5l_fill_2
X_18775_ _18775_/Q clkload59/A _18775_/D _18775_/RESET_B VPWR VGND sg13cmos5l_dfrbpq_1
X_15987_ _15987_/Y _15963_/Y _15981_/Y _15986_/Y VPWR VGND sg13cmos5l_o21ai_1
X_17726_ _17726_/Y _17969_/A _17716_/Y _17725_/Y VPWR VGND sg13cmos5l_a21oi_1
X_14938_ _14938_/Y _14938_/A VPWR VGND sg13cmos5l_inv_1
X_19460__760 _19460_/RESET_B VPWR VGND sg13cmos5l_tiehi
XFILLER_35_200 VPWR VGND sg13cmos5l_fill_2
X_17657_ _19618_/D _17634_/B _17659_/A _17656_/Y VPWR VGND sg13cmos5l_a21oi_1
X_14869_ _14873_/A _14870_/A _14876_/B _14870_/C VPWR VGND sg13cmos5l_and3_1
XFILLER_35_255 VPWR VGND sg13cmos5l_fill_1
X_16608_ _16608_/X _16577_/Y _16831_/B _16608_/S VPWR VGND sg13cmos5l_mux2_1
X_17588_ _17588_/Y _17588_/A _17588_/B VPWR VGND sg13cmos5l_nor2_1
X_19327_ _19327_/Q clkload17/A _19327_/D _19327_/RESET_B VPWR VGND sg13cmos5l_dfrbpq_1
X_16539_ _16539_/Y _16507_/X fanout32/X _16561_/A VPWR VGND sg13cmos5l_o21ai_1
XFILLER_32_973 VPWR VGND sg13cmos5l_decap_4
XFILLER_32_984 VPWR VGND sg13cmos5l_fill_1
X_19258_ _19258_/Q clkload42/A _19258_/D _19258_/RESET_B VPWR VGND sg13cmos5l_dfrbpq_1
XFILLER_31_483 VPWR VGND sg13cmos5l_fill_2
X_18209_ _19700_/D hold2654/X _18212_/S _18208_/Y VPWR VGND sg13cmos5l_a21oi_1
X_19189_ _19189_/Q _19302_/CLK _19189_/D _19189_/RESET_B VPWR VGND sg13cmos5l_dfrbpq_1
XFILLER_105_717 VPWR VGND sg13cmos5l_fill_1
XFILLER_99_984 VPWR VGND sg13cmos5l_fill_1
XFILLER_39_594 VPWR VGND sg13cmos5l_fill_2
XFILLER_82_862 VPWR VGND sg13cmos5l_fill_2
X_18578__1723 _18578_/RESET_B VPWR VGND sg13cmos5l_tiehi
XFILLER_53_58 VPWR VGND sg13cmos5l_fill_1
XFILLER_10_601 VPWR VGND sg13cmos5l_decap_8
X_10550_ _10550_/Y _10904_/A _10547_/X _10575_/A VPWR VGND sg13cmos5l_a21oi_1
XFILLER_6_616 VPWR VGND sg13cmos5l_fill_2
X_10481_ _10481_/X _19747_/Q _10481_/B VPWR VGND sg13cmos5l_xor2_1
X_12220_ _12220_/Y _12220_/A _12723_/A _12231_/C VPWR VGND sg13cmos5l_nor3_1
XFILLER_5_115 VPWR VGND sg13cmos5l_fill_2
X_12151_ _12151_/X _12108_/Y _12004_/B _12162_/B VPWR VGND sg13cmos5l_mux2_1
XFILLER_2_822 VPWR VGND sg13cmos5l_decap_4
X_19509__708 _19509_/RESET_B VPWR VGND sg13cmos5l_tiehi
X_12082_ _12084_/B _12274_/A _12065_/X _12078_/Y _12130_/A VPWR VGND sg13cmos5l_a22oi_1
X_11102_ _11102_/X _11102_/A _11107_/C VPWR VGND sg13cmos5l_and2_1
XFILLER_89_472 VPWR VGND sg13cmos5l_fill_1
X_11033_ _11034_/A _11058_/A _11033_/B VPWR VGND sg13cmos5l_nand2_1
X_15910_ _15920_/B _19393_/Q _15911_/B VPWR VGND sg13cmos5l_nor2b_1
X_16890_ _19523_/D _17152_/A _16890_/B VPWR VGND sg13cmos5l_and2_1
Xhold2080 _10363_/A _19512_/Q VPWR VGND sg13cmos5l_dlygate4sd3_1
X_15841_ _15841_/X _15851_/B _15841_/B VPWR VGND sg13cmos5l_or2_1
X_18560_ _18596_/D _18560_/A _18560_/B VPWR VGND sg13cmos5l_nor2_1
Xhold2091 _13813_/A _18589_/Q VPWR VGND sg13cmos5l_dlygate4sd3_1
X_12984_ _12985_/C _12984_/A _12984_/B _12984_/C VPWR VGND sg13cmos5l_nand3_1
X_15772_ _15772_/X _16042_/A _15772_/B VPWR VGND sg13cmos5l_or2_1
X_11935_ _11935_/Y _18768_/Q _11925_/Y _11931_/Y VPWR VGND sg13cmos5l_a21oi_1
X_17511_ _17516_/A _19626_/Q _17526_/B VPWR VGND sg13cmos5l_and2_1
X_18491_ _18491_/Y _18498_/B _19790_/Q _18490_/Y VPWR VGND sg13cmos5l_a21oi_1
X_14723_ _14724_/C _14721_/A _14721_/B _14722_/Y VPWR VGND sg13cmos5l_o21ai_1
X_17442_ _17447_/A _17442_/A _17461_/D _17442_/C VPWR VGND sg13cmos5l_nand3_1
X_14654_ _14654_/Y _15184_/A _19146_/Q _19145_/Q _15183_/A _14652_/Y VPWR VGND sg13cmos5l_a221oi_1
XFILLER_18_789 VPWR VGND sg13cmos5l_fill_2
XFILLER_32_214 VPWR VGND sg13cmos5l_fill_2
X_13605_ _13605_/X _13606_/A _13627_/A VPWR VGND sg13cmos5l_or2_1
X_11866_ _11876_/A _11762_/Y _11874_/A _11866_/C VPWR VGND sg13cmos5l_nand3b_1
X_11797_ _11797_/X _11797_/A _11797_/B _11797_/C VPWR VGND sg13cmos5l_or3_1
X_17373_ _19590_/D _17373_/A _17373_/B VPWR VGND sg13cmos5l_nor2_1
X_10817_ _10817_/Y _11353_/A _19766_/Q VPWR VGND sg13cmos5l_nand2_1
X_14585_ _14599_/B _14576_/Y _14581_/Y _14584_/Y VPWR VGND sg13cmos5l_o21ai_1
X_10748_ _18581_/D _10748_/A _10796_/B VPWR VGND sg13cmos5l_nor2_1
X_13536_ _13543_/B _13499_/Y _13405_/Y _13548_/B VPWR VGND sg13cmos5l_mux2_1
XFILLER_9_421 VPWR VGND sg13cmos5l_fill_2
X_16324_ _16324_/Y _16345_/A _19399_/Q _19400_/Q _16400_/A _16323_/Y VPWR VGND sg13cmos5l_a221oi_1
X_19112_ _19112_/Q clkload47/A _19112_/D _19112_/RESET_B VPWR VGND sg13cmos5l_dfrbpq_1
X_19043_ _19043_/Q clkload31/A _19043_/D _19043_/RESET_B VPWR VGND sg13cmos5l_dfrbpq_1
X_13467_ _13512_/A _19014_/Q _13467_/B VPWR VGND sg13cmos5l_xor2_1
X_16255_ _16257_/A _16255_/A _16255_/B VPWR VGND sg13cmos5l_nor2_1
X_12418_ _12419_/B _12391_/B _12418_/B VPWR VGND sg13cmos5l_nand2b_1
X_10679_ _10679_/Y input9/X _10679_/B _10679_/C VPWR VGND sg13cmos5l_nand3_1
X_15206_ _15225_/C _19296_/Q _15210_/B _15215_/B VPWR VGND sg13cmos5l_o21ai_1
X_13398_ _13505_/B _13394_/A _13394_/B _13396_/X VPWR VGND sg13cmos5l_o21ai_1
X_16186_ _16186_/X _19416_/Q _19431_/Q VPWR VGND sg13cmos5l_and2_1
X_12349_ _12368_/B _12335_/Y _12344_/Y _12348_/Y VPWR VGND sg13cmos5l_o21ai_1
X_15137_ _15138_/A _15155_/B _15137_/B VPWR VGND sg13cmos5l_nand2_1
X_19664__436 _19664_/D VPWR VGND sg13cmos5l_tielo
X_15068_ _15068_/Y _15109_/A _15271_/A _15065_/Y _15099_/A _15067_/Y VPWR VGND sg13cmos5l_a221oi_1
XFILLER_4_52 VPWR VGND sg13cmos5l_fill_2
X_14019_ _14019_/Y _14013_/A _14013_/B _14049_/B _14020_/A VPWR VGND sg13cmos5l_a22oi_1
XFILLER_67_111 VPWR VGND sg13cmos5l_fill_2
X_18827_ _18827_/Q clkload71/A _18827_/D _18827_/RESET_B VPWR VGND sg13cmos5l_dfrbpq_1
XFILLER_83_604 VPWR VGND sg13cmos5l_fill_2
XFILLER_68_678 VPWR VGND sg13cmos5l_decap_8
X_18758_ _18758_/Q clkload40/A _18758_/D _18758_/RESET_B VPWR VGND sg13cmos5l_dfrbpq_1
XFILLER_82_114 VPWR VGND sg13cmos5l_fill_1
X_19036__1221 _19036_/RESET_B VPWR VGND sg13cmos5l_tiehi
X_18863__1406 _18863_/RESET_B VPWR VGND sg13cmos5l_tiehi
XFILLER_82_136 VPWR VGND sg13cmos5l_fill_1
X_17709_ _17709_/Y _18225_/A _19664_/Q _17709_/C VPWR VGND sg13cmos5l_nor3_1
X_18689_ _18689_/Q _18733_/CLK _18689_/D _18689_/RESET_B VPWR VGND sg13cmos5l_dfrbpq_1
XFILLER_17_1023 VPWR VGND sg13cmos5l_decap_4
XFILLER_105_514 VPWR VGND sg13cmos5l_fill_2
Xfanout400 _12797_/A _12529_/A VPWR VGND sg13cmos5l_buf_1
XFILLER_98_280 VPWR VGND sg13cmos5l_fill_2
XFILLER_86_464 VPWR VGND sg13cmos5l_fill_2
XFILLER_86_453 VPWR VGND sg13cmos5l_fill_1
XFILLER_104_75 VPWR VGND sg13cmos5l_fill_2
X_18589__539 _18589_/D VPWR VGND sg13cmos5l_tielo
X_11720_ _11721_/B _11720_/A _11742_/B VPWR VGND sg13cmos5l_nor2_1
XFILLER_70_821 VPWR VGND sg13cmos5l_fill_1
XFILLER_55_873 VPWR VGND sg13cmos5l_fill_1
X_11651_ _11651_/Y _18750_/Q _18744_/Q VPWR VGND sg13cmos5l_nor2b_1
Xfanout40 _14958_/S _14955_/Y VPWR VGND sg13cmos5l_buf_1
Xfanout51 _12714_/S _12720_/S VPWR VGND sg13cmos5l_buf_1
X_11582_ _11583_/C _11582_/A _11582_/B _11582_/C VPWR VGND sg13cmos5l_and3_1
Xfanout62 _17912_/A _17897_/B VPWR VGND sg13cmos5l_buf_1
X_10602_ _10603_/C _10602_/A _10602_/B _10602_/C VPWR VGND sg13cmos5l_and3_1
X_14370_ _19135_/D _14370_/A _14375_/A VPWR VGND sg13cmos5l_and2_1
Xfanout73 fanout73/X fanout74/X VPWR VGND sg13cmos5l_buf_1
Xfanout95 fanout95/X fanout97/X VPWR VGND sg13cmos5l_buf_1
Xfanout84 fanout84/X fanout85/X VPWR VGND sg13cmos5l_buf_1
X_13321_ _13321_/X _13321_/A _13321_/B VPWR VGND sg13cmos5l_or2_1
XFILLER_10_442 VPWR VGND sg13cmos5l_fill_1
X_10533_ _10533_/Y _10529_/Y _10531_/A _10532_/Y _10526_/B VPWR VGND sg13cmos5l_a22oi_1
X_16040_ _16041_/A _16052_/C _16038_/Y _16039_/Y VPWR VGND sg13cmos5l_o21ai_1
X_13252_ _13255_/A _13252_/A VPWR VGND sg13cmos5l_inv_1
X_10464_ _10465_/C _10464_/A _10464_/B _10464_/C VPWR VGND sg13cmos5l_and3_1
X_12203_ _12203_/Y _12725_/A _18768_/Q _18767_/Q _12724_/A _12202_/Y VPWR VGND sg13cmos5l_a221oi_1
X_10395_ _10395_/Y _10680_/C VPWR VGND sg13cmos5l_inv_1
X_13183_ _13183_/X _13575_/A _13202_/B VPWR VGND sg13cmos5l_and2_1
X_19450__770 _19450_/RESET_B VPWR VGND sg13cmos5l_tiehi
X_12134_ _12134_/Y _12021_/B _12199_/B _12133_/X _12027_/B VPWR VGND sg13cmos5l_a22oi_1
XFILLER_69_409 VPWR VGND sg13cmos5l_fill_2
X_19730_ _19730_/Q clkload35/A _19730_/D _19730_/RESET_B VPWR VGND sg13cmos5l_dfrbpq_1
X_17991_ _17991_/Y _17972_/B _17993_/S _17983_/Y VPWR VGND sg13cmos5l_o21ai_1
XFILLER_104_580 VPWR VGND sg13cmos5l_fill_1
X_12065_ _12065_/X _18804_/Q _12086_/D VPWR VGND sg13cmos5l_xor2_1
X_16942_ _17027_/A _17025_/A VPWR VGND sg13cmos5l_inv_1
XFILLER_78_965 VPWR VGND sg13cmos5l_fill_1
X_16873_ _16873_/Y _16848_/B fanout29/X _17079_/B VPWR VGND sg13cmos5l_o21ai_1
X_19661_ _19661_/Q clkload12/A _19661_/D _19661_/RESET_B VPWR VGND sg13cmos5l_dfrbpq_1
X_11016_ _11026_/A _11016_/A _11016_/B VPWR VGND sg13cmos5l_nor2_1
X_19592_ _19592_/Q clkload36/A _19592_/D _19592_/RESET_B VPWR VGND sg13cmos5l_dfrbpq_1
X_18612_ _18612_/Q clkload45/A _18612_/D _18612_/RESET_B VPWR VGND sg13cmos5l_dfrbpq_1
X_15824_ _15860_/A _19329_/Q _15824_/B VPWR VGND sg13cmos5l_xnor2_1
X_18543_ _19778_/D _18543_/A _18547_/B VPWR VGND sg13cmos5l_nor2_1
X_12967_ _12968_/B _18920_/Q _12879_/B _12856_/Y VPWR VGND sg13cmos5l_a21oi_1
XFILLER_73_681 VPWR VGND sg13cmos5l_fill_1
X_15755_ _15755_/Y _19377_/Q _15774_/A _15779_/B _19378_/Q _15754_/Y VPWR VGND sg13cmos5l_a221oi_1
XFILLER_33_501 VPWR VGND sg13cmos5l_decap_8
X_11918_ _11938_/C _11922_/C _11918_/B VPWR VGND sg13cmos5l_and2_1
X_12898_ _12898_/X _12908_/D _12892_/B _12939_/A VPWR VGND sg13cmos5l_a21o_1
X_18474_ _19753_/D _18474_/A _18481_/A VPWR VGND sg13cmos5l_nor2_1
X_15686_ _15698_/C _15748_/B _15586_/B VPWR VGND sg13cmos5l_nor2b_1
X_14706_ _14706_/Y _19195_/Q fanout90/X _14710_/A VPWR VGND sg13cmos5l_o21ai_1
X_11849_ _11850_/A _11874_/A _11849_/B VPWR VGND sg13cmos5l_nand2_1
X_19024__1236 _19024_/RESET_B VPWR VGND sg13cmos5l_tiehi
X_17425_ _17425_/Y _17406_/B fanout25/X _17677_/A VPWR VGND sg13cmos5l_o21ai_1
X_14637_ _19172_/D _14637_/A _14637_/B VPWR VGND sg13cmos5l_and2_1
X_17356_ _17356_/Y _17333_/B fanout26/X _17375_/A VPWR VGND sg13cmos5l_o21ai_1
X_14568_ _14568_/X _14725_/A _14737_/A VPWR VGND sg13cmos5l_and2_1
XFILLER_13_291 VPWR VGND sg13cmos5l_fill_2
X_16307_ _19423_/D _16307_/A _16307_/B VPWR VGND sg13cmos5l_and2_1
X_17287_ _17290_/D _17284_/A _17284_/B _17286_/Y VPWR VGND sg13cmos5l_o21ai_1
X_13519_ _13519_/X _13475_/X _13517_/X _13519_/S VPWR VGND sg13cmos5l_mux2_1
X_14499_ _14518_/A _19175_/Q _14516_/B VPWR VGND sg13cmos5l_or2_1
Xclkload10 clkload10/Y clkload10/A VPWR VGND sg13cmos5l_inv_4
Xclkload32 clkload32/X clkload32/A VPWR VGND sg13cmos5l_buf_8
X_19026_ _19026_/Q clkload29/A _19026_/D _19026_/RESET_B VPWR VGND sg13cmos5l_dfrbpq_1
Xclkload21 clkload21/Y clkload21/A VPWR VGND sg13cmos5l_inv_2
X_16238_ _16239_/B _16238_/A _16238_/B _16238_/C VPWR VGND sg13cmos5l_nand3_1
Xclkload43 clkload43/Y clkload43/A VPWR VGND sg13cmos5l_inv_2
Xclkload65 clkload65/Y clkload65/A VPWR VGND sg13cmos5l_inv_4
Xclkload54 clkload54/Y clkload54/A VPWR VGND sg13cmos5l_inv_1
X_16169_ _16289_/A _16268_/A _16268_/B VPWR VGND sg13cmos5l_nor2_1
XFILLER_102_528 VPWR VGND sg13cmos5l_decap_8
Xhold2805 _17034_/A _19541_/Q VPWR VGND sg13cmos5l_dlygate4sd3_1
XFILLER_102_539 VPWR VGND sg13cmos5l_fill_2
Xhold2827 _10759_/A _18594_/Q VPWR VGND sg13cmos5l_dlygate4sd3_1
Xhold2838 hold2838/X _18672_/Q VPWR VGND sg13cmos5l_dlygate4sd3_1
Xhold2816 _14500_/A _19175_/Q VPWR VGND sg13cmos5l_dlygate4sd3_1
XFILLER_96_751 VPWR VGND sg13cmos5l_fill_1
XFILLER_69_987 VPWR VGND sg13cmos5l_fill_2
XFILLER_69_976 VPWR VGND sg13cmos5l_fill_2
Xhold2849 _10108_/A _19249_/Q VPWR VGND sg13cmos5l_dlygate4sd3_1
XFILLER_36_350 VPWR VGND sg13cmos5l_decap_4
X_18827__1445 _18827_/RESET_B VPWR VGND sg13cmos5l_tiehi
Xclkload4 clkload4/X clkload4/A VPWR VGND sg13cmos5l_buf_8
X_18730__1551 _18730_/RESET_B VPWR VGND sg13cmos5l_tiehi
X_19197__1048 _19197_/RESET_B VPWR VGND sg13cmos5l_tiehi
X_10180_ _11357_/A _10180_/A VPWR VGND sg13cmos5l_inv_1
Xfanout230 _16655_/A _16829_/A VPWR VGND sg13cmos5l_buf_1
Xfanout241 _16022_/A _15789_/Y VPWR VGND sg13cmos5l_buf_1
Xfanout274 _13925_/A _13857_/Y VPWR VGND sg13cmos5l_buf_1
Xfanout252 _15191_/A _15188_/B VPWR VGND sg13cmos5l_buf_1
Xfanout263 _14643_/B _14639_/B VPWR VGND sg13cmos5l_buf_1
Xfanout296 _12579_/A _12734_/A VPWR VGND sg13cmos5l_buf_1
Xfanout285 _13289_/B _13291_/B VPWR VGND sg13cmos5l_buf_1
XFILLER_47_648 VPWR VGND sg13cmos5l_decap_8
X_13870_ _13870_/Y _13853_/Y hold2339/X _14076_/B VPWR VGND sg13cmos5l_a21oi_1
X_12821_ _12821_/Y _12825_/A _12827_/B _12818_/X VPWR VGND sg13cmos5l_o21ai_1
XFILLER_47_659 VPWR VGND sg13cmos5l_fill_2
XFILLER_61_106 VPWR VGND sg13cmos5l_fill_1
XFILLER_55_670 VPWR VGND sg13cmos5l_fill_2
XFILLER_27_361 VPWR VGND sg13cmos5l_fill_1
XFILLER_28_862 VPWR VGND sg13cmos5l_fill_2
X_12752_ _12753_/A _12767_/C _12751_/Y _12750_/Y VPWR VGND sg13cmos5l_o21ai_1
X_15540_ _15540_/X _15550_/D _15535_/C _15535_/A VPWR VGND sg13cmos5l_a21o_1
X_12683_ _12683_/X _12731_/B _12697_/B _12682_/Y VPWR VGND sg13cmos5l_a21o_1
X_11703_ _11703_/Y _11553_/B _11697_/X _11702_/X _11894_/A _11701_/Y VPWR VGND sg13cmos5l_a221oi_1
X_15471_ _15471_/Y _19334_/Q _10217_/Y _15468_/Y _15469_/Y _15470_/Y VPWR VGND sg13cmos5l_a221oi_1
X_11634_ _11634_/Y _18745_/Q _10299_/Y _11650_/A _18744_/Q VPWR VGND sg13cmos5l_a22oi_1
X_17210_ _19572_/D _17370_/B _17344_/A VPWR VGND sg13cmos5l_nor2_1
X_14422_ _14423_/B _14395_/Y _10235_/Y _14424_/S VPWR VGND sg13cmos5l_mux2_1
XFILLER_24_60 VPWR VGND sg13cmos5l_fill_1
X_18190_ _18190_/Y _18178_/Y _18181_/Y _18191_/A _18191_/B VPWR VGND sg13cmos5l_a22oi_1
XFILLER_7_700 VPWR VGND sg13cmos5l_fill_1
X_11565_ _11565_/Y _11565_/A _11565_/B VPWR VGND sg13cmos5l_nor2_1
X_17141_ _17141_/Y _17408_/B _17136_/S _17140_/Y VPWR VGND sg13cmos5l_a21oi_1
XFILLER_6_210 VPWR VGND sg13cmos5l_decap_8
X_14353_ _19122_/D _14353_/A _14353_/B VPWR VGND sg13cmos5l_and2_1
X_17072_ _17072_/Y _17032_/B _17070_/S _16939_/A VPWR VGND sg13cmos5l_o21ai_1
X_11496_ _11497_/B _18715_/Q _11588_/B VPWR VGND sg13cmos5l_nor2_1
X_13304_ _13304_/Y _18999_/Q _13323_/A _10265_/Y _19000_/Q _13303_/Y VPWR VGND sg13cmos5l_a221oi_1
X_10516_ _10546_/B _19787_/Q _19786_/Q _10526_/B _19788_/Q VPWR VGND sg13cmos5l_nor4_1
X_14284_ _14288_/C _14291_/A _14473_/A VPWR VGND sg13cmos5l_nand2_1
X_13235_ _13235_/Y _13235_/A _13253_/S VPWR VGND sg13cmos5l_nor2_1
X_10447_ _10447_/Y _10445_/Y _10446_/Y _10444_/Y VPWR VGND sg13cmos5l_a21oi_1
X_16023_ _16023_/Y _16555_/A _19359_/Q VPWR VGND sg13cmos5l_nor2_1
X_10378_ _16593_/B _10378_/A VPWR VGND sg13cmos5l_inv_1
X_13166_ _13166_/Y _13164_/Y _13165_/Y _13159_/Y VPWR VGND sg13cmos5l_o21ai_1
X_12117_ _12117_/Y _12116_/A _12116_/B _12116_/C _12116_/D VPWR VGND sg13cmos5l_a22oi_1
X_13097_ _13104_/C _18907_/Q _18908_/Q _18905_/Q _18906_/Q VPWR VGND sg13cmos5l_or4_1
X_17974_ _17974_/Y _19644_/Q _17974_/B VPWR VGND sg13cmos5l_nor2_1
XFILLER_2_460 VPWR VGND sg13cmos5l_fill_1
X_16925_ _17013_/A _16925_/A _16932_/B VPWR VGND sg13cmos5l_nand2_1
X_12048_ _12169_/A _18798_/Q _12051_/B _12047_/Y VPWR VGND sg13cmos5l_a21oi_1
X_19713_ _19713_/Q clkload14/A _19713_/D _19713_/RESET_B VPWR VGND sg13cmos5l_dfrbpq_1
X_19644_ _19644_/Q _19756_/CLK _19644_/D _19644_/RESET_B VPWR VGND sg13cmos5l_dfrbpq_1
X_16856_ _16857_/A _16861_/C _16855_/Y _16854_/Y VPWR VGND sg13cmos5l_a21o_1
X_16787_ _16787_/Y _16792_/B _16787_/B VPWR VGND sg13cmos5l_nand2_1
X_19575_ _19575_/Q clkload36/A _19575_/D _19575_/RESET_B VPWR VGND sg13cmos5l_dfrbpq_1
X_13999_ _14080_/B _13956_/X _13998_/Y _14010_/B VPWR VGND sg13cmos5l_mux2_1
X_15807_ _19363_/D _09987_/Y fanout93/X _15806_/Y VPWR VGND sg13cmos5l_a21oi_1
XFILLER_52_128 VPWR VGND sg13cmos5l_fill_2
X_18526_ _18526_/Y _18501_/A _18530_/S _10646_/B VPWR VGND sg13cmos5l_o21ai_1
X_15738_ _19342_/D _15738_/A _15742_/B VPWR VGND sg13cmos5l_nor2_1
X_18608__1688 _18608_/RESET_B VPWR VGND sg13cmos5l_tiehi
X_18457_ _18457_/Y _18350_/Y _18363_/Y _18448_/Y _18454_/Y _18456_/Y VPWR VGND sg13cmos5l_a221oi_1
XFILLER_34_887 VPWR VGND sg13cmos5l_fill_1
XFILLER_61_695 VPWR VGND sg13cmos5l_fill_1
X_17408_ _17408_/Y _19560_/Q _17408_/B _17408_/C VPWR VGND sg13cmos5l_nor3_1
X_15669_ _15669_/Y _15669_/A VPWR VGND sg13cmos5l_inv_1
XFILLER_33_375 VPWR VGND sg13cmos5l_decap_8
XFILLER_33_397 VPWR VGND sg13cmos5l_fill_1
X_18388_ _18388_/X _18388_/A _18388_/B _18388_/C VPWR VGND sg13cmos5l_or3_1
X_17339_ _17340_/C _17339_/A _17339_/B _17339_/C VPWR VGND sg13cmos5l_nand3_1
X_19009_ _19009_/Q clkload66/A _19009_/D _19009_/RESET_B VPWR VGND sg13cmos5l_dfrbpq_1
X_19429__801 _19429_/RESET_B VPWR VGND sg13cmos5l_tiehi
Xhold2613 _15795_/B _15794_/X VPWR VGND sg13cmos5l_dlygate4sd3_1
Xhold2602 _16508_/A _19456_/Q VPWR VGND sg13cmos5l_dlygate4sd3_1
Xhold2646 _12411_/B _12410_/Y VPWR VGND sg13cmos5l_dlygate4sd3_1
Xhold2624 hold2624/X _11313_/A VPWR VGND sg13cmos5l_dlygate4sd3_1
Xhold1901 _17364_/B _19539_/Q VPWR VGND sg13cmos5l_dlygate4sd3_1
XFILLER_60_1024 VPWR VGND sg13cmos5l_decap_4
Xhold2635 _10209_/A _19358_/Q VPWR VGND sg13cmos5l_dlygate4sd3_1
Xhold1945 _09977_/A _19478_/Q VPWR VGND sg13cmos5l_dlygate4sd3_1
Xhold1923 _17223_/A _19563_/Q VPWR VGND sg13cmos5l_dlygate4sd3_1
Xhold2668 _11454_/A _18653_/Q VPWR VGND sg13cmos5l_dlygate4sd3_1
Xhold1934 _09968_/A _19730_/Q VPWR VGND sg13cmos5l_dlygate4sd3_1
Xhold1912 _13878_/B _18987_/Q VPWR VGND sg13cmos5l_dlygate4sd3_1
Xhold2679 _16170_/A _19424_/Q VPWR VGND sg13cmos5l_dlygate4sd3_1
Xhold2657 _15331_/A _19298_/Q VPWR VGND sg13cmos5l_dlygate4sd3_1
XFILLER_28_103 VPWR VGND sg13cmos5l_fill_2
Xhold1967 _09978_/A _19477_/Q VPWR VGND sg13cmos5l_dlygate4sd3_1
Xhold1956 hold1956/X _10693_/Y VPWR VGND sg13cmos5l_dlygate4sd3_1
Xhold1978 _14364_/B _19087_/Q VPWR VGND sg13cmos5l_dlygate4sd3_1
XFILLER_45_15 VPWR VGND sg13cmos5l_fill_2
XFILLER_44_629 VPWR VGND sg13cmos5l_fill_1
XFILLER_44_618 VPWR VGND sg13cmos5l_decap_8
Xhold1989 _19404_/D _16078_/Y VPWR VGND sg13cmos5l_dlygate4sd3_1
XFILLER_28_158 VPWR VGND sg13cmos5l_fill_2
XFILLER_52_662 VPWR VGND sg13cmos5l_fill_2
XFILLER_40_846 VPWR VGND sg13cmos5l_fill_1
X_11350_ _18667_/D _11691_/A _11350_/B VPWR VGND sg13cmos5l_and2_1
X_10301_ _11646_/B _18688_/Q VPWR VGND sg13cmos5l_inv_1
XFILLER_106_631 VPWR VGND sg13cmos5l_fill_1
X_13020_ _18924_/D _13020_/A _13020_/B VPWR VGND sg13cmos5l_nor2_1
X_11281_ _11281_/Y _11281_/A _11452_/A VPWR VGND sg13cmos5l_nand2_1
XFILLER_106_686 VPWR VGND sg13cmos5l_fill_1
X_10232_ _14932_/B _19192_/Q VPWR VGND sg13cmos5l_inv_1
X_10163_ _17168_/B _19529_/Q VPWR VGND sg13cmos5l_inv_1
XFILLER_79_548 VPWR VGND sg13cmos5l_fill_1
XFILLER_0_964 VPWR VGND sg13cmos5l_decap_4
X_16710_ _16910_/A _17083_/A _16710_/B VPWR VGND sg13cmos5l_xnor2_1
XFILLER_87_570 VPWR VGND sg13cmos5l_fill_2
X_14971_ _19235_/D _09992_/Y fanout72/X _14970_/Y VPWR VGND sg13cmos5l_a21oi_1
X_10094_ _14642_/A _10094_/A VPWR VGND sg13cmos5l_inv_1
XFILLER_48_979 VPWR VGND sg13cmos5l_decap_4
X_17690_ _17709_/C _17693_/C _17690_/B VPWR VGND sg13cmos5l_and2_1
X_13922_ _19076_/D _14080_/A _13922_/B VPWR VGND sg13cmos5l_nor2_1
X_16641_ _16641_/Y _16641_/A _16641_/B _16641_/C VPWR VGND sg13cmos5l_nand3_1
X_13853_ _13853_/Y _14370_/A _14371_/A _13848_/A _13349_/B VPWR VGND sg13cmos5l_a22oi_1
X_18891__1378 _18891_/RESET_B VPWR VGND sg13cmos5l_tiehi
X_16572_ _16583_/B _16563_/Y _16570_/Y _16571_/Y VPWR VGND sg13cmos5l_o21ai_1
X_12804_ _12805_/B _18870_/Q _18863_/Q _18864_/Q VPWR VGND sg13cmos5l_nor3_1
X_19360_ _19360_/Q clkload6/A _19360_/D _19360_/RESET_B VPWR VGND sg13cmos5l_dfrbpq_1
X_19064__1193 _19064_/RESET_B VPWR VGND sg13cmos5l_tiehi
X_13784_ _13785_/B _13784_/A _13784_/B VPWR VGND sg13cmos5l_nor2_1
X_10996_ _10996_/Y _10999_/A _11091_/B VPWR VGND sg13cmos5l_nand2_1
X_15523_ _19320_/D _09988_/Y fanout75/X _15522_/Y VPWR VGND sg13cmos5l_a21oi_1
X_18311_ _18311_/Y _18106_/Y _18299_/X _18302_/B _18302_/A VPWR VGND sg13cmos5l_a22oi_1
X_12735_ _18890_/D _12735_/A _12735_/B VPWR VGND sg13cmos5l_nor2_1
X_19291_ _19291_/Q clkload43/A _19291_/D _19291_/RESET_B VPWR VGND sg13cmos5l_dfrbpq_1
X_12666_ _12735_/B _12633_/Y _12824_/A _12658_/C _12636_/X VPWR VGND sg13cmos5l_a22oi_1
X_18242_ _18252_/B _19747_/Q _10340_/Y _18241_/Y VPWR VGND sg13cmos5l_o21ai_1
X_15454_ _19298_/D _15454_/A _15458_/B VPWR VGND sg13cmos5l_nor2_1
X_12597_ _12702_/A _18883_/Q _12599_/B VPWR VGND sg13cmos5l_nor2_1
X_11617_ _18707_/D _11601_/A _11572_/Y _11479_/A VPWR VGND sg13cmos5l_a21oi_1
X_15385_ _15385_/Y _15395_/S _15384_/Y _15383_/X VPWR VGND sg13cmos5l_a21oi_1
X_14405_ _14405_/Y _14405_/A VPWR VGND sg13cmos5l_inv_1
X_18173_ _18174_/B _18060_/B _18195_/B _18172_/Y VPWR VGND sg13cmos5l_a21oi_1
X_11548_ _11548_/Y _11548_/A _11548_/B VPWR VGND sg13cmos5l_nor2_1
X_17124_ _17124_/Y _17124_/A VPWR VGND sg13cmos5l_inv_1
X_14336_ _14336_/Y _14336_/A _14336_/B VPWR VGND sg13cmos5l_nand2_1
X_17055_ _17055_/Y _17062_/A _17062_/B VPWR VGND sg13cmos5l_nand2_1
X_11479_ _18700_/D _11479_/A _11479_/B VPWR VGND sg13cmos5l_nor2_1
X_14267_ _14267_/Y _14304_/A _14460_/B VPWR VGND sg13cmos5l_nand2b_1
X_13218_ _13257_/B _13232_/A _13232_/B VPWR VGND sg13cmos5l_nand2_1
X_16006_ _19378_/D hold2798/X _16001_/S _16005_/Y VPWR VGND sg13cmos5l_a21oi_1
X_14198_ _19118_/D _14377_/A _14198_/B VPWR VGND sg13cmos5l_nor2_1
X_13149_ _13173_/B _18958_/Q _18957_/Q _18955_/Q _18956_/Q VPWR VGND sg13cmos5l_nor4_1
X_17957_ _17957_/Y _19706_/Q _18471_/A _17975_/C VPWR VGND sg13cmos5l_nor3_1
XFILLER_25_2 VPWR VGND sg13cmos5l_fill_1
X_16908_ _16912_/B _19488_/Q _19487_/Q _19486_/Q _16908_/D VPWR VGND sg13cmos5l_nor4_1
X_17888_ _17888_/X _17912_/A _17889_/B VPWR VGND sg13cmos5l_and2_1
X_16839_ _16849_/B _16830_/Y _16837_/Y _16838_/Y VPWR VGND sg13cmos5l_o21ai_1
X_19627_ _19627_/Q clkload24/A _19627_/D _19627_/RESET_B VPWR VGND sg13cmos5l_dfrbpq_1
XFILLER_53_404 VPWR VGND sg13cmos5l_fill_1
X_19558_ _19558_/Q clkload25/A _19558_/D _19558_/RESET_B VPWR VGND sg13cmos5l_dfrbpq_1
XFILLER_80_256 VPWR VGND sg13cmos5l_fill_2
X_18509_ _18509_/Y _18509_/A _19790_/Q _18514_/C VPWR VGND sg13cmos5l_nor3_1
XFILLER_18_191 VPWR VGND sg13cmos5l_fill_1
X_19489_ _19489_/Q clkload39/A _19489_/D _19489_/RESET_B VPWR VGND sg13cmos5l_dfrbpq_1
XFILLER_90_1028 VPWR VGND sg13cmos5l_fill_1
XFILLER_62_993 VPWR VGND sg13cmos5l_decap_8
X_19668__1791 _19668_/RESET_B VPWR VGND sg13cmos5l_tiehi
XFILLER_103_9 VPWR VGND sg13cmos5l_fill_2
X_19116__1135 _19116_/RESET_B VPWR VGND sg13cmos5l_tiehi
XFILLER_89_824 VPWR VGND sg13cmos5l_fill_1
Xoutput17 uo_out[4] _19442_/Q VPWR VGND sg13cmos5l_buf_1
Xhold2410 _17106_/A _19514_/Q VPWR VGND sg13cmos5l_dlygate4sd3_1
Xhold2421 _10129_/A _19376_/Q VPWR VGND sg13cmos5l_dlygate4sd3_1
Xhold2432 _10023_/A _18704_/Q VPWR VGND sg13cmos5l_dlygate4sd3_1
Xhold2454 _10077_/A _19001_/Q VPWR VGND sg13cmos5l_dlygate4sd3_1
Xhold2443 hold2443/X _19743_/Q VPWR VGND sg13cmos5l_dlygate4sd3_1
Xhold2498 _10300_/A _18682_/Q VPWR VGND sg13cmos5l_dlygate4sd3_1
Xhold2487 _10022_/A _18706_/Q VPWR VGND sg13cmos5l_dlygate4sd3_1
Xhold2465 _18561_/D _10657_/Y VPWR VGND sg13cmos5l_dlygate4sd3_1
X_18984__1278 _18984_/RESET_B VPWR VGND sg13cmos5l_tiehi
XFILLER_56_220 VPWR VGND sg13cmos5l_fill_1
XFILLER_29_423 VPWR VGND sg13cmos5l_fill_2
Xhold2476 _10091_/A _19126_/Q VPWR VGND sg13cmos5l_dlygate4sd3_1
XFILLER_45_938 VPWR VGND sg13cmos5l_fill_2
X_10850_ _10850_/Y _11355_/A _18624_/Q _10850_/C VPWR VGND sg13cmos5l_nor3_1
XFILLER_44_426 VPWR VGND sg13cmos5l_fill_1
XFILLER_71_267 VPWR VGND sg13cmos5l_fill_1
X_10781_ _10781_/Y _13653_/B _10781_/B VPWR VGND sg13cmos5l_nor2_1
XFILLER_12_301 VPWR VGND sg13cmos5l_fill_1
XFILLER_13_824 VPWR VGND sg13cmos5l_fill_1
X_12520_ _12520_/Y _12502_/Y hold2170/X _12728_/B VPWR VGND sg13cmos5l_a21oi_1
X_12451_ _12452_/C _12451_/A _12437_/A VPWR VGND sg13cmos5l_nor2b_1
XFILLER_8_305 VPWR VGND sg13cmos5l_fill_2
X_11402_ _11630_/A _13337_/A _11892_/B VPWR VGND sg13cmos5l_nor2_1
X_15170_ _19248_/D _15055_/Y _15173_/S _15169_/Y VPWR VGND sg13cmos5l_a21oi_1
X_12382_ _12399_/A _12382_/A _12414_/B VPWR VGND sg13cmos5l_nor2_1
X_14121_ _14122_/B _19107_/Q _14118_/Y _14392_/B VPWR VGND sg13cmos5l_o21ai_1
X_11333_ _11335_/A _11336_/A _11336_/B VPWR VGND sg13cmos5l_nor2_1
X_11264_ _11264_/Y _18678_/Q _11268_/D VPWR VGND sg13cmos5l_xnor2_1
X_14052_ _14056_/B _14052_/A _14052_/B VPWR VGND sg13cmos5l_nand2_1
XFILLER_106_483 VPWR VGND sg13cmos5l_fill_1
X_18860_ _18860_/Q _18902_/CLK _18860_/D _18860_/RESET_B VPWR VGND sg13cmos5l_dfrbpq_1
X_13003_ _13004_/B hold2778/X _13007_/A _13019_/B VPWR VGND sg13cmos5l_o21ai_1
X_10215_ _15779_/B _10215_/A VPWR VGND sg13cmos5l_inv_1
X_19469__455 _19469_/D VPWR VGND sg13cmos5l_tielo
X_11195_ _11195_/X _11171_/D _11159_/C _11203_/B VPWR VGND sg13cmos5l_a21o_1
X_17811_ _17837_/A _19673_/Q _19674_/Q _19675_/Q VPWR VGND sg13cmos5l_or3_1
X_18791_ _18791_/Q clkload60/A _18791_/D _18791_/RESET_B VPWR VGND sg13cmos5l_dfrbpq_1
X_10146_ _17081_/A _10146_/A VPWR VGND sg13cmos5l_inv_1
XFILLER_67_518 VPWR VGND sg13cmos5l_fill_1
X_17742_ _17742_/Y _19612_/Q _17757_/D _19613_/Q VPWR VGND sg13cmos5l_o21ai_1
X_10077_ _14076_/A _10077_/A VPWR VGND sg13cmos5l_inv_1
XFILLER_47_220 VPWR VGND sg13cmos5l_fill_1
X_14954_ _14955_/B _19233_/Q _14952_/Y _15210_/B VPWR VGND sg13cmos5l_o21ai_1
X_18822__1450 _18822_/RESET_B VPWR VGND sg13cmos5l_tiehi
X_17673_ _19630_/D _17673_/A _17673_/B VPWR VGND sg13cmos5l_nor2_1
X_13905_ _13906_/B _13907_/A _13923_/B _13902_/Y VPWR VGND sg13cmos5l_a21oi_1
X_16624_ _19482_/D _16624_/A _16624_/B VPWR VGND sg13cmos5l_and2_1
X_19412_ _19412_/Q clkload5/A _19412_/D _19412_/RESET_B VPWR VGND sg13cmos5l_dfrbpq_1
X_14885_ _14889_/B _14885_/A _14885_/B VPWR VGND sg13cmos5l_and2_1
XFILLER_90_565 VPWR VGND sg13cmos5l_fill_2
XFILLER_51_919 VPWR VGND sg13cmos5l_decap_4
X_13836_ _13836_/Y _13836_/A _18982_/Q VPWR VGND sg13cmos5l_nor2_1
X_13767_ _13767_/Y _13730_/X _13767_/B VPWR VGND sg13cmos5l_nand2b_1
X_10979_ _10979_/Y _11159_/A _10990_/B VPWR VGND sg13cmos5l_nand2_1
XFILLER_44_971 VPWR VGND sg13cmos5l_fill_1
X_19343_ _19343_/Q clkload16/A _19343_/D _19343_/RESET_B VPWR VGND sg13cmos5l_dfrbpq_1
X_16555_ _16555_/Y _16555_/A _16555_/B VPWR VGND sg13cmos5l_nor2_1
X_12718_ _12718_/Y _12706_/B _12714_/S _12734_/A VPWR VGND sg13cmos5l_o21ai_1
X_19419__811 _19419_/RESET_B VPWR VGND sg13cmos5l_tiehi
X_19274_ _19274_/Q clkload15/A _19274_/D _19274_/RESET_B VPWR VGND sg13cmos5l_dfrbpq_1
X_15506_ _15506_/Y _18272_/A _16009_/B VPWR VGND sg13cmos5l_nor2_1
X_16486_ _16524_/A _19460_/Q _16500_/B VPWR VGND sg13cmos5l_xnor2_1
X_13698_ _13815_/B _13700_/B _13700_/C VPWR VGND sg13cmos5l_and2_1
X_18225_ _19712_/D _18225_/A _18227_/B VPWR VGND sg13cmos5l_nor2_1
X_15437_ _15437_/Y _15439_/A _15451_/A _15436_/Y VPWR VGND sg13cmos5l_a21oi_1
X_12649_ _12731_/B _12649_/A _12649_/B VPWR VGND sg13cmos5l_and2_1
XFILLER_8_861 VPWR VGND sg13cmos5l_decap_4
X_15368_ _15562_/A _15742_/A _15368_/B VPWR VGND sg13cmos5l_xnor2_1
X_18156_ _18156_/X _18143_/X _18149_/Y _18155_/X VPWR VGND sg13cmos5l_a21o_1
X_17107_ _17107_/Y _19576_/Q _17673_/A VPWR VGND sg13cmos5l_nand2_1
X_18087_ _18202_/A hold2952/X _18200_/B _18085_/A _18086_/Y VPWR VGND sg13cmos5l_a22oi_1
X_15299_ _15299_/Y _15303_/B _15272_/Y VPWR VGND sg13cmos5l_nor2b_1
X_14319_ _14319_/Y _14319_/A _14319_/B VPWR VGND sg13cmos5l_nor2_1
X_17038_ _17038_/X _17087_/B _17047_/S _17037_/Y VPWR VGND sg13cmos5l_a21o_1
Xheichips26_digital_project_1807 uio_oe[10] VPWR VGND sg13cmos5l_tiehi
X_18989_ _18989_/Q clkload65/A _18989_/D _18989_/RESET_B VPWR VGND sg13cmos5l_dfrbpq_1
X_19426__804 _19426_/RESET_B VPWR VGND sg13cmos5l_tiehi
XFILLER_85_348 VPWR VGND sg13cmos5l_fill_2
XFILLER_94_882 VPWR VGND sg13cmos5l_fill_1
XFILLER_93_370 VPWR VGND sg13cmos5l_fill_2
XFILLER_38_297 VPWR VGND sg13cmos5l_fill_2
XFILLER_53_267 VPWR VGND sg13cmos5l_fill_1
X_19639__569 _19639_/RESET_B VPWR VGND sg13cmos5l_tiehi
XFILLER_35_982 VPWR VGND sg13cmos5l_decap_8
X_18657__1636 _18657_/RESET_B VPWR VGND sg13cmos5l_tiehi
XFILLER_50_996 VPWR VGND sg13cmos5l_fill_1
XFILLER_50_974 VPWR VGND sg13cmos5l_fill_1
XFILLER_10_838 VPWR VGND sg13cmos5l_fill_1
X_10000_ _10000_/Y _10796_/A VPWR VGND sg13cmos5l_inv_1
XFILLER_77_827 VPWR VGND sg13cmos5l_fill_2
X_18907__1359 _18907_/RESET_B VPWR VGND sg13cmos5l_tiehi
X_09989_ _09989_/Y _09989_/A VPWR VGND sg13cmos5l_inv_1
Xhold2273 _10286_/A _18768_/Q VPWR VGND sg13cmos5l_dlygate4sd3_1
Xhold2251 _18601_/D _10868_/Y VPWR VGND sg13cmos5l_dlygate4sd3_1
Xhold2240 _19062_/D _13864_/Y VPWR VGND sg13cmos5l_dlygate4sd3_1
Xhold2262 _10252_/A _19064_/Q VPWR VGND sg13cmos5l_dlygate4sd3_1
Xhold2284 _12192_/A _18747_/Q VPWR VGND sg13cmos5l_dlygate4sd3_1
Xhold2295 _10297_/A _18685_/Q VPWR VGND sg13cmos5l_dlygate4sd3_1
X_11951_ _11951_/Y _12215_/A fanout55/X _11950_/Y VPWR VGND sg13cmos5l_a21oi_1
XFILLER_72_532 VPWR VGND sg13cmos5l_fill_1
X_11882_ _11883_/B _11853_/Y _11850_/A _11890_/S VPWR VGND sg13cmos5l_mux2_1
X_18810__1465 _18810_/RESET_B VPWR VGND sg13cmos5l_tiehi
X_10902_ _10902_/Y _10904_/A _10904_/B _10898_/Y VPWR VGND sg13cmos5l_a21oi_1
X_14670_ _14670_/Y _14660_/B _14668_/Y _14669_/Y _14680_/C VPWR VGND sg13cmos5l_a22oi_1
X_13621_ _13622_/B _13636_/B _13619_/Y _16578_/B VPWR VGND sg13cmos5l_o21ai_1
X_10833_ _10833_/Y _10833_/A VPWR VGND sg13cmos5l_inv_1
XFILLER_25_470 VPWR VGND sg13cmos5l_fill_2
X_10764_ _10769_/B _10764_/A _10763_/Y VPWR VGND sg13cmos5l_nor2b_1
X_13552_ _13559_/A _13527_/A _13526_/Y _13524_/Y VPWR VGND sg13cmos5l_a21oi_1
X_16340_ _16340_/Y _19454_/Q _16340_/B _16350_/C VPWR VGND sg13cmos5l_nor3_1
X_12503_ _12503_/Y _12766_/B _12503_/B VPWR VGND sg13cmos5l_nor2_1
XFILLER_9_614 VPWR VGND sg13cmos5l_fill_1
X_10695_ _10695_/Y _13813_/A _13647_/A VPWR VGND sg13cmos5l_nand2b_1
X_13483_ _13493_/B _19016_/Q _13485_/B VPWR VGND sg13cmos5l_nor2b_1
X_18010_ _18010_/Y _18057_/A _18010_/B VPWR VGND sg13cmos5l_nand2b_1
X_16271_ _16271_/X _16225_/Y _16123_/B _16282_/B VPWR VGND sg13cmos5l_mux2_1
X_19180__1068 _19180_/RESET_B VPWR VGND sg13cmos5l_tiehi
X_12434_ _12435_/B _12434_/A _12434_/B VPWR VGND sg13cmos5l_nor2_1
X_15222_ _15223_/A _15225_/C _15221_/Y _15220_/Y VPWR VGND sg13cmos5l_a21o_1
XFILLER_32_71 VPWR VGND sg13cmos5l_fill_2
X_12365_ _12466_/B _12368_/B _12363_/Y _12364_/Y VPWR VGND sg13cmos5l_a21oi_1
X_15153_ _15153_/Y _15134_/A _15134_/B _15146_/X _15151_/Y _15152_/Y VPWR VGND sg13cmos5l_a221oi_1
X_11316_ _11317_/A _11225_/B _11332_/A _11316_/C VPWR VGND sg13cmos5l_nand3b_1
XFILLER_4_330 VPWR VGND sg13cmos5l_decap_8
X_15084_ _15092_/B _19268_/Q _15086_/B VPWR VGND sg13cmos5l_nor2b_1
X_14104_ _14104_/Y _14643_/A _19122_/Q _14114_/C VPWR VGND sg13cmos5l_nand3_1
X_12296_ _12355_/B _12299_/B _12295_/C _12294_/X VPWR VGND sg13cmos5l_a21o_1
X_18912_ _18912_/Q clkload63/A _18912_/D _18912_/RESET_B VPWR VGND sg13cmos5l_dfrbpq_1
X_14035_ _14035_/X _14028_/A _14029_/X _14034_/Y VPWR VGND sg13cmos5l_a21o_1
XFILLER_106_291 VPWR VGND sg13cmos5l_decap_8
X_11247_ _11268_/D _18675_/Q _18676_/Q _18677_/Q VPWR VGND sg13cmos5l_or3_1
X_18843_ _18843_/Q clkload70/A _18843_/D _18843_/RESET_B VPWR VGND sg13cmos5l_dfrbpq_1
X_11178_ _11203_/B _18617_/Q _11178_/B VPWR VGND sg13cmos5l_xor2_1
X_18774_ _18774_/Q clkload57/A _18774_/D _18774_/RESET_B VPWR VGND sg13cmos5l_dfrbpq_1
X_10129_ _16310_/A _10129_/A VPWR VGND sg13cmos5l_inv_1
XFILLER_0_591 VPWR VGND sg13cmos5l_fill_1
X_17725_ _17725_/Y _17705_/B _17719_/S _17770_/A VPWR VGND sg13cmos5l_o21ai_1
X_15986_ _15986_/Y _15993_/A _15993_/B VPWR VGND sg13cmos5l_nand2_1
X_14937_ _14938_/A _14936_/Y _14935_/Y _14948_/C VPWR VGND sg13cmos5l_mux2_1
X_17656_ _17656_/Y _17634_/A _17659_/A _17677_/A VPWR VGND sg13cmos5l_o21ai_1
XFILLER_51_705 VPWR VGND sg13cmos5l_fill_2
X_14868_ _14870_/C _14868_/A _14868_/B _14868_/C VPWR VGND sg13cmos5l_nand3_1
X_13819_ _19058_/D _13819_/A _13819_/B VPWR VGND sg13cmos5l_nor2_1
X_16607_ _16607_/Y _16582_/A fanout31/X _16606_/Y VPWR VGND sg13cmos5l_a21oi_1
X_17587_ _17591_/C _17587_/A _17587_/B VPWR VGND sg13cmos5l_nand2_1
X_14799_ _14799_/Y _19223_/Q _14800_/B VPWR VGND sg13cmos5l_xnor2_1
X_19326_ _19326_/Q clkload18/A _19326_/D _19326_/RESET_B VPWR VGND sg13cmos5l_dfrbpq_1
X_16538_ _19448_/D hold2603/X fanout32/X _16537_/Y VPWR VGND sg13cmos5l_a21oi_1
X_16469_ _16469_/Y _16469_/A _16469_/B _16469_/C VPWR VGND sg13cmos5l_nor3_1
X_19257_ _19257_/Q clkload42/A _19257_/D _19257_/RESET_B VPWR VGND sg13cmos5l_dfrbpq_1
XFILLER_31_495 VPWR VGND sg13cmos5l_fill_2
X_18208_ _18208_/Y _18184_/Y _18212_/S _18231_/A VPWR VGND sg13cmos5l_o21ai_1
X_19188_ _19188_/Q _19302_/CLK _19188_/D _19188_/RESET_B VPWR VGND sg13cmos5l_dfrbpq_1
X_19156__1092 _19156_/RESET_B VPWR VGND sg13cmos5l_tiehi
X_18139_ _18139_/Y _18125_/Y _18130_/Y _18138_/Y VPWR VGND sg13cmos5l_a21oi_1
XFILLER_99_941 VPWR VGND sg13cmos5l_fill_2
XFILLER_98_440 VPWR VGND sg13cmos5l_fill_1
XFILLER_101_968 VPWR VGND sg13cmos5l_fill_1
XFILLER_100_423 VPWR VGND sg13cmos5l_fill_1
XFILLER_73_329 VPWR VGND sg13cmos5l_fill_1
X_18563__1746 _18563_/RESET_B VPWR VGND sg13cmos5l_tiehi
XFILLER_54_521 VPWR VGND sg13cmos5l_decap_8
XFILLER_23_952 VPWR VGND sg13cmos5l_fill_1
XFILLER_23_974 VPWR VGND sg13cmos5l_fill_1
X_10480_ _10589_/B _19747_/Q _10481_/B VPWR VGND sg13cmos5l_xnor2_1
X_12150_ _12157_/B _12115_/Y _12009_/Y _12162_/B VPWR VGND sg13cmos5l_mux2_1
XFILLER_5_149 VPWR VGND sg13cmos5l_decap_8
X_11101_ _11107_/C _11097_/Y _11099_/Y _11100_/Y VPWR VGND sg13cmos5l_o21ai_1
XFILLER_2_801 VPWR VGND sg13cmos5l_decap_4
X_12081_ _12081_/Y _12130_/A VPWR VGND sg13cmos5l_inv_1
X_11032_ _11032_/X _11032_/A _11032_/B VPWR VGND sg13cmos5l_xor2_1
X_19409__821 _19409_/RESET_B VPWR VGND sg13cmos5l_tiehi
X_15840_ _15841_/B _15840_/A _15856_/B VPWR VGND sg13cmos5l_nor2_1
Xhold2081 _19512_/D _16872_/Y VPWR VGND sg13cmos5l_dlygate4sd3_1
Xhold2070 _17688_/A _19596_/Q VPWR VGND sg13cmos5l_dlygate4sd3_1
X_12983_ _12983_/Y _12980_/Y _12982_/Y _12966_/X VPWR VGND sg13cmos5l_o21ai_1
Xhold2092 _11350_/B _18625_/Q VPWR VGND sg13cmos5l_dlygate4sd3_1
XFILLER_45_521 VPWR VGND sg13cmos5l_fill_1
X_15771_ _15772_/B _19318_/Q _15769_/Y _15770_/Y VPWR VGND sg13cmos5l_o21ai_1
XFILLER_18_735 VPWR VGND sg13cmos5l_fill_1
XFILLER_94_88 VPWR VGND sg13cmos5l_fill_2
X_11934_ _11934_/X _11938_/C _11932_/Y _11933_/Y VPWR VGND sg13cmos5l_a21o_1
X_17510_ _17637_/B _19627_/Q _17526_/B VPWR VGND sg13cmos5l_nand2_1
X_18490_ _18490_/Y _19789_/Q _10332_/Y _18513_/B _19788_/Q _18489_/Y VPWR VGND sg13cmos5l_a221oi_1
X_14722_ _14722_/Y _19157_/Q _19158_/Q VPWR VGND sg13cmos5l_xnor2_1
XFILLER_27_71 VPWR VGND sg13cmos5l_fill_2
X_17441_ _17442_/C _19567_/Q _19568_/Q _19569_/Q VPWR VGND sg13cmos5l_o21ai_1
XFILLER_17_256 VPWR VGND sg13cmos5l_fill_1
X_14653_ _14653_/Y _19209_/Q _19147_/Q VPWR VGND sg13cmos5l_nand2b_1
X_13604_ _13627_/A _10725_/Y _13603_/Y _13616_/S VPWR VGND sg13cmos5l_mux2_1
X_11865_ _11865_/Y _11865_/A _11865_/B _11865_/C VPWR VGND sg13cmos5l_nand3_1
X_11796_ _11797_/C _11796_/A _11989_/A VPWR VGND sg13cmos5l_nor2_1
X_10816_ _18590_/D _16889_/A _10816_/B VPWR VGND sg13cmos5l_and2_1
X_17372_ _19589_/D _17296_/C _17296_/D _17373_/A VPWR VGND sg13cmos5l_a21oi_1
X_14584_ _14584_/Y _14611_/A _14648_/B _14583_/Y VPWR VGND sg13cmos5l_a21oi_1
X_19111_ _19111_/Q clkload47/A _19111_/D _19111_/RESET_B VPWR VGND sg13cmos5l_dfrbpq_1
X_10747_ _10796_/B input6/X _10795_/C VPWR VGND sg13cmos5l_nand2_1
X_13535_ _13543_/A _13535_/A VPWR VGND sg13cmos5l_inv_1
XFILLER_9_433 VPWR VGND sg13cmos5l_fill_2
X_16323_ _16323_/Y _19451_/Q _16344_/A _16329_/A _19450_/Q _16322_/Y VPWR VGND sg13cmos5l_a221oi_1
X_19042_ _19042_/Q clkload31/A _19042_/D _19042_/RESET_B VPWR VGND sg13cmos5l_dfrbpq_1
X_10678_ _10678_/X _10678_/A _10679_/C VPWR VGND sg13cmos5l_or2_1
X_13466_ _13475_/B _19011_/Q _19012_/Q _19013_/Q _19014_/Q VPWR VGND sg13cmos5l_nor4_1
X_16254_ _16260_/A _16240_/Y _16247_/X _16253_/Y VPWR VGND sg13cmos5l_o21ai_1
X_19416__814 _19416_/RESET_B VPWR VGND sg13cmos5l_tiehi
X_12417_ _12418_/B _12417_/A _12417_/B _12417_/C VPWR VGND sg13cmos5l_nand3_1
X_15205_ _15205_/Y _15205_/A _15215_/B VPWR VGND sg13cmos5l_nand2_1
X_13397_ _13505_/A _13397_/A _13420_/B _13420_/C VPWR VGND sg13cmos5l_nand3_1
X_16185_ _16185_/Y _16202_/D _16185_/B _16423_/A VPWR VGND sg13cmos5l_nand3_1
X_12348_ _12348_/Y _12337_/Y _12346_/Y _12345_/X VPWR VGND sg13cmos5l_a21oi_1
X_15136_ _15136_/X _15136_/A _15136_/B VPWR VGND sg13cmos5l_xor2_1
X_12279_ _12279_/Y _18784_/Q _12280_/B VPWR VGND sg13cmos5l_xnor2_1
X_15067_ _15067_/Y _19249_/Q _15067_/B VPWR VGND sg13cmos5l_nor2_1
X_19629__579 _19629_/RESET_B VPWR VGND sg13cmos5l_tiehi
X_14018_ _14018_/Y _14049_/B VPWR VGND sg13cmos5l_inv_1
XFILLER_4_86 VPWR VGND sg13cmos5l_fill_1
X_18826_ _18826_/Q clkload71/A _18826_/D _18826_/RESET_B VPWR VGND sg13cmos5l_dfrbpq_1
XFILLER_67_167 VPWR VGND sg13cmos5l_decap_8
X_19599__612 _19599_/RESET_B VPWR VGND sg13cmos5l_tiehi
X_18757_ _18757_/Q clkload40/A _18757_/D _18757_/RESET_B VPWR VGND sg13cmos5l_dfrbpq_1
X_19560__446 _19560_/D VPWR VGND sg13cmos5l_tielo
X_15969_ _15970_/B _15969_/A _15969_/B _15969_/C VPWR VGND sg13cmos5l_and3_1
X_19423__807 _19423_/RESET_B VPWR VGND sg13cmos5l_tiehi
X_18688_ _18688_/Q _18750_/CLK _18688_/D _18688_/RESET_B VPWR VGND sg13cmos5l_dfrbpq_1
X_17708_ _17708_/Y _19602_/Q _17708_/B VPWR VGND sg13cmos5l_nor2_1
X_17639_ _17639_/Y _17639_/A _17639_/B VPWR VGND sg13cmos5l_nand2_1
X_18697__1593 _18697_/RESET_B VPWR VGND sg13cmos5l_tiehi
X_19309_ _19309_/Q clkload17/A _19309_/D _19309_/RESET_B VPWR VGND sg13cmos5l_dfrbpq_1
XFILLER_31_292 VPWR VGND sg13cmos5l_fill_1
Xfanout401 _12529_/A fanout402/X VPWR VGND sg13cmos5l_buf_1
XFILLER_101_754 VPWR VGND sg13cmos5l_fill_2
XFILLER_87_999 VPWR VGND sg13cmos5l_fill_2
XFILLER_74_627 VPWR VGND sg13cmos5l_fill_1
XFILLER_73_115 VPWR VGND sg13cmos5l_fill_2
XFILLER_55_830 VPWR VGND sg13cmos5l_fill_1
XFILLER_39_381 VPWR VGND sg13cmos5l_fill_1
XFILLER_54_351 VPWR VGND sg13cmos5l_fill_2
XFILLER_15_727 VPWR VGND sg13cmos5l_fill_2
XFILLER_15_749 VPWR VGND sg13cmos5l_fill_1
Xfanout30 _16809_/S _16812_/A VPWR VGND sg13cmos5l_buf_1
X_11650_ _11650_/Y _11650_/A _18688_/Q VPWR VGND sg13cmos5l_nor2_1
Xfanout63 _16792_/B _16692_/Y VPWR VGND sg13cmos5l_buf_1
Xfanout52 _12509_/S _12506_/Y VPWR VGND sg13cmos5l_buf_1
X_11581_ _11581_/Y _11604_/B _11581_/B VPWR VGND sg13cmos5l_nand2b_1
X_10601_ _10607_/A _10606_/A _10606_/B _10599_/Y _10602_/A _10600_/X VPWR VGND sg13cmos5l_a221oi_1
Xfanout41 _14895_/S _14901_/S VPWR VGND sg13cmos5l_buf_1
Xfanout74 fanout74/X fanout82/X VPWR VGND sg13cmos5l_buf_1
Xfanout96 fanout96/X fanout97/X VPWR VGND sg13cmos5l_buf_1
X_19515__702 _19515_/RESET_B VPWR VGND sg13cmos5l_tiehi
Xfanout85 fanout85/X _10738_/Y VPWR VGND sg13cmos5l_buf_1
X_13320_ _13321_/B _18940_/Q _13318_/Y _13319_/Y VPWR VGND sg13cmos5l_o21ai_1
X_10532_ _10532_/Y _19800_/Q _19784_/Q _19799_/Q VPWR VGND sg13cmos5l_nand3b_1
XFILLER_11_988 VPWR VGND sg13cmos5l_fill_2
X_13251_ _13252_/A _13251_/A _13265_/A _13251_/C VPWR VGND sg13cmos5l_or3_1
X_10463_ _10610_/A _10461_/Y _10462_/X _10449_/Y VPWR VGND sg13cmos5l_o21ai_1
X_12202_ _12202_/Y _18829_/Q _12215_/A _10288_/Y _18828_/Q VPWR VGND sg13cmos5l_a22oi_1
X_10394_ _10680_/C _10404_/B _10394_/B VPWR VGND sg13cmos5l_nand2b_1
X_13182_ _13292_/B hold2775/X _13397_/A _13199_/S VPWR VGND sg13cmos5l_mux2_1
X_12133_ _12133_/X _12130_/Y _12306_/A _12133_/S VPWR VGND sg13cmos5l_mux2_1
XFILLER_89_88 VPWR VGND sg13cmos5l_fill_1
X_17990_ _19682_/D _17968_/A _17993_/S _17989_/Y VPWR VGND sg13cmos5l_a21oi_1
X_12064_ _12080_/B _18801_/Q _18802_/Q _18803_/Q _18804_/Q VPWR VGND sg13cmos5l_nor4_1
X_16941_ _17025_/A _16941_/A _16941_/B VPWR VGND sg13cmos5l_nor2_1
X_11015_ _11016_/B _11042_/B _11042_/C _11042_/A VPWR VGND sg13cmos5l_a21oi_1
XFILLER_78_988 VPWR VGND sg13cmos5l_decap_4
X_18956__1307 _18956_/RESET_B VPWR VGND sg13cmos5l_tiehi
X_16872_ _16872_/Y _16852_/A fanout29/X _16871_/Y VPWR VGND sg13cmos5l_a21oi_1
XFILLER_65_605 VPWR VGND sg13cmos5l_fill_2
X_19129__1122 _19129_/RESET_B VPWR VGND sg13cmos5l_tiehi
X_19660_ _19660_/Q clkload12/A _19660_/D _19660_/RESET_B VPWR VGND sg13cmos5l_dfrbpq_1
X_19591_ _19591_/Q clkload36/A _19591_/D _19591_/RESET_B VPWR VGND sg13cmos5l_dfrbpq_1
X_18611_ _18611_/Q clkload45/A _18611_/D _18611_/RESET_B VPWR VGND sg13cmos5l_dfrbpq_1
X_15823_ _15830_/B _19329_/Q _15824_/B VPWR VGND sg13cmos5l_nor2b_1
XFILLER_80_608 VPWR VGND sg13cmos5l_fill_1
X_18652__1641 _18652_/RESET_B VPWR VGND sg13cmos5l_tiehi
XFILLER_64_148 VPWR VGND sg13cmos5l_fill_1
X_15754_ _15754_/Y _16311_/A _19315_/Q _15750_/Y _15753_/Y VPWR VGND sg13cmos5l_a22oi_1
X_18542_ _19777_/D _18542_/A _18547_/B VPWR VGND sg13cmos5l_nor2_1
X_12966_ _12966_/X _12981_/A _13008_/A VPWR VGND sg13cmos5l_or2_1
X_14705_ _14705_/Y _09994_/Y fanout90/X _14704_/Y VPWR VGND sg13cmos5l_a21oi_1
X_11917_ _11918_/B _12462_/A _18730_/Q VPWR VGND sg13cmos5l_nand2_1
X_12897_ _12934_/A _18927_/Q _18928_/Q VPWR VGND sg13cmos5l_xor2_1
X_18473_ _19752_/D _18473_/A _18481_/A VPWR VGND sg13cmos5l_nor2_1
X_15685_ _15698_/B _15674_/Y _15680_/Y _15684_/Y VPWR VGND sg13cmos5l_a21oi_1
XFILLER_33_524 VPWR VGND sg13cmos5l_fill_2
X_11848_ _11849_/B _11848_/A _11848_/B VPWR VGND sg13cmos5l_xor2_1
X_17424_ _17424_/Y _17402_/A fanout25/X _17423_/Y VPWR VGND sg13cmos5l_a21oi_1
X_19108__489 _19108_/D VPWR VGND sg13cmos5l_tielo
X_14636_ _19171_/D _14636_/A _14636_/B VPWR VGND sg13cmos5l_and2_1
X_17355_ _19575_/D _17334_/A fanout26/X _17354_/Y VPWR VGND sg13cmos5l_a21oi_1
X_14567_ _14567_/Y _14535_/Y _14577_/B VPWR VGND sg13cmos5l_nand2b_1
X_11779_ _11975_/A _18745_/Q _18746_/Q VPWR VGND sg13cmos5l_xnor2_1
X_13518_ _13518_/Y _13518_/A _13519_/S VPWR VGND sg13cmos5l_nor2_1
X_16306_ _19421_/D _16312_/B _16306_/B VPWR VGND sg13cmos5l_nor2_1
X_19025_ _19025_/Q clkload29/A _19025_/D _19025_/RESET_B VPWR VGND sg13cmos5l_dfrbpq_1
X_17286_ _17286_/Y _17316_/B _17252_/Y VPWR VGND sg13cmos5l_nor2b_1
X_14498_ _14609_/A _19176_/Q _14512_/B VPWR VGND sg13cmos5l_xnor2_1
Xclkload33 clkload33/Y clkload33/A VPWR VGND sg13cmos5l_inv_2
X_18902__1364 _18902_/RESET_B VPWR VGND sg13cmos5l_tiehi
X_13449_ _13555_/A _13534_/A _13534_/B VPWR VGND sg13cmos5l_nor2_1
Xclkload11 clkload11/X clkload11/A VPWR VGND sg13cmos5l_buf_8
Xclkload22 clkload22/Y clkload22/A VPWR VGND sg13cmos5l_inv_4
X_16237_ _16239_/A _16243_/A _16220_/B _16236_/X VPWR VGND sg13cmos5l_o21ai_1
Xclkload44 clkload44/Y clkload44/A VPWR VGND sg13cmos5l_inv_2
Xclkload55 clkload55/Y clkload55/A VPWR VGND sg13cmos5l_inv_2
Xclkload66 clkload66/X clkload66/A VPWR VGND sg13cmos5l_buf_8
XFILLER_6_970 VPWR VGND sg13cmos5l_fill_1
X_16168_ _16268_/B _16168_/A _16168_/B _16287_/B VPWR VGND sg13cmos5l_nor3_1
X_15119_ _15120_/A _15263_/A _15119_/B VPWR VGND sg13cmos5l_and2_1
X_16099_ _16141_/A _19371_/Q _16099_/B VPWR VGND sg13cmos5l_xnor2_1
Xhold2828 hold2828/X _10759_/X VPWR VGND sg13cmos5l_dlygate4sd3_1
Xhold2806 _17035_/B _17034_/X VPWR VGND sg13cmos5l_dlygate4sd3_1
Xhold2817 _14610_/C _14609_/Y VPWR VGND sg13cmos5l_dlygate4sd3_1
Xhold2839 _18397_/A _19763_/Q VPWR VGND sg13cmos5l_dlygate4sd3_1
XFILLER_95_273 VPWR VGND sg13cmos5l_fill_2
X_18809_ _18809_/Q clkload68/A _18809_/D _18809_/RESET_B VPWR VGND sg13cmos5l_dfrbpq_1
X_19789_ _19789_/Q _19790_/CLK _19789_/D _19789_/RESET_B VPWR VGND sg13cmos5l_dfrbpq_1
Xclkbuf_leaf_90_clk clkload9/A clkbuf_4_0_0_clk/X VPWR VGND sg13cmos5l_buf_8
XFILLER_12_719 VPWR VGND sg13cmos5l_fill_2
Xclkload5 clkload5/Y clkload5/A VPWR VGND sg13cmos5l_inv_1
X_19358__878 _19358_/RESET_B VPWR VGND sg13cmos5l_tiehi
XFILLER_50_27 VPWR VGND sg13cmos5l_fill_2
Xfanout220 _17137_/A _17131_/Y VPWR VGND sg13cmos5l_buf_1
Xfanout231 _16555_/B _16359_/Y VPWR VGND sg13cmos5l_buf_1
XFILLER_87_763 VPWR VGND sg13cmos5l_fill_1
XFILLER_87_741 VPWR VGND sg13cmos5l_fill_1
Xfanout253 _15188_/B _15192_/A VPWR VGND sg13cmos5l_buf_1
Xfanout242 _15864_/A _16021_/A VPWR VGND sg13cmos5l_buf_1
Xfanout264 _14639_/B _14417_/Y VPWR VGND sg13cmos5l_buf_1
Xfanout275 _13819_/A _13804_/A VPWR VGND sg13cmos5l_buf_1
Xfanout297 _12460_/B _12462_/B VPWR VGND sg13cmos5l_buf_1
Xfanout286 _13296_/A _13292_/A VPWR VGND sg13cmos5l_buf_1
X_12820_ _12850_/B _18869_/Q _12820_/B VPWR VGND sg13cmos5l_xor2_1
XFILLER_75_969 VPWR VGND sg13cmos5l_decap_8
X_19406__824 _19406_/RESET_B VPWR VGND sg13cmos5l_tiehi
X_18778__1497 _18778_/RESET_B VPWR VGND sg13cmos5l_tiehi
X_12751_ _12751_/Y _12751_/A _13291_/A VPWR VGND sg13cmos5l_nand2_1
XFILLER_42_310 VPWR VGND sg13cmos5l_fill_1
X_12682_ _12682_/Y _12682_/A _12685_/B _12685_/C VPWR VGND sg13cmos5l_nor3_1
X_11702_ _11702_/X _18702_/Q _18695_/Q _18696_/Q VPWR VGND sg13cmos5l_or3_1
X_18640__1656 _18640_/RESET_B VPWR VGND sg13cmos5l_tiehi
X_15470_ _15470_/Y _16013_/A _19273_/Q VPWR VGND sg13cmos5l_nor2_1
Xclkbuf_leaf_81_clk clkload23/A clkload0/A VPWR VGND sg13cmos5l_buf_8
X_11633_ _11633_/Y _12191_/A _18684_/Q VPWR VGND sg13cmos5l_nor2_1
XFILLER_43_899 VPWR VGND sg13cmos5l_fill_1
XFILLER_42_376 VPWR VGND sg13cmos5l_fill_1
X_14421_ _19145_/D _10236_/Y _14424_/S _14420_/Y VPWR VGND sg13cmos5l_a21oi_1
XFILLER_30_527 VPWR VGND sg13cmos5l_decap_8
X_19619__589 _19619_/RESET_B VPWR VGND sg13cmos5l_tiehi
X_17140_ _17140_/Y _17124_/A _17136_/S _17375_/A VPWR VGND sg13cmos5l_o21ai_1
X_11564_ _11564_/Y _11552_/Y _11558_/X _11563_/Y VPWR VGND sg13cmos5l_o21ai_1
X_14352_ _14353_/B _14329_/X _14350_/Y _14371_/B VPWR VGND sg13cmos5l_a21oi_1
X_17071_ _19534_/D _17071_/A _17071_/B VPWR VGND sg13cmos5l_nor2_1
X_19589__622 _19589_/RESET_B VPWR VGND sg13cmos5l_tiehi
X_11495_ _11504_/A _18714_/Q _11588_/B _11596_/A VPWR VGND sg13cmos5l_a21oi_1
X_13303_ _13303_/Y _14074_/A _18937_/Q _13299_/Y _13302_/Y VPWR VGND sg13cmos5l_a22oi_1
X_10515_ _10541_/B _19787_/Q _19786_/Q _10526_/B VPWR VGND sg13cmos5l_nor3_1
X_19413__817 _19413_/RESET_B VPWR VGND sg13cmos5l_tiehi
X_14283_ _14473_/A _14638_/A _14303_/A VPWR VGND sg13cmos5l_and2_1
X_13234_ _13237_/A _13265_/A _13234_/B VPWR VGND sg13cmos5l_or2_1
X_10446_ _10446_/Y _19772_/Q _19733_/Q VPWR VGND sg13cmos5l_xnor2_1
XFILLER_6_277 VPWR VGND sg13cmos5l_fill_2
X_16022_ _19394_/D _16022_/A _16022_/B VPWR VGND sg13cmos5l_nor2_1
XFILLER_6_299 VPWR VGND sg13cmos5l_fill_2
XFILLER_3_940 VPWR VGND sg13cmos5l_decap_4
X_10377_ _16578_/B _19024_/Q VPWR VGND sg13cmos5l_inv_1
X_13165_ _13165_/Y _13159_/A _13159_/B _13365_/A VPWR VGND sg13cmos5l_a21oi_1
X_12116_ _12116_/Y _12116_/A _12116_/B _12116_/C _12116_/D VPWR VGND sg13cmos5l_nand4_1
XFILLER_97_549 VPWR VGND sg13cmos5l_fill_1
XFILLER_97_538 VPWR VGND sg13cmos5l_decap_8
X_13096_ _13096_/X _13098_/B _13090_/B _12939_/A VPWR VGND sg13cmos5l_a21o_1
X_17973_ _17973_/Y _17973_/A _17973_/B _17973_/C VPWR VGND sg13cmos5l_nor3_1
XFILLER_3_984 VPWR VGND sg13cmos5l_fill_2
X_12047_ _12047_/Y _12160_/B _12160_/C _12160_/A VPWR VGND sg13cmos5l_a21oi_1
X_16924_ _19526_/D _16939_/A _17037_/A VPWR VGND sg13cmos5l_and2_1
XFILLER_49_80 VPWR VGND sg13cmos5l_fill_2
X_19712_ _19712_/Q clkload14/A _19712_/D _19712_/RESET_B VPWR VGND sg13cmos5l_dfrbpq_1
X_16855_ _16855_/Y _17368_/A _19538_/Q VPWR VGND sg13cmos5l_nor2_1
X_19643_ _19643_/Q _19756_/CLK _19643_/D _19643_/RESET_B VPWR VGND sg13cmos5l_dfrbpq_1
X_19068__1188 _19068_/RESET_B VPWR VGND sg13cmos5l_tiehi
XFILLER_37_115 VPWR VGND sg13cmos5l_fill_2
XFILLER_66_958 VPWR VGND sg13cmos5l_decap_8
X_15806_ _15806_/Y hold2031/X fanout93/X _15528_/A VPWR VGND sg13cmos5l_o21ai_1
X_16786_ _16787_/B _16786_/A _16786_/B VPWR VGND sg13cmos5l_xnor2_1
X_19574_ _19574_/Q clkload36/A _19574_/D _19574_/RESET_B VPWR VGND sg13cmos5l_dfrbpq_1
X_19596__615 _19596_/RESET_B VPWR VGND sg13cmos5l_tiehi
X_13998_ _13998_/Y _14149_/A _14176_/A VPWR VGND sg13cmos5l_nand2_1
XFILLER_37_159 VPWR VGND sg13cmos5l_fill_2
X_12949_ _12949_/Y _12933_/A _12925_/Y _12948_/Y VPWR VGND sg13cmos5l_a21oi_1
X_18525_ _19765_/D _10321_/Y _18530_/S _18524_/Y VPWR VGND sg13cmos5l_a21oi_1
X_15737_ _19341_/D _15737_/A _15742_/B VPWR VGND sg13cmos5l_nor2_1
X_18616__1680 _18616_/RESET_B VPWR VGND sg13cmos5l_tiehi
X_18456_ _18456_/Y _18456_/A _18468_/A VPWR VGND sg13cmos5l_nor2_1
X_15668_ _15669_/A _15676_/A _15668_/B VPWR VGND sg13cmos5l_nor2_1
Xclkbuf_leaf_72_clk _19304_/CLK clkbuf_4_8_0_clk/X VPWR VGND sg13cmos5l_buf_8
XFILLER_33_332 VPWR VGND sg13cmos5l_decap_8
XFILLER_33_343 VPWR VGND sg13cmos5l_fill_1
XFILLER_60_162 VPWR VGND sg13cmos5l_fill_1
X_17407_ _17407_/Y _17407_/A _17407_/B _17407_/C VPWR VGND sg13cmos5l_nor3_1
X_14619_ _14619_/Y _14619_/A _14619_/B VPWR VGND sg13cmos5l_nor2_1
X_15599_ _15708_/C _19343_/Q _15608_/B _15609_/A VPWR VGND sg13cmos5l_o21ai_1
X_18387_ _18388_/C _18387_/A _18414_/A VPWR VGND sg13cmos5l_nor2_1
X_17338_ _17338_/Y _17335_/Y _17337_/Y _17322_/X VPWR VGND sg13cmos5l_o21ai_1
X_17269_ _17278_/A _19594_/Q _17269_/B VPWR VGND sg13cmos5l_xor2_1
X_19008_ _19008_/Q clkload67/A _19008_/D _19008_/RESET_B VPWR VGND sg13cmos5l_dfrbpq_1
XFILLER_103_816 VPWR VGND sg13cmos5l_fill_2
XFILLER_103_805 VPWR VGND sg13cmos5l_decap_8
X_19193__1055 _19193_/RESET_B VPWR VGND sg13cmos5l_tiehi
Xhold2603 hold2603/X _16510_/B VPWR VGND sg13cmos5l_dlygate4sd3_1
Xhold2647 hold2647/X _12413_/A VPWR VGND sg13cmos5l_dlygate4sd3_1
Xhold2625 _10299_/A _18683_/Q VPWR VGND sg13cmos5l_dlygate4sd3_1
Xhold1902 _17437_/B _19564_/Q VPWR VGND sg13cmos5l_dlygate4sd3_1
Xhold2614 _10324_/A _19768_/Q VPWR VGND sg13cmos5l_dlygate4sd3_1
Xhold2636 _10210_/A _19315_/Q VPWR VGND sg13cmos5l_dlygate4sd3_1
X_19505__712 _19505_/RESET_B VPWR VGND sg13cmos5l_tiehi
Xhold2669 _12147_/A _18795_/Q VPWR VGND sg13cmos5l_dlygate4sd3_1
Xhold1924 _19605_/D _17436_/Y VPWR VGND sg13cmos5l_dlygate4sd3_1
Xhold1935 _19772_/D _18536_/Y VPWR VGND sg13cmos5l_dlygate4sd3_1
Xhold2658 _10333_/A _19726_/Q VPWR VGND sg13cmos5l_dlygate4sd3_1
Xhold1913 _09994_/A _19152_/Q VPWR VGND sg13cmos5l_dlygate4sd3_1
Xhold1968 _19477_/D _16617_/Y VPWR VGND sg13cmos5l_dlygate4sd3_1
Xhold1946 _19520_/D _16886_/Y VPWR VGND sg13cmos5l_dlygate4sd3_1
Xhold1957 _18569_/D _10694_/Y VPWR VGND sg13cmos5l_dlygate4sd3_1
XFILLER_68_284 VPWR VGND sg13cmos5l_fill_1
XFILLER_28_137 VPWR VGND sg13cmos5l_fill_2
Xhold1979 hold1979/X _19771_/Q VPWR VGND sg13cmos5l_dlygate4sd3_1
XFILLER_83_298 VPWR VGND sg13cmos5l_fill_1
XFILLER_71_438 VPWR VGND sg13cmos5l_fill_1
XFILLER_65_991 VPWR VGND sg13cmos5l_fill_2
XFILLER_45_49 VPWR VGND sg13cmos5l_decap_4
XFILLER_80_972 VPWR VGND sg13cmos5l_fill_1
Xclkbuf_leaf_63_clk clkload54/A clkload2/A VPWR VGND sg13cmos5l_buf_8
XFILLER_36_181 VPWR VGND sg13cmos5l_fill_1
XFILLER_12_505 VPWR VGND sg13cmos5l_decap_8
X_19573__445 _19573_/D VPWR VGND sg13cmos5l_tielo
X_19512__705 _19512_/RESET_B VPWR VGND sg13cmos5l_tiehi
X_10300_ _11650_/A _10300_/A VPWR VGND sg13cmos5l_inv_1
X_11280_ _11280_/Y _11280_/A _11280_/B _11359_/B VPWR VGND sg13cmos5l_nand3_1
XFILLER_4_759 VPWR VGND sg13cmos5l_fill_2
X_10231_ _10231_/Y _10231_/A VPWR VGND sg13cmos5l_inv_1
XFILLER_106_654 VPWR VGND sg13cmos5l_fill_2
X_10162_ _17168_/A _19530_/Q VPWR VGND sg13cmos5l_inv_1
XFILLER_0_921 VPWR VGND sg13cmos5l_fill_1
X_18996__1264 _18996_/RESET_B VPWR VGND sg13cmos5l_tiehi
X_10093_ _14639_/A _10093_/A VPWR VGND sg13cmos5l_inv_1
X_14970_ _14970_/Y hold2058/X fanout72/X _15453_/A VPWR VGND sg13cmos5l_o21ai_1
X_13921_ _13922_/B _13513_/Y _13906_/Y _13924_/S _13920_/Y VPWR VGND sg13cmos5l_a22oi_1
XFILLER_48_947 VPWR VGND sg13cmos5l_fill_1
XFILLER_47_446 VPWR VGND sg13cmos5l_fill_1
X_16640_ _16640_/Y _16640_/A _16640_/B _16640_/C VPWR VGND sg13cmos5l_nor3_1
X_13852_ _13852_/Y _14108_/A _13845_/B _13851_/A _14114_/B _13847_/Y VPWR VGND sg13cmos5l_a221oi_1
X_13783_ _13790_/A _13684_/X _13720_/C _13727_/Y _13728_/A _13688_/Y VPWR VGND sg13cmos5l_a221oi_1
X_16571_ _16571_/Y _19496_/Q _16578_/B _19023_/Q _17084_/A VPWR VGND sg13cmos5l_a22oi_1
X_12803_ _12803_/X _12814_/D _12802_/B _12651_/A VPWR VGND sg13cmos5l_a21o_1
XFILLER_76_1021 VPWR VGND sg13cmos5l_decap_8
XFILLER_74_298 VPWR VGND sg13cmos5l_fill_2
XFILLER_62_449 VPWR VGND sg13cmos5l_fill_1
X_12734_ _18889_/D _12734_/A _12734_/B VPWR VGND sg13cmos5l_and2_1
Xclkbuf_leaf_54_clk _19003_/CLK clkbuf_4_12_0_clk/X VPWR VGND sg13cmos5l_buf_8
X_10995_ _10995_/Y _11091_/B VPWR VGND sg13cmos5l_inv_1
X_19290_ _19290_/Q clkload43/A _19290_/D _19290_/RESET_B VPWR VGND sg13cmos5l_dfrbpq_1
XFILLER_16_866 VPWR VGND sg13cmos5l_fill_1
XFILLER_16_877 VPWR VGND sg13cmos5l_fill_1
X_15522_ _15522_/Y hold2011/X fanout75/X _15735_/A VPWR VGND sg13cmos5l_o21ai_1
X_18310_ _18310_/Y _18308_/Y _18309_/Y _18304_/Y VPWR VGND sg13cmos5l_a21oi_1
X_18241_ _18241_/Y _19748_/Q _18243_/B _18240_/Y VPWR VGND sg13cmos5l_a21oi_1
XFILLER_37_1027 VPWR VGND sg13cmos5l_fill_2
XFILLER_35_71 VPWR VGND sg13cmos5l_fill_1
X_12665_ _12665_/Y _12573_/B _12660_/X _12734_/B _12577_/B VPWR VGND sg13cmos5l_a22oi_1
X_15453_ _19297_/D _15453_/A _15453_/B VPWR VGND sg13cmos5l_and2_1
X_12596_ _12703_/A _18882_/Q _12599_/B _12595_/Y VPWR VGND sg13cmos5l_a21oi_1
X_11616_ _18706_/D _11616_/A _11615_/Y VPWR VGND sg13cmos5l_nor2b_1
X_18604__1695 _18604_/RESET_B VPWR VGND sg13cmos5l_tiehi
X_15384_ _15384_/Y _15535_/A _15394_/B VPWR VGND sg13cmos5l_nand2_1
X_14404_ _14405_/A _14408_/C _14402_/Y _14403_/Y VPWR VGND sg13cmos5l_a21o_1
X_18172_ _18172_/Y _18231_/B _18195_/B VPWR VGND sg13cmos5l_nor2_1
X_11547_ _11626_/B _11546_/Y _11537_/A _11560_/B VPWR VGND sg13cmos5l_mux2_1
X_17123_ _17124_/A _17122_/C _17121_/Y _17122_/Y VPWR VGND sg13cmos5l_a21o_1
XFILLER_11_571 VPWR VGND sg13cmos5l_decap_8
X_14335_ _14345_/A _14222_/Y _14343_/A _14335_/C VPWR VGND sg13cmos5l_nand3b_1
X_17054_ _17062_/B _17090_/B _17053_/B _17053_/Y VPWR VGND sg13cmos5l_o21ai_1
X_11478_ _11478_/Y _11447_/B _11469_/B _11300_/B VPWR VGND sg13cmos5l_a21oi_1
XFILLER_7_586 VPWR VGND sg13cmos5l_fill_2
X_16005_ _16005_/Y _15993_/B _16001_/S _15864_/A VPWR VGND sg13cmos5l_o21ai_1
X_14266_ _14463_/A _14266_/A VPWR VGND sg13cmos5l_inv_1
XFILLER_83_1025 VPWR VGND sg13cmos5l_decap_4
X_10429_ _10432_/D _10426_/Y _10427_/Y _10428_/Y VPWR VGND sg13cmos5l_a21o_1
X_13217_ _13257_/A _13217_/A _13232_/B VPWR VGND sg13cmos5l_xnor2_1
X_14197_ _14198_/B _14197_/A _14197_/B VPWR VGND sg13cmos5l_and2_1
X_13148_ _13150_/B _18957_/Q _18955_/Q _18956_/Q VPWR VGND sg13cmos5l_nor3_1
XFILLER_32_4 VPWR VGND sg13cmos5l_fill_2
XFILLER_97_379 VPWR VGND sg13cmos5l_decap_8
X_13079_ _13079_/Y hold1990/X fanout78/X _12527_/A VPWR VGND sg13cmos5l_o21ai_1
X_17956_ _17975_/C _17962_/C _17956_/B VPWR VGND sg13cmos5l_and2_1
X_16907_ _16907_/Y _16895_/Y _16903_/X _16937_/A _16910_/A _16906_/X VPWR VGND sg13cmos5l_a221oi_1
X_17887_ _17889_/B _17887_/A VPWR VGND sg13cmos5l_inv_1
X_19348__888 _19348_/RESET_B VPWR VGND sg13cmos5l_tiehi
X_16838_ _16838_/Y _19538_/Q _16860_/A _19475_/Q _17370_/A VPWR VGND sg13cmos5l_a22oi_1
X_19626_ _19626_/Q clkload24/A _19626_/D _19626_/RESET_B VPWR VGND sg13cmos5l_dfrbpq_1
XFILLER_26_608 VPWR VGND sg13cmos5l_fill_2
X_16769_ _16769_/Y _16792_/B _16769_/B VPWR VGND sg13cmos5l_nand2_1
X_19557_ _19557_/Q clkload24/A _19557_/D _19557_/RESET_B VPWR VGND sg13cmos5l_dfrbpq_1
Xclkbuf_leaf_45_clk clkload70/A clkload4/A VPWR VGND sg13cmos5l_buf_8
XFILLER_81_758 VPWR VGND sg13cmos5l_fill_2
X_18508_ _18508_/Y _18508_/A _19728_/Q VPWR VGND sg13cmos5l_nor2_1
X_19758__791 _19758_/RESET_B VPWR VGND sg13cmos5l_tiehi
X_19488_ _19488_/Q _19546_/CLK _19488_/D _19488_/RESET_B VPWR VGND sg13cmos5l_dfrbpq_1
XFILLER_22_869 VPWR VGND sg13cmos5l_fill_1
X_18439_ _18441_/B _18334_/B _18480_/B _18445_/B VPWR VGND sg13cmos5l_mux2_1
XFILLER_31_18 VPWR VGND sg13cmos5l_fill_2
X_18951__1312 _18951_/RESET_B VPWR VGND sg13cmos5l_tiehi
Xoutput18 uo_out[5] _19443_/Q VPWR VGND sg13cmos5l_buf_1
XFILLER_103_624 VPWR VGND sg13cmos5l_fill_1
XFILLER_0_228 VPWR VGND sg13cmos5l_decap_8
XFILLER_76_508 VPWR VGND sg13cmos5l_fill_2
Xhold2411 _19514_/D _16876_/Y VPWR VGND sg13cmos5l_dlygate4sd3_1
Xhold2400 _19557_/D _17139_/Y VPWR VGND sg13cmos5l_dlygate4sd3_1
X_19728__1279 _19728_/RESET_B VPWR VGND sg13cmos5l_tiehi
Xhold2422 _16073_/B _19401_/Q VPWR VGND sg13cmos5l_dlygate4sd3_1
Xhold2444 _10080_/A _19042_/Q VPWR VGND sg13cmos5l_dlygate4sd3_1
X_19609__599 _19609_/RESET_B VPWR VGND sg13cmos5l_tiehi
Xhold2433 _10103_/A _19208_/Q VPWR VGND sg13cmos5l_dlygate4sd3_1
Xhold2455 _16415_/A _19448_/Q VPWR VGND sg13cmos5l_dlygate4sd3_1
XFILLER_56_210 VPWR VGND sg13cmos5l_fill_1
Xhold2477 hold2477/X _19785_/Q VPWR VGND sg13cmos5l_dlygate4sd3_1
XFILLER_5_1025 VPWR VGND sg13cmos5l_decap_4
Xhold2488 _09986_/A _19438_/Q VPWR VGND sg13cmos5l_dlygate4sd3_1
Xhold2466 _10110_/A _19253_/Q VPWR VGND sg13cmos5l_dlygate4sd3_1
Xhold2499 _11405_/B _11404_/X VPWR VGND sg13cmos5l_dlygate4sd3_1
XFILLER_29_457 VPWR VGND sg13cmos5l_fill_1
XFILLER_29_479 VPWR VGND sg13cmos5l_decap_4
X_19579__632 _19579_/RESET_B VPWR VGND sg13cmos5l_tiehi
XFILLER_16_118 VPWR VGND sg13cmos5l_fill_2
Xclkbuf_leaf_36_clk clkload56/A clkbuf_4_12_0_clk/X VPWR VGND sg13cmos5l_buf_8
XFILLER_72_758 VPWR VGND sg13cmos5l_fill_2
X_10780_ _10780_/Y _10775_/A _10798_/B _13653_/B _10781_/B VPWR VGND sg13cmos5l_a22oi_1
X_12450_ _12452_/B _12450_/A _12451_/A VPWR VGND sg13cmos5l_nor2b_1
X_11401_ _11412_/S _11401_/A _11401_/B VPWR VGND sg13cmos5l_nor2_1
XFILLER_8_339 VPWR VGND sg13cmos5l_fill_2
X_12381_ _12381_/Y _12379_/Y _12380_/Y _12378_/Y VPWR VGND sg13cmos5l_a21oi_1
X_14120_ _14122_/A _14113_/Y _14117_/Y _14118_/Y _19107_/Q _14119_/Y VPWR VGND sg13cmos5l_a221oi_1
X_11332_ _11336_/B _11332_/A _11332_/B VPWR VGND sg13cmos5l_nand2_1
X_19586__625 _19586_/RESET_B VPWR VGND sg13cmos5l_tiehi
X_11263_ _11263_/X _11263_/A _11268_/D VPWR VGND sg13cmos5l_xor2_1
X_19748__960 _19748_/RESET_B VPWR VGND sg13cmos5l_tiehi
X_14051_ _14051_/Y _14051_/A _14051_/B VPWR VGND sg13cmos5l_xnor2_1
XFILLER_4_567 VPWR VGND sg13cmos5l_fill_2
XFILLER_97_55 VPWR VGND sg13cmos5l_fill_2
X_13002_ _13004_/A _13002_/A _13007_/A VPWR VGND sg13cmos5l_nor2b_1
X_11194_ _18654_/D _11358_/A _11194_/B VPWR VGND sg13cmos5l_nor2_1
X_10214_ _15764_/B _19318_/Q VPWR VGND sg13cmos5l_inv_1
X_10145_ _17082_/A _10145_/A VPWR VGND sg13cmos5l_inv_1
X_17810_ _17884_/A _17912_/A _17810_/B VPWR VGND sg13cmos5l_nand2_1
X_18790_ _18790_/Q clkload61/A _18790_/D _18790_/RESET_B VPWR VGND sg13cmos5l_dfrbpq_1
XFILLER_48_700 VPWR VGND sg13cmos5l_fill_2
X_17741_ _17758_/B _19613_/Q _19612_/Q _17757_/D VPWR VGND sg13cmos5l_nor3_1
X_10076_ _14073_/A _10076_/A VPWR VGND sg13cmos5l_inv_1
X_14953_ _14955_/A _19232_/Q _14950_/Y _14952_/Y _19233_/Q _14951_/Y VPWR VGND sg13cmos5l_a221oi_1
X_17672_ _19629_/D _17672_/A _17672_/B VPWR VGND sg13cmos5l_and2_1
X_13904_ _13923_/B _18995_/Q _13904_/B VPWR VGND sg13cmos5l_xor2_1
X_14884_ _14885_/B _14884_/A _14884_/B VPWR VGND sg13cmos5l_xor2_1
X_16623_ _19481_/D _16624_/A _16623_/B VPWR VGND sg13cmos5l_and2_1
X_13835_ _13846_/B _18982_/Q _13833_/Y _13834_/Y VPWR VGND sg13cmos5l_o21ai_1
X_19411_ _19411_/Q clkload9/A _19411_/D _19411_/RESET_B VPWR VGND sg13cmos5l_dfrbpq_1
Xclkbuf_leaf_27_clk clkload33/A clkbuf_4_5_0_clk/X VPWR VGND sg13cmos5l_buf_8
X_13766_ _13767_/B _13768_/B _13786_/A _13766_/C VPWR VGND sg13cmos5l_nand3_1
X_19593__618 _19593_/RESET_B VPWR VGND sg13cmos5l_tiehi
X_10978_ _10978_/X _11159_/A _10990_/B VPWR VGND sg13cmos5l_and2_1
X_16554_ _16554_/Y _16554_/A _16555_/B VPWR VGND sg13cmos5l_nor2_1
X_19342_ _19342_/Q clkload15/A _19342_/D _19342_/RESET_B VPWR VGND sg13cmos5l_dfrbpq_1
X_13697_ _13700_/C _13714_/B _13714_/C _13695_/Y VPWR VGND sg13cmos5l_o21ai_1
X_12717_ _18873_/D hold2541/X _12714_/S _12716_/Y VPWR VGND sg13cmos5l_a21oi_1
X_15505_ _15516_/S _15505_/A _15505_/B VPWR VGND sg13cmos5l_nor2_1
X_16485_ _16501_/A _19462_/Q _16500_/B VPWR VGND sg13cmos5l_nor2_1
X_19273_ _19273_/Q clkload15/A _19273_/D _19273_/RESET_B VPWR VGND sg13cmos5l_dfrbpq_1
X_12648_ _12649_/B _12658_/B _12658_/C _12833_/A VPWR VGND sg13cmos5l_a21o_1
X_18224_ _19711_/D _18224_/A _18227_/B VPWR VGND sg13cmos5l_nor2_1
X_15436_ _15436_/Y _15436_/A _15436_/B VPWR VGND sg13cmos5l_nor2_1
XFILLER_50_1013 VPWR VGND sg13cmos5l_fill_1
X_19209__1036 _19209_/RESET_B VPWR VGND sg13cmos5l_tiehi
XFILLER_31_688 VPWR VGND sg13cmos5l_fill_2
X_18155_ _18155_/X _18054_/Y _18230_/B _18154_/Y VPWR VGND sg13cmos5l_a21o_1
X_12579_ _18868_/D _12579_/A _12672_/A VPWR VGND sg13cmos5l_and2_1
X_17106_ _17106_/Y _17106_/A _17110_/B _17110_/C VPWR VGND sg13cmos5l_nand3_1
X_15367_ _15367_/Y _15360_/A _15553_/A _15364_/Y _15365_/Y VPWR VGND sg13cmos5l_a22oi_1
XFILLER_11_390 VPWR VGND sg13cmos5l_fill_2
X_18086_ _18086_/Y _19713_/Q _18200_/B _18072_/Y VPWR VGND sg13cmos5l_a21oi_1
XFILLER_7_361 VPWR VGND sg13cmos5l_decap_4
XFILLER_7_86 VPWR VGND sg13cmos5l_fill_2
XFILLER_7_75 VPWR VGND sg13cmos5l_decap_8
X_15298_ _15298_/Y _15279_/X _15281_/Y _15114_/Y VPWR VGND sg13cmos5l_a21oi_1
X_14318_ _14319_/B _14198_/B _14336_/B _14317_/Y VPWR VGND sg13cmos5l_a21oi_1
X_17037_ _17037_/Y _17037_/A _17040_/B _17040_/C VPWR VGND sg13cmos5l_nor3_1
X_14249_ _14249_/X _19122_/Q _19137_/Q VPWR VGND sg13cmos5l_and2_1
Xheichips26_digital_project_1808 uio_oe[11] VPWR VGND sg13cmos5l_tiehi
X_18988_ _18988_/Q clkload46/A _18988_/D _18988_/RESET_B VPWR VGND sg13cmos5l_dfrbpq_1
X_17939_ _19674_/D _17942_/A _17939_/B VPWR VGND sg13cmos5l_nor2_1
X_19502__715 _19502_/RESET_B VPWR VGND sg13cmos5l_tiehi
X_19609_ _19609_/Q clkload25/A _19609_/D _19609_/RESET_B VPWR VGND sg13cmos5l_dfrbpq_1
XFILLER_39_799 VPWR VGND sg13cmos5l_fill_2
Xclkbuf_leaf_18_clk clkload26/A clkbuf_4_4_0_clk/X VPWR VGND sg13cmos5l_buf_8
XFILLER_35_972 VPWR VGND sg13cmos5l_fill_2
XFILLER_50_931 VPWR VGND sg13cmos5l_fill_2
XFILLER_34_493 VPWR VGND sg13cmos5l_decap_8
XFILLER_104_933 VPWR VGND sg13cmos5l_fill_2
XFILLER_89_611 VPWR VGND sg13cmos5l_fill_2
X_19691__1745 _19691_/RESET_B VPWR VGND sg13cmos5l_tiehi
XFILLER_1_515 VPWR VGND sg13cmos5l_fill_1
XFILLER_104_955 VPWR VGND sg13cmos5l_decap_8
XFILLER_104_944 VPWR VGND sg13cmos5l_fill_2
XFILLER_27_1026 VPWR VGND sg13cmos5l_fill_2
XFILLER_103_476 VPWR VGND sg13cmos5l_fill_2
XFILLER_103_465 VPWR VGND sg13cmos5l_fill_2
XFILLER_103_454 VPWR VGND sg13cmos5l_fill_1
X_18915__1351 _18915_/RESET_B VPWR VGND sg13cmos5l_tiehi
Xhold2230 _10025_/A _18707_/Q VPWR VGND sg13cmos5l_dlygate4sd3_1
XFILLER_67_36 VPWR VGND sg13cmos5l_decap_4
X_09988_ _09988_/Y _09988_/A VPWR VGND sg13cmos5l_inv_1
Xhold2252 _14392_/A _19104_/Q VPWR VGND sg13cmos5l_dlygate4sd3_1
Xhold2241 _10247_/A _19063_/Q VPWR VGND sg13cmos5l_dlygate4sd3_1
Xhold2263 _19064_/D _13868_/Y VPWR VGND sg13cmos5l_dlygate4sd3_1
Xhold2274 _18768_/D _11953_/Y VPWR VGND sg13cmos5l_dlygate4sd3_1
X_11950_ _11950_/Y _11929_/A fanout55/X _12199_/A VPWR VGND sg13cmos5l_o21ai_1
Xhold2296 _18685_/D _11411_/Y VPWR VGND sg13cmos5l_dlygate4sd3_1
XFILLER_45_703 VPWR VGND sg13cmos5l_fill_1
Xhold2285 _10334_/A _19788_/Q VPWR VGND sg13cmos5l_dlygate4sd3_1
XFILLER_91_319 VPWR VGND sg13cmos5l_fill_1
XFILLER_57_596 VPWR VGND sg13cmos5l_fill_2
X_10901_ _10904_/B _19782_/Q _10901_/B VPWR VGND sg13cmos5l_xor2_1
X_11881_ _18744_/D hold2622/X _11890_/S _11880_/Y VPWR VGND sg13cmos5l_a21oi_1
X_13620_ _13622_/A _10378_/A _13617_/Y _13619_/Y _19023_/Q _13618_/Y VPWR VGND sg13cmos5l_a221oi_1
X_10832_ _10833_/A _10850_/C _10831_/Y _10828_/Y VPWR VGND sg13cmos5l_o21ai_1
X_10763_ _10763_/Y _18591_/Q _18592_/Q _18593_/Q VPWR VGND sg13cmos5l_o21ai_1
X_13551_ _13551_/Y _13531_/Y _13545_/Y _13550_/Y VPWR VGND sg13cmos5l_o21ai_1
X_12502_ _12502_/Y _18875_/Q _13022_/A _12483_/B _18813_/Q VPWR VGND sg13cmos5l_a22oi_1
X_16270_ _16277_/B _16232_/Y _16128_/Y _16282_/B VPWR VGND sg13cmos5l_mux2_1
X_10694_ _10694_/Y _10679_/Y hold1956/X _10748_/A VPWR VGND sg13cmos5l_a21oi_1
X_13482_ _13482_/Y _14076_/A _13482_/B VPWR VGND sg13cmos5l_xnor2_1
XFILLER_8_125 VPWR VGND sg13cmos5l_fill_2
X_15221_ _15221_/Y _15739_/A _19296_/Q VPWR VGND sg13cmos5l_nor2_1
X_12433_ _12440_/A _12468_/B _12433_/B VPWR VGND sg13cmos5l_nor2_1
XFILLER_8_158 VPWR VGND sg13cmos5l_decap_4
X_12364_ _12364_/Y _12364_/A _12368_/B VPWR VGND sg13cmos5l_nor2_1
X_15152_ _15152_/Y _15152_/A _15152_/B VPWR VGND sg13cmos5l_nor2_1
X_19338__898 _19338_/RESET_B VPWR VGND sg13cmos5l_tiehi
X_11315_ _11316_/C _11315_/A _11315_/B _11315_/C VPWR VGND sg13cmos5l_nand3_1
X_15083_ _15083_/Y _15068_/Y _15075_/Y _15082_/Y VPWR VGND sg13cmos5l_o21ai_1
X_14103_ _14103_/Y _19060_/Q _14103_/B VPWR VGND sg13cmos5l_nand2_1
X_12295_ _12355_/A _12111_/B _12299_/B _12295_/C VPWR VGND sg13cmos5l_nand3b_1
X_18911_ _18911_/Q clkload64/A _18911_/D _18911_/RESET_B VPWR VGND sg13cmos5l_dfrbpq_1
X_14034_ _14034_/Y _14052_/A _13950_/B _14078_/B _14045_/S _14031_/Y VPWR VGND sg13cmos5l_a221oi_1
XFILLER_4_364 VPWR VGND sg13cmos5l_fill_1
XFILLER_4_353 VPWR VGND sg13cmos5l_decap_4
X_11246_ _11473_/A _11266_/A _11452_/A VPWR VGND sg13cmos5l_nand2b_1
X_18842_ _18842_/Q clkload62/A _18842_/D _18842_/RESET_B VPWR VGND sg13cmos5l_dfrbpq_1
X_11177_ _11199_/B _18617_/Q _11178_/B VPWR VGND sg13cmos5l_xnor2_1
X_18773_ _18773_/Q _18902_/CLK _18773_/D _18773_/RESET_B VPWR VGND sg13cmos5l_dfrbpq_1
X_10128_ _16309_/A _15912_/C VPWR VGND sg13cmos5l_inv_1
X_15985_ _15993_/B _15862_/B _15984_/B _15984_/Y VPWR VGND sg13cmos5l_o21ai_1
X_10059_ _13286_/A _10059_/A VPWR VGND sg13cmos5l_inv_1
X_17724_ _17724_/Y _17706_/A _17719_/S _17723_/Y VPWR VGND sg13cmos5l_a21oi_1
X_14936_ _14936_/Y _15455_/A _19254_/Q VPWR VGND sg13cmos5l_nor2_1
XFILLER_36_703 VPWR VGND sg13cmos5l_fill_1
XFILLER_94_179 VPWR VGND sg13cmos5l_fill_2
XFILLER_91_853 VPWR VGND sg13cmos5l_fill_2
XFILLER_63_555 VPWR VGND sg13cmos5l_fill_2
X_17655_ _19617_/D _17625_/B _17659_/A _17654_/Y VPWR VGND sg13cmos5l_a21oi_1
X_14867_ _14867_/X _14860_/Y _14861_/X _14866_/Y VPWR VGND sg13cmos5l_a21o_1
X_13818_ _19057_/D _13819_/A _13818_/B VPWR VGND sg13cmos5l_nor2_1
XFILLER_90_374 VPWR VGND sg13cmos5l_decap_4
X_16606_ _16606_/Y _16582_/B fanout31/X _16655_/A VPWR VGND sg13cmos5l_o21ai_1
X_17586_ _17587_/B _17931_/A _17613_/B VPWR VGND sg13cmos5l_and2_1
X_14798_ _14997_/A _14798_/A _14797_/Y VPWR VGND sg13cmos5l_nor2b_1
XFILLER_16_460 VPWR VGND sg13cmos5l_fill_2
X_13749_ _13752_/B _13785_/A _13784_/A VPWR VGND sg13cmos5l_nor2_1
X_19325_ _19325_/Q clkload18/A _19325_/D _19325_/RESET_B VPWR VGND sg13cmos5l_dfrbpq_1
X_16537_ _16537_/Y _16510_/A fanout32/X _16561_/A VPWR VGND sg13cmos5l_o21ai_1
X_19638__570 _19638_/RESET_B VPWR VGND sg13cmos5l_tiehi
X_19256_ _19256_/Q clkload42/A _19256_/D _19256_/RESET_B VPWR VGND sg13cmos5l_dfrbpq_1
X_16468_ _16561_/B _16401_/A _16413_/Y _16467_/Y VPWR VGND sg13cmos5l_o21ai_1
XFILLER_31_485 VPWR VGND sg13cmos5l_fill_1
XFILLER_89_1020 VPWR VGND sg13cmos5l_decap_8
X_18207_ _18207_/Y _18072_/Y _18085_/Y _18198_/Y _18205_/Y _18206_/X VPWR VGND sg13cmos5l_a221oi_1
X_15419_ _15420_/A _15419_/A _15435_/A _15419_/C VPWR VGND sg13cmos5l_or3_1
X_19187_ _19187_/Q _19302_/CLK _19187_/D _19187_/RESET_B VPWR VGND sg13cmos5l_dfrbpq_1
X_16399_ _16405_/B _19451_/Q _19452_/Q _19450_/Q _16399_/D VPWR VGND sg13cmos5l_nor4_1
XFILLER_8_670 VPWR VGND sg13cmos5l_fill_1
XFILLER_8_681 VPWR VGND sg13cmos5l_fill_1
X_18138_ _18138_/Y _18138_/A _18157_/B VPWR VGND sg13cmos5l_nand2_1
X_18069_ _18069_/Y _19687_/Q _19648_/Q VPWR VGND sg13cmos5l_xnor2_1
XFILLER_104_229 VPWR VGND sg13cmos5l_fill_1
X_19569__642 _19569_/RESET_B VPWR VGND sg13cmos5l_tiehi
Xclkbuf_leaf_7_clk clkload13/A clkbuf_4_1_0_clk/X VPWR VGND sg13cmos5l_buf_8
XFILLER_99_964 VPWR VGND sg13cmos5l_fill_2
X_19645__563 _19645_/RESET_B VPWR VGND sg13cmos5l_tiehi
XFILLER_86_647 VPWR VGND sg13cmos5l_fill_1
XFILLER_100_468 VPWR VGND sg13cmos5l_decap_8
X_19240__1002 _19240_/RESET_B VPWR VGND sg13cmos5l_tiehi
XFILLER_2_1028 VPWR VGND sg13cmos5l_fill_1
XFILLER_2_1017 VPWR VGND sg13cmos5l_decap_8
XFILLER_94_691 VPWR VGND sg13cmos5l_fill_2
XFILLER_82_897 VPWR VGND sg13cmos5l_fill_1
X_19576__635 _19576_/RESET_B VPWR VGND sg13cmos5l_tiehi
XFILLER_53_49 VPWR VGND sg13cmos5l_decap_8
XFILLER_53_38 VPWR VGND sg13cmos5l_fill_2
XFILLER_23_920 VPWR VGND sg13cmos5l_fill_2
X_18770__1508 _18770_/RESET_B VPWR VGND sg13cmos5l_tiehi
XFILLER_22_441 VPWR VGND sg13cmos5l_fill_1
XFILLER_5_117 VPWR VGND sg13cmos5l_fill_1
XFILLER_78_13 VPWR VGND sg13cmos5l_fill_1
X_11100_ _11100_/Y _11107_/B _18666_/Q _18603_/Q _11624_/A VPWR VGND sg13cmos5l_a22oi_1
XFILLER_1_301 VPWR VGND sg13cmos5l_fill_2
X_12080_ _12130_/A _18805_/Q _12080_/B VPWR VGND sg13cmos5l_xnor2_1
X_19583__628 _19583_/RESET_B VPWR VGND sg13cmos5l_tiehi
X_11031_ _11032_/B _11013_/A _11013_/B _11003_/Y VPWR VGND sg13cmos5l_a21oi_1
X_19212__479 _19212_/D VPWR VGND sg13cmos5l_tielo
Xhold2060 hold2060/X _19520_/Q VPWR VGND sg13cmos5l_dlygate4sd3_1
Xhold2071 _19596_/D _17420_/Y VPWR VGND sg13cmos5l_dlygate4sd3_1
XFILLER_100_980 VPWR VGND sg13cmos5l_fill_1
Xhold2093 _10716_/A _18575_/Q VPWR VGND sg13cmos5l_dlygate4sd3_1
X_12982_ _12982_/Y _12976_/Y _12978_/Y _12981_/Y VPWR VGND sg13cmos5l_o21ai_1
Xhold2082 _10370_/A _19470_/Q VPWR VGND sg13cmos5l_dlygate4sd3_1
XFILLER_57_371 VPWR VGND sg13cmos5l_fill_2
X_15770_ _15770_/Y _16314_/A _19374_/Q _15779_/C VPWR VGND sg13cmos5l_nand3_1
X_11933_ _11933_/Y _12459_/A _18792_/Q _11938_/C VPWR VGND sg13cmos5l_nor3_1
X_14721_ _14724_/B _14721_/A _14721_/B VPWR VGND sg13cmos5l_nand2_1
X_11864_ _11864_/Y _11846_/A _11846_/B _11857_/Y _11862_/Y _11863_/Y VPWR VGND sg13cmos5l_a221oi_1
X_17440_ _17461_/D _19569_/Q _19567_/Q _19568_/Q VPWR VGND sg13cmos5l_or3_1
X_14652_ _14652_/Y _19207_/Q _10236_/Y _14668_/A _19206_/Q VPWR VGND sg13cmos5l_a22oi_1
X_13603_ _13603_/Y _16818_/A _13603_/B VPWR VGND sg13cmos5l_nor2_1
X_10815_ _18588_/D _18558_/A _18560_/B VPWR VGND sg13cmos5l_nor2_1
X_17371_ _19588_/D _17371_/A _17373_/A VPWR VGND sg13cmos5l_nor2_1
X_18746__1532 _18746_/RESET_B VPWR VGND sg13cmos5l_tiehi
X_11795_ _11989_/A _12193_/A _11795_/B VPWR VGND sg13cmos5l_xnor2_1
X_19110_ _19110_/Q clkload47/A _19110_/D _19110_/RESET_B VPWR VGND sg13cmos5l_dfrbpq_1
X_14583_ _14583_/Y _14586_/A _14649_/B VPWR VGND sg13cmos5l_nor2_1
X_16322_ _16322_/Y _16332_/A _19398_/Q _19397_/Q _10140_/Y _16321_/Y VPWR VGND sg13cmos5l_a221oi_1
X_19111__1141 _19111_/RESET_B VPWR VGND sg13cmos5l_tiehi
X_10746_ _18580_/D _10746_/A input5/X _10795_/C VPWR VGND sg13cmos5l_and3_1
X_13534_ _13534_/Y _13534_/A _13534_/B _13534_/C VPWR VGND sg13cmos5l_nor3_1
XFILLER_41_794 VPWR VGND sg13cmos5l_fill_1
XFILLER_13_474 VPWR VGND sg13cmos5l_fill_2
X_19041_ _19041_/Q clkload31/A _19041_/D _19041_/RESET_B VPWR VGND sg13cmos5l_dfrbpq_1
X_10677_ _10688_/A _10678_/A _10679_/C VPWR VGND sg13cmos5l_nor2_1
X_13465_ _13465_/X _13467_/B _13465_/B _13506_/A VPWR VGND sg13cmos5l_and3_1
X_16253_ _16253_/Y _16139_/B _16318_/B _16252_/X _16144_/B VPWR VGND sg13cmos5l_a22oi_1
X_12416_ _12416_/Y _12416_/A _12415_/Y VPWR VGND sg13cmos5l_nor2b_1
X_16184_ _16423_/A _16227_/A _19418_/Q VPWR VGND sg13cmos5l_xnor2_1
X_15204_ _15215_/B _15195_/Y _15202_/Y _15203_/Y VPWR VGND sg13cmos5l_o21ai_1
X_13396_ _13396_/X _18947_/Q _13419_/B VPWR VGND sg13cmos5l_or2_1
XFILLER_5_640 VPWR VGND sg13cmos5l_fill_2
X_15135_ _15136_/B _19256_/Q _15033_/Y _15030_/Y VPWR VGND sg13cmos5l_a21oi_1
X_12347_ _12347_/Y _12535_/A _12554_/A VPWR VGND sg13cmos5l_nand2_1
X_12278_ _12284_/B _18784_/Q _18783_/Q _18782_/Q _12278_/D VPWR VGND sg13cmos5l_nor4_1
XFILLER_99_238 VPWR VGND sg13cmos5l_fill_1
X_15066_ _15099_/A _19263_/Q _19264_/Q VPWR VGND sg13cmos5l_xor2_1
X_11229_ _11330_/A _18673_/Q _11231_/B VPWR VGND sg13cmos5l_nor2_1
X_14017_ _14049_/B _14016_/A _14176_/A _13991_/B _13980_/X VPWR VGND sg13cmos5l_a22oi_1
X_18825_ _18825_/Q clkload70/A _18825_/D _18825_/RESET_B VPWR VGND sg13cmos5l_dfrbpq_1
XFILLER_96_934 VPWR VGND sg13cmos5l_decap_4
XFILLER_67_113 VPWR VGND sg13cmos5l_fill_1
XFILLER_67_102 VPWR VGND sg13cmos5l_fill_2
XFILLER_83_606 VPWR VGND sg13cmos5l_fill_1
X_18756_ _18756_/Q clkload40/A _18756_/D _18756_/RESET_B VPWR VGND sg13cmos5l_dfrbpq_1
X_15968_ _15970_/A _15969_/B _15969_/C _16018_/B VPWR VGND sg13cmos5l_a21oi_1
X_19779__558 _19779_/RESET_B VPWR VGND sg13cmos5l_tiehi
X_18687_ _18687_/Q clkload40/A _18687_/D _18687_/RESET_B VPWR VGND sg13cmos5l_dfrbpq_1
X_17707_ _17707_/Y _17707_/A _17707_/B _17707_/C VPWR VGND sg13cmos5l_nor3_1
X_15899_ _15899_/Y _19374_/Q _19389_/Q VPWR VGND sg13cmos5l_nand2_1
X_14919_ _14919_/Y _15456_/A _19188_/Q _19187_/Q _15455_/A VPWR VGND sg13cmos5l_a22oi_1
XFILLER_91_650 VPWR VGND sg13cmos5l_fill_1
X_17638_ _17646_/A _17518_/Y _17638_/B _17638_/C VPWR VGND sg13cmos5l_nand3b_1
XFILLER_36_599 VPWR VGND sg13cmos5l_fill_2
XFILLER_90_193 VPWR VGND sg13cmos5l_fill_1
XFILLER_90_0 VPWR VGND sg13cmos5l_fill_1
X_17569_ _17569_/Y _17568_/B _17558_/Y _17573_/A _17573_/B VPWR VGND sg13cmos5l_a22oi_1
XFILLER_104_1006 VPWR VGND sg13cmos5l_fill_2
X_19308_ _19308_/Q _19308_/CLK _19308_/D _19308_/RESET_B VPWR VGND sg13cmos5l_dfrbpq_1
XFILLER_31_271 VPWR VGND sg13cmos5l_fill_2
X_19239_ _19239_/Q clkload48/A _19239_/D _19239_/RESET_B VPWR VGND sg13cmos5l_dfrbpq_1
XFILLER_105_516 VPWR VGND sg13cmos5l_fill_1
XFILLER_105_505 VPWR VGND sg13cmos5l_fill_1
Xfanout402 fanout402/X fanout403/X VPWR VGND sg13cmos5l_buf_1
XFILLER_87_934 VPWR VGND sg13cmos5l_fill_2
XFILLER_48_27 VPWR VGND sg13cmos5l_fill_1
XFILLER_74_606 VPWR VGND sg13cmos5l_fill_2
X_19204__1041 _19204_/RESET_B VPWR VGND sg13cmos5l_tiehi
XFILLER_70_856 VPWR VGND sg13cmos5l_fill_2
Xfanout31 fanout31/X _16608_/S VPWR VGND sg13cmos5l_buf_1
XFILLER_11_901 VPWR VGND sg13cmos5l_fill_1
X_19298__941 _19298_/RESET_B VPWR VGND sg13cmos5l_tiehi
Xfanout20 _18462_/S _18457_/Y VPWR VGND sg13cmos5l_buf_1
Xfanout53 _12241_/S _12238_/Y VPWR VGND sg13cmos5l_buf_1
XFILLER_80_47 VPWR VGND sg13cmos5l_fill_1
X_11580_ _11604_/B _11626_/B _11457_/B _11597_/S VPWR VGND sg13cmos5l_mux2_1
XFILLER_70_1027 VPWR VGND sg13cmos5l_fill_2
Xfanout64 _15156_/B _15131_/X VPWR VGND sg13cmos5l_buf_1
Xfanout42 _14690_/S _14687_/Y VPWR VGND sg13cmos5l_buf_1
X_10600_ _10600_/X _10643_/A _18542_/A _10616_/B VPWR VGND sg13cmos5l_mux2_1
Xfanout86 fanout86/X fanout88/X VPWR VGND sg13cmos5l_buf_1
Xfanout97 fanout97/X fanout98/X VPWR VGND sg13cmos5l_buf_1
Xfanout75 fanout75/X fanout82/X VPWR VGND sg13cmos5l_buf_1
X_10531_ _10531_/Y _10531_/A VPWR VGND sg13cmos5l_inv_1
X_13250_ _13251_/C _13250_/A _13250_/B _13250_/C VPWR VGND sg13cmos5l_and3_1
XFILLER_10_466 VPWR VGND sg13cmos5l_decap_8
XFILLER_10_477 VPWR VGND sg13cmos5l_fill_1
XFILLER_13_74 VPWR VGND sg13cmos5l_fill_2
X_12201_ _18806_/D _12201_/A _12201_/B VPWR VGND sg13cmos5l_nor2_1
X_10462_ _10462_/X _19797_/Q _10621_/B _10448_/Y VPWR VGND sg13cmos5l_a21o_1
X_10393_ _10404_/B _10393_/A _10392_/X VPWR VGND sg13cmos5l_nor2b_1
X_13181_ _13397_/A _13574_/A _13202_/B VPWR VGND sg13cmos5l_nand2_1
X_12132_ _12200_/B _12133_/S _12306_/A _12131_/Y VPWR VGND sg13cmos5l_a21oi_1
X_12063_ _12086_/D _18801_/Q _18802_/Q _18803_/Q VPWR VGND sg13cmos5l_or3_1
X_16940_ _16941_/B _16940_/A _16940_/B VPWR VGND sg13cmos5l_nor2_1
X_19628__580 _19628_/RESET_B VPWR VGND sg13cmos5l_tiehi
X_11014_ _11042_/C _11014_/A _11014_/B _18627_/Q VPWR VGND sg13cmos5l_nand3_1
X_16871_ _16871_/Y _16852_/B fanout29/X _17079_/B VPWR VGND sg13cmos5l_o21ai_1
X_19590_ _19590_/Q clkload36/A _19590_/D _19590_/RESET_B VPWR VGND sg13cmos5l_dfrbpq_1
X_18610_ _18610_/Q clkload21/A _18610_/D _18610_/RESET_B VPWR VGND sg13cmos5l_dfrbpq_1
X_15822_ _15826_/A _15668_/B _15814_/Y _15820_/Y _15821_/Y _15816_/Y VPWR VGND sg13cmos5l_a221oi_1
XFILLER_18_511 VPWR VGND sg13cmos5l_decap_4
X_12965_ _13008_/A _13026_/B _12847_/Y _12986_/B VPWR VGND sg13cmos5l_mux2_1
X_18541_ _19776_/D _18541_/A _18541_/B VPWR VGND sg13cmos5l_and2_1
X_15753_ _15753_/Y _15751_/Y _15753_/B VPWR VGND sg13cmos5l_nand2b_1
X_11916_ _11921_/A _18724_/Q _11922_/B _11922_/C VPWR VGND sg13cmos5l_nand3_1
X_14704_ _14704_/Y _19194_/Q fanout90/X _14978_/A VPWR VGND sg13cmos5l_o21ai_1
X_12896_ _12896_/Y _12932_/A _12896_/B VPWR VGND sg13cmos5l_nor2_1
XFILLER_45_396 VPWR VGND sg13cmos5l_fill_1
X_18472_ _19751_/D _18472_/A _18481_/A VPWR VGND sg13cmos5l_nor2_1
X_15684_ _15684_/Y _15584_/B _15747_/B _15683_/Y VPWR VGND sg13cmos5l_o21ai_1
X_11847_ _11848_/B _11769_/A _11769_/B _11747_/Y VPWR VGND sg13cmos5l_a21oi_1
XFILLER_72_193 VPWR VGND sg13cmos5l_fill_2
XFILLER_54_92 VPWR VGND sg13cmos5l_fill_2
X_17423_ _17423_/Y _17402_/B fanout25/X _17677_/A VPWR VGND sg13cmos5l_o21ai_1
X_14635_ _19169_/D _14622_/A _14634_/Y _14643_/B VPWR VGND sg13cmos5l_a21oi_1
X_11778_ _11789_/B _18745_/Q _18746_/Q VPWR VGND sg13cmos5l_nor2_1
X_17354_ _17354_/Y _17334_/B fanout26/X _17375_/A VPWR VGND sg13cmos5l_o21ai_1
X_14566_ _14566_/X _14599_/A _14644_/B _14563_/Y VPWR VGND sg13cmos5l_a21o_1
X_10729_ _10729_/Y fanout99/X hold2316/X _10721_/Y VPWR VGND sg13cmos5l_o21ai_1
X_17285_ _17290_/C _17298_/A _17285_/B VPWR VGND sg13cmos5l_nand2_1
X_19635__573 _19635_/RESET_B VPWR VGND sg13cmos5l_tiehi
X_13517_ _13517_/X _13899_/A _13907_/A VPWR VGND sg13cmos5l_and2_1
X_16305_ _16306_/B _16293_/A _16290_/A _16305_/S VPWR VGND sg13cmos5l_mux2_1
X_19024_ _19024_/Q clkload33/A _19024_/D _19024_/RESET_B VPWR VGND sg13cmos5l_dfrbpq_1
X_16236_ _16236_/X _16202_/D _16185_/B _16255_/B VPWR VGND sg13cmos5l_a21o_1
X_14497_ _14513_/A _14497_/A _14516_/B VPWR VGND sg13cmos5l_nor2_1
Xclkload34 clkload34/Y clkload34/A VPWR VGND sg13cmos5l_inv_1
X_13448_ _13534_/B _13448_/A _13448_/B _13553_/B VPWR VGND sg13cmos5l_nor3_1
Xclkload12 clkload12/Y clkload12/A VPWR VGND sg13cmos5l_inv_1
Xclkload23 clkload23/Y clkload23/A VPWR VGND sg13cmos5l_inv_1
Xclkload56 clkload56/Y clkload56/A VPWR VGND sg13cmos5l_inv_1
Xclkload67 clkload67/X clkload67/A VPWR VGND sg13cmos5l_buf_8
X_13379_ _13379_/Y _13363_/Y _13372_/Y _13419_/A _13384_/A _13377_/X VPWR VGND sg13cmos5l_a221oi_1
Xclkload45 clkload45/X clkload45/A VPWR VGND sg13cmos5l_buf_8
X_16167_ _16287_/B _19429_/Q _16167_/B VPWR VGND sg13cmos5l_and2_1
X_15118_ _15118_/Y _15106_/Y _15113_/X _15117_/Y VPWR VGND sg13cmos5l_o21ai_1
X_16098_ _16106_/B _19371_/Q _16099_/B VPWR VGND sg13cmos5l_nor2b_1
X_19566__645 _19566_/RESET_B VPWR VGND sg13cmos5l_tiehi
X_15049_ _15160_/B _19261_/Q _15053_/B VPWR VGND sg13cmos5l_and2_1
Xhold2807 _11219_/A _18671_/Q VPWR VGND sg13cmos5l_dlygate4sd3_1
Xhold2829 hold2829/X _19291_/Q VPWR VGND sg13cmos5l_dlygate4sd3_1
Xhold2818 hold2818/X _14619_/A VPWR VGND sg13cmos5l_dlygate4sd3_1
XFILLER_96_742 VPWR VGND sg13cmos5l_fill_1
XFILLER_69_978 VPWR VGND sg13cmos5l_fill_1
X_18808_ _18808_/Q clkload68/A _18808_/D _18808_/RESET_B VPWR VGND sg13cmos5l_dfrbpq_1
XFILLER_84_937 VPWR VGND sg13cmos5l_fill_2
X_19642__566 _19642_/RESET_B VPWR VGND sg13cmos5l_tiehi
X_19788_ _19788_/Q _19790_/CLK _19788_/D _19788_/RESET_B VPWR VGND sg13cmos5l_dfrbpq_1
X_18739_ _18739_/Q _18750_/CLK _18739_/D _18739_/RESET_B VPWR VGND sg13cmos5l_dfrbpq_1
XFILLER_52_801 VPWR VGND sg13cmos5l_fill_2
XFILLER_63_193 VPWR VGND sg13cmos5l_fill_1
X_19573__638 _19573_/RESET_B VPWR VGND sg13cmos5l_tiehi
Xclkload6 clkload6/Y clkload6/A VPWR VGND sg13cmos5l_inv_2
XFILLER_106_869 VPWR VGND sg13cmos5l_fill_2
Xfanout221 _17375_/A _17365_/B VPWR VGND sg13cmos5l_buf_1
Xfanout210 _17933_/B _17718_/Y VPWR VGND sg13cmos5l_buf_1
Xfanout232 _16562_/A _16359_/Y VPWR VGND sg13cmos5l_buf_1
XFILLER_59_444 VPWR VGND sg13cmos5l_fill_1
Xfanout243 _15748_/A _15586_/A VPWR VGND sg13cmos5l_buf_1
Xfanout265 _14637_/B _14649_/A VPWR VGND sg13cmos5l_buf_1
Xfanout254 _15192_/A _14957_/Y VPWR VGND sg13cmos5l_buf_1
Xfanout298 _12452_/A _12467_/A VPWR VGND sg13cmos5l_buf_1
Xfanout276 _13804_/A _13801_/A VPWR VGND sg13cmos5l_buf_1
Xfanout287 _13292_/A _13291_/B VPWR VGND sg13cmos5l_buf_1
XFILLER_83_981 VPWR VGND sg13cmos5l_fill_2
X_12750_ _12750_/Y _12750_/A _12754_/B _12754_/C VPWR VGND sg13cmos5l_nand3_1
X_19066__493 _19066_/D VPWR VGND sg13cmos5l_tielo
X_12681_ _12681_/Y _12704_/A _12681_/B VPWR VGND sg13cmos5l_nand2_1
X_11701_ _11701_/Y _11701_/A _11727_/A VPWR VGND sg13cmos5l_nor2_1
X_11632_ _11632_/Y _12194_/A _18687_/Q VPWR VGND sg13cmos5l_nor2_1
X_14420_ _14420_/Y _14399_/A _14424_/S _14637_/B VPWR VGND sg13cmos5l_o21ai_1
X_14351_ _14353_/A _14343_/A _14229_/X _14350_/Y VPWR VGND sg13cmos5l_a21o_1
X_11563_ _11563_/Y _11466_/X _11628_/B _11629_/B _11471_/X VPWR VGND sg13cmos5l_a22oi_1
X_13302_ _13302_/Y _13300_/Y _13302_/B VPWR VGND sg13cmos5l_nand2b_1
XFILLER_7_724 VPWR VGND sg13cmos5l_decap_8
X_17070_ _17071_/B _17049_/B _17046_/Y _17070_/S VPWR VGND sg13cmos5l_mux2_1
X_11494_ _11596_/A _11595_/B _11595_/C _11595_/A VPWR VGND sg13cmos5l_a21oi_1
X_10514_ _10536_/B _19786_/Q _10526_/B VPWR VGND sg13cmos5l_nor2_1
X_14282_ _14282_/Y _14282_/A _14282_/B _14282_/C _14282_/D VPWR VGND sg13cmos5l_nand4_1
X_13233_ _13234_/B _13233_/A _13233_/B VPWR VGND sg13cmos5l_xnor2_1
X_10445_ _10445_/Y _19771_/Q _19732_/Q VPWR VGND sg13cmos5l_xnor2_1
X_16021_ _19393_/D _16021_/A _16021_/B VPWR VGND sg13cmos5l_and2_1
X_19035__1222 _19035_/RESET_B VPWR VGND sg13cmos5l_tiehi
X_18862__1407 _18862_/RESET_B VPWR VGND sg13cmos5l_tiehi
X_13164_ _13164_/Y _13575_/A _13162_/X _13163_/Y _13160_/X VPWR VGND sg13cmos5l_a22oi_1
X_12115_ _12115_/Y _12197_/B VPWR VGND sg13cmos5l_inv_1
X_10376_ _10376_/Y _10376_/A VPWR VGND sg13cmos5l_inv_1
X_13095_ _13095_/Y _12939_/A _13126_/A _13094_/Y VPWR VGND sg13cmos5l_a21oi_1
X_17972_ _17973_/C _18257_/A _17972_/B VPWR VGND sg13cmos5l_nor2_1
XFILLER_2_484 VPWR VGND sg13cmos5l_fill_2
X_16923_ _17037_/A _16922_/Y hold3025/X _16938_/S VPWR VGND sg13cmos5l_mux2_1
X_12046_ _12160_/C _12045_/A _12045_/B _12056_/A VPWR VGND sg13cmos5l_o21ai_1
XFILLER_77_241 VPWR VGND sg13cmos5l_fill_2
X_19711_ _19711_/Q clkload13/A _19711_/D _19711_/RESET_B VPWR VGND sg13cmos5l_dfrbpq_1
X_16854_ _16854_/Y _16854_/A _19476_/Q _16861_/C VPWR VGND sg13cmos5l_nor3_1
X_19642_ _19642_/Q clkload13/A _19642_/D _19642_/RESET_B VPWR VGND sg13cmos5l_dfrbpq_1
XFILLER_92_233 VPWR VGND sg13cmos5l_fill_2
XFILLER_19_831 VPWR VGND sg13cmos5l_fill_1
X_15805_ _15805_/Y _09988_/Y fanout83/X _15804_/Y VPWR VGND sg13cmos5l_a21oi_1
X_16785_ _16786_/B _16785_/A _16785_/B VPWR VGND sg13cmos5l_xnor2_1
XFILLER_81_929 VPWR VGND sg13cmos5l_decap_4
X_19573_ _19573_/Q _19814_/CLK _19573_/D _19573_/RESET_B VPWR VGND sg13cmos5l_dfrbpq_1
X_13997_ _13997_/Y _13911_/B _14078_/B _14079_/B _13915_/X VPWR VGND sg13cmos5l_a22oi_1
X_12948_ _12948_/Y _12890_/X _12948_/B VPWR VGND sg13cmos5l_nand2b_1
XFILLER_74_981 VPWR VGND sg13cmos5l_fill_2
X_18524_ _18524_/Y _18505_/A _18530_/S _10646_/B VPWR VGND sg13cmos5l_o21ai_1
X_15736_ _19340_/D _15736_/A _15736_/B VPWR VGND sg13cmos5l_and2_1
XFILLER_34_834 VPWR VGND sg13cmos5l_fill_1
X_12879_ _12880_/C _12879_/A _12879_/B VPWR VGND sg13cmos5l_or2_1
X_18455_ _18468_/B _18350_/Y _18363_/Y _18448_/Y _18454_/Y VPWR VGND sg13cmos5l_a22oi_1
X_15667_ _15667_/X _15577_/B _15665_/X _15666_/Y VPWR VGND sg13cmos5l_a21o_1
XFILLER_61_686 VPWR VGND sg13cmos5l_decap_8
X_17406_ _17407_/C _17702_/A _17406_/B VPWR VGND sg13cmos5l_nor2_1
X_14618_ _14622_/B _14618_/A _14618_/B VPWR VGND sg13cmos5l_nor2_1
XFILLER_14_580 VPWR VGND sg13cmos5l_fill_2
X_15598_ _15609_/A _19342_/Q _15608_/B _15597_/Y VPWR VGND sg13cmos5l_a21o_1
X_18386_ _18414_/A _19761_/Q _18386_/B VPWR VGND sg13cmos5l_xnor2_1
X_17337_ _17337_/Y _17337_/A VPWR VGND sg13cmos5l_inv_1
X_14549_ _14553_/B _19169_/Q _14550_/B VPWR VGND sg13cmos5l_nor2b_1
X_17268_ _17316_/A _17268_/A _17269_/B VPWR VGND sg13cmos5l_xnor2_1
X_17199_ _17199_/Y _17163_/X _17199_/B VPWR VGND sg13cmos5l_nand2b_1
X_19007_ _19007_/Q clkload66/A _19007_/D _19007_/RESET_B VPWR VGND sg13cmos5l_dfrbpq_1
X_16219_ _16238_/B _16255_/B _16256_/B VPWR VGND sg13cmos5l_nand2b_1
Xhold2604 _10170_/A _19622_/Q VPWR VGND sg13cmos5l_dlygate4sd3_1
Xhold2615 _10375_/A _19019_/Q VPWR VGND sg13cmos5l_dlygate4sd3_1
X_19288__951 _19288_/RESET_B VPWR VGND sg13cmos5l_tiehi
Xhold2637 hold2637/X _19179_/Q VPWR VGND sg13cmos5l_dlygate4sd3_1
Xhold2626 _10217_/A _19272_/Q VPWR VGND sg13cmos5l_dlygate4sd3_1
Xhold1903 _10794_/A _18579_/Q VPWR VGND sg13cmos5l_dlygate4sd3_1
Xhold1936 _14070_/B _19003_/Q VPWR VGND sg13cmos5l_dlygate4sd3_1
Xhold2648 _18366_/A _19750_/Q VPWR VGND sg13cmos5l_dlygate4sd3_1
Xhold2659 _10234_/A _19147_/Q VPWR VGND sg13cmos5l_dlygate4sd3_1
Xhold1925 _15528_/B _19282_/Q VPWR VGND sg13cmos5l_dlygate4sd3_1
Xhold1914 _19194_/D _14705_/Y VPWR VGND sg13cmos5l_dlygate4sd3_1
XFILLER_83_211 VPWR VGND sg13cmos5l_fill_2
Xhold1958 hold1958/X _18816_/Q VPWR VGND sg13cmos5l_dlygate4sd3_1
Xhold1969 hold1969/X _19519_/Q VPWR VGND sg13cmos5l_dlygate4sd3_1
X_18733__1546 _18733_/RESET_B VPWR VGND sg13cmos5l_tiehi
Xhold1947 _09993_/A _19153_/Q VPWR VGND sg13cmos5l_dlygate4sd3_1
XFILLER_45_28 VPWR VGND sg13cmos5l_fill_1
XFILLER_37_650 VPWR VGND sg13cmos5l_fill_2
XFILLER_52_664 VPWR VGND sg13cmos5l_fill_1
X_19295__944 _19295_/RESET_B VPWR VGND sg13cmos5l_tiehi
X_19618__590 _19618_/RESET_B VPWR VGND sg13cmos5l_tiehi
XFILLER_4_727 VPWR VGND sg13cmos5l_decap_8
X_10230_ _14935_/A _10230_/A VPWR VGND sg13cmos5l_inv_1
XFILLER_3_259 VPWR VGND sg13cmos5l_decap_4
X_19023__1237 _19023_/RESET_B VPWR VGND sg13cmos5l_tiehi
X_10161_ _17667_/A _17291_/A VPWR VGND sg13cmos5l_inv_1
X_10092_ _14638_/A _10092_/A VPWR VGND sg13cmos5l_inv_1
X_13920_ _13920_/Y _13920_/A _13923_/B VPWR VGND sg13cmos5l_nor2_1
XFILLER_0_999 VPWR VGND sg13cmos5l_decap_8
X_19625__583 _19625_/RESET_B VPWR VGND sg13cmos5l_tiehi
X_13851_ _13851_/Y _13851_/A VPWR VGND sg13cmos5l_inv_1
X_13782_ _13782_/Y _13782_/A _13802_/A VPWR VGND sg13cmos5l_nand2_1
X_16570_ _16570_/Y _17083_/A _19022_/Q _16569_/Y VPWR VGND sg13cmos5l_a21oi_1
X_12802_ _12839_/A _12814_/D _12802_/B VPWR VGND sg13cmos5l_and2_1
X_10994_ _11091_/B _10960_/X _10989_/C _10965_/Y VPWR VGND sg13cmos5l_a21oi_1
X_12733_ _18888_/D _12735_/A _12733_/B VPWR VGND sg13cmos5l_nor2_1
XFILLER_16_845 VPWR VGND sg13cmos5l_fill_1
X_15521_ _19319_/D _09989_/Y fanout75/X _15520_/Y VPWR VGND sg13cmos5l_a21oi_1
XFILLER_71_973 VPWR VGND sg13cmos5l_fill_2
X_18240_ _18240_/Y _19747_/Q _10340_/Y _18263_/B _19746_/Q _18239_/Y VPWR VGND sg13cmos5l_a221oi_1
X_15452_ _19295_/D _15439_/A hold2984/X _15458_/B VPWR VGND sg13cmos5l_a21oi_1
X_12664_ _12734_/B _12630_/A _12849_/A _12664_/S VPWR VGND sg13cmos5l_mux2_1
XFILLER_42_196 VPWR VGND sg13cmos5l_fill_2
XFILLER_15_399 VPWR VGND sg13cmos5l_fill_1
X_14403_ _14403_/Y _14907_/A _19170_/Q _14408_/C VPWR VGND sg13cmos5l_nor3_1
X_12595_ _12595_/Y _12695_/B _12695_/C _12695_/A VPWR VGND sg13cmos5l_a21oi_1
X_11615_ _11615_/Y _11598_/A _11614_/B _11479_/A VPWR VGND sg13cmos5l_a21oi_1
X_15383_ _15383_/X _15383_/A _15389_/A _15383_/C _15389_/C VPWR VGND sg13cmos5l_and4_1
XFILLER_30_369 VPWR VGND sg13cmos5l_fill_1
X_18171_ _18195_/B _18180_/B _18180_/C VPWR VGND sg13cmos5l_nor2_1
X_11546_ _11546_/Y _11893_/A _11720_/A VPWR VGND sg13cmos5l_nand2_1
X_17122_ _17122_/Y _17671_/A _17122_/B _17122_/C VPWR VGND sg13cmos5l_nor3_1
X_14334_ _14334_/Y _14334_/A _14334_/B _14334_/C VPWR VGND sg13cmos5l_nand3_1
X_17053_ _17053_/Y _17053_/A _17053_/B VPWR VGND sg13cmos5l_nand2_1
X_19632__576 _19632_/RESET_B VPWR VGND sg13cmos5l_tiehi
X_14265_ _14266_/A _14642_/A _14265_/B VPWR VGND sg13cmos5l_xnor2_1
X_11477_ _18699_/D _11479_/A _11477_/B VPWR VGND sg13cmos5l_nor2_1
X_13216_ _13216_/Y _13229_/A _13232_/B VPWR VGND sg13cmos5l_nor2_1
X_16004_ _19377_/D _15963_/A _16001_/S _16003_/Y VPWR VGND sg13cmos5l_a21oi_1
X_10428_ _10428_/Y _10400_/A _10419_/A _10424_/Y VPWR VGND sg13cmos5l_o21ai_1
X_14196_ _14197_/B _14178_/A _14178_/B _14195_/Y VPWR VGND sg13cmos5l_o21ai_1
X_13147_ _13154_/B _18955_/Q _18956_/Q VPWR VGND sg13cmos5l_nor2_1
X_10359_ _17408_/B _10359_/A VPWR VGND sg13cmos5l_inv_1
X_18826__1446 _18826_/RESET_B VPWR VGND sg13cmos5l_tiehi
XFILLER_97_347 VPWR VGND sg13cmos5l_decap_8
X_13078_ _13078_/Y _13061_/Y hold2379/X _13289_/B VPWR VGND sg13cmos5l_a21oi_1
X_17955_ _17956_/B _18477_/A _19644_/Q VPWR VGND sg13cmos5l_nand2_1
X_12029_ _12140_/A _12029_/A _12029_/B VPWR VGND sg13cmos5l_nor2_1
X_16906_ _16906_/X _16906_/A _16933_/A VPWR VGND sg13cmos5l_and2_1
X_17886_ _17887_/A _17886_/A _17886_/B VPWR VGND sg13cmos5l_xnor2_1
X_16837_ _16837_/Y _17369_/A _19474_/Q _16836_/Y VPWR VGND sg13cmos5l_a21oi_1
X_19625_ _19625_/Q clkload24/A _19625_/D _19625_/RESET_B VPWR VGND sg13cmos5l_dfrbpq_1
X_16768_ _16768_/X _16792_/B _16769_/B VPWR VGND sg13cmos5l_and2_1
X_19556_ _19556_/Q clkload24/A _19556_/D _19556_/RESET_B VPWR VGND sg13cmos5l_dfrbpq_1
XFILLER_47_981 VPWR VGND sg13cmos5l_decap_8
X_19196__1049 _19196_/RESET_B VPWR VGND sg13cmos5l_tiehi
XFILLER_62_940 VPWR VGND sg13cmos5l_fill_1
X_18507_ _18507_/Y _10320_/Y _18501_/A _18505_/A _10321_/Y _18506_/Y VPWR VGND sg13cmos5l_a221oi_1
X_15719_ _15720_/B _15719_/A _15719_/B VPWR VGND sg13cmos5l_nor2_1
X_19487_ _19487_/Q _19546_/CLK _19487_/D _19487_/RESET_B VPWR VGND sg13cmos5l_dfrbpq_1
X_16699_ _16916_/A _17085_/A _16699_/B VPWR VGND sg13cmos5l_xnor2_1
X_18438_ _18441_/A _18438_/A VPWR VGND sg13cmos5l_inv_1
X_18369_ _18370_/B _18369_/A _18369_/B VPWR VGND sg13cmos5l_xor2_1
Xoutput19 uo_out[6] _19444_/Q VPWR VGND sg13cmos5l_buf_1
Xhold2412 _10290_/A _18770_/Q VPWR VGND sg13cmos5l_dlygate4sd3_1
Xhold2401 _10360_/A _19515_/Q VPWR VGND sg13cmos5l_dlygate4sd3_1
X_19017__498 _19017_/D VPWR VGND sg13cmos5l_tielo
XFILLER_5_1004 VPWR VGND sg13cmos5l_fill_2
Xhold2423 hold2423/X _16073_/Y VPWR VGND sg13cmos5l_dlygate4sd3_1
Xhold2434 _15103_/A _19248_/Q VPWR VGND sg13cmos5l_dlygate4sd3_1
Xhold2445 _14564_/A _19164_/Q VPWR VGND sg13cmos5l_dlygate4sd3_1
Xhold2478 _10173_/A _19661_/Q VPWR VGND sg13cmos5l_dlygate4sd3_1
Xhold2489 _16361_/B _16360_/X VPWR VGND sg13cmos5l_dlygate4sd3_1
Xhold2467 _19303_/D _15459_/Y VPWR VGND sg13cmos5l_dlygate4sd3_1
Xhold2456 _19463_/D _16557_/Y VPWR VGND sg13cmos5l_dlygate4sd3_1
XFILLER_29_425 VPWR VGND sg13cmos5l_fill_1
XFILLER_84_586 VPWR VGND sg13cmos5l_decap_4
XFILLER_37_491 VPWR VGND sg13cmos5l_fill_1
XFILLER_72_59 VPWR VGND sg13cmos5l_fill_1
XFILLER_24_185 VPWR VGND sg13cmos5l_fill_1
XFILLER_8_307 VPWR VGND sg13cmos5l_fill_1
X_11400_ _11401_/B _18687_/Q _11398_/Y _11646_/B VPWR VGND sg13cmos5l_o21ai_1
X_12380_ _12380_/Y _18816_/Q _18777_/Q VPWR VGND sg13cmos5l_xnor2_1
X_11331_ _11332_/B _11331_/A _11331_/B VPWR VGND sg13cmos5l_xor2_1
XFILLER_106_452 VPWR VGND sg13cmos5l_fill_1
X_11262_ _11290_/B _11622_/A _11262_/B VPWR VGND sg13cmos5l_xnor2_1
X_14050_ _14051_/B _14050_/A _14050_/B VPWR VGND sg13cmos5l_xor2_1
XFILLER_21_96 VPWR VGND sg13cmos5l_fill_2
XFILLER_106_474 VPWR VGND sg13cmos5l_decap_8
X_13001_ _18912_/D _13001_/A _13001_/B VPWR VGND sg13cmos5l_and2_1
X_11193_ _11194_/B _11280_/A _11280_/B VPWR VGND sg13cmos5l_nand2_1
X_10213_ _10213_/Y _10213_/A VPWR VGND sg13cmos5l_inv_1
X_10144_ _17083_/A _10144_/A VPWR VGND sg13cmos5l_inv_1
X_17740_ _17757_/D _19611_/Q _19609_/Q _19610_/Q VPWR VGND sg13cmos5l_or3_1
X_10075_ _14072_/A _10075_/A VPWR VGND sg13cmos5l_inv_1
XFILLER_48_734 VPWR VGND sg13cmos5l_fill_2
X_14952_ _14952_/Y _19253_/Q _15460_/A _14932_/B _14700_/B VPWR VGND sg13cmos5l_a22oi_1
Xhold2990 hold2990/X _18871_/Q VPWR VGND sg13cmos5l_dlygate4sd3_1
X_17671_ _19628_/D _17671_/A _17671_/B VPWR VGND sg13cmos5l_nor2_1
X_13903_ _13903_/Y _13903_/A _13904_/B VPWR VGND sg13cmos5l_xnor2_1
X_14883_ _14884_/B _14883_/A _14883_/B VPWR VGND sg13cmos5l_or2_1
X_16622_ _19480_/D _16889_/A _16622_/B VPWR VGND sg13cmos5l_and2_1
X_13834_ _13834_/Y _19082_/Q _14371_/A _13849_/C VPWR VGND sg13cmos5l_nand3_1
X_19410_ _19410_/Q clkload5/A _19410_/D _19410_/RESET_B VPWR VGND sg13cmos5l_dfrbpq_1
XFILLER_47_299 VPWR VGND sg13cmos5l_fill_2
X_19341_ _19341_/Q clkload16/A _19341_/D _19341_/RESET_B VPWR VGND sg13cmos5l_dfrbpq_1
XFILLER_90_567 VPWR VGND sg13cmos5l_fill_1
X_13765_ _13766_/C _13765_/A _13765_/B VPWR VGND sg13cmos5l_or2_1
X_10977_ _10982_/C _10977_/A _10977_/B _10989_/B _10989_/C VPWR VGND sg13cmos5l_nand4_1
X_16553_ _16553_/X _16553_/A _16553_/B VPWR VGND sg13cmos5l_and2_1
X_13696_ _13700_/B _13696_/A _13720_/B _13720_/C VPWR VGND sg13cmos5l_nand3_1
X_12716_ _12716_/Y _12677_/B _12714_/S _12734_/A VPWR VGND sg13cmos5l_o21ai_1
X_15504_ _15505_/B _19317_/Q _15502_/Y _15764_/B VPWR VGND sg13cmos5l_o21ai_1
X_19272_ _19272_/Q _19738_/CLK _19272_/D _19272_/RESET_B VPWR VGND sg13cmos5l_dfrbpq_1
X_16484_ _16484_/Y _16482_/Y _16483_/Y _16481_/Y VPWR VGND sg13cmos5l_a21oi_1
X_12647_ _12649_/A _12647_/A _12658_/B _12658_/C VPWR VGND sg13cmos5l_nand3_1
X_18223_ _19710_/D _18223_/A _18227_/B VPWR VGND sg13cmos5l_nor2_1
X_15435_ _15451_/A _15435_/A _15435_/B VPWR VGND sg13cmos5l_nor2_1
XFILLER_30_155 VPWR VGND sg13cmos5l_fill_1
X_15366_ _15366_/X _15366_/A _15366_/B VPWR VGND sg13cmos5l_xor2_1
X_18154_ _18154_/Y _18059_/A _18059_/B _18154_/B1 _18152_/Y _18151_/Y VPWR VGND sg13cmos5l_a221oi_1
X_12578_ _12672_/A _12535_/B _12575_/B _12347_/Y VPWR VGND sg13cmos5l_o21ai_1
X_17105_ _17105_/Y _17110_/B _17101_/X _17104_/Y VPWR VGND sg13cmos5l_a21oi_1
XFILLER_8_874 VPWR VGND sg13cmos5l_fill_1
X_11529_ _11530_/B _18704_/Q _11533_/B _18705_/Q VPWR VGND sg13cmos5l_o21ai_1
X_18085_ _18085_/Y _18085_/A VPWR VGND sg13cmos5l_inv_1
X_15297_ _19285_/D _15464_/A _15297_/B VPWR VGND sg13cmos5l_nor2_1
X_19354__882 _19354_/RESET_B VPWR VGND sg13cmos5l_tiehi
X_14317_ _14317_/Y _14375_/B _14336_/B VPWR VGND sg13cmos5l_nor2_1
X_19079__492 _19079_/D VPWR VGND sg13cmos5l_tielo
X_17036_ _17036_/Y _17036_/A VPWR VGND sg13cmos5l_inv_1
X_14248_ _14248_/Y _14262_/D _14248_/B _14441_/A VPWR VGND sg13cmos5l_nand3_1
X_14179_ _14179_/Y _19073_/Q _14185_/B VPWR VGND sg13cmos5l_nand2b_1
Xheichips26_digital_project_1809 uio_oe[12] VPWR VGND sg13cmos5l_tiehi
XFILLER_98_689 VPWR VGND sg13cmos5l_fill_2
XFILLER_85_306 VPWR VGND sg13cmos5l_fill_2
X_18987_ _18987_/Q _19087_/CLK _18987_/D _18987_/RESET_B VPWR VGND sg13cmos5l_dfrbpq_1
X_17938_ _19673_/D _17942_/A _17938_/B VPWR VGND sg13cmos5l_nor2_1
X_19285__954 _19285_/RESET_B VPWR VGND sg13cmos5l_tiehi
X_17869_ _17869_/Y _18029_/A _17875_/B VPWR VGND sg13cmos5l_nand2_1
XFILLER_16_0 VPWR VGND sg13cmos5l_fill_2
XFILLER_93_372 VPWR VGND sg13cmos5l_fill_1
XFILLER_54_726 VPWR VGND sg13cmos5l_decap_8
X_19608_ _19608_/Q clkload13/A _19608_/D _19608_/RESET_B VPWR VGND sg13cmos5l_dfrbpq_1
XFILLER_27_929 VPWR VGND sg13cmos5l_fill_1
XFILLER_81_556 VPWR VGND sg13cmos5l_fill_1
XFILLER_81_534 VPWR VGND sg13cmos5l_decap_4
X_19361__875 _19361_/RESET_B VPWR VGND sg13cmos5l_tiehi
XFILLER_81_567 VPWR VGND sg13cmos5l_decap_4
X_19539_ _19539_/Q clkload34/A _19539_/D _19539_/RESET_B VPWR VGND sg13cmos5l_dfrbpq_1
XFILLER_34_461 VPWR VGND sg13cmos5l_fill_2
XFILLER_34_472 VPWR VGND sg13cmos5l_decap_8
XFILLER_50_965 VPWR VGND sg13cmos5l_decap_8
XFILLER_42_29 VPWR VGND sg13cmos5l_fill_2
X_19292__947 _19292_/RESET_B VPWR VGND sg13cmos5l_tiehi
X_19615__593 _19615_/RESET_B VPWR VGND sg13cmos5l_tiehi
X_18890__1379 _18890_/RESET_B VPWR VGND sg13cmos5l_tiehi
X_19063__1194 _19063_/RESET_B VPWR VGND sg13cmos5l_tiehi
XFILLER_104_978 VPWR VGND sg13cmos5l_fill_1
Xhold2220 _11893_/A _18702_/Q VPWR VGND sg13cmos5l_dlygate4sd3_1
X_09987_ _09987_/Y _09987_/A VPWR VGND sg13cmos5l_inv_1
Xhold2264 _17995_/B _19685_/Q VPWR VGND sg13cmos5l_dlygate4sd3_1
Xhold2231 _15759_/A _19314_/Q VPWR VGND sg13cmos5l_dlygate4sd3_1
Xhold2253 _19104_/D _14130_/Y VPWR VGND sg13cmos5l_dlygate4sd3_1
Xhold2242 _19063_/D _13866_/Y VPWR VGND sg13cmos5l_dlygate4sd3_1
Xhold2275 _10291_/A _18727_/Q VPWR VGND sg13cmos5l_dlygate4sd3_1
Xhold2286 _10317_/A _18602_/Q VPWR VGND sg13cmos5l_dlygate4sd3_1
Xhold2297 _14428_/B _19149_/Q VPWR VGND sg13cmos5l_dlygate4sd3_1
X_19622__586 _19622_/RESET_B VPWR VGND sg13cmos5l_tiehi
X_10900_ _10900_/Y _10900_/A _10901_/B VPWR VGND sg13cmos5l_xnor2_1
XFILLER_17_428 VPWR VGND sg13cmos5l_fill_2
X_11880_ _11880_/Y _11856_/Y _11890_/S _11904_/A VPWR VGND sg13cmos5l_o21ai_1
X_10831_ _10831_/Y _18620_/Q _11357_/A VPWR VGND sg13cmos5l_nand2_1
XFILLER_26_984 VPWR VGND sg13cmos5l_fill_1
X_10762_ _10804_/B _13808_/A _13809_/A VPWR VGND sg13cmos5l_xnor2_1
X_13550_ _13550_/Y _13557_/A _13557_/B VPWR VGND sg13cmos5l_nand2_1
XFILLER_26_995 VPWR VGND sg13cmos5l_fill_1
X_12501_ _12501_/Y _12760_/A _12495_/A _12503_/B _12766_/B VPWR VGND sg13cmos5l_a22oi_1
X_13481_ _13902_/A _19001_/Q _13482_/B VPWR VGND sg13cmos5l_xnor2_1
X_12432_ _12433_/B _12372_/Y _12375_/Y _12374_/A VPWR VGND sg13cmos5l_a21oi_1
X_10693_ _10693_/Y _10678_/X _10692_/Y _10385_/A VPWR VGND sg13cmos5l_o21ai_1
XFILLER_8_104 VPWR VGND sg13cmos5l_fill_2
X_15220_ _15220_/Y _15220_/A _19234_/Q _15225_/C VPWR VGND sg13cmos5l_nor3_1
X_12363_ _12363_/Y _12363_/A VPWR VGND sg13cmos5l_inv_1
XFILLER_5_800 VPWR VGND sg13cmos5l_decap_4
X_15151_ _15151_/Y _15138_/Y _15141_/X _15152_/A _15152_/B VPWR VGND sg13cmos5l_a22oi_1
X_12294_ _12294_/X _12294_/A _12294_/B VPWR VGND sg13cmos5l_and2_1
X_11314_ _11314_/Y _11309_/X _11311_/A _11313_/Y VPWR VGND sg13cmos5l_o21ai_1
X_15082_ _15082_/Y _15114_/A _15115_/A _15263_/A _15121_/A VPWR VGND sg13cmos5l_a22oi_1
XFILLER_5_844 VPWR VGND sg13cmos5l_decap_4
X_14102_ _14102_/X _14396_/A _14102_/B VPWR VGND sg13cmos5l_and2_1
X_18910_ _18910_/Q clkload64/A _18910_/D _18910_/RESET_B VPWR VGND sg13cmos5l_dfrbpq_1
X_11245_ _11452_/A _11245_/A _11245_/B VPWR VGND sg13cmos5l_nand2_1
X_14033_ _14033_/Y _14033_/A VPWR VGND sg13cmos5l_inv_1
X_19667__1792 _19667_/RESET_B VPWR VGND sg13cmos5l_tiehi
XFILLER_4_398 VPWR VGND sg13cmos5l_fill_1
XFILLER_4_387 VPWR VGND sg13cmos5l_decap_8
X_18841_ _18841_/Q clkload62/A _18841_/D _18841_/RESET_B VPWR VGND sg13cmos5l_dfrbpq_1
X_11176_ _11176_/X _10965_/A _11173_/X _11174_/Y VPWR VGND sg13cmos5l_a21o_1
X_18772_ _18772_/Q clkload68/A _18772_/D _18772_/RESET_B VPWR VGND sg13cmos5l_dfrbpq_1
X_10127_ _16312_/A _10127_/A VPWR VGND sg13cmos5l_inv_1
X_15984_ _15984_/Y _16021_/B _15984_/B VPWR VGND sg13cmos5l_nand2_1
X_10058_ _13288_/A _10058_/A VPWR VGND sg13cmos5l_inv_1
XFILLER_48_531 VPWR VGND sg13cmos5l_fill_2
X_17723_ _17723_/Y _17706_/B _17719_/S _17770_/A VPWR VGND sg13cmos5l_o21ai_1
X_14935_ _14935_/Y _14935_/A _19192_/Q VPWR VGND sg13cmos5l_nor2_1
XFILLER_75_361 VPWR VGND sg13cmos5l_fill_1
X_17654_ _17654_/Y _17625_/A _17659_/A _17677_/A VPWR VGND sg13cmos5l_o21ai_1
X_14866_ _14866_/Y _14876_/B _14782_/B _14911_/B _14871_/S _14863_/Y VPWR VGND sg13cmos5l_a221oi_1
X_13817_ _19056_/D _13817_/A _13817_/B VPWR VGND sg13cmos5l_and2_1
X_16605_ _16605_/Y _16586_/A fanout31/X _16604_/Y VPWR VGND sg13cmos5l_a21oi_1
X_17585_ _17585_/Y _17585_/A _17585_/B _17585_/C _17585_/D VPWR VGND sg13cmos5l_nand4_1
XFILLER_51_707 VPWR VGND sg13cmos5l_fill_1
X_14797_ _14797_/Y _19207_/Q _19208_/Q _19209_/Q VPWR VGND sg13cmos5l_o21ai_1
X_19115__1136 _19115_/RESET_B VPWR VGND sg13cmos5l_tiehi
X_13748_ _13784_/A _19051_/Q _13751_/B VPWR VGND sg13cmos5l_nor2_1
X_19324_ _19324_/Q _19738_/CLK _19324_/D _19324_/RESET_B VPWR VGND sg13cmos5l_dfrbpq_1
X_16536_ _16536_/Y _16501_/A _16501_/B _16533_/A _16533_/B _16535_/Y VPWR VGND sg13cmos5l_a221oi_1
X_19255_ _19255_/Q _19805_/CLK _19255_/D _19255_/RESET_B VPWR VGND sg13cmos5l_dfrbpq_1
X_13679_ _13687_/B _16822_/A _13680_/B VPWR VGND sg13cmos5l_and2_1
X_18206_ _18206_/X _18206_/A _18206_/B VPWR VGND sg13cmos5l_and2_1
X_16467_ _16467_/Y _16467_/A _16467_/B VPWR VGND sg13cmos5l_nand2_1
X_15418_ _15419_/C _15418_/A _15418_/B _15418_/C VPWR VGND sg13cmos5l_and3_1
X_19186_ _19186_/Q _19302_/CLK _19186_/D _19186_/RESET_B VPWR VGND sg13cmos5l_dfrbpq_1
X_16398_ _16401_/A _19467_/Q _16398_/B VPWR VGND sg13cmos5l_xnor2_1
X_15349_ _15349_/X _15383_/A _15383_/C _15535_/A VPWR VGND sg13cmos5l_and3_1
X_18137_ _18137_/X _18154_/B1 _18135_/X _18134_/Y VPWR VGND sg13cmos5l_a21o_1
X_18068_ _18068_/Y _19689_/Q _19650_/Q VPWR VGND sg13cmos5l_nand2_1
XFILLER_8_693 VPWR VGND sg13cmos5l_fill_2
X_17019_ _17203_/A _17179_/A _17171_/A VPWR VGND sg13cmos5l_nand2b_1
XFILLER_99_954 VPWR VGND sg13cmos5l_fill_2
X_19694__1739 _19694_/RESET_B VPWR VGND sg13cmos5l_tiehi
XFILLER_22_431 VPWR VGND sg13cmos5l_fill_1
XFILLER_10_615 VPWR VGND sg13cmos5l_fill_2
XFILLER_6_608 VPWR VGND sg13cmos5l_fill_2
X_18821__1451 _18821_/RESET_B VPWR VGND sg13cmos5l_tiehi
XFILLER_78_25 VPWR VGND sg13cmos5l_fill_2
XFILLER_103_252 VPWR VGND sg13cmos5l_decap_8
X_11030_ _11030_/Y _11030_/A _11030_/B VPWR VGND sg13cmos5l_nor2_1
XFILLER_104_797 VPWR VGND sg13cmos5l_decap_4
Xhold2061 _12219_/A _18766_/Q VPWR VGND sg13cmos5l_dlygate4sd3_1
Xhold2072 _18346_/A _19731_/Q VPWR VGND sg13cmos5l_dlygate4sd3_1
Xhold2050 hold2050/X _16370_/Y VPWR VGND sg13cmos5l_dlygate4sd3_1
Xhold2094 hold2094/X _10697_/Y VPWR VGND sg13cmos5l_dlygate4sd3_1
Xhold2083 _19470_/D _16605_/Y VPWR VGND sg13cmos5l_dlygate4sd3_1
X_12981_ _12981_/Y _12981_/A _13008_/A VPWR VGND sg13cmos5l_nand2_1
XFILLER_57_361 VPWR VGND sg13cmos5l_fill_1
X_11932_ _11932_/Y _11932_/A _18730_/Q VPWR VGND sg13cmos5l_nor2_1
X_14720_ _14721_/B _19164_/Q _19157_/Q VPWR VGND sg13cmos5l_nor2_1
XFILLER_17_236 VPWR VGND sg13cmos5l_fill_1
X_11863_ _11863_/Y _11863_/A _11863_/B VPWR VGND sg13cmos5l_nor2_1
X_19344__892 _19344_/RESET_B VPWR VGND sg13cmos5l_tiehi
X_14651_ _14651_/Y _15184_/A _19146_/Q VPWR VGND sg13cmos5l_nor2_1
X_13602_ _13602_/Y _13602_/A VPWR VGND sg13cmos5l_inv_1
X_10814_ _18587_/D _18558_/A _18559_/B VPWR VGND sg13cmos5l_nor2_1
X_17370_ _19587_/D _17370_/A _17370_/B VPWR VGND sg13cmos5l_nor2_1
XFILLER_72_386 VPWR VGND sg13cmos5l_fill_2
X_11794_ _11800_/B _18747_/Q _18748_/Q _18745_/Q _18746_/Q VPWR VGND sg13cmos5l_nor4_1
X_14582_ _14649_/B _14555_/A _14557_/Y _14556_/A VPWR VGND sg13cmos5l_o21ai_1
X_16321_ _16321_/Y _16399_/D _16335_/A _10201_/Y _19448_/Q VPWR VGND sg13cmos5l_a22oi_1
X_10745_ _18579_/D _09999_/Y fanout68/X _10744_/Y VPWR VGND sg13cmos5l_a21oi_1
X_18646__533 _18646_/D VPWR VGND sg13cmos5l_tielo
X_13533_ _13533_/Y _13533_/A _13533_/B VPWR VGND sg13cmos5l_xnor2_1
X_19040_ _19040_/Q clkload31/A _19040_/D _19040_/RESET_B VPWR VGND sg13cmos5l_dfrbpq_1
X_10676_ _10679_/C _10680_/A _10652_/B _10658_/A VPWR VGND sg13cmos5l_o21ai_1
X_13464_ _13464_/Y _13497_/A _13462_/Y _13463_/Y _13476_/C VPWR VGND sg13cmos5l_a22oi_1
X_16252_ _16252_/X _16248_/X _16250_/B _16252_/S VPWR VGND sg13cmos5l_mux2_1
XFILLER_9_457 VPWR VGND sg13cmos5l_decap_8
XFILLER_9_468 VPWR VGND sg13cmos5l_fill_2
X_12415_ _12415_/Y _12417_/B _12436_/A _12415_/C VPWR VGND sg13cmos5l_nand3_1
X_13395_ _13395_/Y _13420_/B _13420_/C VPWR VGND sg13cmos5l_nand2_1
X_16183_ _16185_/B _19431_/Q _19432_/Q _19433_/Q VPWR VGND sg13cmos5l_o21ai_1
X_15203_ _15203_/Y _19296_/Q _15210_/B _19233_/Q _15741_/A VPWR VGND sg13cmos5l_a22oi_1
X_12346_ _12346_/Y _12342_/A _12342_/B _12338_/Y VPWR VGND sg13cmos5l_a21oi_1
X_15134_ _15134_/Y _15134_/A _15134_/B VPWR VGND sg13cmos5l_nor2_1
XFILLER_4_151 VPWR VGND sg13cmos5l_fill_1
X_12277_ _12277_/Y _12265_/Y _12273_/X _12307_/A _12078_/Y _12274_/X VPWR VGND sg13cmos5l_a221oi_1
X_15065_ _15065_/Y _19249_/Q _15067_/B VPWR VGND sg13cmos5l_nand2_1
XFILLER_5_696 VPWR VGND sg13cmos5l_fill_2
XFILLER_4_184 VPWR VGND sg13cmos5l_decap_4
X_19351__885 _19351_/RESET_B VPWR VGND sg13cmos5l_tiehi
X_11228_ _11331_/A hold2838/X _11231_/B _11227_/Y VPWR VGND sg13cmos5l_a21oi_1
X_14016_ _14016_/Y _14016_/A _14176_/A VPWR VGND sg13cmos5l_nand2_1
X_18824_ _18824_/Q clkload70/A _18824_/D _18824_/RESET_B VPWR VGND sg13cmos5l_dfrbpq_1
XFILLER_96_924 VPWR VGND sg13cmos5l_fill_2
XFILLER_95_412 VPWR VGND sg13cmos5l_fill_1
XFILLER_68_615 VPWR VGND sg13cmos5l_fill_2
X_18656__1637 _18656_/RESET_B VPWR VGND sg13cmos5l_tiehi
X_11159_ _11159_/Y _11159_/A _11171_/D _11159_/C VPWR VGND sg13cmos5l_nand3_1
XFILLER_95_467 VPWR VGND sg13cmos5l_fill_1
X_18755_ _18755_/Q clkload40/A _18755_/D _18755_/RESET_B VPWR VGND sg13cmos5l_dfrbpq_1
X_15967_ _15967_/Y _15967_/A VPWR VGND sg13cmos5l_inv_1
X_18686_ _18686_/Q _18750_/CLK _18686_/D _18686_/RESET_B VPWR VGND sg13cmos5l_dfrbpq_1
X_17706_ _17707_/C _17706_/A _17706_/B VPWR VGND sg13cmos5l_nor2_1
X_15898_ _15898_/Y _19389_/Q _19390_/Q VPWR VGND sg13cmos5l_xnor2_1
X_14918_ _14918_/Y _15454_/A _19186_/Q _14917_/Y VPWR VGND sg13cmos5l_o21ai_1
X_19282__957 _19282_/RESET_B VPWR VGND sg13cmos5l_tiehi
XFILLER_75_191 VPWR VGND sg13cmos5l_fill_1
XFILLER_64_876 VPWR VGND sg13cmos5l_fill_1
X_17637_ _17638_/C _17637_/A _17637_/B _17637_/C VPWR VGND sg13cmos5l_nand3_1
X_14849_ _14849_/Y _14877_/A _14915_/B _14848_/Y VPWR VGND sg13cmos5l_a21oi_1
XFILLER_36_578 VPWR VGND sg13cmos5l_decap_8
XFILLER_90_183 VPWR VGND sg13cmos5l_fill_2
XFILLER_90_172 VPWR VGND sg13cmos5l_fill_1
XFILLER_90_161 VPWR VGND sg13cmos5l_fill_2
X_17568_ _17568_/Y _17607_/A _17568_/B VPWR VGND sg13cmos5l_nand2b_1
X_19307_ _19307_/Q _19308_/CLK _19307_/D _19307_/RESET_B VPWR VGND sg13cmos5l_dfrbpq_1
X_17499_ _17499_/Y _17499_/A _17499_/B VPWR VGND sg13cmos5l_nor2_1
X_16519_ _16519_/Y _16560_/B _16526_/B VPWR VGND sg13cmos5l_nor2_1
XFILLER_104_1018 VPWR VGND sg13cmos5l_decap_8
XFILLER_83_0 VPWR VGND sg13cmos5l_fill_2
XFILLER_20_946 VPWR VGND sg13cmos5l_fill_2
X_19238_ _19238_/Q clkload48/A _19238_/D _19238_/RESET_B VPWR VGND sg13cmos5l_dfrbpq_1
X_19169_ _19169_/Q _19220_/CLK _19169_/D _19169_/RESET_B VPWR VGND sg13cmos5l_dfrbpq_1
X_18589__1710 _18589_/RESET_B VPWR VGND sg13cmos5l_tiehi
X_19612__596 _19612_/RESET_B VPWR VGND sg13cmos5l_tiehi
Xfanout403 fanout403/X input1/X VPWR VGND sg13cmos5l_buf_1
X_19170__483 _19170_/D VPWR VGND sg13cmos5l_tielo
XFILLER_59_626 VPWR VGND sg13cmos5l_fill_2
XFILLER_74_618 VPWR VGND sg13cmos5l_fill_2
X_18839__1433 _18839_/RESET_B VPWR VGND sg13cmos5l_tiehi
XFILLER_64_49 VPWR VGND sg13cmos5l_fill_2
Xfanout21 _18212_/S _18207_/Y VPWR VGND sg13cmos5l_buf_1
Xfanout54 _12186_/S _12175_/Y VPWR VGND sg13cmos5l_buf_1
Xfanout65 _14876_/B _14780_/Y VPWR VGND sg13cmos5l_buf_1
Xfanout43 _14131_/S _14122_/Y VPWR VGND sg13cmos5l_buf_1
Xfanout32 fanout32/X _16536_/Y VPWR VGND sg13cmos5l_buf_1
Xfanout87 fanout87/X fanout88/X VPWR VGND sg13cmos5l_buf_1
Xfanout98 fanout98/X _10738_/Y VPWR VGND sg13cmos5l_buf_1
Xfanout76 fanout76/X fanout81/X VPWR VGND sg13cmos5l_buf_1
XFILLER_50_592 VPWR VGND sg13cmos5l_fill_1
XFILLER_10_434 VPWR VGND sg13cmos5l_fill_2
X_10530_ _10531_/A _19799_/Q _10530_/B VPWR VGND sg13cmos5l_xnor2_1
X_10461_ _10461_/Y _10622_/A _10461_/B VPWR VGND sg13cmos5l_nor2_1
X_12200_ _18805_/D _12200_/A _12200_/B VPWR VGND sg13cmos5l_nor2_1
X_10392_ _10392_/X _10392_/A _10392_/B VPWR VGND sg13cmos5l_and2_1
X_13180_ _13199_/S _13175_/Y _13178_/Y _13179_/Y VPWR VGND sg13cmos5l_a21o_1
X_12131_ _12131_/Y _12133_/S _12130_/Y VPWR VGND sg13cmos5l_nor2b_1
X_12062_ _12274_/A _12459_/A _12062_/B VPWR VGND sg13cmos5l_xnor2_1
XFILLER_49_103 VPWR VGND sg13cmos5l_fill_1
X_11013_ _11042_/B _11013_/A _11013_/B VPWR VGND sg13cmos5l_nand2_1
X_16870_ _16870_/Y _17364_/B _17930_/A VPWR VGND sg13cmos5l_nand2b_1
XFILLER_65_629 VPWR VGND sg13cmos5l_fill_2
XFILLER_65_607 VPWR VGND sg13cmos5l_fill_1
XFILLER_58_670 VPWR VGND sg13cmos5l_decap_4
XFILLER_37_309 VPWR VGND sg13cmos5l_fill_2
X_15821_ _15821_/Y _15821_/A _15828_/D _15821_/C VPWR VGND sg13cmos5l_nand3_1
XFILLER_92_459 VPWR VGND sg13cmos5l_fill_2
X_12964_ _12986_/B _12962_/A _13028_/B _12963_/Y _12959_/Y VPWR VGND sg13cmos5l_a22oi_1
X_18540_ _19775_/D _18540_/A _18540_/B VPWR VGND sg13cmos5l_and2_1
X_15752_ _15753_/B _16310_/A _19314_/Q _19313_/Q _16309_/A VPWR VGND sg13cmos5l_a22oi_1
X_19155__1093 _19155_/RESET_B VPWR VGND sg13cmos5l_tiehi
X_11915_ _11922_/C _11915_/A _11915_/B VPWR VGND sg13cmos5l_nand2_1
XFILLER_61_802 VPWR VGND sg13cmos5l_fill_2
X_18471_ _19750_/D _18471_/A _18481_/A VPWR VGND sg13cmos5l_nor2_1
X_14703_ _14703_/Y _09995_/Y fanout90/X _14702_/Y VPWR VGND sg13cmos5l_a21oi_1
X_12895_ _12895_/Y _12932_/A _12896_/B VPWR VGND sg13cmos5l_nand2_1
X_17422_ _17422_/Y _17696_/A fanout25/X _17421_/Y VPWR VGND sg13cmos5l_a21oi_1
X_15683_ _15683_/Y _15586_/B _15748_/B VPWR VGND sg13cmos5l_nand2b_1
X_11846_ _11846_/Y _11846_/A _11846_/B VPWR VGND sg13cmos5l_nor2_1
XFILLER_14_751 VPWR VGND sg13cmos5l_fill_2
X_14634_ _14634_/Y _14634_/A _14634_/B VPWR VGND sg13cmos5l_nand2_1
X_11777_ _11820_/B _18759_/Q _18760_/Q _18761_/Q VPWR VGND sg13cmos5l_o21ai_1
X_17353_ _19574_/D hold2652/X fanout26/X _17352_/Y VPWR VGND sg13cmos5l_a21oi_1
X_14565_ _14644_/B hold2637/X _14564_/Y _14573_/S VPWR VGND sg13cmos5l_mux2_1
X_10728_ _13598_/A _10734_/A _18572_/Q VPWR VGND sg13cmos5l_nor2b_1
X_17284_ _17313_/S _17284_/A _17284_/B VPWR VGND sg13cmos5l_nor2_1
X_13516_ _13516_/X _13529_/A _13584_/B _13511_/Y VPWR VGND sg13cmos5l_a21o_1
X_16304_ _19420_/D hold2912/X _16305_/S _16303_/Y VPWR VGND sg13cmos5l_a21oi_1
X_19023_ _19023_/Q clkload32/A _19023_/D _19023_/RESET_B VPWR VGND sg13cmos5l_dfrbpq_1
X_16235_ _16238_/C _16423_/A _16248_/B VPWR VGND sg13cmos5l_nand2_1
X_14496_ _14496_/Y _14494_/Y _14495_/Y _14493_/Y VPWR VGND sg13cmos5l_a21oi_1
X_10659_ _10659_/Y _10659_/A _18561_/Q VPWR VGND sg13cmos5l_xnor2_1
X_13447_ _13553_/B _19009_/Q _13447_/B VPWR VGND sg13cmos5l_and2_1
Xclkload24 clkload24/X clkload24/A VPWR VGND sg13cmos5l_buf_8
Xclkload35 clkload35/X clkload35/A VPWR VGND sg13cmos5l_buf_8
Xclkload13 clkload13/Y clkload13/A VPWR VGND sg13cmos5l_inv_2
Xclkload68 clkload68/Y clkload68/A VPWR VGND sg13cmos5l_inv_2
Xclkload57 clkload57/Y clkload57/A VPWR VGND sg13cmos5l_inv_2
X_13378_ _13378_/Y _13377_/A _13414_/A _13419_/A _13384_/A VPWR VGND sg13cmos5l_a22oi_1
Xclkload46 clkload46/Y clkload46/A VPWR VGND sg13cmos5l_inv_2
X_16166_ _16168_/B _16288_/A _16287_/A VPWR VGND sg13cmos5l_nor2_1
X_12329_ _12335_/B _12364_/A _12329_/B VPWR VGND sg13cmos5l_nor2_1
X_15117_ _15117_/Y _15018_/X _15191_/B _15192_/B _15132_/A VPWR VGND sg13cmos5l_a22oi_1
X_16097_ _16097_/X _16091_/X _16095_/Y _16090_/X VPWR VGND sg13cmos5l_a21o_1
XFILLER_102_509 VPWR VGND sg13cmos5l_decap_4
XFILLER_69_902 VPWR VGND sg13cmos5l_fill_2
X_15048_ _15050_/B _15161_/A _15160_/A VPWR VGND sg13cmos5l_nor2_1
X_18577__1725 _18577_/RESET_B VPWR VGND sg13cmos5l_tiehi
Xhold2808 _11324_/C _11323_/Y VPWR VGND sg13cmos5l_dlygate4sd3_1
Xhold2819 _14050_/A _19093_/Q VPWR VGND sg13cmos5l_dlygate4sd3_1
X_18807_ _18807_/Q clkload60/A _18807_/D _18807_/RESET_B VPWR VGND sg13cmos5l_dfrbpq_1
X_16999_ _16999_/Y _16999_/A _17171_/A VPWR VGND sg13cmos5l_nand2_1
XFILLER_56_629 VPWR VGND sg13cmos5l_fill_2
X_19787_ _19787_/Q clkload48/A _19787_/D _19787_/RESET_B VPWR VGND sg13cmos5l_dfrbpq_1
XFILLER_37_810 VPWR VGND sg13cmos5l_fill_2
X_18738_ _18738_/Q _18750_/CLK _18738_/D _18738_/RESET_B VPWR VGND sg13cmos5l_dfrbpq_1
XFILLER_95_297 VPWR VGND sg13cmos5l_fill_1
X_18669_ _18669_/Q clkload58/A _18669_/D _18669_/RESET_B VPWR VGND sg13cmos5l_dfrbpq_1
XFILLER_24_504 VPWR VGND sg13cmos5l_fill_2
XFILLER_32_592 VPWR VGND sg13cmos5l_fill_1
XFILLER_50_29 VPWR VGND sg13cmos5l_fill_1
Xclkload7 clkload7/X clkload7/A VPWR VGND sg13cmos5l_buf_8
XFILLER_30_1001 VPWR VGND sg13cmos5l_fill_1
XFILLER_106_815 VPWR VGND sg13cmos5l_fill_2
XFILLER_106_804 VPWR VGND sg13cmos5l_fill_2
Xfanout222 _17087_/A _17071_/A VPWR VGND sg13cmos5l_buf_1
Xfanout211 _17943_/A _17770_/A VPWR VGND sg13cmos5l_buf_1
Xfanout200 _18481_/A _18483_/A VPWR VGND sg13cmos5l_buf_1
Xfanout255 _15194_/A _14956_/Y VPWR VGND sg13cmos5l_buf_1
Xfanout244 _15742_/B _15586_/A VPWR VGND sg13cmos5l_buf_1
Xfanout233 _16561_/A _16358_/Y VPWR VGND sg13cmos5l_buf_1
Xfanout299 _12467_/A _12462_/B VPWR VGND sg13cmos5l_buf_1
Xfanout277 _13801_/A _13624_/Y VPWR VGND sg13cmos5l_buf_1
Xfanout288 _13290_/B _13297_/A VPWR VGND sg13cmos5l_buf_1
Xfanout266 _14377_/A _14376_/A VPWR VGND sg13cmos5l_buf_1
XFILLER_27_320 VPWR VGND sg13cmos5l_fill_1
XFILLER_55_662 VPWR VGND sg13cmos5l_decap_4
X_12680_ _12680_/X _12704_/A _12680_/B VPWR VGND sg13cmos5l_and2_1
X_11700_ _11727_/A _18695_/Q _18696_/Q VPWR VGND sg13cmos5l_xnor2_1
XFILLER_70_654 VPWR VGND sg13cmos5l_fill_1
XFILLER_27_397 VPWR VGND sg13cmos5l_fill_1
X_11631_ _18722_/D _11631_/A _11631_/B VPWR VGND sg13cmos5l_nor2_1
X_19341__895 _19341_/RESET_B VPWR VGND sg13cmos5l_tiehi
X_11562_ _11562_/Y _11629_/B VPWR VGND sg13cmos5l_inv_1
X_14350_ _14350_/Y _14350_/A _14350_/B VPWR VGND sg13cmos5l_nand2_1
X_13301_ _13302_/B _14073_/A _18936_/Q _18935_/Q _14072_/A VPWR VGND sg13cmos5l_a22oi_1
X_10513_ _18543_/A _10511_/A _10512_/B _10564_/A VPWR VGND sg13cmos5l_mux2_1
X_11493_ _11595_/C _18713_/Q _11588_/B _11589_/A VPWR VGND sg13cmos5l_o21ai_1
XFILLER_7_747 VPWR VGND sg13cmos5l_fill_1
XFILLER_6_235 VPWR VGND sg13cmos5l_fill_2
XFILLER_6_224 VPWR VGND sg13cmos5l_fill_2
XFILLER_10_275 VPWR VGND sg13cmos5l_fill_2
X_14281_ _14281_/X _14282_/C _14282_/D VPWR VGND sg13cmos5l_and2_1
X_13232_ _13233_/B _13232_/A _13232_/B VPWR VGND sg13cmos5l_xor2_1
X_10444_ _10444_/Y _19773_/Q _19734_/Q VPWR VGND sg13cmos5l_nand2_1
XFILLER_40_40 VPWR VGND sg13cmos5l_fill_1
XFILLER_7_769 VPWR VGND sg13cmos5l_fill_2
X_16020_ _19392_/D _16020_/A _16020_/B VPWR VGND sg13cmos5l_nor2_1
X_10375_ _13606_/A _10375_/A VPWR VGND sg13cmos5l_inv_1
X_13163_ _13163_/Y _18955_/Q _18970_/Q VPWR VGND sg13cmos5l_nand2_1
XFILLER_40_84 VPWR VGND sg13cmos5l_decap_4
XFILLER_6_279 VPWR VGND sg13cmos5l_fill_1
X_12114_ _12197_/B _12116_/C _12116_/D VPWR VGND sg13cmos5l_and2_1
XFILLER_97_507 VPWR VGND sg13cmos5l_fill_2
XFILLER_97_518 VPWR VGND sg13cmos5l_fill_1
X_18696__1594 _18696_/RESET_B VPWR VGND sg13cmos5l_tiehi
X_13094_ _13094_/Y _12751_/A _13122_/A _13092_/Y _13093_/Y VPWR VGND sg13cmos5l_a22oi_1
X_17971_ _17972_/B _17975_/C _17969_/Y _17970_/Y VPWR VGND sg13cmos5l_a21o_1
X_19710_ _19710_/Q clkload13/A _19710_/D _19710_/RESET_B VPWR VGND sg13cmos5l_dfrbpq_1
XFILLER_3_986 VPWR VGND sg13cmos5l_fill_1
X_12045_ _12057_/A _12045_/A _12045_/B VPWR VGND sg13cmos5l_nor2_1
X_16922_ _16922_/Y _16940_/B _16898_/Y VPWR VGND sg13cmos5l_nor2b_1
XFILLER_49_82 VPWR VGND sg13cmos5l_fill_1
X_16853_ _16853_/Y _10361_/Y _16843_/Y _16847_/X _16852_/X _16848_/X VPWR VGND sg13cmos5l_a221oi_1
X_19641_ _19641_/Q _19756_/CLK _19641_/D _19641_/RESET_B VPWR VGND sg13cmos5l_dfrbpq_1
X_19572_ _19572_/Q _19814_/CLK _19572_/D _19572_/RESET_B VPWR VGND sg13cmos5l_dfrbpq_1
X_15804_ _15804_/Y _19362_/Q fanout83/X _16082_/A VPWR VGND sg13cmos5l_o21ai_1
X_16784_ _16784_/Y _16768_/X _16774_/X _16780_/X _16783_/A VPWR VGND sg13cmos5l_a22oi_1
X_18523_ _19764_/D _18529_/A _18523_/B VPWR VGND sg13cmos5l_nor2_1
X_13996_ _13996_/Y _14079_/B VPWR VGND sg13cmos5l_inv_1
X_12947_ _13130_/A _12947_/A _13114_/A VPWR VGND sg13cmos5l_and2_1
XFILLER_46_684 VPWR VGND sg13cmos5l_fill_1
X_15735_ _19339_/D _15735_/A _15735_/B VPWR VGND sg13cmos5l_and2_1
X_12878_ _12985_/B _12860_/A _12879_/B _12876_/Y VPWR VGND sg13cmos5l_a21oi_1
X_18454_ _18454_/Y _18456_/A _18468_/A _18453_/Y VPWR VGND sg13cmos5l_a21oi_1
X_15666_ _15666_/Y _15572_/A _15572_/B _15678_/A _15656_/Y _15657_/Y VPWR VGND sg13cmos5l_a221oi_1
XFILLER_34_857 VPWR VGND sg13cmos5l_fill_1
X_11829_ _11829_/X _11833_/B _12017_/A _11827_/Y VPWR VGND sg13cmos5l_a21o_1
X_17405_ _17406_/B _17408_/C _17404_/Y _17403_/Y VPWR VGND sg13cmos5l_a21o_1
X_14617_ _14618_/B _14617_/A _14617_/B VPWR VGND sg13cmos5l_xnor2_1
X_18385_ _18391_/B _19761_/Q _18386_/B VPWR VGND sg13cmos5l_nor2b_1
X_17336_ _17337_/A _17322_/A _17322_/B _17333_/A _17333_/B VPWR VGND sg13cmos5l_a22oi_1
XFILLER_53_1023 VPWR VGND sg13cmos5l_decap_4
X_15597_ _15597_/Y _15701_/B _15701_/C _15701_/A VPWR VGND sg13cmos5l_a21oi_1
X_14548_ _14555_/A _19184_/Q _14548_/B VPWR VGND sg13cmos5l_xnor2_1
X_19121__488 _19121_/D VPWR VGND sg13cmos5l_tielo
X_17267_ _17276_/B _19592_/Q _19594_/Q _19593_/Q _17267_/D VPWR VGND sg13cmos5l_nor4_1
X_14479_ _14479_/Y _14457_/D _14441_/C _14464_/X VPWR VGND sg13cmos5l_a21oi_1
X_17198_ _19569_/D _17377_/A _17198_/B VPWR VGND sg13cmos5l_nor2_1
X_19006_ _19006_/Q clkload66/A _19006_/D _19006_/RESET_B VPWR VGND sg13cmos5l_dfrbpq_1
X_16218_ _16220_/B _16248_/B _16255_/B VPWR VGND sg13cmos5l_nor2_1
X_16149_ _16149_/Y _19404_/Q _19365_/Q VPWR VGND sg13cmos5l_xnor2_1
X_18659__532 _18659_/D VPWR VGND sg13cmos5l_tielo
Xhold2605 _13603_/B _19044_/Q VPWR VGND sg13cmos5l_dlygate4sd3_1
Xhold2638 _10052_/A _18591_/Q VPWR VGND sg13cmos5l_dlygate4sd3_1
XFILLER_69_732 VPWR VGND sg13cmos5l_fill_1
Xhold2616 _10328_/A _19723_/Q VPWR VGND sg13cmos5l_dlygate4sd3_1
Xhold2627 _15242_/B _15241_/X VPWR VGND sg13cmos5l_dlygate4sd3_1
Xhold1904 _19027_/D _13643_/Y VPWR VGND sg13cmos5l_dlygate4sd3_1
Xhold1926 _10393_/A _18565_/Q VPWR VGND sg13cmos5l_dlygate4sd3_1
XFILLER_68_242 VPWR VGND sg13cmos5l_fill_1
Xhold2649 _10159_/A _19575_/Q VPWR VGND sg13cmos5l_dlygate4sd3_1
Xhold1915 _15453_/B _19255_/Q VPWR VGND sg13cmos5l_dlygate4sd3_1
Xhold1959 hold1959/X _19603_/Q VPWR VGND sg13cmos5l_dlygate4sd3_1
Xhold1937 _10012_/A _18690_/Q VPWR VGND sg13cmos5l_dlygate4sd3_1
Xhold1948 _19195_/D _14707_/Y VPWR VGND sg13cmos5l_dlygate4sd3_1
XFILLER_28_139 VPWR VGND sg13cmos5l_fill_1
X_18879__1390 _18879_/RESET_B VPWR VGND sg13cmos5l_tiehi
XFILLER_83_256 VPWR VGND sg13cmos5l_fill_1
XFILLER_51_175 VPWR VGND sg13cmos5l_fill_1
X_18955__1308 _18955_/RESET_B VPWR VGND sg13cmos5l_tiehi
X_19128__1123 _19128_/RESET_B VPWR VGND sg13cmos5l_tiehi
XFILLER_106_623 VPWR VGND sg13cmos5l_decap_4
X_18651__1642 _18651_/RESET_B VPWR VGND sg13cmos5l_tiehi
XFILLER_3_205 VPWR VGND sg13cmos5l_fill_1
XFILLER_106_656 VPWR VGND sg13cmos5l_fill_1
XFILLER_79_507 VPWR VGND sg13cmos5l_fill_1
X_10160_ _17673_/A _17122_/B VPWR VGND sg13cmos5l_inv_1
X_10091_ _14641_/A _10091_/A VPWR VGND sg13cmos5l_inv_1
XFILLER_0_978 VPWR VGND sg13cmos5l_decap_8
XFILLER_101_383 VPWR VGND sg13cmos5l_fill_2
XFILLER_19_117 VPWR VGND sg13cmos5l_fill_2
X_13850_ _13851_/A _13849_/C _13848_/Y _13849_/Y VPWR VGND sg13cmos5l_o21ai_1
X_13781_ _13802_/A _13652_/A _13780_/B _13780_/Y VPWR VGND sg13cmos5l_a21oi_1
X_12801_ _12802_/B _18863_/Q _18864_/Q _18865_/Q VPWR VGND sg13cmos5l_o21ai_1
XFILLER_90_749 VPWR VGND sg13cmos5l_fill_1
X_10993_ _10993_/Y _10930_/B _11090_/B _10988_/Y VPWR VGND sg13cmos5l_a21oi_1
XFILLER_16_835 VPWR VGND sg13cmos5l_fill_2
X_12732_ _18887_/D _12732_/A _12732_/B VPWR VGND sg13cmos5l_nor2_1
XFILLER_55_481 VPWR VGND sg13cmos5l_fill_1
XFILLER_43_654 VPWR VGND sg13cmos5l_decap_8
X_15520_ _15520_/Y hold2059/X fanout74/X _15453_/A VPWR VGND sg13cmos5l_o21ai_1
XFILLER_43_665 VPWR VGND sg13cmos5l_fill_1
X_15451_ _15451_/Y _15451_/A _15451_/B VPWR VGND sg13cmos5l_nand2_1
XFILLER_30_304 VPWR VGND sg13cmos5l_fill_2
X_12663_ _12849_/A _12663_/A _12825_/A VPWR VGND sg13cmos5l_nor2_1
XFILLER_43_698 VPWR VGND sg13cmos5l_fill_1
XFILLER_15_389 VPWR VGND sg13cmos5l_fill_1
X_14402_ _14402_/Y _14402_/A _19108_/Q VPWR VGND sg13cmos5l_nor2_1
X_12594_ _12695_/C _12593_/A _12593_/B _12604_/A VPWR VGND sg13cmos5l_o21ai_1
X_11614_ _11616_/A _11614_/A _11614_/B VPWR VGND sg13cmos5l_nor2_1
X_18170_ _18180_/C _18170_/A VPWR VGND sg13cmos5l_inv_1
X_15382_ _15382_/X _15291_/X _15462_/B _15377_/Y VPWR VGND sg13cmos5l_a21o_1
XFILLER_11_540 VPWR VGND sg13cmos5l_decap_4
XFILLER_30_359 VPWR VGND sg13cmos5l_fill_1
X_11545_ _11565_/B _11513_/A _11522_/B _11543_/Y _11544_/Y _11513_/B VPWR VGND sg13cmos5l_a221oi_1
X_17121_ _17121_/Y _19518_/Q _17121_/B VPWR VGND sg13cmos5l_nor2_1
X_14333_ _14333_/Y _14331_/Y _14332_/Y _14319_/Y VPWR VGND sg13cmos5l_a21oi_1
X_17052_ _17062_/A _16957_/Y _17060_/A _17052_/C VPWR VGND sg13cmos5l_nand3b_1
X_11476_ _11476_/Y _11477_/B VPWR VGND sg13cmos5l_inv_1
X_14264_ _14271_/A _19142_/Q _14264_/B VPWR VGND sg13cmos5l_xor2_1
X_10427_ _10427_/Y input8/X input9/X _10673_/B VPWR VGND sg13cmos5l_a21oi_1
X_13215_ _13215_/Y _13213_/Y _13214_/Y _13212_/Y VPWR VGND sg13cmos5l_a21oi_1
XFILLER_7_588 VPWR VGND sg13cmos5l_fill_1
X_16003_ _16003_/Y _15963_/B _16001_/S _15864_/A VPWR VGND sg13cmos5l_o21ai_1
X_14195_ _14195_/Y _14195_/A _14199_/B VPWR VGND sg13cmos5l_nor2_1
X_13146_ _13151_/A _13170_/B _13145_/Y VPWR VGND sg13cmos5l_nor2b_1
X_10358_ _17392_/B _19560_/Q VPWR VGND sg13cmos5l_inv_1
X_10289_ _12210_/B _18772_/Q VPWR VGND sg13cmos5l_inv_1
X_13077_ _13077_/Y _13328_/A _13077_/B VPWR VGND sg13cmos5l_nand2_1
X_17954_ _17954_/X _17954_/A _17962_/C VPWR VGND sg13cmos5l_and2_1
XFILLER_3_794 VPWR VGND sg13cmos5l_fill_2
X_12028_ _12029_/B _12028_/A _12028_/B VPWR VGND sg13cmos5l_nor2_1
X_16905_ _16937_/A _19487_/Q _16905_/B VPWR VGND sg13cmos5l_xnor2_1
XFILLER_78_551 VPWR VGND sg13cmos5l_fill_2
X_19563__649 _19563_/RESET_B VPWR VGND sg13cmos5l_tiehi
X_17885_ _17886_/B _19666_/Q _17808_/B _17785_/Y VPWR VGND sg13cmos5l_a21oi_1
X_16836_ _16836_/Y _19535_/Q _16854_/A _10372_/Y _19536_/Q _16835_/Y VPWR VGND sg13cmos5l_a221oi_1
X_19624_ _19624_/Q clkload24/A _19624_/D _19624_/RESET_B VPWR VGND sg13cmos5l_dfrbpq_1
XFILLER_20_1022 VPWR VGND sg13cmos5l_decap_8
X_16767_ _16769_/B _16767_/A _16767_/B VPWR VGND sg13cmos5l_xor2_1
X_19555_ _19555_/Q clkload24/A _19555_/D _19555_/RESET_B VPWR VGND sg13cmos5l_dfrbpq_1
X_13979_ _13990_/B _19100_/Q _13980_/B VPWR VGND sg13cmos5l_nor2b_1
X_19486_ _19486_/Q _19546_/CLK _19486_/D _19486_/RESET_B VPWR VGND sg13cmos5l_dfrbpq_1
X_18506_ _18506_/Y _19764_/Q _18497_/Y _18505_/Y _19765_/Q VPWR VGND sg13cmos5l_a22oi_1
X_15718_ _15720_/A _15718_/A _15718_/B VPWR VGND sg13cmos5l_nor2_1
X_16698_ _16729_/A _17084_/A _16698_/B VPWR VGND sg13cmos5l_xnor2_1
XFILLER_92_90 VPWR VGND sg13cmos5l_fill_2
XFILLER_62_985 VPWR VGND sg13cmos5l_fill_2
XFILLER_62_963 VPWR VGND sg13cmos5l_decap_4
X_18437_ _18438_/A _18437_/A _18452_/A _18437_/C VPWR VGND sg13cmos5l_or3_1
XFILLER_33_131 VPWR VGND sg13cmos5l_decap_8
XFILLER_33_142 VPWR VGND sg13cmos5l_fill_2
X_15649_ _15649_/Y _15840_/A _15671_/B VPWR VGND sg13cmos5l_nor2_1
XFILLER_33_164 VPWR VGND sg13cmos5l_fill_1
X_18368_ _18368_/Y _18436_/B _18368_/B VPWR VGND sg13cmos5l_nand2_1
X_17319_ _17319_/Y _17341_/A _17376_/B _17377_/B _17209_/Y VPWR VGND sg13cmos5l_a22oi_1
X_18299_ _18299_/X _19697_/Q _18299_/B VPWR VGND sg13cmos5l_xor2_1
X_19748__428 _19748_/D VPWR VGND sg13cmos5l_tielo
X_18777__1498 _18777_/RESET_B VPWR VGND sg13cmos5l_tiehi
XFILLER_103_659 VPWR VGND sg13cmos5l_fill_2
Xhold2413 _18770_/D _11957_/Y VPWR VGND sg13cmos5l_dlygate4sd3_1
Xhold2402 _19515_/D _16878_/Y VPWR VGND sg13cmos5l_dlygate4sd3_1
XFILLER_69_540 VPWR VGND sg13cmos5l_fill_2
XFILLER_57_702 VPWR VGND sg13cmos5l_decap_8
Xhold2446 _10356_/A _19555_/Q VPWR VGND sg13cmos5l_dlygate4sd3_1
Xhold2435 _10115_/A _19292_/Q VPWR VGND sg13cmos5l_dlygate4sd3_1
Xhold2424 _19401_/D _16074_/Y VPWR VGND sg13cmos5l_dlygate4sd3_1
Xhold2457 _13016_/A _18870_/Q VPWR VGND sg13cmos5l_dlygate4sd3_1
Xhold2479 _10109_/A _19250_/Q VPWR VGND sg13cmos5l_dlygate4sd3_1
Xhold2468 _15316_/A _19301_/Q VPWR VGND sg13cmos5l_dlygate4sd3_1
XFILLER_96_392 VPWR VGND sg13cmos5l_decap_4
XFILLER_44_407 VPWR VGND sg13cmos5l_fill_2
X_18669__1624 _18669_/RESET_B VPWR VGND sg13cmos5l_tiehi
XFILLER_12_315 VPWR VGND sg13cmos5l_fill_2
XFILLER_40_646 VPWR VGND sg13cmos5l_fill_1
XFILLER_12_348 VPWR VGND sg13cmos5l_fill_2
X_18572__1730 _18572_/RESET_B VPWR VGND sg13cmos5l_tiehi
X_11330_ _11331_/B _11330_/A _11330_/B VPWR VGND sg13cmos5l_or2_1
XFILLER_21_42 VPWR VGND sg13cmos5l_fill_1
XFILLER_106_420 VPWR VGND sg13cmos5l_fill_2
X_18919__1347 _18919_/RESET_B VPWR VGND sg13cmos5l_tiehi
X_11261_ _11261_/Y _18663_/Q _11262_/B VPWR VGND sg13cmos5l_xnor2_1
X_13000_ _13001_/B _12972_/X _13007_/A _13020_/B VPWR VGND sg13cmos5l_a21oi_1
X_11192_ _11280_/B _11204_/B _11204_/C _11190_/Y VPWR VGND sg13cmos5l_a21o_1
XFILLER_4_569 VPWR VGND sg13cmos5l_fill_1
X_10212_ _10212_/Y _15764_/A VPWR VGND sg13cmos5l_inv_1
XFILLER_97_79 VPWR VGND sg13cmos5l_fill_1
XFILLER_97_57 VPWR VGND sg13cmos5l_fill_1
X_18615__1681 _18615_/RESET_B VPWR VGND sg13cmos5l_tiehi
X_10143_ _16340_/B _16415_/A VPWR VGND sg13cmos5l_inv_1
XFILLER_43_1022 VPWR VGND sg13cmos5l_decap_8
X_10074_ _14075_/A _13329_/A VPWR VGND sg13cmos5l_inv_1
X_14951_ _14951_/Y _15220_/A _14945_/B _14950_/A _15225_/B _14946_/Y VPWR VGND sg13cmos5l_a221oi_1
X_17670_ _19627_/D _17670_/A _17671_/B VPWR VGND sg13cmos5l_nor2_1
XFILLER_63_705 VPWR VGND sg13cmos5l_fill_1
X_13902_ _13902_/Y _13902_/A _13902_/B VPWR VGND sg13cmos5l_nor2_1
X_14882_ _14889_/A _14916_/B _14882_/B VPWR VGND sg13cmos5l_nor2_1
Xhold2991 _15041_/A _19237_/Q VPWR VGND sg13cmos5l_dlygate4sd3_1
X_16621_ _19479_/D _09976_/Y fanout69/X _16620_/Y VPWR VGND sg13cmos5l_a21oi_1
X_13833_ _13833_/Y _18978_/Q _13833_/B VPWR VGND sg13cmos5l_nand2_1
XFILLER_16_643 VPWR VGND sg13cmos5l_fill_1
X_16552_ _16552_/Y _16552_/A _16555_/B VPWR VGND sg13cmos5l_nor2_1
X_19340_ _19340_/Q clkload15/A _19340_/D _19340_/RESET_B VPWR VGND sg13cmos5l_dfrbpq_1
X_13764_ _13764_/Y _13762_/X _13794_/A VPWR VGND sg13cmos5l_nand2b_1
X_10976_ _10976_/Y _10911_/X _11086_/B _11087_/B _11036_/A VPWR VGND sg13cmos5l_a22oi_1
X_15503_ _15505_/A _19316_/Q _15500_/Y _15502_/Y _19317_/Q _15501_/Y VPWR VGND sg13cmos5l_a221oi_1
X_13695_ _13695_/Y _19039_/Q _16651_/A VPWR VGND sg13cmos5l_nor2_1
X_12715_ _18872_/D _12732_/A _12715_/B VPWR VGND sg13cmos5l_nor2_1
X_19192__1056 _19192_/RESET_B VPWR VGND sg13cmos5l_tiehi
X_19271_ _19271_/Q _19738_/CLK _19271_/D _19271_/RESET_B VPWR VGND sg13cmos5l_dfrbpq_1
X_16483_ _16483_/Y _19445_/Q _19406_/Q VPWR VGND sg13cmos5l_xnor2_1
X_12646_ _12833_/A _13017_/A _12824_/A VPWR VGND sg13cmos5l_nand2_1
X_18222_ _19709_/D _18222_/A _18227_/B VPWR VGND sg13cmos5l_nor2_1
X_15434_ _15435_/B _15434_/A _15434_/B VPWR VGND sg13cmos5l_xnor2_1
XFILLER_31_668 VPWR VGND sg13cmos5l_fill_1
X_15365_ _15365_/Y _19310_/Q _15366_/B VPWR VGND sg13cmos5l_xnor2_1
X_18153_ _18231_/B _18154_/B1 _18152_/Y _18151_/Y VPWR VGND sg13cmos5l_a21o_1
X_12577_ _18867_/D _12732_/A _12577_/B VPWR VGND sg13cmos5l_nor2_1
X_17104_ _17104_/Y _17122_/B _17667_/A _17122_/C VPWR VGND sg13cmos5l_nor3_1
X_14316_ _14336_/B _14314_/A _14314_/B _14315_/Y VPWR VGND sg13cmos5l_a21oi_1
X_11528_ _11560_/A _11528_/A _11534_/A VPWR VGND sg13cmos5l_xor2_1
X_18084_ _18085_/A _18201_/A _18084_/B VPWR VGND sg13cmos5l_or2_1
X_15296_ _15296_/Y _15297_/B VPWR VGND sg13cmos5l_inv_1
X_17035_ _17036_/A _17060_/A _17035_/B VPWR VGND sg13cmos5l_nand2_1
X_11459_ _11459_/X _11459_/A _11469_/B VPWR VGND sg13cmos5l_and2_1
XFILLER_7_99 VPWR VGND sg13cmos5l_decap_8
X_14247_ _14247_/Y _14262_/D _14248_/B _14441_/A VPWR VGND sg13cmos5l_a21oi_1
X_14178_ _14201_/A _14178_/A _14178_/B VPWR VGND sg13cmos5l_nor2_1
X_13129_ _18949_/D _13296_/A _13196_/A VPWR VGND sg13cmos5l_nor2_1
XFILLER_100_607 VPWR VGND sg13cmos5l_fill_2
XFILLER_98_668 VPWR VGND sg13cmos5l_fill_1
X_18986_ _18986_/Q clkload58/A _18986_/D _18986_/RESET_B VPWR VGND sg13cmos5l_dfrbpq_1
X_17937_ _19672_/D _17937_/A _17937_/B VPWR VGND sg13cmos5l_nor2_1
XFILLER_94_863 VPWR VGND sg13cmos5l_fill_1
X_17868_ _17868_/Y _17861_/A _17861_/B _17867_/X VPWR VGND sg13cmos5l_o21ai_1
X_16819_ _19500_/D _16819_/A _16823_/B VPWR VGND sg13cmos5l_nor2_1
X_19607_ _19607_/Q clkload35/A _19607_/D _19607_/RESET_B VPWR VGND sg13cmos5l_dfrbpq_1
X_17799_ _17799_/Y _17902_/B _17902_/C _17902_/A VPWR VGND sg13cmos5l_a21oi_1
XFILLER_35_941 VPWR VGND sg13cmos5l_decap_8
X_19538_ _19538_/Q clkload37/A _19538_/D _19538_/RESET_B VPWR VGND sg13cmos5l_dfrbpq_1
XFILLER_50_944 VPWR VGND sg13cmos5l_decap_8
X_19469_ _19469_/Q _19679_/CLK _19469_/D _19469_/RESET_B VPWR VGND sg13cmos5l_dfrbpq_1
XFILLER_35_996 VPWR VGND sg13cmos5l_fill_2
X_18995__1265 _18995_/RESET_B VPWR VGND sg13cmos5l_tiehi
X_19168__1080 _19168_/RESET_B VPWR VGND sg13cmos5l_tiehi
XFILLER_104_946 VPWR VGND sg13cmos5l_fill_1
XFILLER_104_935 VPWR VGND sg13cmos5l_fill_1
XFILLER_89_635 VPWR VGND sg13cmos5l_fill_2
XFILLER_27_1028 VPWR VGND sg13cmos5l_fill_1
XFILLER_103_467 VPWR VGND sg13cmos5l_fill_1
Xhold2221 _13308_/A _18936_/Q VPWR VGND sg13cmos5l_dlygate4sd3_1
Xhold2210 _10335_/A _19683_/Q VPWR VGND sg13cmos5l_dlygate4sd3_1
X_09986_ _09986_/Y _09986_/A VPWR VGND sg13cmos5l_inv_1
Xhold2243 _10326_/A _19724_/Q VPWR VGND sg13cmos5l_dlygate4sd3_1
Xhold2254 _10349_/A _19598_/Q VPWR VGND sg13cmos5l_dlygate4sd3_1
Xhold2232 _19314_/D _15513_/Y VPWR VGND sg13cmos5l_dlygate4sd3_1
X_18750__523 _18750_/D VPWR VGND sg13cmos5l_tielo
Xhold2276 _10284_/A _18812_/Q VPWR VGND sg13cmos5l_dlygate4sd3_1
Xhold2287 _18602_/D _10870_/Y VPWR VGND sg13cmos5l_dlygate4sd3_1
X_18603__1696 _18603_/RESET_B VPWR VGND sg13cmos5l_tiehi
Xhold2265 hold2265/X _17995_/Y VPWR VGND sg13cmos5l_dlygate4sd3_1
XFILLER_29_223 VPWR VGND sg13cmos5l_fill_2
Xhold2298 hold2298/X _14428_/Y VPWR VGND sg13cmos5l_dlygate4sd3_1
XFILLER_18_919 VPWR VGND sg13cmos5l_fill_1
XFILLER_57_598 VPWR VGND sg13cmos5l_fill_1
X_10830_ _10850_/C _10838_/C _10830_/B VPWR VGND sg13cmos5l_and2_1
X_10761_ _10801_/B _10774_/B _10760_/Y VPWR VGND sg13cmos5l_nor2b_1
XFILLER_73_1026 VPWR VGND sg13cmos5l_fill_2
X_12500_ _12503_/B _12498_/C _12499_/Y _12498_/Y VPWR VGND sg13cmos5l_a21o_1
X_10692_ _10692_/Y _10692_/A _19811_/Q VPWR VGND sg13cmos5l_nor2b_1
X_13480_ _13488_/B _14076_/A _13482_/B VPWR VGND sg13cmos5l_and2_1
XFILLER_40_421 VPWR VGND sg13cmos5l_fill_2
XFILLER_16_97 VPWR VGND sg13cmos5l_fill_1
X_12431_ _12431_/X _12437_/A _12450_/A VPWR VGND sg13cmos5l_and2_1
XFILLER_8_127 VPWR VGND sg13cmos5l_fill_1
XFILLER_8_116 VPWR VGND sg13cmos5l_decap_4
X_12362_ _12363_/A _12342_/A _12342_/B _12329_/B VPWR VGND sg13cmos5l_a21oi_1
X_15150_ _15152_/B _15019_/B _15191_/B _15156_/B VPWR VGND sg13cmos5l_mux2_1
X_12293_ _18821_/D _12460_/B _12293_/B VPWR VGND sg13cmos5l_nor2_1
X_11313_ _11313_/Y _11313_/A _11313_/B VPWR VGND sg13cmos5l_nand2_1
X_15081_ _15081_/Y _15121_/A VPWR VGND sg13cmos5l_inv_1
X_14101_ _14101_/X _14396_/A _14102_/B VPWR VGND sg13cmos5l_or2_1
X_11244_ _11245_/B _11624_/A _18666_/Q _11270_/B VPWR VGND sg13cmos5l_nand3_1
X_14032_ _14033_/A _14078_/B _14045_/S _14031_/Y VPWR VGND sg13cmos5l_a21o_1
X_18840_ _18840_/Q clkload62/A _18840_/D _18840_/RESET_B VPWR VGND sg13cmos5l_dfrbpq_1
X_11175_ _11175_/Y _10965_/A _11173_/X _11174_/Y VPWR VGND sg13cmos5l_a21oi_1
X_18771_ _18771_/Q clkload62/A _18771_/D _18771_/RESET_B VPWR VGND sg13cmos5l_dfrbpq_1
X_10126_ _16311_/A _10126_/A VPWR VGND sg13cmos5l_inv_1
X_15983_ _15993_/A _15880_/Y _15991_/A _15983_/C VPWR VGND sg13cmos5l_nand3b_1
X_10057_ _13289_/A _10057_/A VPWR VGND sg13cmos5l_inv_1
X_17722_ _17722_/Y _17944_/B _17719_/S _17721_/Y VPWR VGND sg13cmos5l_a21oi_1
X_14934_ _14941_/B _14948_/C _14933_/Y _14932_/Y VPWR VGND sg13cmos5l_o21ai_1
X_17653_ _19616_/D _17679_/A _17653_/B _17653_/C VPWR VGND sg13cmos5l_nor3_1
X_16604_ _16604_/Y _16586_/B fanout31/X _16655_/A VPWR VGND sg13cmos5l_o21ai_1
X_14865_ _14865_/Y _14865_/A VPWR VGND sg13cmos5l_inv_1
X_13816_ _19055_/D _13819_/A _13816_/B VPWR VGND sg13cmos5l_nor2_1
X_18950__1313 _18950_/RESET_B VPWR VGND sg13cmos5l_tiehi
X_17584_ _17675_/B _17585_/C _17585_/D VPWR VGND sg13cmos5l_and2_1
X_14796_ _14810_/A _19224_/Q _14796_/B VPWR VGND sg13cmos5l_xor2_1
X_13747_ _13785_/A _19050_/Q _13751_/B _13746_/Y VPWR VGND sg13cmos5l_a21oi_1
X_10959_ _10968_/B _18638_/Q _10960_/B VPWR VGND sg13cmos5l_nor2b_1
X_19323_ _19323_/Q clkload15/A _19323_/D _19323_/RESET_B VPWR VGND sg13cmos5l_dfrbpq_1
X_16535_ _16535_/Y _16523_/X _16528_/Y _16534_/Y VPWR VGND sg13cmos5l_a21oi_1
XFILLER_71_590 VPWR VGND sg13cmos5l_decap_8
X_19254_ _19254_/Q clkload44/A _19254_/D _19254_/RESET_B VPWR VGND sg13cmos5l_dfrbpq_1
X_16466_ _16466_/Y _16462_/X _16560_/B _16465_/Y VPWR VGND sg13cmos5l_o21ai_1
XFILLER_32_977 VPWR VGND sg13cmos5l_fill_1
X_13678_ _13678_/X _13678_/A _13678_/B _13678_/C VPWR VGND sg13cmos5l_or3_1
X_15417_ _15417_/X _15332_/Y _15416_/X _15414_/Y VPWR VGND sg13cmos5l_a21o_1
X_18205_ _18205_/Y _18205_/A _18205_/B VPWR VGND sg13cmos5l_nor2_1
X_12629_ _12629_/Y _12615_/Y _12622_/Y _12628_/Y VPWR VGND sg13cmos5l_o21ai_1
X_19185_ _19185_/Q _19227_/CLK _19185_/D _19185_/RESET_B VPWR VGND sg13cmos5l_dfrbpq_1
X_16397_ _16403_/A _16387_/X _16391_/Y _16402_/A _16463_/A _16396_/X VPWR VGND sg13cmos5l_a221oi_1
X_15348_ _15348_/Y _15378_/B _15346_/Y _15347_/Y _15351_/C VPWR VGND sg13cmos5l_a22oi_1
XFILLER_8_661 VPWR VGND sg13cmos5l_fill_1
X_18136_ _18229_/B _18154_/B1 _18135_/X _18134_/Y VPWR VGND sg13cmos5l_a21oi_1
X_15279_ _15279_/X _15263_/Y _15275_/Y _15278_/Y VPWR VGND sg13cmos5l_a21o_1
XFILLER_7_160 VPWR VGND sg13cmos5l_fill_1
X_18067_ _19698_/D _18067_/A _18169_/B VPWR VGND sg13cmos5l_nor2_1
X_17018_ _17018_/Y _17008_/Y _17014_/Y _17017_/Y VPWR VGND sg13cmos5l_o21ai_1
XFILLER_98_421 VPWR VGND sg13cmos5l_fill_1
XFILLER_99_966 VPWR VGND sg13cmos5l_fill_1
X_18969_ _18969_/Q clkload65/A _18969_/D _18969_/RESET_B VPWR VGND sg13cmos5l_dfrbpq_1
XFILLER_100_459 VPWR VGND sg13cmos5l_decap_4
XFILLER_100_448 VPWR VGND sg13cmos5l_fill_1
X_19721__431 _19721_/D VPWR VGND sg13cmos5l_tielo
XFILLER_96_1026 VPWR VGND sg13cmos5l_fill_2
XFILLER_23_922 VPWR VGND sg13cmos5l_fill_1
XFILLER_62_590 VPWR VGND sg13cmos5l_fill_1
XFILLER_23_966 VPWR VGND sg13cmos5l_fill_2
X_19739__1095 _19739_/RESET_B VPWR VGND sg13cmos5l_tiehi
XFILLER_50_796 VPWR VGND sg13cmos5l_fill_1
XFILLER_22_498 VPWR VGND sg13cmos5l_fill_2
XFILLER_2_815 VPWR VGND sg13cmos5l_fill_2
XFILLER_1_303 VPWR VGND sg13cmos5l_fill_1
XFILLER_2_826 VPWR VGND sg13cmos5l_fill_2
XFILLER_104_743 VPWR VGND sg13cmos5l_fill_2
XFILLER_77_605 VPWR VGND sg13cmos5l_fill_2
X_09969_ _09969_/Y _09969_/A VPWR VGND sg13cmos5l_inv_1
Xhold2062 _18766_/D _11949_/Y VPWR VGND sg13cmos5l_dlygate4sd3_1
Xhold2040 _13045_/A _18892_/Q VPWR VGND sg13cmos5l_dlygate4sd3_1
Xhold2051 _19443_/D _16371_/Y VPWR VGND sg13cmos5l_dlygate4sd3_1
XFILLER_100_971 VPWR VGND sg13cmos5l_fill_2
Xhold2095 _18575_/D _10737_/Y VPWR VGND sg13cmos5l_dlygate4sd3_1
X_12980_ _12980_/Y _12971_/Y _12973_/Y _12976_/Y _12978_/Y _12979_/Y VPWR VGND sg13cmos5l_a221oi_1
Xhold2073 _19773_/D _18538_/Y VPWR VGND sg13cmos5l_dlygate4sd3_1
X_19208__1037 _19208_/RESET_B VPWR VGND sg13cmos5l_tiehi
Xhold2084 _10094_/A _19127_/Q VPWR VGND sg13cmos5l_dlygate4sd3_1
X_11931_ _11931_/Y _10286_/Y _11925_/A _11929_/A _12215_/A _11930_/Y VPWR VGND sg13cmos5l_a221oi_1
XFILLER_73_855 VPWR VGND sg13cmos5l_fill_1
XFILLER_27_63 VPWR VGND sg13cmos5l_decap_4
X_11862_ _11862_/Y _11850_/Y _11853_/Y _11863_/A _11863_/B VPWR VGND sg13cmos5l_a22oi_1
X_14650_ _14650_/Y _15187_/A _19149_/Q VPWR VGND sg13cmos5l_nor2_1
X_13601_ _13602_/A _13601_/A _13601_/B VPWR VGND sg13cmos5l_nand2_1
X_10813_ _18586_/D _18558_/A _18558_/B VPWR VGND sg13cmos5l_nor2_1
X_14581_ _14581_/Y _14611_/A _14648_/B _14580_/Y VPWR VGND sg13cmos5l_o21ai_1
XFILLER_26_782 VPWR VGND sg13cmos5l_fill_2
X_11793_ _11796_/A _18763_/Q _11793_/B VPWR VGND sg13cmos5l_xnor2_1
X_13532_ _13533_/B _13450_/A _13450_/B _13427_/Y VPWR VGND sg13cmos5l_a21oi_1
XFILLER_43_40 VPWR VGND sg13cmos5l_fill_2
X_16320_ _19436_/D _16320_/A _16320_/B VPWR VGND sg13cmos5l_nor2_1
X_10744_ _10744_/Y input4/X fanout68/X _10746_/A VPWR VGND sg13cmos5l_o21ai_1
XFILLER_9_414 VPWR VGND sg13cmos5l_fill_2
X_10675_ _10679_/B _10678_/A VPWR VGND sg13cmos5l_inv_1
X_13463_ _13463_/Y _19012_/Q _19011_/Q _18996_/Q VPWR VGND sg13cmos5l_nand3b_1
XFILLER_43_95 VPWR VGND sg13cmos5l_fill_2
X_16251_ _16319_/B _16220_/Y _16248_/X _16250_/X VPWR VGND sg13cmos5l_a21oi_1
X_12414_ _12415_/C _12414_/A _12414_/B VPWR VGND sg13cmos5l_or2_1
X_13394_ _13421_/A _13394_/A _13394_/B VPWR VGND sg13cmos5l_nor2_1
X_16182_ _16182_/X _16433_/A _16244_/A VPWR VGND sg13cmos5l_or2_1
X_15202_ _15202_/Y _15740_/A _19232_/Q _15201_/Y VPWR VGND sg13cmos5l_a21oi_1
X_12345_ _12345_/X _12345_/A _12345_/B VPWR VGND sg13cmos5l_xor2_1
X_15133_ _15134_/B _15192_/B _15156_/B _15132_/Y VPWR VGND sg13cmos5l_a21oi_1
X_12276_ _12307_/A _12276_/A _12276_/B VPWR VGND sg13cmos5l_xnor2_1
X_15064_ _15067_/B _19248_/Q _19263_/Q VPWR VGND sg13cmos5l_nand2_1
X_11227_ _11227_/Y _11323_/B _11323_/C _11323_/A VPWR VGND sg13cmos5l_a21oi_1
X_14015_ _14015_/Y _14001_/Y _14008_/Y _14014_/Y VPWR VGND sg13cmos5l_o21ai_1
X_18823_ _18823_/Q clkload70/A _18823_/D _18823_/RESET_B VPWR VGND sg13cmos5l_dfrbpq_1
XFILLER_68_627 VPWR VGND sg13cmos5l_fill_1
XFILLER_67_104 VPWR VGND sg13cmos5l_fill_1
X_11158_ _11159_/C _18611_/Q _18612_/Q _18613_/Q VPWR VGND sg13cmos5l_o21ai_1
X_10109_ _15456_/A _10109_/A VPWR VGND sg13cmos5l_inv_1
X_18754_ _18754_/Q clkload40/A _18754_/D _18754_/RESET_B VPWR VGND sg13cmos5l_dfrbpq_1
X_11089_ _18636_/D _11089_/A _11089_/B VPWR VGND sg13cmos5l_nor2_1
X_15966_ _15967_/A _15991_/A _15966_/B VPWR VGND sg13cmos5l_nand2_1
X_18685_ _18685_/Q clkload59/A _18685_/D _18685_/RESET_B VPWR VGND sg13cmos5l_dfrbpq_1
X_17705_ _17707_/B _17969_/A _17705_/B VPWR VGND sg13cmos5l_nor2_1
X_15897_ _15897_/X _15904_/B _15902_/B _16090_/A VPWR VGND sg13cmos5l_a21o_1
X_14917_ _14917_/Y _19187_/Q _19249_/Q VPWR VGND sg13cmos5l_nand2b_1
X_19757__825 _19757_/RESET_B VPWR VGND sg13cmos5l_tiehi
X_17636_ _17636_/Y _17633_/Y _17635_/Y _17620_/Y VPWR VGND sg13cmos5l_a21oi_1
X_14848_ _14848_/Y _14850_/A _14916_/B VPWR VGND sg13cmos5l_nor2_1
X_17567_ _17573_/B _17613_/A VPWR VGND sg13cmos5l_inv_1
XFILLER_51_538 VPWR VGND sg13cmos5l_fill_1
X_19306_ _19306_/Q _19308_/CLK _19306_/D _19306_/RESET_B VPWR VGND sg13cmos5l_dfrbpq_1
X_14779_ _14779_/Y _14779_/A _14779_/B _14883_/B VPWR VGND sg13cmos5l_nor3_1
X_16518_ _16518_/Y _16532_/A _16518_/B VPWR VGND sg13cmos5l_nand2_1
X_17498_ _19613_/D _17678_/A _17498_/B VPWR VGND sg13cmos5l_nor2_1
XFILLER_17_1016 VPWR VGND sg13cmos5l_decap_8
XFILLER_17_1027 VPWR VGND sg13cmos5l_fill_2
XFILLER_104_1008 VPWR VGND sg13cmos5l_fill_1
X_18914__1352 _18914_/RESET_B VPWR VGND sg13cmos5l_tiehi
X_16449_ _16452_/C _19409_/Q _16457_/C _16457_/D VPWR VGND sg13cmos5l_nand3_1
XFILLER_20_936 VPWR VGND sg13cmos5l_fill_1
X_19237_ _19237_/Q _19302_/CLK _19237_/D _19237_/RESET_B VPWR VGND sg13cmos5l_dfrbpq_1
XFILLER_31_273 VPWR VGND sg13cmos5l_fill_1
X_19168_ _19168_/Q clkload50/A _19168_/D _19168_/RESET_B VPWR VGND sg13cmos5l_dfrbpq_1
XFILLER_20_969 VPWR VGND sg13cmos5l_fill_1
X_18119_ _18150_/A _18474_/A _18119_/B VPWR VGND sg13cmos5l_xnor2_1
X_18701__528 _18701_/D VPWR VGND sg13cmos5l_tielo
X_19099_ _19099_/Q clkload54/A _19099_/D _19099_/RESET_B VPWR VGND sg13cmos5l_dfrbpq_1
XFILLER_87_958 VPWR VGND sg13cmos5l_fill_1
XFILLER_95_991 VPWR VGND sg13cmos5l_fill_1
Xfanout22 _17928_/S _17917_/Y VPWR VGND sg13cmos5l_buf_1
Xfanout55 fanout55/X _11945_/Y VPWR VGND sg13cmos5l_buf_1
Xfanout44 _14062_/S _14057_/Y VPWR VGND sg13cmos5l_buf_1
Xfanout33 fanout33/X _16536_/Y VPWR VGND sg13cmos5l_buf_1
Xfanout99 fanout99/X _10719_/Y VPWR VGND sg13cmos5l_buf_1
Xfanout88 fanout88/X fanout89/X VPWR VGND sg13cmos5l_buf_1
Xfanout77 fanout77/X fanout79/X VPWR VGND sg13cmos5l_buf_1
Xfanout66 fanout66/X fanout71/X VPWR VGND sg13cmos5l_buf_1
XFILLER_7_907 VPWR VGND sg13cmos5l_decap_4
X_10460_ _10461_/B _19797_/Q _10621_/B VPWR VGND sg13cmos5l_nor2_1
XFILLER_89_36 VPWR VGND sg13cmos5l_fill_1
X_10391_ _10392_/B _10391_/A _18562_/Q _18561_/Q VPWR VGND sg13cmos5l_nor3_1
X_12130_ _12130_/Y _12130_/A _12136_/B VPWR VGND sg13cmos5l_nor2_1
XFILLER_104_540 VPWR VGND sg13cmos5l_decap_4
X_12061_ _12265_/B _18789_/Q _12062_/B VPWR VGND sg13cmos5l_xnor2_1
X_11012_ _11042_/A _18628_/Q _11013_/B VPWR VGND sg13cmos5l_xnor2_1
XFILLER_77_446 VPWR VGND sg13cmos5l_fill_1
X_15820_ _15820_/Y _15847_/A _15818_/X _15819_/X _16011_/A VPWR VGND sg13cmos5l_a22oi_1
X_12963_ _12963_/Y _12986_/A _13027_/B _12962_/Y VPWR VGND sg13cmos5l_a21oi_1
XFILLER_79_1010 VPWR VGND sg13cmos5l_fill_1
XFILLER_45_310 VPWR VGND sg13cmos5l_fill_2
X_15751_ _15751_/Y _19375_/Q _10212_/Y _10213_/Y _19374_/Q VPWR VGND sg13cmos5l_a22oi_1
X_11914_ _11915_/B _18792_/Q _11922_/B _18729_/Q _12461_/A VPWR VGND sg13cmos5l_a22oi_1
X_18990__1270 _18990_/RESET_B VPWR VGND sg13cmos5l_tiehi
X_18470_ _19749_/D _18470_/A _18470_/B VPWR VGND sg13cmos5l_and2_1
X_15682_ _15748_/B _15615_/Y _15681_/B _15656_/B _15647_/A VPWR VGND sg13cmos5l_a22oi_1
Xclkbuf_leaf_84_clk clkload16/A clkbuf_4_2_0_clk/X VPWR VGND sg13cmos5l_buf_8
X_14702_ _14702_/Y _19193_/Q fanout90/X _14708_/A VPWR VGND sg13cmos5l_o21ai_1
X_19778__560 _19778_/RESET_B VPWR VGND sg13cmos5l_tiehi
X_12894_ _12896_/B _18912_/Q _18927_/Q VPWR VGND sg13cmos5l_nand2_1
XFILLER_73_696 VPWR VGND sg13cmos5l_fill_2
X_17421_ _17421_/Y _17396_/B fanout25/X _17677_/A VPWR VGND sg13cmos5l_o21ai_1
X_14633_ _19168_/D hold2818/X _14628_/S _14632_/Y VPWR VGND sg13cmos5l_a21oi_1
X_11845_ _11846_/B _11903_/B _11867_/B _11844_/Y VPWR VGND sg13cmos5l_a21oi_1
XFILLER_14_730 VPWR VGND sg13cmos5l_fill_2
XFILLER_14_741 VPWR VGND sg13cmos5l_fill_1
X_11776_ _11820_/A _18759_/Q _18760_/Q _18761_/Q VPWR VGND sg13cmos5l_or3_1
X_17352_ _17352_/Y _17328_/X fanout26/X _17375_/A VPWR VGND sg13cmos5l_o21ai_1
X_14564_ _14564_/Y _14564_/A _14578_/B VPWR VGND sg13cmos5l_nand2_1
X_10727_ _18571_/D _10703_/Y fanout99/X _10726_/Y VPWR VGND sg13cmos5l_a21oi_1
X_17283_ _17284_/B _17316_/B _17283_/B VPWR VGND sg13cmos5l_nor2_1
X_13515_ _13515_/X _13519_/S _13513_/Y _13512_/Y VPWR VGND sg13cmos5l_a21o_1
X_16303_ _16303_/Y _16291_/B _16305_/S _16308_/B VPWR VGND sg13cmos5l_o21ai_1
X_14495_ _14495_/Y _19152_/Q _19113_/Q VPWR VGND sg13cmos5l_xnor2_1
X_19039__1218 _19039_/RESET_B VPWR VGND sg13cmos5l_tiehi
X_19022_ _19022_/Q clkload32/A _19022_/D _19022_/RESET_B VPWR VGND sg13cmos5l_dfrbpq_1
X_13446_ _13448_/B _13554_/A _13553_/A VPWR VGND sg13cmos5l_nor2_1
X_16234_ _16234_/Y _16233_/A _16233_/B _16233_/C _16233_/D VPWR VGND sg13cmos5l_a22oi_1
X_10658_ _10658_/Y _10658_/A _10658_/B VPWR VGND sg13cmos5l_nor2_1
Xclkload25 clkload25/Y clkload25/A VPWR VGND sg13cmos5l_inv_4
XFILLER_6_940 VPWR VGND sg13cmos5l_fill_1
Xclkload14 clkload14/Y clkload14/A VPWR VGND sg13cmos5l_inv_2
Xclkload69 clkload69/Y clkload69/A VPWR VGND sg13cmos5l_inv_4
X_18562__1748 _18562_/RESET_B VPWR VGND sg13cmos5l_tiehi
Xclkload36 clkload36/Y clkload36/A VPWR VGND sg13cmos5l_inv_8
X_13377_ _13377_/X _13377_/A _13414_/A VPWR VGND sg13cmos5l_and2_1
Xclkload58 clkload58/Y clkload58/A VPWR VGND sg13cmos5l_inv_2
Xclkload47 clkload47/Y clkload47/A VPWR VGND sg13cmos5l_inv_1
X_16165_ _16287_/A _19429_/Q _16167_/B VPWR VGND sg13cmos5l_nor2_1
X_10589_ _10592_/A _10589_/A _10589_/B VPWR VGND sg13cmos5l_nor2_1
X_12328_ _12335_/A _12364_/A _12329_/B _12322_/Y _12326_/Y _12327_/Y VPWR VGND sg13cmos5l_a221oi_1
X_15116_ _15192_/B _15115_/X _15114_/Y _15121_/C VPWR VGND sg13cmos5l_mux2_1
XFILLER_6_995 VPWR VGND sg13cmos5l_fill_1
X_16096_ _16096_/Y _16091_/X _16095_/Y _16090_/X VPWR VGND sg13cmos5l_a21oi_1
X_12259_ _18818_/D _12527_/A _12259_/B VPWR VGND sg13cmos5l_and2_1
XFILLER_5_494 VPWR VGND sg13cmos5l_decap_4
X_15047_ _15160_/A _19261_/Q _15053_/B VPWR VGND sg13cmos5l_nor2_1
Xhold2809 hold2809/X _11334_/A VPWR VGND sg13cmos5l_dlygate4sd3_1
XFILLER_69_969 VPWR VGND sg13cmos5l_fill_2
X_18806_ _18806_/Q clkload61/A _18806_/D _18806_/RESET_B VPWR VGND sg13cmos5l_dfrbpq_1
X_16998_ _16998_/Y _16998_/A _16998_/B _16998_/C VPWR VGND sg13cmos5l_nor3_1
X_19786_ _19786_/Q _19790_/CLK _19786_/D _19786_/RESET_B VPWR VGND sg13cmos5l_dfrbpq_1
X_18737_ _18737_/Q _18750_/CLK _18737_/D _18737_/RESET_B VPWR VGND sg13cmos5l_dfrbpq_1
X_15949_ _15949_/Y _15933_/Y _15945_/Y _15948_/Y VPWR VGND sg13cmos5l_o21ai_1
XFILLER_48_181 VPWR VGND sg13cmos5l_fill_1
Xclkbuf_leaf_75_clk clkload44/A clkbuf_4_8_0_clk/X VPWR VGND sg13cmos5l_buf_8
XFILLER_36_321 VPWR VGND sg13cmos5l_decap_4
XFILLER_36_343 VPWR VGND sg13cmos5l_fill_2
XFILLER_36_354 VPWR VGND sg13cmos5l_fill_1
XFILLER_63_140 VPWR VGND sg13cmos5l_decap_4
X_18668_ _18668_/Q clkload55/A _18668_/D _18668_/RESET_B VPWR VGND sg13cmos5l_dfrbpq_1
XFILLER_37_888 VPWR VGND sg13cmos5l_fill_1
X_17619_ _17658_/A _17493_/B _17639_/B _17618_/Y VPWR VGND sg13cmos5l_a21oi_1
X_18599_ _18599_/Q clkload55/A _18599_/D _18599_/RESET_B VPWR VGND sg13cmos5l_dfrbpq_1
Xclkload8 clkload8/Y clkload8/A VPWR VGND sg13cmos5l_inv_2
XFILLER_59_39 VPWR VGND sg13cmos5l_decap_4
Xfanout223 _17091_/A _17071_/A VPWR VGND sg13cmos5l_buf_1
Xfanout201 _18483_/A _18273_/Y VPWR VGND sg13cmos5l_buf_1
Xfanout212 _17770_/A _17717_/Y VPWR VGND sg13cmos5l_buf_1
X_18745__1533 _18745_/RESET_B VPWR VGND sg13cmos5l_tiehi
Xfanout256 _15185_/B _14956_/Y VPWR VGND sg13cmos5l_buf_1
Xfanout245 _15586_/A _15507_/Y VPWR VGND sg13cmos5l_buf_1
Xfanout234 _16553_/B _16358_/Y VPWR VGND sg13cmos5l_buf_1
Xfanout278 _13813_/B _13817_/A VPWR VGND sg13cmos5l_buf_1
XFILLER_86_265 VPWR VGND sg13cmos5l_fill_1
Xfanout289 _13027_/A _13025_/A VPWR VGND sg13cmos5l_buf_1
Xfanout267 _14371_/B _14376_/A VPWR VGND sg13cmos5l_buf_1
XFILLER_67_490 VPWR VGND sg13cmos5l_fill_1
Xclkbuf_leaf_66_clk _19220_/CLK clkbuf_4_10_0_clk/X VPWR VGND sg13cmos5l_buf_8
XFILLER_27_365 VPWR VGND sg13cmos5l_fill_1
XFILLER_54_173 VPWR VGND sg13cmos5l_fill_2
XFILLER_42_335 VPWR VGND sg13cmos5l_fill_1
X_11630_ _18721_/D _11630_/A _11630_/B VPWR VGND sg13cmos5l_and2_1
XFILLER_70_677 VPWR VGND sg13cmos5l_fill_1
XFILLER_24_31 VPWR VGND sg13cmos5l_fill_1
X_11561_ _11629_/B _11560_/B _11736_/A _11560_/Y VPWR VGND sg13cmos5l_o21ai_1
XFILLER_23_593 VPWR VGND sg13cmos5l_fill_2
X_13300_ _13300_/Y _13476_/C _10262_/Y _10263_/Y _18996_/Q VPWR VGND sg13cmos5l_a22oi_1
XFILLER_11_744 VPWR VGND sg13cmos5l_fill_1
X_10512_ _10512_/Y _10564_/A _10512_/B VPWR VGND sg13cmos5l_nand2_1
X_11492_ _11589_/A _18712_/Q _11503_/B _11583_/A VPWR VGND sg13cmos5l_a21o_1
XFILLER_7_759 VPWR VGND sg13cmos5l_fill_2
XFILLER_6_203 VPWR VGND sg13cmos5l_decap_8
X_14280_ _14282_/D _14277_/A _14277_/B _14279_/Y VPWR VGND sg13cmos5l_o21ai_1
X_10443_ _21225_/A _10795_/C _10443_/B _10443_/C _10443_/D VPWR VGND sg13cmos5l_nor4_1
X_13231_ _13265_/A _13228_/Y _13230_/X _13229_/Y VPWR VGND sg13cmos5l_o21ai_1
X_10374_ _16564_/B _16573_/A VPWR VGND sg13cmos5l_inv_1
X_13162_ _13162_/X _18969_/Q _18970_/Q VPWR VGND sg13cmos5l_xor2_1
X_12113_ _12116_/D _12104_/A _12104_/B _12112_/Y VPWR VGND sg13cmos5l_o21ai_1
XFILLER_2_420 VPWR VGND sg13cmos5l_fill_1
X_13093_ _13093_/Y _12932_/A _18906_/Q VPWR VGND sg13cmos5l_nand2b_1
X_17970_ _17970_/Y _18474_/A _19706_/Q _17975_/C VPWR VGND sg13cmos5l_nor3_1
X_12044_ _12045_/B _12153_/B _12153_/C _12153_/A VPWR VGND sg13cmos5l_a21oi_1
X_16921_ _19525_/D _16939_/A _17040_/A VPWR VGND sg13cmos5l_and2_1
XFILLER_2_486 VPWR VGND sg13cmos5l_fill_1
X_16852_ _16852_/X _16852_/A _16852_/B VPWR VGND sg13cmos5l_or2_1
X_19640_ _19640_/Q _19756_/CLK _19640_/D _19640_/RESET_B VPWR VGND sg13cmos5l_dfrbpq_1
XFILLER_38_619 VPWR VGND sg13cmos5l_fill_1
X_16783_ _16783_/Y _16783_/A VPWR VGND sg13cmos5l_inv_1
X_19571_ _19571_/Q _19814_/CLK _19571_/D _19571_/RESET_B VPWR VGND sg13cmos5l_dfrbpq_1
X_15803_ _15803_/Y _09989_/Y fanout83/X _15802_/Y VPWR VGND sg13cmos5l_a21oi_1
X_18522_ _18522_/X _18497_/Y _10322_/Y _18530_/S VPWR VGND sg13cmos5l_mux2_1
Xclkbuf_leaf_57_clk clkload45/A clkbuf_4_9_0_clk/X VPWR VGND sg13cmos5l_buf_8
XFILLER_46_630 VPWR VGND sg13cmos5l_fill_1
X_15734_ _15734_/Y _15718_/B _15722_/Y _15733_/Y VPWR VGND sg13cmos5l_a21oi_1
X_13995_ _14079_/B _13960_/Y _14186_/A _14010_/B VPWR VGND sg13cmos5l_mux2_1
X_12946_ _12946_/Y _12931_/Y _12938_/Y _12944_/Y _12977_/A _12945_/Y VPWR VGND sg13cmos5l_a221oi_1
XFILLER_18_365 VPWR VGND sg13cmos5l_fill_2
X_12877_ _12993_/A _12860_/A _12875_/B _12876_/Y VPWR VGND sg13cmos5l_a21o_1
X_18453_ _18453_/Y _18453_/A _18453_/B VPWR VGND sg13cmos5l_nor2_1
X_15665_ _15665_/X _15678_/A _15663_/Y _15662_/Y VPWR VGND sg13cmos5l_a21o_1
X_11828_ _11903_/B _11833_/B _12017_/A _11827_/Y VPWR VGND sg13cmos5l_a21oi_1
X_17404_ _17404_/Y _17934_/A _19622_/Q VPWR VGND sg13cmos5l_nor2_1
X_14616_ _14617_/B _14616_/A _14616_/B VPWR VGND sg13cmos5l_or2_1
X_15596_ _15701_/C _19321_/Q _19282_/Q _19341_/Q VPWR VGND sg13cmos5l_nand3_1
X_18384_ _18388_/B _18384_/A _18409_/A VPWR VGND sg13cmos5l_nor2_1
XFILLER_33_368 VPWR VGND sg13cmos5l_decap_8
X_17335_ _17335_/Y _17335_/A _17335_/B _17335_/C VPWR VGND sg13cmos5l_nor3_1
X_14547_ _14557_/B _19184_/Q _14548_/B VPWR VGND sg13cmos5l_nand2b_1
X_11759_ _11760_/B _11858_/B _11858_/C _11858_/A VPWR VGND sg13cmos5l_a21oi_1
X_17266_ _17266_/Y _17255_/X _17258_/X _17264_/Y VPWR VGND sg13cmos5l_o21ai_1
X_14478_ _14478_/Y _14478_/A _14478_/B VPWR VGND sg13cmos5l_nor2_1
X_19721__1410 _19721_/RESET_B VPWR VGND sg13cmos5l_tiehi
X_17197_ _17197_/Y _17198_/B VPWR VGND sg13cmos5l_inv_1
X_19005_ _19005_/Q clkload66/A _19005_/D _19005_/RESET_B VPWR VGND sg13cmos5l_dfrbpq_1
X_13429_ _13429_/Y _18984_/Q _18945_/Q VPWR VGND sg13cmos5l_xnor2_1
X_16217_ _16222_/B _16550_/A _16248_/B VPWR VGND sg13cmos5l_and2_1
X_16148_ _16148_/Y _19403_/Q _19364_/Q VPWR VGND sg13cmos5l_xnor2_1
X_19203__1042 _19203_/RESET_B VPWR VGND sg13cmos5l_tiehi
X_16079_ _16079_/Y hold2031/X fanout66/X _16081_/A VPWR VGND sg13cmos5l_o21ai_1
Xhold2617 _10042_/A _18792_/Q VPWR VGND sg13cmos5l_dlygate4sd3_1
Xhold2628 _10373_/A _19021_/Q VPWR VGND sg13cmos5l_dlygate4sd3_1
Xhold2606 _16964_/A _19540_/Q VPWR VGND sg13cmos5l_dlygate4sd3_1
XFILLER_68_210 VPWR VGND sg13cmos5l_decap_4
XFILLER_96_563 VPWR VGND sg13cmos5l_fill_2
Xhold1927 _10672_/B _10671_/Y VPWR VGND sg13cmos5l_dlygate4sd3_1
XFILLER_60_1028 VPWR VGND sg13cmos5l_fill_1
Xhold1916 _13877_/B _18986_/Q VPWR VGND sg13cmos5l_dlygate4sd3_1
Xhold2639 _10215_/A _19316_/Q VPWR VGND sg13cmos5l_dlygate4sd3_1
Xhold1905 _15527_/B _19281_/Q VPWR VGND sg13cmos5l_dlygate4sd3_1
Xinput1 input1/X rst_n VPWR VGND sg13cmos5l_buf_1
Xhold1949 _10384_/A _18568_/Q VPWR VGND sg13cmos5l_dlygate4sd3_1
Xhold1938 _18690_/D _11419_/Y VPWR VGND sg13cmos5l_dlygate4sd3_1
Xclkbuf_leaf_48_clk clkload63/A clkbuf_4_14_0_clk/X VPWR VGND sg13cmos5l_buf_8
X_19769_ _19769_/Q clkload45/A _19769_/D _19769_/RESET_B VPWR VGND sg13cmos5l_dfrbpq_1
XFILLER_37_630 VPWR VGND sg13cmos5l_fill_1
XFILLER_36_162 VPWR VGND sg13cmos5l_decap_8
XFILLER_36_173 VPWR VGND sg13cmos5l_fill_1
XFILLER_24_346 VPWR VGND sg13cmos5l_fill_1
XFILLER_101_69 VPWR VGND sg13cmos5l_fill_1
X_18963__1300 _18963_/RESET_B VPWR VGND sg13cmos5l_tiehi
XFILLER_106_635 VPWR VGND sg13cmos5l_decap_8
XFILLER_3_228 VPWR VGND sg13cmos5l_fill_1
XFILLER_105_178 VPWR VGND sg13cmos5l_fill_2
XFILLER_59_221 VPWR VGND sg13cmos5l_fill_2
XFILLER_0_957 VPWR VGND sg13cmos5l_decap_8
X_10090_ _14640_/A _10090_/A VPWR VGND sg13cmos5l_inv_1
XFILLER_0_968 VPWR VGND sg13cmos5l_fill_2
XFILLER_102_896 VPWR VGND sg13cmos5l_decap_8
XFILLER_75_714 VPWR VGND sg13cmos5l_fill_1
X_12800_ _12844_/A _18866_/Q _12814_/D VPWR VGND sg13cmos5l_xor2_1
XFILLER_90_706 VPWR VGND sg13cmos5l_fill_2
Xclkbuf_leaf_39_clk clkload59/A clkload3/A VPWR VGND sg13cmos5l_buf_8
X_18709__1572 _18709_/RESET_B VPWR VGND sg13cmos5l_tiehi
X_13780_ _13780_/Y _13780_/A _13780_/B VPWR VGND sg13cmos5l_nor2_1
X_18901__1366 _18901_/RESET_B VPWR VGND sg13cmos5l_tiehi
X_10992_ _11090_/B _10992_/A _10992_/B VPWR VGND sg13cmos5l_and2_1
XFILLER_27_151 VPWR VGND sg13cmos5l_fill_2
X_12731_ _18886_/D _12732_/A _12731_/B VPWR VGND sg13cmos5l_nor2_1
XFILLER_43_622 VPWR VGND sg13cmos5l_decap_8
XFILLER_35_41 VPWR VGND sg13cmos5l_fill_1
X_12662_ _12662_/Y _12650_/Y _12656_/X _12661_/Y VPWR VGND sg13cmos5l_o21ai_1
X_15450_ _19294_/D hold2470/X _15447_/S _15449_/Y VPWR VGND sg13cmos5l_a21oi_1
X_11613_ _18705_/D _11628_/A _11613_/B _11613_/C VPWR VGND sg13cmos5l_nor3_1
X_14401_ _14401_/Y _10235_/Y _14395_/A _14399_/A _10236_/Y _14400_/Y VPWR VGND sg13cmos5l_a221oi_1
X_19079__1175 _19079_/RESET_B VPWR VGND sg13cmos5l_tiehi
X_12593_ _12605_/A _12593_/A _12593_/B VPWR VGND sg13cmos5l_nor2_1
X_17120_ _17120_/Y _19556_/Q _17109_/Y _17119_/Y _19557_/Q _17115_/Y VPWR VGND sg13cmos5l_a221oi_1
X_19753__872 _19753_/RESET_B VPWR VGND sg13cmos5l_tiehi
X_15381_ _15462_/B _15395_/S _15570_/A _15378_/Y VPWR VGND sg13cmos5l_a21o_1
XFILLER_30_349 VPWR VGND sg13cmos5l_fill_1
X_11544_ _11544_/Y _11511_/X _11713_/A _11525_/B _11527_/Y _11548_/B VPWR VGND sg13cmos5l_a221oi_1
X_14332_ _14332_/Y _14319_/A _14319_/B _14323_/A _14323_/B VPWR VGND sg13cmos5l_a22oi_1
X_17051_ _17051_/Y _17051_/A _17051_/B _17051_/C VPWR VGND sg13cmos5l_nand3_1
X_11475_ _11477_/B _11473_/B _11474_/Y _11473_/Y VPWR VGND sg13cmos5l_a21oi_1
X_19749__919 _19749_/RESET_B VPWR VGND sg13cmos5l_tiehi
X_14263_ _14310_/A _14263_/A _14264_/B VPWR VGND sg13cmos5l_xnor2_1
X_10426_ _10426_/Y _10426_/A _10426_/B VPWR VGND sg13cmos5l_nand2_1
X_13214_ _13214_/Y _18942_/Q _18903_/Q VPWR VGND sg13cmos5l_xnor2_1
X_16002_ _19376_/D _16020_/A _16002_/B VPWR VGND sg13cmos5l_nor2_1
X_14194_ _14197_/A _14194_/A _14200_/B VPWR VGND sg13cmos5l_nand2_1
X_13145_ _13145_/Y _18972_/Q _13159_/A _18973_/Q VPWR VGND sg13cmos5l_o21ai_1
X_10357_ _10357_/Y _10357_/A VPWR VGND sg13cmos5l_inv_1
X_10288_ _10288_/Y _12219_/A VPWR VGND sg13cmos5l_inv_1
X_13076_ _13076_/Y _10265_/Y _13064_/Y _13075_/Y VPWR VGND sg13cmos5l_a21oi_1
X_17953_ _17962_/C _17949_/Y _17951_/Y _17952_/Y VPWR VGND sg13cmos5l_o21ai_1
X_12027_ _18783_/D _12200_/A _12027_/B VPWR VGND sg13cmos5l_nor2_1
X_16904_ _16909_/B _19487_/Q _16905_/B VPWR VGND sg13cmos5l_nor2b_1
XFILLER_78_574 VPWR VGND sg13cmos5l_fill_2
X_19623_ _19623_/Q clkload34/A _19623_/D _19623_/RESET_B VPWR VGND sg13cmos5l_dfrbpq_1
X_17884_ _17884_/Y _17884_/A _17884_/B VPWR VGND sg13cmos5l_nor2_1
X_16835_ _16835_/Y _17368_/A _19473_/Q _16831_/Y _16834_/Y VPWR VGND sg13cmos5l_a22oi_1
X_16766_ _16767_/B _19498_/Q _16693_/B _16672_/Y VPWR VGND sg13cmos5l_a21oi_1
X_19554_ _19554_/Q clkload24/A _19554_/D _19554_/RESET_B VPWR VGND sg13cmos5l_dfrbpq_1
X_13978_ _13978_/Y _13967_/Y _14002_/A _13971_/Y _13964_/Y _13977_/Y VPWR VGND sg13cmos5l_a221oi_1
XFILLER_19_674 VPWR VGND sg13cmos5l_fill_1
X_19485_ _19485_/Q _19546_/CLK _19485_/D _19485_/RESET_B VPWR VGND sg13cmos5l_dfrbpq_1
X_16697_ _16699_/B _17084_/A _16698_/B VPWR VGND sg13cmos5l_nand2_1
X_12929_ _12931_/D _12940_/A _12926_/B _12928_/Y VPWR VGND sg13cmos5l_o21ai_1
X_18505_ _18505_/Y _18505_/A VPWR VGND sg13cmos5l_inv_1
X_15717_ _15718_/B _15717_/A _15717_/B VPWR VGND sg13cmos5l_nand2_1
XFILLER_34_622 VPWR VGND sg13cmos5l_fill_2
X_18436_ _18437_/C _18436_/A _18436_/B _18436_/C VPWR VGND sg13cmos5l_and3_1
X_15648_ _15648_/Y _15840_/A _15671_/B _15647_/Y VPWR VGND sg13cmos5l_a21oi_1
X_18367_ _18368_/B _18452_/A _18367_/B VPWR VGND sg13cmos5l_nor2_1
X_15579_ _15579_/Y _15564_/A _15564_/B _15578_/Y VPWR VGND sg13cmos5l_o21ai_1
X_17318_ _17318_/Y _17377_/B VPWR VGND sg13cmos5l_inv_1
X_18298_ _18341_/A _19697_/Q _18299_/B VPWR VGND sg13cmos5l_xnor2_1
X_17249_ _17256_/A _17267_/D _17249_/B _17442_/A VPWR VGND sg13cmos5l_nand3_1
X_18785__1490 _18785_/RESET_B VPWR VGND sg13cmos5l_tiehi
XFILLER_103_649 VPWR VGND sg13cmos5l_fill_2
Xhold2403 _10046_/A _18830_/Q VPWR VGND sg13cmos5l_dlygate4sd3_1
XFILLER_88_327 VPWR VGND sg13cmos5l_fill_2
Xhold2425 _10381_/A _18574_/Q VPWR VGND sg13cmos5l_dlygate4sd3_1
Xhold2414 _17078_/B _19497_/Q VPWR VGND sg13cmos5l_dlygate4sd3_1
X_19644__438 _19644_/D VPWR VGND sg13cmos5l_tielo
Xhold2436 _10135_/A _19421_/Q VPWR VGND sg13cmos5l_dlygate4sd3_1
Xhold2447 _12220_/A _18834_/Q VPWR VGND sg13cmos5l_dlygate4sd3_1
XFILLER_56_18 VPWR VGND sg13cmos5l_fill_2
XFILLER_5_1006 VPWR VGND sg13cmos5l_fill_1
X_19327__909 _19327_/RESET_B VPWR VGND sg13cmos5l_tiehi
Xhold2458 _10120_/A _19336_/Q VPWR VGND sg13cmos5l_dlygate4sd3_1
Xhold2469 _15427_/C _15426_/Y VPWR VGND sg13cmos5l_dlygate4sd3_1
XFILLER_84_555 VPWR VGND sg13cmos5l_decap_4
X_19034__1223 _19034_/RESET_B VPWR VGND sg13cmos5l_tiehi
X_18861__1408 _18861_/RESET_B VPWR VGND sg13cmos5l_tiehi
XFILLER_24_154 VPWR VGND sg13cmos5l_fill_2
X_11260_ _11260_/Y _11253_/Y _11286_/A _11259_/Y VPWR VGND sg13cmos5l_o21ai_1
XFILLER_106_465 VPWR VGND sg13cmos5l_decap_4
XFILLER_97_47 VPWR VGND sg13cmos5l_fill_2
X_11191_ _11280_/A _11191_/A _11204_/B _11204_/C VPWR VGND sg13cmos5l_nand3_1
X_10211_ _15750_/B _15759_/A VPWR VGND sg13cmos5l_inv_1
X_10142_ _16409_/A _19454_/Q VPWR VGND sg13cmos5l_inv_1
X_10073_ _14074_/A _10073_/A VPWR VGND sg13cmos5l_inv_1
X_14950_ _14950_/Y _14950_/A VPWR VGND sg13cmos5l_inv_1
Xhold2981 _10039_/A _12110_/A VPWR VGND sg13cmos5l_dlygate4sd3_1
X_13901_ _13906_/A _13887_/X _13900_/Y _13885_/Y VPWR VGND sg13cmos5l_o21ai_1
X_14881_ _14882_/B _14846_/Y _14849_/Y _14850_/A VPWR VGND sg13cmos5l_a21oi_1
Xhold2992 _15147_/C _15041_/Y VPWR VGND sg13cmos5l_dlygate4sd3_1
Xhold2970 _14325_/A _19131_/Q VPWR VGND sg13cmos5l_dlygate4sd3_1
X_16620_ _16620_/Y hold2032/X fanout69/X _16624_/A VPWR VGND sg13cmos5l_o21ai_1
XFILLER_75_566 VPWR VGND sg13cmos5l_fill_1
X_13832_ _13832_/Y _13848_/A _13829_/X _13849_/C _13831_/Y VPWR VGND sg13cmos5l_a22oi_1
X_13763_ _13794_/A _13699_/Y _13700_/A _13780_/B VPWR VGND sg13cmos5l_mux2_1
XFILLER_44_931 VPWR VGND sg13cmos5l_fill_1
X_16551_ _19457_/D _16551_/A _16555_/B VPWR VGND sg13cmos5l_nor2_1
X_12714_ _12715_/B _12693_/B _12690_/A _12714_/S VPWR VGND sg13cmos5l_mux2_1
X_10975_ _11087_/B _10938_/Y _10969_/X _10974_/Y VPWR VGND sg13cmos5l_a21oi_1
XFILLER_44_964 VPWR VGND sg13cmos5l_fill_1
X_15502_ _15502_/Y _19337_/Q _16016_/A _15482_/B _15247_/B VPWR VGND sg13cmos5l_a22oi_1
X_13694_ _13694_/Y _13720_/B _13720_/C VPWR VGND sg13cmos5l_nand2_1
X_19270_ _19270_/Q clkload15/A _19270_/D _19270_/RESET_B VPWR VGND sg13cmos5l_dfrbpq_1
X_16482_ _16482_/Y _19446_/Q _19407_/Q VPWR VGND sg13cmos5l_xnor2_1
XFILLER_30_102 VPWR VGND sg13cmos5l_decap_8
X_12645_ _12645_/X hold2746/X _12828_/A _12664_/S VPWR VGND sg13cmos5l_mux2_1
X_18221_ _19708_/D _18221_/A _18227_/B VPWR VGND sg13cmos5l_nor2_1
X_15433_ _15434_/B _19303_/Q _15433_/B VPWR VGND sg13cmos5l_xnor2_1
XFILLER_30_113 VPWR VGND sg13cmos5l_fill_2
X_12576_ _12577_/B _12574_/B _12575_/Y _12574_/Y VPWR VGND sg13cmos5l_a21oi_1
X_15364_ _15364_/Y _15741_/A _15364_/B VPWR VGND sg13cmos5l_xnor2_1
X_19278__963 _19278_/RESET_B VPWR VGND sg13cmos5l_tiehi
X_18152_ _18152_/Y _18152_/A _18159_/B VPWR VGND sg13cmos5l_nor2_1
X_11527_ _11527_/Y _11527_/A VPWR VGND sg13cmos5l_inv_1
X_17103_ _17122_/C _17110_/C _17103_/B VPWR VGND sg13cmos5l_and2_1
X_18083_ _18084_/B _19713_/Q _18200_/B VPWR VGND sg13cmos5l_nor2_1
XFILLER_8_854 VPWR VGND sg13cmos5l_fill_2
XFILLER_8_865 VPWR VGND sg13cmos5l_fill_1
X_14315_ _14315_/Y _14315_/A _14377_/B VPWR VGND sg13cmos5l_nor2_1
X_17034_ _17034_/X _17034_/A _17034_/B VPWR VGND sg13cmos5l_xor2_1
XFILLER_7_375 VPWR VGND sg13cmos5l_fill_1
XFILLER_7_56 VPWR VGND sg13cmos5l_fill_1
X_15295_ _15297_/B _15283_/X _15294_/Y _15293_/Y VPWR VGND sg13cmos5l_a21oi_1
X_11458_ _11458_/Y _11446_/X _11450_/Y _11278_/Y VPWR VGND sg13cmos5l_a21oi_1
X_14246_ _14441_/A _19123_/Q _19124_/Q VPWR VGND sg13cmos5l_xnor2_1
X_11389_ _11390_/B _11896_/A _11899_/A _11393_/C VPWR VGND sg13cmos5l_nand3_1
X_10409_ _19813_/D _19808_/D _10409_/B VPWR VGND sg13cmos5l_nand2b_1
X_14177_ _14200_/C _14177_/A _14185_/B VPWR VGND sg13cmos5l_nand2_1
X_13128_ _13196_/A _13127_/Y _12940_/B _13136_/C VPWR VGND sg13cmos5l_mux2_1
XFILLER_79_861 VPWR VGND sg13cmos5l_fill_1
X_18985_ _18985_/Q _19003_/CLK _18985_/D _18985_/RESET_B VPWR VGND sg13cmos5l_dfrbpq_1
XFILLER_30_4 VPWR VGND sg13cmos5l_fill_1
X_13059_ _13059_/Y _13059_/A VPWR VGND sg13cmos5l_inv_1
X_17936_ _19671_/D _17936_/A _17937_/B VPWR VGND sg13cmos5l_nor2_1
XFILLER_66_544 VPWR VGND sg13cmos5l_fill_1
X_17867_ _17867_/X _17867_/A _17941_/B VPWR VGND sg13cmos5l_or2_1
X_16818_ _19499_/D _16818_/A _16823_/B VPWR VGND sg13cmos5l_nor2_1
XFILLER_93_363 VPWR VGND sg13cmos5l_decap_8
X_19606_ _19606_/Q clkload13/A _19606_/D _19606_/RESET_B VPWR VGND sg13cmos5l_dfrbpq_1
XFILLER_26_408 VPWR VGND sg13cmos5l_fill_1
X_19537_ _19537_/Q clkload41/A _19537_/D _19537_/RESET_B VPWR VGND sg13cmos5l_dfrbpq_1
X_17798_ _17902_/C _19669_/Q _17803_/B _17809_/A VPWR VGND sg13cmos5l_o21ai_1
X_16749_ _16749_/Y _16827_/B VPWR VGND sg13cmos5l_inv_1
XFILLER_22_625 VPWR VGND sg13cmos5l_fill_1
X_19468_ _19468_/Q _19679_/CLK _19468_/D _19468_/RESET_B VPWR VGND sg13cmos5l_dfrbpq_1
XFILLER_34_463 VPWR VGND sg13cmos5l_fill_1
X_19022__1238 _19022_/RESET_B VPWR VGND sg13cmos5l_tiehi
XFILLER_22_658 VPWR VGND sg13cmos5l_fill_2
XFILLER_22_669 VPWR VGND sg13cmos5l_fill_1
X_19399_ _19399_/Q clkload6/A _19399_/D _19399_/RESET_B VPWR VGND sg13cmos5l_dfrbpq_1
X_18419_ _18431_/B _18413_/Y _18416_/Y _18483_/B _18449_/A _18418_/Y VPWR VGND sg13cmos5l_a221oi_1
Xhold2200 _19769_/D _18532_/Y VPWR VGND sg13cmos5l_dlygate4sd3_1
Xhold2211 _19683_/D _17992_/Y VPWR VGND sg13cmos5l_dlygate4sd3_1
X_09985_ _09985_/Y _09985_/A VPWR VGND sg13cmos5l_inv_1
Xhold2233 _10659_/A _18562_/Q VPWR VGND sg13cmos5l_dlygate4sd3_1
Xhold2222 _18936_/D _13072_/Y VPWR VGND sg13cmos5l_dlygate4sd3_1
Xhold2255 _19598_/D _17424_/Y VPWR VGND sg13cmos5l_dlygate4sd3_1
Xhold2244 _19724_/D _18279_/Y VPWR VGND sg13cmos5l_dlygate4sd3_1
Xhold2277 _18812_/D _12250_/Y VPWR VGND sg13cmos5l_dlygate4sd3_1
Xhold2288 _10293_/A _18725_/Q VPWR VGND sg13cmos5l_dlygate4sd3_1
Xhold2266 _19685_/D _17996_/Y VPWR VGND sg13cmos5l_dlygate4sd3_1
Xhold2299 _12251_/B _18813_/Q VPWR VGND sg13cmos5l_dlygate4sd3_1
X_10760_ _10760_/Y _13808_/A _18585_/Q _18586_/Q VPWR VGND sg13cmos5l_o21ai_1
X_10691_ _18568_/D _10748_/A _10691_/B VPWR VGND sg13cmos5l_nor2_1
X_18825__1447 _18825_/RESET_B VPWR VGND sg13cmos5l_tiehi
X_12430_ _12450_/A _12467_/B _12429_/B _12429_/Y VPWR VGND sg13cmos5l_o21ai_1
X_12361_ _12361_/Y _12301_/A _12301_/B _12465_/B VPWR VGND sg13cmos5l_o21ai_1
X_14100_ _14102_/B _14114_/C _14098_/Y _14099_/Y VPWR VGND sg13cmos5l_o21ai_1
X_12292_ _12293_/B _12292_/A _12292_/B VPWR VGND sg13cmos5l_nor2_1
X_11312_ _11313_/B _11283_/Y _11189_/B _11325_/B VPWR VGND sg13cmos5l_mux2_1
XFILLER_5_857 VPWR VGND sg13cmos5l_fill_2
X_15080_ _15121_/A _19267_/Q _15080_/B VPWR VGND sg13cmos5l_xnor2_1
XFILLER_106_0 VPWR VGND sg13cmos5l_fill_2
X_11243_ _11245_/A _11624_/A _11270_/B _18666_/Q VPWR VGND sg13cmos5l_a21o_1
X_14031_ _14031_/Y _13927_/A _14018_/Y _14019_/Y _14015_/Y _13911_/B VPWR VGND sg13cmos5l_a221oi_1
XFILLER_5_879 VPWR VGND sg13cmos5l_fill_2
XFILLER_106_284 VPWR VGND sg13cmos5l_decap_8
X_11174_ _11174_/Y _11174_/A _11203_/A VPWR VGND sg13cmos5l_nor2_1
X_18770_ _18770_/Q clkload68/A _18770_/D _18770_/RESET_B VPWR VGND sg13cmos5l_dfrbpq_1
XFILLER_67_319 VPWR VGND sg13cmos5l_fill_2
X_15982_ _15982_/Y _15982_/A _15982_/B _15982_/C VPWR VGND sg13cmos5l_nand3_1
X_10125_ _16010_/A _15617_/A VPWR VGND sg13cmos5l_inv_1
XFILLER_103_991 VPWR VGND sg13cmos5l_fill_1
XFILLER_94_149 VPWR VGND sg13cmos5l_fill_1
X_10056_ _13022_/A _10056_/A VPWR VGND sg13cmos5l_inv_1
XFILLER_76_831 VPWR VGND sg13cmos5l_fill_1
X_17721_ _17721_/Y _17699_/A _17719_/S _17770_/A VPWR VGND sg13cmos5l_o21ai_1
X_14933_ _14933_/Y _19250_/Q _15460_/A VPWR VGND sg13cmos5l_nand2_1
X_17652_ _17653_/C _17652_/A _17659_/A VPWR VGND sg13cmos5l_nor2b_1
XFILLER_48_566 VPWR VGND sg13cmos5l_fill_2
X_16603_ _16609_/A _17078_/B _16603_/B VPWR VGND sg13cmos5l_nand2b_1
X_14864_ _14865_/A _14911_/B _14871_/S _14863_/Y VPWR VGND sg13cmos5l_a21o_1
X_13815_ _19054_/D _13819_/A _13815_/B VPWR VGND sg13cmos5l_nor2_1
X_18758__1520 _18758_/RESET_B VPWR VGND sg13cmos5l_tiehi
X_17583_ _17585_/D _17593_/A _17580_/B _17582_/Y VPWR VGND sg13cmos5l_o21ai_1
X_14795_ _14795_/Y _14795_/A _14842_/A VPWR VGND sg13cmos5l_nor2_1
XFILLER_16_441 VPWR VGND sg13cmos5l_fill_2
XFILLER_28_290 VPWR VGND sg13cmos5l_fill_1
X_13746_ _13746_/Y _13778_/B _13778_/C _13778_/A VPWR VGND sg13cmos5l_a21oi_1
X_10958_ _10958_/Y _11356_/A _10958_/B VPWR VGND sg13cmos5l_xnor2_1
X_16534_ _16534_/Y _16525_/Y _16527_/Y _16533_/X VPWR VGND sg13cmos5l_o21ai_1
X_19322_ _19322_/Q _19738_/CLK _19322_/D _19322_/RESET_B VPWR VGND sg13cmos5l_dfrbpq_1
X_13677_ _13678_/C _13720_/A _16632_/A VPWR VGND sg13cmos5l_nor2_1
XFILLER_92_6 VPWR VGND sg13cmos5l_fill_1
X_19253_ _19253_/Q _19308_/CLK _19253_/D _19253_/RESET_B VPWR VGND sg13cmos5l_dfrbpq_1
X_16465_ _16465_/Y _16465_/A _16465_/B _16465_/C _16465_/D VPWR VGND sg13cmos5l_nand4_1
X_12628_ _12628_/Y _12658_/A _12657_/A _12630_/A _12663_/A VPWR VGND sg13cmos5l_a22oi_1
X_10889_ _10889_/Y _10526_/B _19778_/Q VPWR VGND sg13cmos5l_nand2b_1
X_18204_ _18205_/B _18204_/A _18204_/B VPWR VGND sg13cmos5l_nor2_1
X_15416_ _15416_/X _15287_/B _15404_/X _15415_/Y VPWR VGND sg13cmos5l_a21o_1
X_19184_ _19184_/Q _19227_/CLK _19184_/D _19184_/RESET_B VPWR VGND sg13cmos5l_dfrbpq_1
X_16396_ _16396_/X _16396_/A _16396_/B _16454_/A VPWR VGND sg13cmos5l_and3_1
X_12559_ _18863_/D _12579_/A _12685_/A VPWR VGND sg13cmos5l_and2_1
X_15347_ _15347_/Y _19306_/Q _19305_/Q _19290_/Q VPWR VGND sg13cmos5l_nand3b_1
X_18135_ _18135_/X _18135_/A _18135_/B VPWR VGND sg13cmos5l_and2_1
X_15278_ _15278_/Y _15278_/A _15278_/B VPWR VGND sg13cmos5l_nor2_1
XFILLER_8_695 VPWR VGND sg13cmos5l_fill_1
X_18066_ _18066_/Y _18169_/B VPWR VGND sg13cmos5l_inv_1
X_17017_ _17017_/Y _16930_/Y _17088_/B _17089_/B _17030_/A VPWR VGND sg13cmos5l_a22oi_1
X_14229_ _14229_/X _14229_/A _14229_/B VPWR VGND sg13cmos5l_xor2_1
XFILLER_99_956 VPWR VGND sg13cmos5l_fill_1
XFILLER_99_923 VPWR VGND sg13cmos5l_fill_1
XFILLER_101_906 VPWR VGND sg13cmos5l_fill_2
X_18968_ _18968_/Q clkload64/A _18968_/D _18968_/RESET_B VPWR VGND sg13cmos5l_dfrbpq_1
X_17919_ _19658_/D _17807_/Y _17928_/S _17918_/Y VPWR VGND sg13cmos5l_a21oi_1
X_18899_ _18899_/Q _18902_/CLK _18899_/D _18899_/RESET_B VPWR VGND sg13cmos5l_dfrbpq_1
XFILLER_54_514 VPWR VGND sg13cmos5l_decap_8
X_19074__1180 _19074_/RESET_B VPWR VGND sg13cmos5l_tiehi
XFILLER_34_260 VPWR VGND sg13cmos5l_fill_1
XFILLER_5_109 VPWR VGND sg13cmos5l_fill_1
XFILLER_104_733 VPWR VGND sg13cmos5l_fill_2
X_09968_ _09968_/Y _09968_/A VPWR VGND sg13cmos5l_inv_1
Xhold2030 _13938_/A _19069_/Q VPWR VGND sg13cmos5l_dlygate4sd3_1
Xhold2041 _18892_/D _12778_/Y VPWR VGND sg13cmos5l_dlygate4sd3_1
XFILLER_58_853 VPWR VGND sg13cmos5l_fill_1
Xhold2052 _15477_/A _19270_/Q VPWR VGND sg13cmos5l_dlygate4sd3_1
Xhold2063 _15735_/B _19297_/Q VPWR VGND sg13cmos5l_dlygate4sd3_1
Xhold2074 _10044_/A _18832_/Q VPWR VGND sg13cmos5l_dlygate4sd3_1
Xhold2085 _10148_/A _19495_/Q VPWR VGND sg13cmos5l_dlygate4sd3_1
X_11930_ _11930_/Y _18766_/Q _11920_/X _11929_/Y _18767_/Q VPWR VGND sg13cmos5l_a22oi_1
Xhold2096 _17847_/A _19658_/Q VPWR VGND sg13cmos5l_dlygate4sd3_1
XFILLER_72_322 VPWR VGND sg13cmos5l_fill_2
XFILLER_58_897 VPWR VGND sg13cmos5l_fill_2
X_11861_ _11863_/B _11735_/B _11902_/B _11867_/B VPWR VGND sg13cmos5l_mux2_1
X_11792_ _11803_/B _18763_/Q _11793_/B VPWR VGND sg13cmos5l_nor2b_1
X_13600_ _13601_/B _13600_/A _16823_/A _13616_/S VPWR VGND sg13cmos5l_nand3_1
X_10812_ _18585_/D _18558_/A _18557_/B VPWR VGND sg13cmos5l_nor2_1
XFILLER_60_528 VPWR VGND sg13cmos5l_fill_1
X_14580_ _14580_/Y _14580_/A _14580_/B VPWR VGND sg13cmos5l_nand2_1
X_19657__437 _19657_/D VPWR VGND sg13cmos5l_tielo
X_10743_ _18578_/D _10000_/Y fanout68/X _10742_/Y VPWR VGND sg13cmos5l_a21oi_1
X_13531_ _13531_/Y _13531_/A _13531_/B VPWR VGND sg13cmos5l_nor2_1
X_16250_ _16250_/X _16252_/S _16250_/B VPWR VGND sg13cmos5l_and2_1
X_10674_ _10678_/A _10680_/B _10680_/C _10680_/D _10674_/D VPWR VGND sg13cmos5l_nand4_1
X_13462_ _13462_/Y _18996_/Q _19011_/Q VPWR VGND sg13cmos5l_nand2_1
X_15201_ _15201_/Y _19293_/Q _15220_/A _15225_/B _19294_/Q _15200_/Y VPWR VGND sg13cmos5l_a221oi_1
X_12413_ _12413_/Y _12413_/A _12413_/B VPWR VGND sg13cmos5l_nor2_1
X_13393_ _13420_/C _13393_/A _13419_/B VPWR VGND sg13cmos5l_or2_1
X_16181_ _16181_/Y _16433_/A _16244_/A VPWR VGND sg13cmos5l_nor2_1
X_12344_ _12344_/Y _12337_/Y _12535_/A _12343_/Y VPWR VGND sg13cmos5l_o21ai_1
X_15132_ _15132_/Y _15132_/A _15156_/B VPWR VGND sg13cmos5l_nor2_1
XFILLER_5_665 VPWR VGND sg13cmos5l_fill_2
X_15063_ _15271_/A _19249_/Q _19250_/Q VPWR VGND sg13cmos5l_xnor2_1
X_12275_ _12280_/B _18783_/Q _12276_/B VPWR VGND sg13cmos5l_nor2b_1
XFILLER_99_219 VPWR VGND sg13cmos5l_fill_1
X_14014_ _14014_/Y _13922_/B _14022_/A _14013_/Y VPWR VGND sg13cmos5l_a21oi_1
X_11226_ _11323_/C _11225_/A _11225_/B _11236_/A VPWR VGND sg13cmos5l_o21ai_1
XFILLER_4_35 VPWR VGND sg13cmos5l_fill_2
X_18822_ _18822_/Q clkload70/A _18822_/D _18822_/RESET_B VPWR VGND sg13cmos5l_dfrbpq_1
XFILLER_68_617 VPWR VGND sg13cmos5l_fill_1
X_11157_ _11199_/A _18614_/Q _11171_/D VPWR VGND sg13cmos5l_xnor2_1
X_19159__1089 _19159_/RESET_B VPWR VGND sg13cmos5l_tiehi
X_18753_ _18753_/Q clkload38/A _18753_/D _18753_/RESET_B VPWR VGND sg13cmos5l_dfrbpq_1
XFILLER_1_882 VPWR VGND sg13cmos5l_fill_2
X_10108_ _15455_/A _10108_/A VPWR VGND sg13cmos5l_inv_1
XFILLER_49_853 VPWR VGND sg13cmos5l_fill_1
X_17704_ _17705_/B _17709_/C _17702_/Y _17703_/Y VPWR VGND sg13cmos5l_a21o_1
X_11088_ _18635_/D _11089_/A _11088_/B VPWR VGND sg13cmos5l_nor2_1
X_15965_ _15965_/X _15965_/A _15965_/B VPWR VGND sg13cmos5l_xor2_1
X_10039_ _12457_/A _10039_/A VPWR VGND sg13cmos5l_inv_1
X_18684_ _18684_/Q clkload59/A _18684_/D _18684_/RESET_B VPWR VGND sg13cmos5l_dfrbpq_1
X_15896_ _16090_/A _15912_/C _19376_/Q VPWR VGND sg13cmos5l_xnor2_1
X_14916_ _19226_/D _14916_/A _14916_/B VPWR VGND sg13cmos5l_and2_1
X_17635_ _17635_/Y _17620_/A _17658_/A _17634_/Y VPWR VGND sg13cmos5l_a21oi_1
X_19700__1720 _19700_/RESET_B VPWR VGND sg13cmos5l_tiehi
X_14847_ _14916_/B _14816_/A _14823_/A _14820_/Y VPWR VGND sg13cmos5l_a21o_1
X_17566_ _17613_/A _17936_/A _17566_/B VPWR VGND sg13cmos5l_xnor2_1
XFILLER_17_772 VPWR VGND sg13cmos5l_fill_1
X_19062__1195 _19062_/RESET_B VPWR VGND sg13cmos5l_tiehi
X_19690__1747 _19690_/RESET_B VPWR VGND sg13cmos5l_tiehi
X_19305_ _19305_/Q _19308_/CLK _19305_/D _19305_/RESET_B VPWR VGND sg13cmos5l_dfrbpq_1
X_14778_ _14883_/B _19219_/Q _14783_/B VPWR VGND sg13cmos5l_and2_1
X_16517_ _16518_/B _16517_/A _16517_/B VPWR VGND sg13cmos5l_xnor2_1
X_13729_ _13780_/B _13727_/A _13727_/B _13728_/Y VPWR VGND sg13cmos5l_a21oi_1
X_17497_ _17639_/A _17474_/Y _17495_/Y _17494_/X VPWR VGND sg13cmos5l_a21o_1
XFILLER_20_948 VPWR VGND sg13cmos5l_fill_1
X_16448_ _16448_/Y _16448_/A _16448_/B _16448_/C _16448_/D VPWR VGND sg13cmos5l_nand4_1
X_19236_ _19236_/Q _19805_/CLK _19236_/D _19236_/RESET_B VPWR VGND sg13cmos5l_dfrbpq_1
X_19167_ _19167_/Q clkload50/A _19167_/D _19167_/RESET_B VPWR VGND sg13cmos5l_dfrbpq_1
X_16379_ _16398_/B _19463_/Q _19464_/Q _19465_/Q _19466_/Q VPWR VGND sg13cmos5l_nor4_1
XFILLER_69_0 VPWR VGND sg13cmos5l_fill_2
X_18118_ _18302_/A _19703_/Q _18119_/B VPWR VGND sg13cmos5l_xnor2_1
X_19098_ _19098_/Q clkload54/A _19098_/D _19098_/RESET_B VPWR VGND sg13cmos5l_dfrbpq_1
X_18049_ _19694_/D _18233_/A _18180_/A VPWR VGND sg13cmos5l_nor2_1
XFILLER_59_628 VPWR VGND sg13cmos5l_fill_1
XFILLER_100_268 VPWR VGND sg13cmos5l_fill_1
XFILLER_58_149 VPWR VGND sg13cmos5l_fill_1
XFILLER_66_160 VPWR VGND sg13cmos5l_decap_8
X_19443__782 _19443_/RESET_B VPWR VGND sg13cmos5l_tiehi
XFILLER_42_528 VPWR VGND sg13cmos5l_decap_4
X_19773__650 _19773_/RESET_B VPWR VGND sg13cmos5l_tiehi
Xfanout56 _11890_/S _11879_/Y VPWR VGND sg13cmos5l_buf_1
X_19666__1793 _19666_/RESET_B VPWR VGND sg13cmos5l_tiehi
Xfanout23 _17719_/S _17716_/Y VPWR VGND sg13cmos5l_buf_1
Xfanout34 fanout34/X _16305_/S VPWR VGND sg13cmos5l_buf_1
Xfanout45 _13859_/S _13856_/Y VPWR VGND sg13cmos5l_buf_1
Xfanout89 fanout89/X _10738_/Y VPWR VGND sg13cmos5l_buf_1
Xfanout78 fanout78/X fanout79/X VPWR VGND sg13cmos5l_buf_1
Xfanout67 fanout67/X fanout71/X VPWR VGND sg13cmos5l_buf_1
XFILLER_10_425 VPWR VGND sg13cmos5l_decap_4
XFILLER_10_436 VPWR VGND sg13cmos5l_fill_1
X_10390_ _19814_/D _10390_/A VPWR VGND sg13cmos5l_inv_1
X_19114__1137 _19114_/RESET_B VPWR VGND sg13cmos5l_tiehi
X_12060_ _12078_/B _18789_/Q _12110_/A _18788_/Q VPWR VGND sg13cmos5l_nor3_1
XFILLER_78_926 VPWR VGND sg13cmos5l_fill_1
X_11011_ _11016_/A _18628_/Q _11013_/B VPWR VGND sg13cmos5l_and2_1
XFILLER_104_585 VPWR VGND sg13cmos5l_decap_4
XFILLER_38_52 VPWR VGND sg13cmos5l_fill_1
X_12962_ _12962_/Y _12962_/A _13028_/B VPWR VGND sg13cmos5l_nor2_1
X_15750_ _15750_/Y _19376_/Q _15750_/B VPWR VGND sg13cmos5l_nand2_1
X_11913_ _11915_/A _12461_/A _18729_/Q _11912_/Y VPWR VGND sg13cmos5l_o21ai_1
X_12893_ _12939_/A _12932_/A _18914_/Q VPWR VGND sg13cmos5l_xnor2_1
X_15681_ _15681_/Y _15840_/A _15681_/B VPWR VGND sg13cmos5l_nand2_1
X_14701_ _19191_/D _14683_/Y hold2346/X _14902_/A VPWR VGND sg13cmos5l_a21oi_1
X_11844_ _11844_/Y _11844_/A _11867_/B VPWR VGND sg13cmos5l_nor2_1
X_17420_ _17420_/Y _17400_/A fanout25/X _17419_/Y VPWR VGND sg13cmos5l_a21oi_1
X_14632_ _14632_/Y _14619_/B _14628_/S _14637_/B VPWR VGND sg13cmos5l_o21ai_1
XFILLER_33_517 VPWR VGND sg13cmos5l_decap_8
X_19559__655 _19559_/RESET_B VPWR VGND sg13cmos5l_tiehi
XFILLER_54_73 VPWR VGND sg13cmos5l_fill_1
X_11775_ _11775_/Y _18759_/Q _18760_/Q VPWR VGND sg13cmos5l_xnor2_1
X_17351_ _17351_/Y _17232_/A _17232_/B _17348_/A _17348_/B _17350_/Y VPWR VGND sg13cmos5l_a221oi_1
X_14563_ _14563_/Y _14476_/A _14476_/B _14573_/S _14743_/A _14561_/Y VPWR VGND sg13cmos5l_a221oi_1
XFILLER_13_252 VPWR VGND sg13cmos5l_fill_1
X_10726_ _10726_/Y fanout99/X _10725_/Y _10721_/Y VPWR VGND sg13cmos5l_o21ai_1
X_17282_ _17285_/B _17668_/A _17309_/B VPWR VGND sg13cmos5l_and2_1
X_13514_ _13584_/B _13519_/S _13513_/Y _13512_/Y VPWR VGND sg13cmos5l_a21oi_1
X_16302_ _19419_/D _16265_/A fanout34/X _16301_/Y VPWR VGND sg13cmos5l_a21oi_1
X_14494_ _14494_/Y _19151_/Q _19112_/Q VPWR VGND sg13cmos5l_xnor2_1
X_19021_ _19021_/Q clkload33/A _19021_/D _19021_/RESET_B VPWR VGND sg13cmos5l_dfrbpq_1
X_10657_ _10657_/Y _10663_/A _10655_/Y _10656_/Y VPWR VGND sg13cmos5l_a21oi_1
X_13445_ _13553_/A _19009_/Q _13447_/B VPWR VGND sg13cmos5l_nor2_1
X_16233_ _16233_/Y _16233_/A _16233_/B _16233_/C _16233_/D VPWR VGND sg13cmos5l_nand4_1
X_19047__1210 _19047_/RESET_B VPWR VGND sg13cmos5l_tiehi
XFILLER_70_72 VPWR VGND sg13cmos5l_fill_1
Xclkload26 clkload26/Y clkload26/A VPWR VGND sg13cmos5l_inv_8
Xclkload15 clkload15/X clkload15/A VPWR VGND sg13cmos5l_buf_8
Xclkload59 clkload59/Y clkload59/A VPWR VGND sg13cmos5l_inv_1
Xclkload37 clkload37/Y clkload37/A VPWR VGND sg13cmos5l_inv_8
X_13376_ _13419_/A _18951_/Q _13376_/B VPWR VGND sg13cmos5l_xnor2_1
XFILLER_10_992 VPWR VGND sg13cmos5l_fill_2
X_16164_ _16288_/A _19428_/Q _16167_/B _16163_/Y VPWR VGND sg13cmos5l_a21oi_1
Xclkload48 clkload48/Y clkload48/A VPWR VGND sg13cmos5l_inv_1
X_10588_ _10588_/Y _10571_/Y _10578_/Y _10587_/Y VPWR VGND sg13cmos5l_o21ai_1
X_12327_ _12327_/Y _12336_/D _12322_/B _12546_/A VPWR VGND sg13cmos5l_a21oi_1
X_15115_ _15115_/X _15115_/A _15121_/B VPWR VGND sg13cmos5l_or2_1
X_16095_ _16095_/Y _16092_/Y _16093_/Y _16124_/B _15912_/C VPWR VGND sg13cmos5l_a22oi_1
X_12258_ _18817_/D _10008_/Y fanout95/X _12257_/Y VPWR VGND sg13cmos5l_a21oi_1
XFILLER_69_904 VPWR VGND sg13cmos5l_fill_1
X_15046_ _15161_/A hold2923/X _15053_/B _15045_/Y VPWR VGND sg13cmos5l_a21oi_1
XFILLER_68_403 VPWR VGND sg13cmos5l_fill_1
X_19607__601 _19607_/RESET_B VPWR VGND sg13cmos5l_tiehi
X_11209_ _11329_/A _11173_/X _11199_/B _10965_/Y VPWR VGND sg13cmos5l_a21oi_1
X_18805_ _18805_/Q clkload61/A _18805_/D _18805_/RESET_B VPWR VGND sg13cmos5l_dfrbpq_1
X_12189_ _18794_/D _12189_/A _12192_/B VPWR VGND sg13cmos5l_and2_1
X_16997_ _16998_/C _16999_/A _17171_/A VPWR VGND sg13cmos5l_nor2_1
X_19785_ _19785_/Q clkload48/A _19785_/D _19785_/RESET_B VPWR VGND sg13cmos5l_dfrbpq_1
X_18736_ _18736_/Q clkload59/A _18736_/D _18736_/RESET_B VPWR VGND sg13cmos5l_dfrbpq_1
XFILLER_48_171 VPWR VGND sg13cmos5l_fill_1
X_15948_ _15948_/Y _15933_/A _16019_/B _16020_/B _15961_/A VPWR VGND sg13cmos5l_a22oi_1
X_18820__1452 _18820_/RESET_B VPWR VGND sg13cmos5l_tiehi
X_18667_ _18667_/Q clkload57/A _18667_/D _18667_/RESET_B VPWR VGND sg13cmos5l_dfrbpq_1
XFILLER_64_675 VPWR VGND sg13cmos5l_fill_1
X_17618_ _17618_/Y _17677_/B _17639_/B VPWR VGND sg13cmos5l_nor2_1
X_15879_ _15982_/C _15878_/A _15878_/B _15890_/A VPWR VGND sg13cmos5l_o21ai_1
X_18598_ _18598_/Q clkload55/A _18598_/D _18598_/RESET_B VPWR VGND sg13cmos5l_dfrbpq_1
XFILLER_51_336 VPWR VGND sg13cmos5l_fill_1
X_17549_ _17549_/Y _17549_/A _17549_/B _17549_/C VPWR VGND sg13cmos5l_nand3_1
XFILLER_32_550 VPWR VGND sg13cmos5l_fill_2
Xclkload9 clkload9/X clkload9/A VPWR VGND sg13cmos5l_buf_8
X_19219_ _19219_/Q clkload50/A _19219_/D _19219_/RESET_B VPWR VGND sg13cmos5l_dfrbpq_1
XFILLER_106_806 VPWR VGND sg13cmos5l_fill_1
XFILLER_99_572 VPWR VGND sg13cmos5l_fill_1
Xfanout213 _17678_/A _17679_/A VPWR VGND sg13cmos5l_buf_1
Xfanout202 _18482_/A _18272_/Y VPWR VGND sg13cmos5l_buf_1
Xfanout224 _17071_/A _16870_/Y VPWR VGND sg13cmos5l_buf_1
X_19110__1143 _19110_/RESET_B VPWR VGND sg13cmos5l_tiehi
Xfanout235 _16320_/A _16312_/B VPWR VGND sg13cmos5l_buf_1
XFILLER_8_1026 VPWR VGND sg13cmos5l_fill_2
Xfanout246 _15747_/A _15736_/B VPWR VGND sg13cmos5l_buf_1
Xfanout279 _13817_/A _13623_/Y VPWR VGND sg13cmos5l_buf_1
XFILLER_86_255 VPWR VGND sg13cmos5l_fill_1
XFILLER_59_469 VPWR VGND sg13cmos5l_fill_2
Xfanout257 _14913_/A _14915_/A VPWR VGND sg13cmos5l_buf_1
Xfanout268 _14374_/A _14375_/A VPWR VGND sg13cmos5l_buf_1
XFILLER_101_577 VPWR VGND sg13cmos5l_fill_1
XFILLER_15_506 VPWR VGND sg13cmos5l_fill_2
XFILLER_70_623 VPWR VGND sg13cmos5l_fill_1
X_11560_ _11560_/Y _11560_/A _11560_/B VPWR VGND sg13cmos5l_nand2_1
XFILLER_51_892 VPWR VGND sg13cmos5l_fill_1
XFILLER_11_712 VPWR VGND sg13cmos5l_fill_1
X_18655__1638 _18655_/RESET_B VPWR VGND sg13cmos5l_tiehi
X_10511_ _10511_/Y _10511_/A _10580_/A VPWR VGND sg13cmos5l_nand2_1
X_13230_ _13230_/X _18967_/Q _13263_/B _13216_/Y VPWR VGND sg13cmos5l_a21o_1
X_11491_ _11583_/A _11582_/B _11582_/C _11582_/A VPWR VGND sg13cmos5l_a21oi_1
XFILLER_7_738 VPWR VGND sg13cmos5l_fill_2
X_10442_ _10443_/D _10442_/A _10442_/B _10442_/C _10442_/D VPWR VGND sg13cmos5l_nand4_1
XFILLER_6_237 VPWR VGND sg13cmos5l_fill_1
X_10373_ _16588_/A _10373_/A VPWR VGND sg13cmos5l_inv_1
X_13161_ _13161_/Y _18969_/Q _18970_/Q VPWR VGND sg13cmos5l_nand2_1
XFILLER_40_75 VPWR VGND sg13cmos5l_decap_4
X_12112_ _12112_/Y _12112_/A _12136_/B VPWR VGND sg13cmos5l_nor2_1
X_13092_ _13092_/Y _18912_/Q _18905_/Q VPWR VGND sg13cmos5l_nor2_1
XFILLER_3_955 VPWR VGND sg13cmos5l_fill_2
XFILLER_3_944 VPWR VGND sg13cmos5l_fill_2
XFILLER_3_933 VPWR VGND sg13cmos5l_decap_8
XFILLER_97_509 VPWR VGND sg13cmos5l_fill_1
X_16920_ _17040_/A _16938_/S _16919_/X _16915_/Y VPWR VGND sg13cmos5l_o21ai_1
X_12043_ _12153_/C _12043_/A _12043_/B _12147_/A VPWR VGND sg13cmos5l_nand3_1
X_16851_ _16852_/B _19476_/Q _16849_/Y _16850_/Y VPWR VGND sg13cmos5l_o21ai_1
X_16782_ _16783_/A _16663_/B _16826_/B _16788_/S VPWR VGND sg13cmos5l_mux2_1
X_19570_ _19570_/Q _19814_/CLK _19570_/D _19570_/RESET_B VPWR VGND sg13cmos5l_dfrbpq_1
X_15802_ _15802_/Y _19361_/Q fanout83/X _16307_/A VPWR VGND sg13cmos5l_o21ai_1
X_18521_ _18530_/S _18521_/A _18521_/B VPWR VGND sg13cmos5l_nor2_1
X_15733_ _15733_/Y _15718_/A _15722_/Y _15747_/A VPWR VGND sg13cmos5l_o21ai_1
XFILLER_19_845 VPWR VGND sg13cmos5l_fill_1
X_13994_ _14186_/A _14366_/A _14176_/A VPWR VGND sg13cmos5l_nand2_1
X_12945_ _12945_/Y _12938_/A _12938_/B _12938_/C _12938_/D VPWR VGND sg13cmos5l_a22oi_1
XFILLER_61_601 VPWR VGND sg13cmos5l_fill_1
XFILLER_34_815 VPWR VGND sg13cmos5l_fill_2
X_18588__1711 _18588_/RESET_B VPWR VGND sg13cmos5l_tiehi
X_12876_ _12876_/Y _12881_/A _12881_/B _12991_/B VPWR VGND sg13cmos5l_nor3_1
X_18452_ _18468_/A _18452_/A _18451_/Y VPWR VGND sg13cmos5l_nor2b_1
X_15664_ _15745_/B _15678_/A _15663_/Y _15662_/Y VPWR VGND sg13cmos5l_a21oi_1
X_11827_ _11827_/Y _11827_/A _11827_/B _11827_/C VPWR VGND sg13cmos5l_nor3_1
X_17403_ _17403_/Y _17403_/A _19560_/Q _17408_/C VPWR VGND sg13cmos5l_nor3_1
X_14615_ _14622_/A _14615_/A _14649_/B VPWR VGND sg13cmos5l_nor2_1
X_15595_ _15701_/B _15606_/A _15608_/B VPWR VGND sg13cmos5l_nand2_1
X_18383_ _18388_/A _18375_/X _18379_/Y _18409_/A _18384_/A _18380_/X VPWR VGND sg13cmos5l_a221oi_1
X_11758_ _11858_/C _11758_/A _18694_/Q _11848_/A VPWR VGND sg13cmos5l_nand3_1
X_17334_ _17335_/C _17334_/A _17334_/B VPWR VGND sg13cmos5l_nor2_1
X_14546_ _14546_/Y _14577_/A _14716_/A _14542_/Y _14544_/Y _14545_/Y VPWR VGND sg13cmos5l_a221oi_1
X_10709_ _10709_/Y _18572_/Q _10707_/Y _10708_/Y VPWR VGND sg13cmos5l_a21oi_1
X_11689_ _18733_/D _10011_/Y fanout98/X _11688_/Y VPWR VGND sg13cmos5l_a21oi_1
X_17265_ _17265_/Y _17256_/Y _17257_/Y _17464_/A _17310_/A _17259_/Y VPWR VGND sg13cmos5l_a221oi_1
X_19004_ _19004_/Q clkload66/A _19004_/D _19004_/RESET_B VPWR VGND sg13cmos5l_dfrbpq_1
X_14477_ _19158_/D _14648_/A _14477_/B VPWR VGND sg13cmos5l_nor2_1
X_17196_ _17198_/B _17304_/A _17304_/B VPWR VGND sg13cmos5l_nand2_1
X_13428_ _13428_/Y _18983_/Q _18944_/Q VPWR VGND sg13cmos5l_xnor2_1
X_16216_ _16238_/A _16199_/Y _16209_/X _16214_/Y VPWR VGND sg13cmos5l_o21ai_1
X_13359_ _18988_/D _14070_/A _13439_/B VPWR VGND sg13cmos5l_and2_1
X_16147_ _16147_/Y _19405_/Q _19366_/Q VPWR VGND sg13cmos5l_nand2_1
X_18838__1434 _18838_/RESET_B VPWR VGND sg13cmos5l_tiehi
X_16078_ _16078_/Y _09980_/Y fanout66/X _16077_/Y VPWR VGND sg13cmos5l_a21oi_1
Xhold2618 _12054_/A _18794_/Q VPWR VGND sg13cmos5l_dlygate4sd3_1
Xhold2607 hold2607/X _16965_/Y VPWR VGND sg13cmos5l_dlygate4sd3_1
Xhold2629 _10271_/A _18896_/Q VPWR VGND sg13cmos5l_dlygate4sd3_1
X_15029_ _19246_/D _15191_/A _15029_/B VPWR VGND sg13cmos5l_nor2_1
Xhold1917 _11892_/B _18709_/Q VPWR VGND sg13cmos5l_dlygate4sd3_1
Xhold1906 _09976_/A _19479_/Q VPWR VGND sg13cmos5l_dlygate4sd3_1
XFILLER_96_597 VPWR VGND sg13cmos5l_fill_1
Xinput2 input2/X ui_in[0] VPWR VGND sg13cmos5l_buf_1
Xhold1928 _18220_/B _19665_/Q VPWR VGND sg13cmos5l_dlygate4sd3_1
Xhold1939 _11078_/B _19791_/Q VPWR VGND sg13cmos5l_dlygate4sd3_1
X_19768_ _19768_/Q clkload45/A _19768_/D _19768_/RESET_B VPWR VGND sg13cmos5l_dfrbpq_1
X_18719_ _18719_/Q clkload57/A _18719_/D _18719_/RESET_B VPWR VGND sg13cmos5l_dfrbpq_1
XFILLER_37_664 VPWR VGND sg13cmos5l_fill_1
X_19699_ _19699_/Q _19738_/CLK _19699_/D _19699_/RESET_B VPWR VGND sg13cmos5l_dfrbpq_1
XFILLER_80_921 VPWR VGND sg13cmos5l_fill_2
XFILLER_80_965 VPWR VGND sg13cmos5l_decap_8
X_19336__900 _19336_/RESET_B VPWR VGND sg13cmos5l_tiehi
XFILLER_32_380 VPWR VGND sg13cmos5l_decap_8
XFILLER_3_218 VPWR VGND sg13cmos5l_fill_2
X_19154__1094 _19154_/RESET_B VPWR VGND sg13cmos5l_tiehi
X_19549__665 _19549_/RESET_B VPWR VGND sg13cmos5l_tiehi
XFILLER_0_903 VPWR VGND sg13cmos5l_fill_1
XFILLER_10_89 VPWR VGND sg13cmos5l_fill_1
XFILLER_101_385 VPWR VGND sg13cmos5l_fill_1
X_10991_ _10992_/B _10991_/A _11204_/A VPWR VGND sg13cmos5l_nand2_1
XFILLER_27_130 VPWR VGND sg13cmos5l_fill_1
X_12730_ _18885_/D _12732_/A _12730_/B VPWR VGND sg13cmos5l_nor2_1
XFILLER_76_1014 VPWR VGND sg13cmos5l_decap_8
X_12661_ _12661_/Y _12567_/X _12732_/B _12733_/B _12675_/A VPWR VGND sg13cmos5l_a22oi_1
X_11612_ _11613_/C _11614_/B _11592_/Y VPWR VGND sg13cmos5l_nor2b_1
X_19556__658 _19556_/RESET_B VPWR VGND sg13cmos5l_tiehi
X_14400_ _14400_/Y _19144_/Q _14391_/Y _14399_/Y _19145_/Q VPWR VGND sg13cmos5l_a22oi_1
XFILLER_24_870 VPWR VGND sg13cmos5l_fill_2
XFILLER_30_306 VPWR VGND sg13cmos5l_fill_1
XFILLER_30_317 VPWR VGND sg13cmos5l_decap_4
X_12592_ _12593_/B _12688_/B _12688_/C _12688_/A VPWR VGND sg13cmos5l_a21oi_1
X_18576__1726 _18576_/RESET_B VPWR VGND sg13cmos5l_tiehi
X_15380_ _15380_/Y _15395_/S _15570_/A _15378_/Y VPWR VGND sg13cmos5l_a21oi_1
X_11543_ _11543_/Y _11540_/Y _11541_/Y _11542_/Y VPWR VGND sg13cmos5l_o21ai_1
X_14331_ _14331_/Y _14328_/Y _14330_/Y _14323_/X VPWR VGND sg13cmos5l_o21ai_1
X_17050_ _17050_/Y _17032_/A _17032_/B _17042_/X _17048_/Y _17049_/Y VPWR VGND sg13cmos5l_a221oi_1
X_11474_ _11474_/Y _11474_/A _11474_/B VPWR VGND sg13cmos5l_nor2_1
XFILLER_7_535 VPWR VGND sg13cmos5l_fill_2
X_14262_ _14270_/B _19140_/Q _19142_/Q _19141_/Q _14262_/D VPWR VGND sg13cmos5l_nor4_1
X_10425_ _10426_/B _19809_/Q _19813_/Q VPWR VGND sg13cmos5l_nand2_1
X_13213_ _13213_/Y _18941_/Q _18902_/Q VPWR VGND sg13cmos5l_xnor2_1
X_18619__1677 _18619_/RESET_B VPWR VGND sg13cmos5l_tiehi
X_16001_ _16002_/B _15980_/B _15977_/A _16001_/S VPWR VGND sg13cmos5l_mux2_1
X_14193_ _19117_/D _14377_/A _14193_/B VPWR VGND sg13cmos5l_nor2_1
X_13144_ _13170_/B _18972_/Q _18973_/Q _13159_/A VPWR VGND sg13cmos5l_nor3_1
XFILLER_83_1018 VPWR VGND sg13cmos5l_decap_8
X_10356_ _10356_/Y _10356_/A VPWR VGND sg13cmos5l_inv_1
X_10287_ _12215_/A _10287_/A VPWR VGND sg13cmos5l_inv_1
X_13075_ _13075_/Y _13059_/A _13067_/S _13290_/B VPWR VGND sg13cmos5l_o21ai_1
X_17952_ _17952_/Y _19706_/Q _17962_/B _19643_/Q _18476_/A VPWR VGND sg13cmos5l_a22oi_1
XFILLER_3_796 VPWR VGND sg13cmos5l_fill_1
X_12026_ _12162_/A _12023_/A _12024_/A _12024_/Y VPWR VGND sg13cmos5l_a21oi_1
X_16903_ _16903_/X _16901_/Y _16902_/X _16897_/X VPWR VGND sg13cmos5l_a21o_1
X_17883_ _17884_/B _17867_/A _17904_/B _17882_/Y VPWR VGND sg13cmos5l_a21oi_1
XFILLER_25_7 VPWR VGND sg13cmos5l_fill_2
X_16834_ _16834_/Y _16832_/Y _16834_/B VPWR VGND sg13cmos5l_nand2b_1
X_19622_ _19622_/Q clkload25/A _19622_/D _19622_/RESET_B VPWR VGND sg13cmos5l_dfrbpq_1
X_16765_ _16765_/Y _16797_/A _16797_/B VPWR VGND sg13cmos5l_nand2_1
X_19553_ _19553_/Q clkload39/A _19553_/D _19553_/RESET_B VPWR VGND sg13cmos5l_dfrbpq_1
XFILLER_46_450 VPWR VGND sg13cmos5l_fill_2
X_13977_ _13977_/Y _13984_/A _14164_/A VPWR VGND sg13cmos5l_nor2_1
X_19484_ _19484_/Q _19546_/CLK _19484_/D _19484_/RESET_B VPWR VGND sg13cmos5l_dfrbpq_1
X_16696_ _16698_/B _19494_/Q _19493_/Q _19492_/Q _16722_/A VPWR VGND sg13cmos5l_nor4_1
X_12928_ _12928_/Y _12928_/A _12954_/B VPWR VGND sg13cmos5l_nor2_1
X_18504_ _18505_/A _18503_/Y _18502_/Y _18514_/C VPWR VGND sg13cmos5l_mux2_1
XFILLER_47_995 VPWR VGND sg13cmos5l_fill_2
X_15716_ _15717_/B _15716_/A _15716_/B VPWR VGND sg13cmos5l_xnor2_1
XFILLER_62_987 VPWR VGND sg13cmos5l_fill_1
X_18435_ _18435_/X _18427_/A _18429_/Y _18434_/Y VPWR VGND sg13cmos5l_a21o_1
X_15647_ _15647_/Y _15647_/A _15834_/A VPWR VGND sg13cmos5l_nor2_1
XFILLER_34_678 VPWR VGND sg13cmos5l_fill_2
X_12859_ _12859_/Y _12857_/Y _12858_/Y _12856_/Y VPWR VGND sg13cmos5l_a21oi_1
X_18366_ _18367_/B _18366_/A _18369_/B VPWR VGND sg13cmos5l_nor2_1
X_15578_ _15578_/Y _15578_/A _15582_/B VPWR VGND sg13cmos5l_nor2_1
X_17317_ _17377_/B _17272_/A _17309_/B _17316_/Y VPWR VGND sg13cmos5l_a21oi_1
X_14529_ _14716_/A _14908_/A _14533_/A VPWR VGND sg13cmos5l_xnor2_1
X_18297_ _18314_/B _19697_/Q _18299_/B VPWR VGND sg13cmos5l_nor2b_1
X_17248_ _17442_/A _19576_/Q _19575_/Q VPWR VGND sg13cmos5l_xnor2_1
X_17179_ _17194_/C _17179_/A _17199_/B VPWR VGND sg13cmos5l_nand2_1
X_19765__777 _19765_/RESET_B VPWR VGND sg13cmos5l_tiehi
Xhold2404 _11682_/B _18729_/Q VPWR VGND sg13cmos5l_dlygate4sd3_1
Xhold2426 _18574_/D _10736_/Y VPWR VGND sg13cmos5l_dlygate4sd3_1
XFILLER_69_542 VPWR VGND sg13cmos5l_fill_1
Xhold2415 _10327_/A _19786_/Q VPWR VGND sg13cmos5l_dlygate4sd3_1
Xhold2437 _19461_/D _16555_/Y VPWR VGND sg13cmos5l_dlygate4sd3_1
XFILLER_97_884 VPWR VGND sg13cmos5l_fill_2
XFILLER_96_350 VPWR VGND sg13cmos5l_fill_2
Xhold2459 _10055_/A _18875_/Q VPWR VGND sg13cmos5l_dlygate4sd3_1
XFILLER_69_575 VPWR VGND sg13cmos5l_fill_1
Xhold2448 _10029_/A _18665_/Q VPWR VGND sg13cmos5l_dlygate4sd3_1
XFILLER_57_748 VPWR VGND sg13cmos5l_fill_2
XFILLER_38_984 VPWR VGND sg13cmos5l_fill_1
XFILLER_25_601 VPWR VGND sg13cmos5l_fill_1
XFILLER_71_239 VPWR VGND sg13cmos5l_fill_2
XFILLER_25_656 VPWR VGND sg13cmos5l_fill_1
X_18695__1595 _18695_/RESET_B VPWR VGND sg13cmos5l_tiehi
XFILLER_12_317 VPWR VGND sg13cmos5l_fill_1
XFILLER_25_689 VPWR VGND sg13cmos5l_fill_1
XFILLER_40_659 VPWR VGND sg13cmos5l_decap_4
XFILLER_106_411 VPWR VGND sg13cmos5l_fill_1
X_10210_ _15774_/A _10210_/A VPWR VGND sg13cmos5l_inv_1
X_11190_ _11190_/Y _11190_/A _11203_/B VPWR VGND sg13cmos5l_nor2_1
XFILLER_0_711 VPWR VGND sg13cmos5l_fill_2
X_10141_ _16404_/A _19453_/Q VPWR VGND sg13cmos5l_inv_1
X_10072_ _13580_/A _10072_/A VPWR VGND sg13cmos5l_inv_1
XFILLER_102_672 VPWR VGND sg13cmos5l_fill_2
X_19562__651 _19562_/RESET_B VPWR VGND sg13cmos5l_tiehi
X_13900_ _13900_/Y _13513_/A _13889_/Y _13897_/X _13898_/Y _13899_/Y VPWR VGND sg13cmos5l_a221oi_1
Xhold2960 _17790_/A _19670_/Q VPWR VGND sg13cmos5l_dlygate4sd3_1
Xhold2993 _10525_/A _19805_/Q VPWR VGND sg13cmos5l_dlygate4sd3_1
Xhold2982 _15366_/A _19310_/Q VPWR VGND sg13cmos5l_dlygate4sd3_1
X_14880_ _14880_/Y _14855_/Y _14874_/Y _14879_/Y VPWR VGND sg13cmos5l_o21ai_1
Xhold2971 _18321_/A _19693_/Q VPWR VGND sg13cmos5l_dlygate4sd3_1
XFILLER_90_515 VPWR VGND sg13cmos5l_fill_1
XFILLER_46_41 VPWR VGND sg13cmos5l_decap_8
X_13831_ _13831_/Y _19086_/Q _19080_/Q VPWR VGND sg13cmos5l_nor2b_1
XFILLER_90_526 VPWR VGND sg13cmos5l_fill_1
X_13762_ _13762_/X _13786_/A _13762_/B VPWR VGND sg13cmos5l_and2_1
XFILLER_56_792 VPWR VGND sg13cmos5l_fill_2
X_10974_ _10974_/Y _10989_/B _10989_/C _11191_/A VPWR VGND sg13cmos5l_a21oi_1
X_16550_ _16550_/X _16550_/A _16553_/B VPWR VGND sg13cmos5l_and2_1
X_12713_ _18871_/D _12732_/A _12713_/B VPWR VGND sg13cmos5l_nor2_1
XFILLER_71_740 VPWR VGND sg13cmos5l_fill_1
XFILLER_44_976 VPWR VGND sg13cmos5l_fill_2
X_15501_ _15501_/Y _15774_/A _15495_/A _15500_/A _15779_/B _15496_/Y VPWR VGND sg13cmos5l_a221oi_1
X_13693_ _13714_/C _19059_/Q _13693_/B VPWR VGND sg13cmos5l_xor2_1
XFILLER_71_773 VPWR VGND sg13cmos5l_fill_1
X_18220_ _19707_/D _18273_/B _18220_/B VPWR VGND sg13cmos5l_and2_1
X_16481_ _16481_/Y _19447_/Q _19408_/Q VPWR VGND sg13cmos5l_nand2_1
X_12644_ _12828_/A _18870_/Q _12824_/A VPWR VGND sg13cmos5l_nand2_1
XFILLER_62_51 VPWR VGND sg13cmos5l_fill_2
X_15432_ _15439_/A _15403_/A _15405_/A _15400_/Y VPWR VGND sg13cmos5l_a21oi_1
X_12575_ _12575_/Y _12575_/A _12575_/B VPWR VGND sg13cmos5l_nor2_1
XFILLER_11_350 VPWR VGND sg13cmos5l_fill_1
X_15363_ _15556_/A _19295_/Q _15364_/B VPWR VGND sg13cmos5l_xnor2_1
X_18151_ _18151_/Y _18125_/Y _18130_/Y _18150_/Y VPWR VGND sg13cmos5l_a21oi_1
X_11526_ _11527_/A _18721_/Q _11526_/B VPWR VGND sg13cmos5l_xnor2_1
X_17102_ _17103_/B _17673_/A _19518_/Q VPWR VGND sg13cmos5l_nand2_1
X_18082_ _18201_/A _19712_/Q _18200_/B _18081_/Y VPWR VGND sg13cmos5l_a21oi_1
X_14314_ _14314_/Y _14314_/A _14314_/B VPWR VGND sg13cmos5l_nand2_1
X_18878__1391 _18878_/RESET_B VPWR VGND sg13cmos5l_tiehi
X_17033_ _17034_/B _19540_/Q _17058_/B _16944_/Y VPWR VGND sg13cmos5l_a21oi_1
X_18732__1548 _18732_/RESET_B VPWR VGND sg13cmos5l_tiehi
XFILLER_7_365 VPWR VGND sg13cmos5l_fill_1
XFILLER_7_354 VPWR VGND sg13cmos5l_fill_2
XFILLER_7_343 VPWR VGND sg13cmos5l_fill_1
X_15294_ _15294_/Y _15272_/B _15271_/C _15303_/B VPWR VGND sg13cmos5l_a21oi_1
XFILLER_8_899 VPWR VGND sg13cmos5l_fill_2
X_11457_ _18695_/D _11479_/A _11457_/B VPWR VGND sg13cmos5l_nor2_1
XFILLER_7_398 VPWR VGND sg13cmos5l_decap_4
X_14245_ _14248_/B _19137_/Q _19138_/Q _19139_/Q VPWR VGND sg13cmos5l_o21ai_1
X_19679__1780 _19679_/RESET_B VPWR VGND sg13cmos5l_tiehi
X_10408_ _19811_/D _10409_/B VPWR VGND sg13cmos5l_inv_1
X_11388_ _11388_/Y _11388_/A _18646_/Q _11393_/C VPWR VGND sg13cmos5l_nor3_1
X_14176_ _14178_/B _14176_/A _14199_/B VPWR VGND sg13cmos5l_nor2_1
X_13127_ _13127_/Y _13127_/A VPWR VGND sg13cmos5l_inv_1
X_18984_ _18984_/Q _19087_/CLK _18984_/D _18984_/RESET_B VPWR VGND sg13cmos5l_dfrbpq_1
X_10339_ _18243_/B _19686_/Q VPWR VGND sg13cmos5l_inv_1
X_13058_ _13059_/A _13056_/C _13057_/Y _13056_/Y VPWR VGND sg13cmos5l_a21o_1
X_17935_ _19670_/D _17935_/A _17937_/B VPWR VGND sg13cmos5l_nor2_1
X_12009_ _12009_/Y _12010_/B VPWR VGND sg13cmos5l_inv_1
XFILLER_23_4 VPWR VGND sg13cmos5l_fill_1
X_17866_ _17941_/B _18056_/A _17865_/X _17871_/S VPWR VGND sg13cmos5l_mux2_1
XFILLER_38_214 VPWR VGND sg13cmos5l_fill_1
X_19326__910 _19326_/RESET_B VPWR VGND sg13cmos5l_tiehi
X_16817_ _16817_/X _16817_/A _16829_/A VPWR VGND sg13cmos5l_and2_1
XFILLER_93_342 VPWR VGND sg13cmos5l_decap_8
X_19605_ _19605_/Q clkload28/A _19605_/D _19605_/RESET_B VPWR VGND sg13cmos5l_dfrbpq_1
X_18954__1309 _18954_/RESET_B VPWR VGND sg13cmos5l_tiehi
X_17797_ _17809_/A _17797_/A _17897_/A VPWR VGND sg13cmos5l_nand2_1
X_19127__1124 _19127_/RESET_B VPWR VGND sg13cmos5l_tiehi
X_16748_ _16827_/B _16747_/Y _16714_/Y _16753_/A VPWR VGND sg13cmos5l_mux2_1
X_19536_ _19536_/Q clkload41/A _19536_/D _19536_/RESET_B VPWR VGND sg13cmos5l_dfrbpq_1
X_18650__1643 _18650_/RESET_B VPWR VGND sg13cmos5l_tiehi
X_19402__831 _19402_/RESET_B VPWR VGND sg13cmos5l_tiehi
X_16679_ _16684_/A _19500_/Q _16693_/B VPWR VGND sg13cmos5l_nand2_1
X_19467_ _19467_/Q _19679_/CLK _19467_/D _19467_/RESET_B VPWR VGND sg13cmos5l_dfrbpq_1
XFILLER_34_486 VPWR VGND sg13cmos5l_decap_8
XFILLER_35_998 VPWR VGND sg13cmos5l_fill_1
XFILLER_99_0 VPWR VGND sg13cmos5l_fill_2
X_19539__675 _19539_/RESET_B VPWR VGND sg13cmos5l_tiehi
XFILLER_21_125 VPWR VGND sg13cmos5l_fill_2
X_19398_ _19398_/Q _19462_/CLK _19398_/D _19398_/RESET_B VPWR VGND sg13cmos5l_dfrbpq_1
X_18418_ _18418_/Y _18418_/A _18482_/B VPWR VGND sg13cmos5l_nor2_1
X_18349_ _18349_/Y _18347_/Y _18348_/Y _18346_/Y VPWR VGND sg13cmos5l_a21oi_1
X_19333__903 _19333_/RESET_B VPWR VGND sg13cmos5l_tiehi
Xhold2201 _13600_/A _19040_/Q VPWR VGND sg13cmos5l_dlygate4sd3_1
X_09984_ _09984_/Y _09984_/A VPWR VGND sg13cmos5l_inv_1
Xhold2212 _10204_/A _19357_/Q VPWR VGND sg13cmos5l_dlygate4sd3_1
X_19546__668 _19546_/RESET_B VPWR VGND sg13cmos5l_tiehi
Xhold2234 _10661_/B _10660_/Y VPWR VGND sg13cmos5l_dlygate4sd3_1
Xhold2245 _10266_/A _18895_/Q VPWR VGND sg13cmos5l_dlygate4sd3_1
Xhold2223 _18243_/A _19682_/Q VPWR VGND sg13cmos5l_dlygate4sd3_1
Xhold2278 _10296_/A _18728_/Q VPWR VGND sg13cmos5l_dlygate4sd3_1
Xhold2256 _10312_/A _18599_/Q VPWR VGND sg13cmos5l_dlygate4sd3_1
XFILLER_57_523 VPWR VGND sg13cmos5l_fill_1
Xhold2267 _10190_/A _19744_/Q VPWR VGND sg13cmos5l_dlygate4sd3_1
XFILLER_29_225 VPWR VGND sg13cmos5l_fill_1
Xhold2289 _18725_/D _11675_/Y VPWR VGND sg13cmos5l_dlygate4sd3_1
XFILLER_16_33 VPWR VGND sg13cmos5l_fill_1
XFILLER_80_570 VPWR VGND sg13cmos5l_fill_1
XFILLER_73_1028 VPWR VGND sg13cmos5l_fill_1
X_10690_ _10690_/Y _10384_/A _10688_/Y _10689_/Y VPWR VGND sg13cmos5l_a21oi_1
XFILLER_12_125 VPWR VGND sg13cmos5l_fill_1
X_12360_ _12360_/Y _12352_/Y _12355_/Y _12358_/Y _12302_/B _12359_/Y VPWR VGND sg13cmos5l_a221oi_1
XFILLER_21_681 VPWR VGND sg13cmos5l_fill_2
X_11311_ _11311_/Y _11311_/A VPWR VGND sg13cmos5l_inv_1
XFILLER_5_814 VPWR VGND sg13cmos5l_fill_2
X_12291_ _12292_/B _12291_/A _12299_/B VPWR VGND sg13cmos5l_and2_1
X_11242_ _11266_/A _18664_/Q _11242_/B VPWR VGND sg13cmos5l_xnor2_1
X_14030_ _14030_/X _13916_/B _14079_/B _14045_/S VPWR VGND sg13cmos5l_mux2_1
XFILLER_4_357 VPWR VGND sg13cmos5l_fill_1
XFILLER_106_263 VPWR VGND sg13cmos5l_decap_4
X_11173_ _11173_/X _11173_/A _11173_/B VPWR VGND sg13cmos5l_xor2_1
X_10124_ _16016_/A _10124_/A VPWR VGND sg13cmos5l_inv_1
X_15981_ _15981_/Y _15963_/A _15963_/B _15974_/Y _15979_/Y _15980_/Y VPWR VGND sg13cmos5l_a221oi_1
X_10055_ _13021_/A _10055_/A VPWR VGND sg13cmos5l_inv_1
X_17720_ _19638_/D _17933_/B _17720_/B VPWR VGND sg13cmos5l_nor2_1
X_14932_ _14932_/Y _14932_/A _14932_/B _14932_/C VPWR VGND sg13cmos5l_nand3_1
X_17651_ _17653_/B _17659_/A _17627_/A VPWR VGND sg13cmos5l_nor2b_1
Xhold2790 hold2790/X _11306_/A VPWR VGND sg13cmos5l_dlygate4sd3_1
XFILLER_57_73 VPWR VGND sg13cmos5l_decap_8
X_14863_ _14863_/Y _14850_/A _14916_/B _14849_/Y _14846_/Y _14742_/B VPWR VGND sg13cmos5l_a221oi_1
X_13814_ _19053_/D _13819_/A _13814_/B VPWR VGND sg13cmos5l_nor2_1
X_16602_ _16829_/A _17417_/A _17078_/B VPWR VGND sg13cmos5l_nor2_1
X_17582_ _17582_/Y _17607_/B _17546_/Y VPWR VGND sg13cmos5l_nor2b_1
X_14794_ _14842_/A _15186_/A _14798_/A VPWR VGND sg13cmos5l_xnor2_1
X_19321_ _19321_/Q clkload15/A _19321_/D _19321_/RESET_B VPWR VGND sg13cmos5l_dfrbpq_1
X_13745_ _13778_/C _13744_/A _13770_/A _13754_/A VPWR VGND sg13cmos5l_o21ai_1
X_10957_ _10965_/A _18623_/Q _10958_/B VPWR VGND sg13cmos5l_xnor2_1
X_16533_ _16533_/X _16533_/A _16533_/B VPWR VGND sg13cmos5l_or2_1
XFILLER_32_924 VPWR VGND sg13cmos5l_fill_2
X_13676_ _16632_/A _16821_/A _13676_/B VPWR VGND sg13cmos5l_xnor2_1
X_18776__1499 _18776_/RESET_B VPWR VGND sg13cmos5l_tiehi
X_19252_ _19252_/Q _19304_/CLK _19252_/D _19252_/RESET_B VPWR VGND sg13cmos5l_dfrbpq_1
X_16464_ _16560_/B _16402_/A _16413_/Y _16463_/Y VPWR VGND sg13cmos5l_o21ai_1
X_12627_ _12627_/Y _13020_/A _12627_/B VPWR VGND sg13cmos5l_xnor2_1
X_10888_ _10888_/Y _19784_/Q _19777_/Q VPWR VGND sg13cmos5l_nor2_1
X_18203_ _18205_/A _18206_/A _18206_/B VPWR VGND sg13cmos5l_nor2_1
X_19183_ _19183_/Q _19227_/CLK _19183_/D _19183_/RESET_B VPWR VGND sg13cmos5l_dfrbpq_1
X_15415_ _15415_/Y _15405_/A _15405_/B _15461_/B VPWR VGND sg13cmos5l_a21oi_1
X_16395_ _16463_/A _16400_/B _16395_/B VPWR VGND sg13cmos5l_nand2b_1
X_18134_ _18134_/Y _18125_/Y _18130_/Y _18131_/Y VPWR VGND sg13cmos5l_a21oi_1
X_12558_ _12685_/A _12574_/B _12557_/Y _12556_/Y VPWR VGND sg13cmos5l_a21o_1
XFILLER_89_1013 VPWR VGND sg13cmos5l_decap_8
X_15346_ _15346_/Y _19290_/Q _19305_/Q VPWR VGND sg13cmos5l_nand2_1
X_12489_ _12489_/Y _12479_/B _12487_/Y _12488_/Y _12498_/C VPWR VGND sg13cmos5l_a22oi_1
X_11509_ _11512_/B _18722_/Q _11511_/B VPWR VGND sg13cmos5l_nor2b_1
X_18065_ _18169_/B _18032_/B _18034_/Y _17875_/X VPWR VGND sg13cmos5l_a21oi_1
XFILLER_7_173 VPWR VGND sg13cmos5l_decap_8
X_15277_ _15278_/B _19246_/Q _15277_/B VPWR VGND sg13cmos5l_xnor2_1
X_17016_ _17089_/B _16994_/A _17015_/Y _17020_/S VPWR VGND sg13cmos5l_mux2_1
X_14228_ _14343_/A _14211_/A _14226_/B _14227_/Y VPWR VGND sg13cmos5l_a21oi_1
XFILLER_98_412 VPWR VGND sg13cmos5l_decap_8
X_18668__1625 _18668_/RESET_B VPWR VGND sg13cmos5l_tiehi
X_14159_ _14167_/B _19077_/Q _14160_/B VPWR VGND sg13cmos5l_nor2b_1
X_18967_ _18967_/Q clkload64/A _18967_/D _18967_/RESET_B VPWR VGND sg13cmos5l_dfrbpq_1
X_18898_ _18898_/Q _19087_/CLK _18898_/D _18898_/RESET_B VPWR VGND sg13cmos5l_dfrbpq_1
X_17918_ _17918_/Y _17893_/X _17928_/S _17943_/A VPWR VGND sg13cmos5l_o21ai_1
XFILLER_39_523 VPWR VGND sg13cmos5l_fill_1
XFILLER_39_545 VPWR VGND sg13cmos5l_fill_2
X_17849_ _17871_/S _17841_/Y _17846_/Y _17848_/Y VPWR VGND sg13cmos5l_o21ai_1
XFILLER_96_1028 VPWR VGND sg13cmos5l_fill_1
X_18571__1731 _18571_/RESET_B VPWR VGND sg13cmos5l_tiehi
XFILLER_54_537 VPWR VGND sg13cmos5l_fill_2
XFILLER_82_868 VPWR VGND sg13cmos5l_fill_2
XFILLER_81_356 VPWR VGND sg13cmos5l_fill_2
X_19519_ _19519_/Q _19814_/CLK _19519_/D _19519_/RESET_B VPWR VGND sg13cmos5l_dfrbpq_1
X_18918__1348 _18918_/RESET_B VPWR VGND sg13cmos5l_tiehi
X_18614__1682 _18614_/RESET_B VPWR VGND sg13cmos5l_tiehi
XFILLER_103_233 VPWR VGND sg13cmos5l_fill_1
XFILLER_89_434 VPWR VGND sg13cmos5l_fill_2
XFILLER_103_266 VPWR VGND sg13cmos5l_fill_1
X_09967_ _09967_/Y _18346_/A VPWR VGND sg13cmos5l_inv_1
Xhold2020 _09970_/A _19647_/Q VPWR VGND sg13cmos5l_dlygate4sd3_1
X_19191__1057 _19191_/RESET_B VPWR VGND sg13cmos5l_tiehi
Xhold2042 _09982_/A _19442_/Q VPWR VGND sg13cmos5l_dlygate4sd3_1
Xhold2053 _19270_/D _15237_/Y VPWR VGND sg13cmos5l_dlygate4sd3_1
Xhold2031 hold2031/X _19363_/Q VPWR VGND sg13cmos5l_dlygate4sd3_1
XFILLER_100_973 VPWR VGND sg13cmos5l_fill_1
Xhold2097 _10555_/A _19742_/Q VPWR VGND sg13cmos5l_dlygate4sd3_1
X_19268__974 _19268_/RESET_B VPWR VGND sg13cmos5l_tiehi
Xhold2086 _09985_/A _19439_/Q VPWR VGND sg13cmos5l_dlygate4sd3_1
Xhold2075 _10207_/A _19354_/Q VPWR VGND sg13cmos5l_dlygate4sd3_1
Xhold2064 _15030_/A _19237_/Q VPWR VGND sg13cmos5l_dlygate4sd3_1
X_11860_ _11863_/A _11860_/A VPWR VGND sg13cmos5l_inv_1
XFILLER_72_334 VPWR VGND sg13cmos5l_fill_1
X_19774__607 _19774_/RESET_B VPWR VGND sg13cmos5l_tiehi
X_11791_ _11797_/B _11827_/A _11791_/B VPWR VGND sg13cmos5l_nor2_1
X_10811_ _18584_/D _10721_/Y _10808_/B _18592_/D VPWR VGND sg13cmos5l_a21o_1
X_10742_ _10742_/Y input3/X fanout68/X _10746_/A VPWR VGND sg13cmos5l_o21ai_1
X_13530_ _13531_/B _13584_/B _13548_/B _13529_/Y VPWR VGND sg13cmos5l_o21ai_1
XFILLER_43_42 VPWR VGND sg13cmos5l_fill_1
XFILLER_13_467 VPWR VGND sg13cmos5l_decap_8
X_19553__447 _19553_/D VPWR VGND sg13cmos5l_tielo
X_10673_ _10674_/D _10680_/A _10673_/B _10673_/C VPWR VGND sg13cmos5l_nand3b_1
X_13461_ _13461_/X _13467_/B _13465_/B _13506_/A VPWR VGND sg13cmos5l_a21o_1
X_15200_ _15200_/Y _15739_/A _19231_/Q _15196_/Y _15199_/Y VPWR VGND sg13cmos5l_a22oi_1
X_12412_ _12413_/B _12464_/B _12298_/B _12429_/B VPWR VGND sg13cmos5l_mux2_1
X_13392_ _13394_/B _13393_/A _13419_/B VPWR VGND sg13cmos5l_nor2_1
X_16180_ _16244_/A _19434_/Q _16202_/D VPWR VGND sg13cmos5l_xor2_1
X_19275__967 _19275_/RESET_B VPWR VGND sg13cmos5l_tiehi
X_12343_ _12343_/Y _12334_/A _12368_/A _12342_/A _12342_/B VPWR VGND sg13cmos5l_a22oi_1
X_15131_ _15131_/X _15142_/B _15142_/C VPWR VGND sg13cmos5l_or2_1
X_12274_ _12274_/X _12274_/A _12303_/A VPWR VGND sg13cmos5l_and2_1
X_15062_ _15072_/B _19249_/Q _19250_/Q VPWR VGND sg13cmos5l_nor2_1
X_11225_ _11237_/A _11225_/A _11225_/B VPWR VGND sg13cmos5l_nor2_1
X_14013_ _14013_/Y _14013_/A _14013_/B VPWR VGND sg13cmos5l_nor2_1
X_18821_ _18821_/Q clkload62/A _18821_/D _18821_/RESET_B VPWR VGND sg13cmos5l_dfrbpq_1
XFILLER_96_938 VPWR VGND sg13cmos5l_fill_2
X_11156_ _11156_/X _18614_/Q _11171_/D VPWR VGND sg13cmos5l_xor2_1
XFILLER_95_437 VPWR VGND sg13cmos5l_decap_4
X_19529__685 _19529_/RESET_B VPWR VGND sg13cmos5l_tiehi
X_18752_ _18752_/Q clkload40/A _18752_/D _18752_/RESET_B VPWR VGND sg13cmos5l_dfrbpq_1
XFILLER_68_94 VPWR VGND sg13cmos5l_decap_8
X_18994__1266 _18994_/RESET_B VPWR VGND sg13cmos5l_tiehi
X_11087_ _18634_/D _11089_/A _11087_/B VPWR VGND sg13cmos5l_nor2_1
X_10107_ _15458_/A _10107_/A VPWR VGND sg13cmos5l_inv_1
X_19167__1081 _19167_/RESET_B VPWR VGND sg13cmos5l_tiehi
X_15964_ _15965_/B _19382_/Q _15887_/B _15865_/Y VPWR VGND sg13cmos5l_a21oi_1
X_10038_ _12460_/A _10038_/A VPWR VGND sg13cmos5l_inv_1
X_17703_ _17703_/Y _18224_/A _19664_/Q _17709_/C VPWR VGND sg13cmos5l_nor3_1
X_14915_ _19225_/D _14915_/A _14915_/B VPWR VGND sg13cmos5l_nor2_1
X_18683_ _18683_/Q clkload59/A _18683_/D _18683_/RESET_B VPWR VGND sg13cmos5l_dfrbpq_1
X_15895_ _15895_/X _15904_/B _15902_/B VPWR VGND sg13cmos5l_and2_1
XFILLER_36_526 VPWR VGND sg13cmos5l_fill_2
X_17634_ _17634_/Y _17634_/A _17634_/B VPWR VGND sg13cmos5l_nor2_1
X_14846_ _14846_/Y _14836_/Y _14841_/Y _14845_/Y VPWR VGND sg13cmos5l_o21ai_1
X_19323__913 _19323_/RESET_B VPWR VGND sg13cmos5l_tiehi
X_17565_ _17572_/B _17936_/A _17566_/B VPWR VGND sg13cmos5l_nand2_1
XFILLER_51_529 VPWR VGND sg13cmos5l_fill_2
X_14777_ _14779_/B _14884_/A _14883_/A VPWR VGND sg13cmos5l_nor2_1
X_11989_ _11989_/Y _11989_/A _12022_/A VPWR VGND sg13cmos5l_nor2_1
X_13728_ _13728_/Y _13728_/A _13819_/B VPWR VGND sg13cmos5l_nor2_1
XFILLER_56_1023 VPWR VGND sg13cmos5l_decap_4
X_19304_ _19304_/Q _19304_/CLK _19304_/D _19304_/RESET_B VPWR VGND sg13cmos5l_dfrbpq_1
X_16516_ _16517_/B _16516_/A _16524_/B VPWR VGND sg13cmos5l_and2_1
XFILLER_32_710 VPWR VGND sg13cmos5l_fill_2
X_17496_ _17498_/B _17474_/Y _17495_/Y _17494_/X VPWR VGND sg13cmos5l_a21oi_1
X_19235_ _19235_/Q _19805_/CLK _19235_/D _19235_/RESET_B VPWR VGND sg13cmos5l_dfrbpq_1
X_13659_ _13659_/X _13666_/B _13664_/B _16641_/A VPWR VGND sg13cmos5l_a21o_1
X_16447_ _16447_/X _16448_/C _16448_/D VPWR VGND sg13cmos5l_and2_1
X_19536__678 _19536_/RESET_B VPWR VGND sg13cmos5l_tiehi
X_18602__1697 _18602_/RESET_B VPWR VGND sg13cmos5l_tiehi
XFILLER_9_961 VPWR VGND sg13cmos5l_fill_2
X_19166_ _19166_/Q clkload50/A _19166_/D _19166_/RESET_B VPWR VGND sg13cmos5l_dfrbpq_1
X_16378_ _16396_/A _19463_/Q _19464_/Q _19465_/Q VPWR VGND sg13cmos5l_or3_1
X_19097_ _19097_/Q _19136_/CLK _19097_/D _19097_/RESET_B VPWR VGND sg13cmos5l_dfrbpq_1
XFILLER_9_994 VPWR VGND sg13cmos5l_decap_4
X_15329_ _15435_/A _15327_/Y _15328_/X _15313_/Y VPWR VGND sg13cmos5l_o21ai_1
X_18117_ _18117_/X _18120_/B _18117_/B _18309_/A VPWR VGND sg13cmos5l_and3_1
X_18048_ _18048_/X _18039_/X _18046_/Y _18045_/Y VPWR VGND sg13cmos5l_a21o_1
XFILLER_99_721 VPWR VGND sg13cmos5l_fill_1
X_19330__906 _19330_/RESET_B VPWR VGND sg13cmos5l_tiehi
XFILLER_101_737 VPWR VGND sg13cmos5l_fill_1
XFILLER_86_437 VPWR VGND sg13cmos5l_fill_1
XFILLER_66_150 VPWR VGND sg13cmos5l_fill_1
XFILLER_54_323 VPWR VGND sg13cmos5l_fill_1
XFILLER_54_367 VPWR VGND sg13cmos5l_fill_1
XFILLER_23_732 VPWR VGND sg13cmos5l_fill_2
Xfanout46 _13803_/A _13791_/Y VPWR VGND sg13cmos5l_buf_1
Xfanout24 _17659_/A _17662_/A VPWR VGND sg13cmos5l_buf_1
Xfanout35 _16063_/S _16060_/Y VPWR VGND sg13cmos5l_buf_1
Xfanout57 _11672_/S _11669_/Y VPWR VGND sg13cmos5l_buf_1
Xfanout79 fanout79/X fanout80/X VPWR VGND sg13cmos5l_buf_1
Xfanout68 fanout68/X fanout70/X VPWR VGND sg13cmos5l_buf_1
XFILLER_11_927 VPWR VGND sg13cmos5l_fill_2
X_18749__1529 _18749_/RESET_B VPWR VGND sg13cmos5l_tiehi
XFILLER_78_938 VPWR VGND sg13cmos5l_decap_4
X_11010_ _11049_/B _11010_/A _11022_/B VPWR VGND sg13cmos5l_nand2_1
XFILLER_1_146 VPWR VGND sg13cmos5l_fill_1
XFILLER_2_669 VPWR VGND sg13cmos5l_fill_1
XFILLER_86_971 VPWR VGND sg13cmos5l_fill_1
X_12961_ _13028_/B _12910_/Y _12948_/B _12960_/Y VPWR VGND sg13cmos5l_a21o_1
XFILLER_58_684 VPWR VGND sg13cmos5l_fill_2
XFILLER_18_515 VPWR VGND sg13cmos5l_fill_1
X_11912_ _11912_/Y _18790_/Q _11937_/B _11911_/Y VPWR VGND sg13cmos5l_a21oi_1
X_12892_ _12941_/A _12908_/D _12892_/B VPWR VGND sg13cmos5l_and2_1
X_15680_ _15680_/Y _15584_/B _15747_/B _15675_/Y VPWR VGND sg13cmos5l_a21oi_1
X_14700_ _14700_/Y _14932_/B _14700_/B VPWR VGND sg13cmos5l_nand2_1
X_11843_ _11867_/B _11852_/B _11852_/C VPWR VGND sg13cmos5l_nand2_1
X_14631_ _19167_/D _14591_/A _14628_/S _14630_/Y VPWR VGND sg13cmos5l_a21oi_1
X_17350_ _17350_/Y _17338_/Y _17343_/Y _17349_/Y VPWR VGND sg13cmos5l_a21oi_1
XFILLER_60_326 VPWR VGND sg13cmos5l_fill_1
X_11774_ _11846_/A _11874_/A _11774_/B VPWR VGND sg13cmos5l_nand2_1
X_16301_ _16301_/Y _16265_/B fanout34/X _16308_/B VPWR VGND sg13cmos5l_o21ai_1
X_14562_ _14645_/B _14573_/S _14743_/A _14561_/Y VPWR VGND sg13cmos5l_a21o_1
X_10725_ _10725_/Y _10734_/A hold2683/X VPWR VGND sg13cmos5l_nor2b_1
X_17281_ _17298_/A _17265_/Y _17275_/X _17279_/Y VPWR VGND sg13cmos5l_o21ai_1
X_13513_ _13513_/Y _13513_/A _13513_/B VPWR VGND sg13cmos5l_nor2_1
X_14493_ _14493_/Y _19153_/Q _19114_/Q VPWR VGND sg13cmos5l_nand2_1
X_19020_ _19020_/Q clkload33/A _19020_/D _19020_/RESET_B VPWR VGND sg13cmos5l_dfrbpq_1
X_10656_ _10656_/Y _10019_/A _10663_/A _16603_/B VPWR VGND sg13cmos5l_o21ai_1
X_13444_ _13554_/A _19008_/Q _13447_/B _13443_/Y VPWR VGND sg13cmos5l_a21oi_1
X_16232_ _16232_/Y _16316_/B VPWR VGND sg13cmos5l_inv_1
X_16163_ _16163_/Y _16280_/B _16280_/C _16280_/A VPWR VGND sg13cmos5l_a21oi_1
Xclkload16 clkload16/Y clkload16/A VPWR VGND sg13cmos5l_inv_4
Xclkload38 clkload38/Y clkload38/A VPWR VGND sg13cmos5l_inv_1
Xclkload27 clkload27/X clkload27/A VPWR VGND sg13cmos5l_buf_8
X_13375_ _13383_/B _18951_/Q _13376_/B VPWR VGND sg13cmos5l_nor2b_1
X_15114_ _15114_/Y _15114_/A _15119_/B VPWR VGND sg13cmos5l_nand2_1
Xclkload49 clkload49/Y clkload49/A VPWR VGND sg13cmos5l_inv_1
X_10587_ _10587_/Y _18545_/A _10646_/A _18546_/A _10586_/Y VPWR VGND sg13cmos5l_a22oi_1
X_12326_ _12326_/Y _12724_/A _12324_/X _12325_/Y _12323_/X VPWR VGND sg13cmos5l_a22oi_1
XFILLER_86_1027 VPWR VGND sg13cmos5l_fill_2
X_16094_ _16124_/B _19367_/Q _19368_/Q VPWR VGND sg13cmos5l_xnor2_1
X_12257_ _12257_/Y hold1983/X fanout95/X _12527_/A VPWR VGND sg13cmos5l_o21ai_1
X_15045_ _15045_/Y _15154_/B _15154_/C _15154_/A VPWR VGND sg13cmos5l_a21oi_1
X_12188_ _18793_/D _12188_/A _12188_/B VPWR VGND sg13cmos5l_and2_1
X_11208_ _18657_/D _11358_/A _11208_/B VPWR VGND sg13cmos5l_nor2_1
X_18804_ _18804_/Q clkload60/A _18804_/D _18804_/RESET_B VPWR VGND sg13cmos5l_dfrbpq_1
XFILLER_84_908 VPWR VGND sg13cmos5l_fill_2
XFILLER_83_407 VPWR VGND sg13cmos5l_fill_2
X_16996_ _17171_/A _17369_/A _16996_/B VPWR VGND sg13cmos5l_xnor2_1
X_11139_ _11139_/Y _11119_/B _11133_/S _11351_/B VPWR VGND sg13cmos5l_o21ai_1
X_19784_ _19784_/Q clkload48/A _19784_/D _19784_/RESET_B VPWR VGND sg13cmos5l_dfrbpq_1
XFILLER_95_81 VPWR VGND sg13cmos5l_fill_2
XFILLER_77_971 VPWR VGND sg13cmos5l_fill_1
X_18735_ _18735_/Q clkload57/A _18735_/D _18735_/RESET_B VPWR VGND sg13cmos5l_dfrbpq_1
XFILLER_64_610 VPWR VGND sg13cmos5l_fill_1
XFILLER_48_161 VPWR VGND sg13cmos5l_fill_1
X_15947_ _16020_/B _15909_/A _15946_/Y _15952_/A VPWR VGND sg13cmos5l_mux2_1
X_18666_ _18666_/Q _18733_/CLK _18666_/D _18666_/RESET_B VPWR VGND sg13cmos5l_dfrbpq_1
X_15878_ _15891_/A _15878_/A _15878_/B VPWR VGND sg13cmos5l_nor2_1
XFILLER_36_312 VPWR VGND sg13cmos5l_decap_4
XFILLER_36_345 VPWR VGND sg13cmos5l_fill_1
X_17617_ _17639_/B _17502_/B _17642_/B _17616_/Y _17612_/Y VPWR VGND sg13cmos5l_a22oi_1
X_14829_ _14829_/Y _14843_/S _14827_/Y _14828_/Y VPWR VGND sg13cmos5l_o21ai_1
X_18597_ _18597_/Q clkload30/A _18597_/D _18597_/RESET_B VPWR VGND sg13cmos5l_dfrbpq_1
X_17548_ _17548_/X _17549_/A _17549_/B _17549_/C VPWR VGND sg13cmos5l_and3_1
X_17479_ _19609_/D _17677_/A _17479_/B VPWR VGND sg13cmos5l_and2_1
X_19218_ _19218_/Q clkload51/A _19218_/D _19218_/RESET_B VPWR VGND sg13cmos5l_dfrbpq_1
X_19784__1232 _19784_/RESET_B VPWR VGND sg13cmos5l_tiehi
X_19149_ _19149_/Q _19262_/CLK _19149_/D _19149_/RESET_B VPWR VGND sg13cmos5l_dfrbpq_1
X_19258__984 _19258_/RESET_B VPWR VGND sg13cmos5l_tiehi
X_19768__742 _19768_/RESET_B VPWR VGND sg13cmos5l_tiehi
X_19207__1038 _19207_/RESET_B VPWR VGND sg13cmos5l_tiehi
Xfanout214 _17679_/A _17671_/B VPWR VGND sg13cmos5l_buf_1
Xfanout203 _18233_/A _18213_/A VPWR VGND sg13cmos5l_buf_1
XFILLER_101_523 VPWR VGND sg13cmos5l_fill_1
Xfanout225 _16939_/A _17079_/B VPWR VGND sg13cmos5l_buf_1
Xfanout236 _16312_/B _16314_/B VPWR VGND sg13cmos5l_buf_1
Xfanout247 _15736_/B _15506_/Y VPWR VGND sg13cmos5l_buf_1
XFILLER_101_567 VPWR VGND sg13cmos5l_fill_2
Xfanout269 _14375_/A _14123_/Y VPWR VGND sg13cmos5l_buf_1
Xfanout258 _14915_/A _14902_/A VPWR VGND sg13cmos5l_buf_1
XFILLER_55_610 VPWR VGND sg13cmos5l_fill_1
X_19265__977 _19265_/RESET_B VPWR VGND sg13cmos5l_tiehi
XFILLER_91_28 VPWR VGND sg13cmos5l_fill_2
XFILLER_70_635 VPWR VGND sg13cmos5l_fill_2
X_11490_ _11582_/C _18691_/Q _18652_/Q _18711_/Q VPWR VGND sg13cmos5l_nand3_1
X_18663__1630 _18663_/RESET_B VPWR VGND sg13cmos5l_tiehi
X_10510_ _10512_/B _10590_/B _10510_/B VPWR VGND sg13cmos5l_nand2b_1
X_10441_ _10442_/D _18835_/Q _18877_/Q _18919_/Q _18961_/Q VPWR VGND sg13cmos5l_nor4_1
X_10372_ _10372_/Y _16860_/B VPWR VGND sg13cmos5l_inv_1
X_13160_ _13160_/X _18954_/Q _18969_/Q VPWR VGND sg13cmos5l_and2_1
X_12111_ _12116_/C _12111_/A _12111_/B VPWR VGND sg13cmos5l_nand2_1
X_13091_ _13122_/A _18905_/Q _18906_/Q VPWR VGND sg13cmos5l_xnor2_1
XFILLER_40_98 VPWR VGND sg13cmos5l_decap_8
X_12042_ _12153_/B _12054_/A _12054_/B VPWR VGND sg13cmos5l_nand2_1
XFILLER_46_1022 VPWR VGND sg13cmos5l_decap_8
X_18913__1353 _18913_/RESET_B VPWR VGND sg13cmos5l_tiehi
X_16850_ _16850_/Y _17371_/A _19532_/Q _16861_/C VPWR VGND sg13cmos5l_nand3_1
X_16781_ _16781_/Y _16781_/A _16792_/B _16781_/C VPWR VGND sg13cmos5l_nand3_1
X_19526__688 _19526_/RESET_B VPWR VGND sg13cmos5l_tiehi
XFILLER_59_993 VPWR VGND sg13cmos5l_fill_1
X_13993_ _14078_/B hold2751/X _14180_/A _14010_/B VPWR VGND sg13cmos5l_mux2_1
X_15801_ _19359_/D _15784_/Y hold2409/X _16022_/A VPWR VGND sg13cmos5l_a21oi_1
X_12944_ _12944_/Y _12943_/A _12944_/B VPWR VGND sg13cmos5l_nand2b_1
XFILLER_65_51 VPWR VGND sg13cmos5l_fill_2
X_18520_ _18521_/B _19769_/Q _18518_/Y _10854_/A VPWR VGND sg13cmos5l_o21ai_1
X_15732_ _19336_/D hold2933/X _15727_/S _15731_/Y VPWR VGND sg13cmos5l_a21oi_1
XFILLER_74_974 VPWR VGND sg13cmos5l_fill_2
XFILLER_65_73 VPWR VGND sg13cmos5l_fill_2
XFILLER_46_654 VPWR VGND sg13cmos5l_decap_4
X_18451_ _18451_/Y _18451_/A _18451_/B VPWR VGND sg13cmos5l_xnor2_1
X_19496__721 _19496_/RESET_B VPWR VGND sg13cmos5l_tiehi
X_12875_ _12991_/B _18925_/Q _12875_/B VPWR VGND sg13cmos5l_and2_1
XFILLER_65_95 VPWR VGND sg13cmos5l_fill_2
X_17402_ _17407_/B _17402_/A _17402_/B VPWR VGND sg13cmos5l_nor2_1
X_15663_ _15663_/Y _15640_/B _15631_/B _15671_/B VPWR VGND sg13cmos5l_a21oi_1
X_11826_ _12017_/A _11826_/A _11998_/B VPWR VGND sg13cmos5l_nor2_1
X_14614_ _14614_/Y _14591_/Y _14608_/Y _14613_/Y VPWR VGND sg13cmos5l_o21ai_1
X_15594_ _15701_/A _19342_/Q _15608_/B VPWR VGND sg13cmos5l_xnor2_1
X_18382_ _18409_/A _19760_/Q _18382_/B VPWR VGND sg13cmos5l_xor2_1
X_11757_ _11858_/B _11769_/A _11769_/B VPWR VGND sg13cmos5l_nand2_1
XFILLER_81_50 VPWR VGND sg13cmos5l_fill_1
X_17333_ _17335_/B _17333_/A _17333_/B VPWR VGND sg13cmos5l_nor2_1
X_14545_ _14545_/Y _14545_/A _14572_/A VPWR VGND sg13cmos5l_nor2_1
X_10708_ _10708_/Y _13809_/A _10708_/B VPWR VGND sg13cmos5l_nand2_1
X_17264_ _17264_/Y _17306_/A _17455_/A _17464_/A _17310_/A VPWR VGND sg13cmos5l_a22oi_1
X_11688_ _11688_/Y hold2046/X fanout94/X _10860_/B VPWR VGND sg13cmos5l_o21ai_1
X_19003_ _19003_/Q _19003_/CLK _19003_/D _19003_/RESET_B VPWR VGND sg13cmos5l_dfrbpq_1
X_16215_ _16243_/A _16200_/Y _16208_/Y _16248_/B _16255_/B _16213_/Y VPWR VGND sg13cmos5l_a221oi_1
X_14476_ _14477_/B _14476_/A _14476_/B VPWR VGND sg13cmos5l_and2_1
X_17195_ _17304_/B _17203_/B _17178_/X _17193_/Y VPWR VGND sg13cmos5l_o21ai_1
X_13427_ _13427_/Y _18985_/Q _13439_/B VPWR VGND sg13cmos5l_nand2_1
X_10639_ _19795_/D _18258_/A _10642_/B VPWR VGND sg13cmos5l_nor2_1
X_13358_ _18987_/D _14070_/A _13358_/B VPWR VGND sg13cmos5l_and2_1
X_16146_ _19414_/D _16318_/A _16261_/A VPWR VGND sg13cmos5l_and2_1
X_12309_ _12429_/A _12288_/Y _12307_/Y _12306_/X VPWR VGND sg13cmos5l_a21o_1
X_16077_ _16077_/Y _19362_/Q fanout66/X _16307_/A VPWR VGND sg13cmos5l_o21ai_1
X_13289_ _18966_/D _13289_/A _13289_/B VPWR VGND sg13cmos5l_nor2_1
X_15028_ _15163_/A _15000_/B _15024_/B _14820_/Y VPWR VGND sg13cmos5l_a21o_1
Xhold2619 hold2619/X _12055_/Y VPWR VGND sg13cmos5l_dlygate4sd3_1
XFILLER_68_201 VPWR VGND sg13cmos5l_fill_1
Xhold2608 _10136_/A _19422_/Q VPWR VGND sg13cmos5l_dlygate4sd3_1
Xhold1907 _19521_/D _16888_/Y VPWR VGND sg13cmos5l_dlygate4sd3_1
XFILLER_68_223 VPWR VGND sg13cmos5l_fill_2
Xhold1918 _16159_/A _19405_/Q VPWR VGND sg13cmos5l_dlygate4sd3_1
Xhold1929 _11692_/B _18694_/Q VPWR VGND sg13cmos5l_dlygate4sd3_1
X_19767_ _19767_/Q clkload21/A _19767_/D _19767_/RESET_B VPWR VGND sg13cmos5l_dfrbpq_1
X_16979_ _16979_/X _16979_/A _16979_/B VPWR VGND sg13cmos5l_xor2_1
X_18718_ _18718_/Q clkload57/A _18718_/D _18718_/RESET_B VPWR VGND sg13cmos5l_dfrbpq_1
Xinput3 input3/X ui_in[1] VPWR VGND sg13cmos5l_buf_1
X_19698_ _19698_/Q _19738_/CLK _19698_/D _19698_/RESET_B VPWR VGND sg13cmos5l_dfrbpq_1
X_18649_ _18649_/Q clkload21/A _18649_/D _18649_/RESET_B VPWR VGND sg13cmos5l_dfrbpq_1
XFILLER_52_624 VPWR VGND sg13cmos5l_fill_2
XFILLER_101_38 VPWR VGND sg13cmos5l_fill_1
XFILLER_80_977 VPWR VGND sg13cmos5l_fill_2
XFILLER_80_955 VPWR VGND sg13cmos5l_fill_1
X_18789__1486 _18789_/RESET_B VPWR VGND sg13cmos5l_tiehi
Xheichips26_digital_project_420 uo_out[11] VPWR VGND sg13cmos5l_tielo
XFILLER_102_865 VPWR VGND sg13cmos5l_fill_2
XFILLER_87_565 VPWR VGND sg13cmos5l_fill_1
XFILLER_59_267 VPWR VGND sg13cmos5l_fill_2
XFILLER_47_429 VPWR VGND sg13cmos5l_fill_2
X_19038__1219 _19038_/RESET_B VPWR VGND sg13cmos5l_tiehi
XFILLER_55_440 VPWR VGND sg13cmos5l_fill_2
X_10990_ _11204_/A _11174_/A _10990_/B VPWR VGND sg13cmos5l_nand2_1
XFILLER_27_153 VPWR VGND sg13cmos5l_fill_1
X_12660_ _12660_/X _12664_/S _12843_/A _12658_/X VPWR VGND sg13cmos5l_a21o_1
XFILLER_42_123 VPWR VGND sg13cmos5l_fill_1
X_11611_ _11613_/B _11611_/A _11614_/B VPWR VGND sg13cmos5l_nor2b_1
X_12591_ _12688_/C _18859_/Q _18820_/Q _18879_/Q VPWR VGND sg13cmos5l_nand3_1
XFILLER_51_690 VPWR VGND sg13cmos5l_fill_1
X_14330_ _14330_/Y _14343_/A _14229_/X _14328_/A _14328_/B _14329_/X VPWR VGND sg13cmos5l_a221oi_1
X_11542_ _11542_/Y _11711_/A _11527_/A _11560_/A _11559_/B VPWR VGND sg13cmos5l_a22oi_1
XFILLER_7_503 VPWR VGND sg13cmos5l_decap_4
X_11473_ _11473_/Y _11473_/A _11473_/B VPWR VGND sg13cmos5l_nor2_1
XFILLER_7_525 VPWR VGND sg13cmos5l_fill_2
X_14261_ _14261_/Y _14260_/A _14261_/B VPWR VGND sg13cmos5l_nand2b_1
X_10424_ _10424_/Y _10395_/Y _10402_/Y _19813_/Q VPWR VGND sg13cmos5l_o21ai_1
X_13212_ _13212_/Y _13212_/A _13212_/B VPWR VGND sg13cmos5l_nand2_1
XFILLER_7_569 VPWR VGND sg13cmos5l_fill_2
X_16000_ _19375_/D _16020_/A _16000_/B VPWR VGND sg13cmos5l_nor2_1
X_14192_ _14192_/Y _14193_/B VPWR VGND sg13cmos5l_inv_1
X_13143_ _13159_/A _18969_/Q _18970_/Q _18971_/Q VPWR VGND sg13cmos5l_or3_1
X_10355_ _17379_/B _10355_/A VPWR VGND sg13cmos5l_inv_1
X_10286_ _10286_/Y _10286_/A VPWR VGND sg13cmos5l_inv_1
X_13074_ _13074_/Y _13323_/A _13067_/S _13073_/Y VPWR VGND sg13cmos5l_a21oi_1
X_17951_ _17951_/Y _18475_/A _19642_/Q _17950_/Y VPWR VGND sg13cmos5l_o21ai_1
XFILLER_2_252 VPWR VGND sg13cmos5l_fill_1
X_12025_ _12027_/B _12024_/A _12024_/B _12023_/Y VPWR VGND sg13cmos5l_o21ai_1
X_16902_ _16902_/X _16908_/D _16897_/C _16897_/A VPWR VGND sg13cmos5l_a21o_1
X_17882_ _17882_/Y _17941_/B _17904_/B VPWR VGND sg13cmos5l_nor2_1
XFILLER_39_908 VPWR VGND sg13cmos5l_fill_1
XFILLER_93_502 VPWR VGND sg13cmos5l_fill_1
X_16833_ _16834_/B _17367_/A _19472_/Q _19471_/Q _17366_/A VPWR VGND sg13cmos5l_a22oi_1
X_19621_ _19621_/Q clkload25/A _19621_/D _19621_/RESET_B VPWR VGND sg13cmos5l_dfrbpq_1
XFILLER_76_94 VPWR VGND sg13cmos5l_fill_2
XFILLER_76_72 VPWR VGND sg13cmos5l_fill_1
X_16764_ _16797_/B _16792_/B _16764_/B VPWR VGND sg13cmos5l_and2_1
X_19552_ _19552_/Q clkload39/A _19552_/D _19552_/RESET_B VPWR VGND sg13cmos5l_dfrbpq_1
XFILLER_47_974 VPWR VGND sg13cmos5l_decap_8
XFILLER_47_963 VPWR VGND sg13cmos5l_decap_4
X_13976_ _14164_/A _14369_/A _13976_/B VPWR VGND sg13cmos5l_xnor2_1
X_19248__994 _19248_/RESET_B VPWR VGND sg13cmos5l_tiehi
X_19483_ _19483_/Q _19546_/CLK _19483_/D _19483_/RESET_B VPWR VGND sg13cmos5l_dfrbpq_1
X_16695_ _16710_/B _19493_/Q _19492_/Q _16722_/A VPWR VGND sg13cmos5l_nor3_1
X_12927_ _12931_/C _12933_/A _12927_/B VPWR VGND sg13cmos5l_nand2_1
XFILLER_74_782 VPWR VGND sg13cmos5l_fill_1
X_18503_ _18503_/Y _19790_/Q _18486_/A VPWR VGND sg13cmos5l_nor2b_1
X_19783__1275 _19783_/RESET_B VPWR VGND sg13cmos5l_tiehi
X_15715_ _15716_/B _19345_/Q _15721_/B VPWR VGND sg13cmos5l_xor2_1
XFILLER_34_624 VPWR VGND sg13cmos5l_fill_1
X_12858_ _12858_/Y _18900_/Q _18861_/Q VPWR VGND sg13cmos5l_xnor2_1
X_15646_ _15671_/B _19353_/Q _15646_/B VPWR VGND sg13cmos5l_xor2_1
X_18434_ _18434_/Y _18436_/B _18368_/B _18478_/B _18445_/B _18431_/Y VPWR VGND sg13cmos5l_a221oi_1
X_11809_ _11827_/B _11797_/X _11804_/Y _11808_/Y VPWR VGND sg13cmos5l_a21oi_1
X_18365_ _18452_/A _18363_/Y _18364_/X _18351_/Y VPWR VGND sg13cmos5l_o21ai_1
XFILLER_21_307 VPWR VGND sg13cmos5l_fill_1
XFILLER_33_156 VPWR VGND sg13cmos5l_decap_4
X_12789_ _12789_/Y hold1990/X fanout96/X _12527_/A VPWR VGND sg13cmos5l_o21ai_1
X_17316_ _17316_/Y _17316_/A _17316_/B VPWR VGND sg13cmos5l_nor2_1
X_15577_ _19327_/D _15748_/A _15577_/B VPWR VGND sg13cmos5l_nor2_1
X_18744__1534 _18744_/RESET_B VPWR VGND sg13cmos5l_tiehi
X_14528_ _14528_/Y _19168_/Q _14533_/A VPWR VGND sg13cmos5l_xnor2_1
X_18296_ _18299_/B _19695_/Q _19696_/Q _19693_/Q _19694_/Q VPWR VGND sg13cmos5l_nor4_1
X_17247_ _17249_/B _19589_/Q _19590_/Q hold2896/X VPWR VGND sg13cmos5l_o21ai_1
X_14459_ _14463_/B _19120_/Q _14459_/B VPWR VGND sg13cmos5l_xor2_1
X_17178_ _17178_/X _17179_/A _17199_/B VPWR VGND sg13cmos5l_and2_1
XFILLER_6_580 VPWR VGND sg13cmos5l_decap_8
X_16129_ _19410_/D _16320_/A _16129_/B VPWR VGND sg13cmos5l_nor2_1
X_19255__987 _19255_/RESET_B VPWR VGND sg13cmos5l_tiehi
Xhold2405 hold2405/X _11682_/Y VPWR VGND sg13cmos5l_dlygate4sd3_1
Xhold2416 _10122_/A _19334_/Q VPWR VGND sg13cmos5l_dlygate4sd3_1
Xhold2427 _10117_/A _19295_/Q VPWR VGND sg13cmos5l_dlygate4sd3_1
Xhold2449 _10053_/A _18872_/Q VPWR VGND sg13cmos5l_dlygate4sd3_1
XFILLER_84_513 VPWR VGND sg13cmos5l_fill_1
Xhold2438 _10093_/A _19124_/Q VPWR VGND sg13cmos5l_dlygate4sd3_1
XFILLER_84_579 VPWR VGND sg13cmos5l_decap_8
XFILLER_53_944 VPWR VGND sg13cmos5l_decap_4
XFILLER_20_395 VPWR VGND sg13cmos5l_fill_1
XFILLER_106_401 VPWR VGND sg13cmos5l_fill_1
X_19254__475 _19254_/D VPWR VGND sg13cmos5l_tielo
X_19486__731 _19486_/RESET_B VPWR VGND sg13cmos5l_tiehi
XFILLER_97_49 VPWR VGND sg13cmos5l_fill_1
X_10140_ _10140_/Y _16399_/D VPWR VGND sg13cmos5l_inv_1
X_10071_ _13579_/A _10071_/A VPWR VGND sg13cmos5l_inv_1
XFILLER_0_745 VPWR VGND sg13cmos5l_fill_2
Xhold2950 _12036_/A _18800_/Q VPWR VGND sg13cmos5l_dlygate4sd3_1
XFILLER_88_885 VPWR VGND sg13cmos5l_fill_2
XFILLER_0_778 VPWR VGND sg13cmos5l_fill_1
Xhold2972 _16984_/B _19548_/Q VPWR VGND sg13cmos5l_dlygate4sd3_1
Xhold2961 hold2961/X _19525_/Q VPWR VGND sg13cmos5l_dlygate4sd3_1
Xhold2983 _15313_/A _19304_/Q VPWR VGND sg13cmos5l_dlygate4sd3_1
XFILLER_29_930 VPWR VGND sg13cmos5l_fill_2
XFILLER_47_248 VPWR VGND sg13cmos5l_fill_1
X_13830_ _13849_/C _19086_/Q _13848_/A _13833_/B VPWR VGND sg13cmos5l_o21ai_1
Xhold2994 _15085_/A _19268_/Q VPWR VGND sg13cmos5l_dlygate4sd3_1
XFILLER_28_451 VPWR VGND sg13cmos5l_fill_1
X_13761_ _13762_/B _13761_/A _13761_/B VPWR VGND sg13cmos5l_xor2_1
X_10973_ _11191_/A _11352_/A _10990_/B VPWR VGND sg13cmos5l_nand2_1
XFILLER_29_985 VPWR VGND sg13cmos5l_fill_2
X_12712_ _12713_/B _12683_/X _12681_/Y _12714_/S VPWR VGND sg13cmos5l_mux2_1
XFILLER_90_549 VPWR VGND sg13cmos5l_fill_2
X_15500_ _15500_/Y _15500_/A VPWR VGND sg13cmos5l_inv_1
X_16480_ _16510_/A _16416_/Y _16451_/X _16526_/B VPWR VGND sg13cmos5l_mux2_1
X_13692_ _13720_/C _19059_/Q _13693_/B VPWR VGND sg13cmos5l_xnor2_1
X_19202__1043 _19202_/RESET_B VPWR VGND sg13cmos5l_tiehi
X_15431_ _15431_/Y _15407_/Y _15425_/Y _15430_/Y VPWR VGND sg13cmos5l_o21ai_1
XFILLER_31_627 VPWR VGND sg13cmos5l_fill_1
X_12643_ _12664_/S _12658_/B _12658_/C VPWR VGND sg13cmos5l_nand2_1
X_19493__724 _19493_/RESET_B VPWR VGND sg13cmos5l_tiehi
X_12574_ _12574_/Y _12574_/A _12574_/B VPWR VGND sg13cmos5l_nor2_1
X_15362_ _15368_/B _15741_/A _15364_/B VPWR VGND sg13cmos5l_nand2_1
X_18150_ _18150_/Y _18150_/A _18157_/B VPWR VGND sg13cmos5l_nand2_1
X_11525_ _11565_/A _11548_/B _11525_/B VPWR VGND sg13cmos5l_nor2_1
X_17101_ _17101_/X _19512_/Q _17110_/C VPWR VGND sg13cmos5l_and2_1
X_18081_ _18081_/Y _18193_/B _18193_/C _18193_/A VPWR VGND sg13cmos5l_a21oi_1
XFILLER_7_322 VPWR VGND sg13cmos5l_decap_8
XFILLER_7_311 VPWR VGND sg13cmos5l_fill_1
XFILLER_8_856 VPWR VGND sg13cmos5l_fill_1
X_15293_ _15293_/Y _15279_/X _15281_/Y _15108_/C VPWR VGND sg13cmos5l_a21oi_1
X_14313_ _14314_/B _14336_/A _14376_/B _14377_/B _14315_/A VPWR VGND sg13cmos5l_a22oi_1
X_17032_ _17032_/Y _17032_/A _17032_/B VPWR VGND sg13cmos5l_nor2_1
X_14244_ _14298_/B _19140_/Q _14262_/D VPWR VGND sg13cmos5l_xnor2_1
X_11456_ _11456_/X _11473_/B _11454_/Y _11451_/Y VPWR VGND sg13cmos5l_a21o_1
X_11387_ _11392_/B _11387_/A _11387_/B VPWR VGND sg13cmos5l_nor2_1
X_10407_ _10409_/B _10406_/Y _10746_/A VPWR VGND sg13cmos5l_nand2b_1
X_14175_ _14200_/B _14162_/Y _14169_/X _14173_/Y VPWR VGND sg13cmos5l_o21ai_1
X_13126_ _13127_/A _13126_/A _13136_/B VPWR VGND sg13cmos5l_nor2_1
X_18983_ _18983_/Q _19003_/CLK _18983_/D _18983_/RESET_B VPWR VGND sg13cmos5l_dfrbpq_1
X_10338_ _10338_/Y _10338_/A VPWR VGND sg13cmos5l_inv_1
X_13057_ _13057_/Y _13578_/A _18960_/Q VPWR VGND sg13cmos5l_nor2_1
X_17934_ _19669_/D _17934_/A _17942_/A VPWR VGND sg13cmos5l_nor2_1
X_12008_ _12010_/B _12116_/A _12116_/B VPWR VGND sg13cmos5l_nand2_1
XFILLER_78_362 VPWR VGND sg13cmos5l_fill_2
X_10269_ _12757_/A _13045_/A VPWR VGND sg13cmos5l_inv_1
X_17865_ _17865_/X _17865_/A _17870_/B VPWR VGND sg13cmos5l_and2_1
X_18962__1301 _18962_/RESET_B VPWR VGND sg13cmos5l_tiehi
X_19604_ _19604_/Q clkload37/A _19604_/D _19604_/RESET_B VPWR VGND sg13cmos5l_dfrbpq_1
X_16816_ _19497_/D _17930_/A _16816_/B VPWR VGND sg13cmos5l_and2_1
XFILLER_54_719 VPWR VGND sg13cmos5l_decap_8
X_17796_ _17897_/A _17895_/B _17895_/C _17895_/A VPWR VGND sg13cmos5l_a21o_1
XFILLER_19_440 VPWR VGND sg13cmos5l_fill_2
X_16747_ _16747_/Y _16932_/A VPWR VGND sg13cmos5l_inv_1
X_19535_ _19535_/Q clkload41/A _19535_/D _19535_/RESET_B VPWR VGND sg13cmos5l_dfrbpq_1
X_13959_ _13960_/A _19095_/Q _13959_/B VPWR VGND sg13cmos5l_xnor2_1
X_16678_ _16791_/B _19501_/Q _16785_/B VPWR VGND sg13cmos5l_nand2_1
X_19466_ _19466_/Q _19679_/CLK _19466_/D _19466_/RESET_B VPWR VGND sg13cmos5l_dfrbpq_1
XFILLER_50_958 VPWR VGND sg13cmos5l_fill_2
X_15629_ _15629_/Y _15676_/B _15629_/B VPWR VGND sg13cmos5l_nor2_1
X_19397_ _19397_/Q _19462_/CLK _19397_/D _19397_/RESET_B VPWR VGND sg13cmos5l_dfrbpq_1
X_18417_ _18483_/B _18391_/X _18414_/C _10592_/A VPWR VGND sg13cmos5l_a21oi_1
X_18348_ _18348_/Y _19730_/Q _19691_/Q VPWR VGND sg13cmos5l_xnor2_1
X_18279_ _18279_/Y _18261_/A _18282_/S _18278_/Y VPWR VGND sg13cmos5l_a21oi_1
XFILLER_30_682 VPWR VGND sg13cmos5l_fill_2
X_18708__1573 _18708_/RESET_B VPWR VGND sg13cmos5l_tiehi
XFILLER_66_1025 VPWR VGND sg13cmos5l_decap_4
X_09983_ _09983_/Y _09983_/A VPWR VGND sg13cmos5l_inv_1
Xhold2202 _12189_/A _18744_/Q VPWR VGND sg13cmos5l_dlygate4sd3_1
Xhold2235 _10043_/A _18786_/Q VPWR VGND sg13cmos5l_dlygate4sd3_1
Xhold2246 _18895_/D _12784_/Y VPWR VGND sg13cmos5l_dlygate4sd3_1
Xhold2224 _17291_/A _19574_/Q VPWR VGND sg13cmos5l_dlygate4sd3_1
X_19078__1176 _19078_/RESET_B VPWR VGND sg13cmos5l_tiehi
Xhold2213 _19357_/D _15797_/Y VPWR VGND sg13cmos5l_dlygate4sd3_1
Xhold2279 _18728_/D _11681_/Y VPWR VGND sg13cmos5l_dlygate4sd3_1
Xhold2257 _18599_/D _10864_/Y VPWR VGND sg13cmos5l_dlygate4sd3_1
Xhold2268 _17729_/B _19643_/Q VPWR VGND sg13cmos5l_dlygate4sd3_1
XFILLER_57_557 VPWR VGND sg13cmos5l_fill_2
XFILLER_25_443 VPWR VGND sg13cmos5l_fill_2
XFILLER_26_944 VPWR VGND sg13cmos5l_fill_2
XFILLER_73_1007 VPWR VGND sg13cmos5l_fill_1
XFILLER_41_958 VPWR VGND sg13cmos5l_fill_2
XFILLER_32_33 VPWR VGND sg13cmos5l_fill_2
XFILLER_32_44 VPWR VGND sg13cmos5l_fill_2
X_11310_ _11311_/A _11359_/B _11194_/B _11325_/B VPWR VGND sg13cmos5l_mux2_1
XFILLER_5_804 VPWR VGND sg13cmos5l_fill_1
X_12290_ _12292_/A _12299_/B _12295_/C _12289_/Y VPWR VGND sg13cmos5l_a21oi_1
X_11241_ _11270_/B _18663_/Q _18662_/Q _11437_/A _18664_/Q VPWR VGND sg13cmos5l_nor4_1
X_11172_ _11172_/Y _18616_/Q _11173_/B VPWR VGND sg13cmos5l_xnor2_1
X_10123_ _16015_/A _10123_/A VPWR VGND sg13cmos5l_inv_1
XFILLER_0_553 VPWR VGND sg13cmos5l_fill_2
X_15980_ _15980_/Y _15980_/A _15980_/B VPWR VGND sg13cmos5l_nor2_1
X_10054_ _13017_/A _12625_/D VPWR VGND sg13cmos5l_inv_1
XFILLER_48_524 VPWR VGND sg13cmos5l_fill_2
X_14931_ _14931_/Y _14932_/B _14927_/X _14930_/Y VPWR VGND sg13cmos5l_a21oi_1
X_17650_ _17662_/A _17650_/A _17664_/C _17650_/C VPWR VGND sg13cmos5l_nand3_1
X_14862_ _14862_/X _14747_/B _14912_/B _14871_/S VPWR VGND sg13cmos5l_mux2_1
Xhold2780 _16512_/C _16492_/Y VPWR VGND sg13cmos5l_dlygate4sd3_1
Xhold2791 _14214_/A _19133_/Q VPWR VGND sg13cmos5l_dlygate4sd3_1
X_13813_ _19052_/D _13813_/A _13813_/B VPWR VGND sg13cmos5l_and2_1
X_16601_ _16608_/S _16601_/A _16601_/B VPWR VGND sg13cmos5l_nor2_1
X_17581_ _17585_/C _17587_/A _17581_/B VPWR VGND sg13cmos5l_nand2_1
X_14793_ _14986_/A _19210_/Q _14798_/A VPWR VGND sg13cmos5l_xnor2_1
XFILLER_16_421 VPWR VGND sg13cmos5l_fill_1
XFILLER_17_944 VPWR VGND sg13cmos5l_fill_2
X_19320_ _19320_/Q clkload23/A _19320_/D _19320_/RESET_B VPWR VGND sg13cmos5l_dfrbpq_1
X_16532_ _16533_/B _16532_/A _16532_/B VPWR VGND sg13cmos5l_nand2_1
XFILLER_28_281 VPWR VGND sg13cmos5l_fill_1
X_13744_ _13755_/A _13744_/A _13770_/A VPWR VGND sg13cmos5l_nor2_1
X_10956_ _10964_/B _11356_/A _10958_/B VPWR VGND sg13cmos5l_and2_1
X_19245__997 _19245_/RESET_B VPWR VGND sg13cmos5l_tiehi
XFILLER_32_903 VPWR VGND sg13cmos5l_fill_2
X_18784__1491 _18784_/RESET_B VPWR VGND sg13cmos5l_tiehi
X_13675_ _13675_/Y _19042_/Q _13676_/B VPWR VGND sg13cmos5l_xnor2_1
X_10887_ _10887_/Y _19777_/Q _19778_/Q VPWR VGND sg13cmos5l_xnor2_1
X_19251_ _19251_/Q _19308_/CLK _19251_/D _19251_/RESET_B VPWR VGND sg13cmos5l_dfrbpq_1
X_16463_ _16463_/Y _16463_/A _16463_/B VPWR VGND sg13cmos5l_nand2_1
XFILLER_32_947 VPWR VGND sg13cmos5l_fill_1
X_12626_ _12663_/A _18874_/Q _12627_/B VPWR VGND sg13cmos5l_xnor2_1
X_18202_ _18206_/B _18202_/A _18202_/B VPWR VGND sg13cmos5l_nand2_1
X_19182_ _19182_/Q _19227_/CLK _19182_/D _19182_/RESET_B VPWR VGND sg13cmos5l_dfrbpq_1
X_15414_ _15414_/Y _15292_/B _15404_/X _15410_/B _15427_/B _15412_/Y VPWR VGND sg13cmos5l_a221oi_1
X_16394_ _16395_/B _19450_/Q _16399_/D _19451_/Q VPWR VGND sg13cmos5l_o21ai_1
XFILLER_31_468 VPWR VGND sg13cmos5l_fill_1
X_15345_ _15378_/B _19305_/Q _19306_/Q VPWR VGND sg13cmos5l_xnor2_1
X_18133_ _18133_/X _18125_/Y _18130_/Y _18132_/Y VPWR VGND sg13cmos5l_a21o_1
X_12557_ _12557_/Y _18821_/Q _12575_/B VPWR VGND sg13cmos5l_nor2_1
X_12488_ _12488_/Y _18876_/Q _18870_/Q VPWR VGND sg13cmos5l_nor2b_1
X_11508_ _11511_/B _18721_/Q _11526_/B VPWR VGND sg13cmos5l_nor2b_1
X_18064_ _19697_/D _18231_/A _18195_/A VPWR VGND sg13cmos5l_and2_1
X_15276_ _15280_/B _19246_/Q _15277_/B VPWR VGND sg13cmos5l_nor2b_1
XFILLER_8_686 VPWR VGND sg13cmos5l_decap_8
X_17015_ _17015_/Y _17179_/A _17015_/B VPWR VGND sg13cmos5l_nand2b_1
X_11439_ _11439_/Y _11253_/Y _11464_/A _11459_/A _11438_/X _11437_/X VPWR VGND sg13cmos5l_a221oi_1
X_14227_ _14227_/Y _14227_/A _14227_/B _14341_/B VPWR VGND sg13cmos5l_nor3_1
X_19033__1224 _19033_/RESET_B VPWR VGND sg13cmos5l_tiehi
X_18860__1409 _18860_/RESET_B VPWR VGND sg13cmos5l_tiehi
X_14158_ _14162_/A _14149_/Y _14153_/Y _14157_/Y _14002_/A _14154_/Y VPWR VGND sg13cmos5l_a221oi_1
XFILLER_98_457 VPWR VGND sg13cmos5l_decap_4
X_13109_ _13122_/B _13109_/A _13110_/B VPWR VGND sg13cmos5l_xor2_1
X_18966_ _18966_/Q clkload64/A _18966_/D _18966_/RESET_B VPWR VGND sg13cmos5l_dfrbpq_1
X_14089_ _14089_/Y _14640_/A _19063_/Q _14085_/Y _14088_/Y VPWR VGND sg13cmos5l_a22oi_1
X_18897_ _18897_/Q clkload67/A _18897_/D _18897_/RESET_B VPWR VGND sg13cmos5l_dfrbpq_1
X_17917_ _17917_/Y _17804_/A _17804_/B _17907_/Y _17915_/Y _17916_/Y VPWR VGND sg13cmos5l_a221oi_1
XFILLER_39_513 VPWR VGND sg13cmos5l_fill_1
X_17848_ _17848_/Y _17875_/B _17870_/B VPWR VGND sg13cmos5l_nand2b_1
X_17779_ _19654_/D _17942_/A _17867_/A VPWR VGND sg13cmos5l_nor2_1
X_19518_ _19518_/Q clkload35/A _19518_/D _19518_/RESET_B VPWR VGND sg13cmos5l_dfrbpq_1
X_18926__1340 _18926_/RESET_B VPWR VGND sg13cmos5l_tiehi
XFILLER_62_582 VPWR VGND sg13cmos5l_fill_2
XFILLER_62_571 VPWR VGND sg13cmos5l_fill_2
XFILLER_23_958 VPWR VGND sg13cmos5l_fill_2
X_19449_ _19449_/Q clkload10/A _19449_/D _19449_/RESET_B VPWR VGND sg13cmos5l_dfrbpq_1
XFILLER_50_755 VPWR VGND sg13cmos5l_fill_1
XFILLER_10_608 VPWR VGND sg13cmos5l_decap_8
XFILLER_31_980 VPWR VGND sg13cmos5l_decap_4
XFILLER_31_991 VPWR VGND sg13cmos5l_fill_1
X_19552__662 _19552_/RESET_B VPWR VGND sg13cmos5l_tiehi
XFILLER_1_339 VPWR VGND sg13cmos5l_fill_2
X_19483__734 _19483_/RESET_B VPWR VGND sg13cmos5l_tiehi
Xhold2021 _19689_/D _18002_/Y VPWR VGND sg13cmos5l_dlygate4sd3_1
Xhold2010 _19102_/D _14126_/Y VPWR VGND sg13cmos5l_dlygate4sd3_1
Xhold2054 _10030_/A _18748_/Q VPWR VGND sg13cmos5l_dlygate4sd3_1
Xhold2032 hold2032/X _19027_/Q VPWR VGND sg13cmos5l_dlygate4sd3_1
Xhold2043 _19442_/D _16369_/Y VPWR VGND sg13cmos5l_dlygate4sd3_1
XFILLER_57_343 VPWR VGND sg13cmos5l_fill_1
Xhold2087 _19439_/D _16363_/Y VPWR VGND sg13cmos5l_dlygate4sd3_1
Xhold2076 _19354_/D _15791_/Y VPWR VGND sg13cmos5l_dlygate4sd3_1
Xhold2065 _19237_/D _14975_/Y VPWR VGND sg13cmos5l_dlygate4sd3_1
XFILLER_45_527 VPWR VGND sg13cmos5l_fill_2
Xhold2098 _14636_/B _19129_/Q VPWR VGND sg13cmos5l_dlygate4sd3_1
X_11790_ _11797_/A _11780_/X _11783_/Y _11827_/A _11791_/B _11784_/X VPWR VGND sg13cmos5l_a221oi_1
X_10810_ _18592_/D _18558_/A _10810_/B VPWR VGND sg13cmos5l_nor2_1
X_10741_ _18577_/D _10795_/A fanout68/X _10740_/Y VPWR VGND sg13cmos5l_a21oi_1
X_13460_ _13506_/A _13476_/C _18998_/Q VPWR VGND sg13cmos5l_xnor2_1
X_12411_ _12413_/A _12419_/A _12411_/B VPWR VGND sg13cmos5l_nor2_1
X_19490__727 _19490_/RESET_B VPWR VGND sg13cmos5l_tiehi
X_10672_ _18565_/D _10683_/A _10672_/B VPWR VGND sg13cmos5l_nor2_1
XFILLER_9_439 VPWR VGND sg13cmos5l_fill_2
Xclkbuf_leaf_20_clk _19814_/CLK clkbuf_4_4_0_clk/X VPWR VGND sg13cmos5l_buf_8
X_13391_ _13420_/B _13379_/Y _13386_/X _13389_/Y VPWR VGND sg13cmos5l_o21ai_1
XFILLER_22_991 VPWR VGND sg13cmos5l_decap_8
X_12342_ _12554_/A _12342_/A _12342_/B VPWR VGND sg13cmos5l_nand2_1
X_15130_ _15142_/C _15130_/A _15194_/B VPWR VGND sg13cmos5l_and2_1
X_12273_ _12273_/X _12268_/X _12272_/Y _12267_/X VPWR VGND sg13cmos5l_a21o_1
X_15061_ _15109_/A _15074_/B _15061_/B VPWR VGND sg13cmos5l_and2_1
X_11224_ _11225_/B _11315_/B _11315_/C _11315_/A VPWR VGND sg13cmos5l_a21oi_1
X_14012_ _14013_/B _13984_/A _14200_/A _14012_/S VPWR VGND sg13cmos5l_mux2_1
XFILLER_5_667 VPWR VGND sg13cmos5l_fill_1
XFILLER_4_37 VPWR VGND sg13cmos5l_fill_1
X_18820_ _18820_/Q clkload68/A _18820_/D _18820_/RESET_B VPWR VGND sg13cmos5l_dfrbpq_1
XFILLER_68_608 VPWR VGND sg13cmos5l_decap_8
X_11155_ _11167_/B _18611_/Q _18612_/Q _18613_/Q _18614_/Q VPWR VGND sg13cmos5l_nor4_1
X_19021__1239 _19021_/RESET_B VPWR VGND sg13cmos5l_tiehi
X_18751_ _18751_/Q _18902_/CLK _18751_/D _18751_/RESET_B VPWR VGND sg13cmos5l_dfrbpq_1
XFILLER_68_73 VPWR VGND sg13cmos5l_decap_4
X_11086_ _18633_/D _11089_/A _11086_/B VPWR VGND sg13cmos5l_nor2_1
X_15963_ _15963_/Y _15963_/A _15963_/B VPWR VGND sg13cmos5l_nor2_1
X_10106_ _15457_/A _10106_/A VPWR VGND sg13cmos5l_inv_1
X_10037_ _12459_/A _10037_/A VPWR VGND sg13cmos5l_inv_1
XFILLER_88_490 VPWR VGND sg13cmos5l_fill_1
X_17702_ _17702_/Y _17702_/A _19602_/Q VPWR VGND sg13cmos5l_nor2_1
X_14914_ _19224_/D _14916_/A _14914_/B VPWR VGND sg13cmos5l_and2_1
Xclkbuf_leaf_87_clk clkload19/A clkbuf_4_2_0_clk/X VPWR VGND sg13cmos5l_buf_8
X_18682_ _18682_/Q clkload40/A _18682_/D _18682_/RESET_B VPWR VGND sg13cmos5l_dfrbpq_1
XFILLER_48_376 VPWR VGND sg13cmos5l_fill_2
X_15894_ _15902_/B _19389_/Q _19390_/Q hold3052/X VPWR VGND sg13cmos5l_o21ai_1
XFILLER_91_633 VPWR VGND sg13cmos5l_fill_2
X_17633_ _17633_/Y _17625_/Y _17627_/X _17632_/Y VPWR VGND sg13cmos5l_o21ai_1
X_14845_ _14845_/Y _14840_/A _14914_/B _14844_/Y VPWR VGND sg13cmos5l_a21oi_1
XFILLER_36_538 VPWR VGND sg13cmos5l_decap_4
X_11988_ _11992_/B _18742_/Q _11988_/B VPWR VGND sg13cmos5l_xor2_1
X_18707__1583 _18707_/RESET_B VPWR VGND sg13cmos5l_tiehi
X_17564_ _17573_/A _19636_/Q _17564_/B VPWR VGND sg13cmos5l_xor2_1
XFILLER_63_368 VPWR VGND sg13cmos5l_fill_2
X_14776_ _14883_/A _19219_/Q _14783_/B VPWR VGND sg13cmos5l_nor2_1
X_13727_ _13727_/Y _13727_/A _13727_/B VPWR VGND sg13cmos5l_nand2_1
X_10939_ _10939_/Y _18618_/Q _18633_/Q VPWR VGND sg13cmos5l_nand2_1
X_19303_ _19303_/Q clkload44/A _19303_/D _19303_/RESET_B VPWR VGND sg13cmos5l_dfrbpq_1
X_16515_ _16515_/Y _16505_/Y _16507_/X _16521_/A _16521_/B VPWR VGND sg13cmos5l_a22oi_1
XFILLER_90_5 VPWR VGND sg13cmos5l_fill_1
X_17495_ _17495_/Y _17495_/A _17495_/B VPWR VGND sg13cmos5l_nor2_1
X_19234_ _19234_/Q clkload16/A _19234_/D _19234_/RESET_B VPWR VGND sg13cmos5l_dfrbpq_1
XFILLER_31_221 VPWR VGND sg13cmos5l_fill_2
X_13658_ _16641_/A _19039_/Q _19040_/Q VPWR VGND sg13cmos5l_xnor2_1
X_16446_ _16448_/D _16425_/Y _16457_/C _16457_/D VPWR VGND sg13cmos5l_nand3b_1
X_13589_ _13589_/Y _18572_/Q _19040_/Q VPWR VGND sg13cmos5l_nand2b_1
X_12609_ _12621_/B _18872_/Q _12625_/D VPWR VGND sg13cmos5l_nor2_1
Xclkbuf_leaf_11_clk clkload21/A clkload0/A VPWR VGND sg13cmos5l_buf_8
X_19165_ _19165_/Q clkload50/A _19165_/D _19165_/RESET_B VPWR VGND sg13cmos5l_dfrbpq_1
X_16377_ _16377_/Y _09979_/Y fanout85/X _16376_/Y VPWR VGND sg13cmos5l_a21oi_1
X_15328_ _15328_/X _19303_/Q _15433_/B _15312_/Y VPWR VGND sg13cmos5l_a21o_1
X_18116_ _18116_/Y _18135_/A _18114_/Y _18115_/Y _19701_/Q VPWR VGND sg13cmos5l_a22oi_1
X_19096_ _19096_/Q _19136_/CLK _19096_/D _19096_/RESET_B VPWR VGND sg13cmos5l_dfrbpq_1
X_15259_ _15262_/B _19243_/Q _19244_/Q _19241_/Q _19242_/Q VPWR VGND sg13cmos5l_nor4_1
XFILLER_8_494 VPWR VGND sg13cmos5l_fill_1
X_18047_ _18180_/A _18039_/X _18046_/Y _18045_/Y VPWR VGND sg13cmos5l_a21oi_1
XFILLER_63_1028 VPWR VGND sg13cmos5l_fill_1
X_18949_ _18949_/Q _18975_/CLK _18949_/D _18949_/RESET_B VPWR VGND sg13cmos5l_dfrbpq_1
X_18824__1448 _18824_/RESET_B VPWR VGND sg13cmos5l_tiehi
Xclkbuf_leaf_78_clk clkload48/A clkbuf_4_9_0_clk/X VPWR VGND sg13cmos5l_buf_8
XFILLER_104_49 VPWR VGND sg13cmos5l_fill_1
XFILLER_94_460 VPWR VGND sg13cmos5l_decap_4
XFILLER_94_493 VPWR VGND sg13cmos5l_fill_2
XFILLER_55_869 VPWR VGND sg13cmos5l_decap_4
XFILLER_54_313 VPWR VGND sg13cmos5l_fill_1
XFILLER_63_891 VPWR VGND sg13cmos5l_fill_2
Xfanout47 fanout47/X _13571_/S VPWR VGND sg13cmos5l_buf_1
Xfanout25 fanout25/X _17416_/Y VPWR VGND sg13cmos5l_buf_1
Xfanout36 _16001_/S _15996_/Y VPWR VGND sg13cmos5l_buf_1
Xfanout69 fanout69/X fanout70/X VPWR VGND sg13cmos5l_buf_1
Xfanout58 _11342_/S _11337_/Y VPWR VGND sg13cmos5l_buf_1
XFILLER_23_799 VPWR VGND sg13cmos5l_fill_1
XFILLER_10_449 VPWR VGND sg13cmos5l_fill_2
XFILLER_89_210 VPWR VGND sg13cmos5l_fill_1
X_18757__1521 _18757_/RESET_B VPWR VGND sg13cmos5l_tiehi
XFILLER_58_652 VPWR VGND sg13cmos5l_decap_8
Xclkbuf_leaf_69_clk clkload51/A clkbuf_4_10_0_clk/X VPWR VGND sg13cmos5l_buf_8
X_12960_ _12960_/Y _12960_/A _12960_/B VPWR VGND sg13cmos5l_nor2_1
XFILLER_58_674 VPWR VGND sg13cmos5l_fill_1
X_11911_ _11911_/Y _12459_/A _18727_/Q _18728_/Q _12460_/A _11910_/Y VPWR VGND sg13cmos5l_a221oi_1
X_12891_ _12892_/B _18927_/Q _18928_/Q _18929_/Q VPWR VGND sg13cmos5l_o21ai_1
XFILLER_46_847 VPWR VGND sg13cmos5l_fill_1
X_11842_ _11852_/C _11842_/A VPWR VGND sg13cmos5l_inv_1
XFILLER_45_368 VPWR VGND sg13cmos5l_fill_1
X_14630_ _14630_/Y _14591_/B _14628_/S _14637_/B VPWR VGND sg13cmos5l_o21ai_1
XFILLER_33_508 VPWR VGND sg13cmos5l_fill_1
XFILLER_60_316 VPWR VGND sg13cmos5l_fill_1
X_14561_ _14561_/Y _14541_/B _14541_/C _14552_/Y _14556_/Y _14557_/Y VPWR VGND sg13cmos5l_a221oi_1
X_11773_ _11774_/B _11773_/A _11773_/B VPWR VGND sg13cmos5l_xnor2_1
X_13512_ _13512_/Y _13512_/A _13512_/B _13512_/C VPWR VGND sg13cmos5l_nor3_1
X_16300_ _19418_/D hold2936/X fanout34/X _16299_/Y VPWR VGND sg13cmos5l_a21oi_1
X_10724_ _18570_/D _10695_/Y fanout99/X _10723_/Y VPWR VGND sg13cmos5l_a21oi_1
X_17280_ _17284_/A _17266_/Y _17274_/Y _17316_/B _17309_/B _17278_/Y VPWR VGND sg13cmos5l_a221oi_1
X_14492_ _19162_/D _14648_/A _14586_/A VPWR VGND sg13cmos5l_nor2_1
X_10655_ _10655_/Y _10019_/Y _19808_/Q _10673_/C VPWR VGND sg13cmos5l_a21oi_1
X_13443_ _13443_/Y _13546_/B _13546_/C _13546_/A VPWR VGND sg13cmos5l_a21oi_1
X_16231_ _16316_/B _16233_/C _16233_/D VPWR VGND sg13cmos5l_and2_1
XFILLER_103_1022 VPWR VGND sg13cmos5l_decap_8
X_13374_ _13374_/Y _13377_/A _13414_/A _13371_/X VPWR VGND sg13cmos5l_o21ai_1
Xclkload17 clkload17/Y clkload17/A VPWR VGND sg13cmos5l_inv_2
XFILLER_10_950 VPWR VGND sg13cmos5l_fill_2
X_16162_ _16280_/C _16161_/A _16161_/B _16172_/A VPWR VGND sg13cmos5l_o21ai_1
X_12325_ _12325_/Y _18829_/Q _18844_/Q VPWR VGND sg13cmos5l_nand2_1
Xclkload39 clkload39/Y clkload39/A VPWR VGND sg13cmos5l_inv_1
Xclkload28 clkload28/Y clkload28/A VPWR VGND sg13cmos5l_inv_2
X_19073__1181 _19073_/RESET_B VPWR VGND sg13cmos5l_tiehi
X_15113_ _15113_/X _15014_/B _15102_/Y _15112_/Y VPWR VGND sg13cmos5l_a21o_1
XFILLER_10_994 VPWR VGND sg13cmos5l_fill_1
X_10586_ _10586_/Y _10647_/A VPWR VGND sg13cmos5l_inv_1
XFILLER_6_976 VPWR VGND sg13cmos5l_decap_4
X_16093_ _16093_/Y _15912_/C _19368_/Q VPWR VGND sg13cmos5l_nand2b_1
X_12256_ _18816_/D _10009_/Y fanout95/X _12255_/Y VPWR VGND sg13cmos5l_a21oi_1
X_15044_ _15154_/C _15043_/A _15043_/B _15056_/A VPWR VGND sg13cmos5l_o21ai_1
X_12187_ _18791_/D _12201_/A _12187_/B VPWR VGND sg13cmos5l_nor2_1
X_11207_ _11325_/A _11204_/A _11205_/A _11205_/Y VPWR VGND sg13cmos5l_a21oi_1
X_18803_ _18803_/Q clkload60/A _18803_/D _18803_/RESET_B VPWR VGND sg13cmos5l_dfrbpq_1
X_11138_ _11138_/Y _11120_/A _11133_/S _11137_/Y VPWR VGND sg13cmos5l_a21oi_1
X_19738__1097 _19738_/RESET_B VPWR VGND sg13cmos5l_tiehi
X_16995_ _16999_/A _16995_/A _16995_/B VPWR VGND sg13cmos5l_xnor2_1
X_19783_ _19783_/Q clkload47/A _19783_/D _19783_/RESET_B VPWR VGND sg13cmos5l_dfrbpq_1
X_18734_ _18734_/Q clkload59/A _18734_/D _18734_/RESET_B VPWR VGND sg13cmos5l_dfrbpq_1
X_11069_ _11070_/B _11044_/A _11047_/B _11076_/B VPWR VGND sg13cmos5l_mux2_1
XFILLER_49_685 VPWR VGND sg13cmos5l_fill_2
X_15946_ _15946_/Y _16100_/A _15951_/B VPWR VGND sg13cmos5l_nand2_1
Xclkbuf_leaf_0_clk clkload5/A clkbuf_4_0_0_clk/X VPWR VGND sg13cmos5l_buf_8
X_19542__672 _19542_/RESET_B VPWR VGND sg13cmos5l_tiehi
XFILLER_63_121 VPWR VGND sg13cmos5l_fill_1
X_18665_ _18665_/Q clkload55/A _18665_/D _18665_/RESET_B VPWR VGND sg13cmos5l_dfrbpq_1
X_15877_ _15878_/B _15975_/B _15975_/C _15975_/A VPWR VGND sg13cmos5l_a21oi_1
XFILLER_91_441 VPWR VGND sg13cmos5l_fill_1
X_17616_ _17616_/Y _17639_/A _17678_/B _17679_/B _17642_/A VPWR VGND sg13cmos5l_a22oi_1
X_14828_ _14828_/Y _14828_/A _14843_/S VPWR VGND sg13cmos5l_nand2_1
X_18596_ _18596_/Q clkload30/A _18596_/D _18596_/RESET_B VPWR VGND sg13cmos5l_dfrbpq_1
X_17547_ _17549_/C _17751_/A _17544_/Y _17546_/Y VPWR VGND sg13cmos5l_a21o_1
X_14759_ _19204_/D _14913_/A _14850_/A VPWR VGND sg13cmos5l_nor2_1
X_17478_ _17479_/B _17591_/A _17591_/B VPWR VGND sg13cmos5l_and2_1
XFILLER_60_872 VPWR VGND sg13cmos5l_fill_2
X_16429_ _16434_/A _16433_/A _16433_/B _16424_/X _16428_/Y _16423_/X VPWR VGND sg13cmos5l_a221oi_1
X_19217_ _19217_/Q _19262_/CLK _19217_/D _19217_/RESET_B VPWR VGND sg13cmos5l_dfrbpq_1
XFILLER_74_0 VPWR VGND sg13cmos5l_fill_1
X_19148_ _19148_/Q _19262_/CLK _19148_/D _19148_/RESET_B VPWR VGND sg13cmos5l_dfrbpq_1
X_19215__1030 _19215_/RESET_B VPWR VGND sg13cmos5l_tiehi
X_19059__494 _19059_/D VPWR VGND sg13cmos5l_tielo
X_19079_ _19079_/Q clkload54/A _19079_/D _19079_/RESET_B VPWR VGND sg13cmos5l_dfrbpq_1
Xfanout204 _18227_/B _18213_/A VPWR VGND sg13cmos5l_buf_1
Xfanout215 _17671_/B _17673_/B VPWR VGND sg13cmos5l_buf_1
Xfanout226 _17079_/B _16869_/Y VPWR VGND sg13cmos5l_buf_1
XFILLER_8_1028 VPWR VGND sg13cmos5l_fill_1
Xfanout237 _16318_/A _16061_/Y VPWR VGND sg13cmos5l_buf_1
Xfanout248 _15458_/B _15466_/A VPWR VGND sg13cmos5l_buf_1
Xfanout259 _14902_/A _14689_/Y VPWR VGND sg13cmos5l_buf_1
X_19480__737 _19480_/RESET_B VPWR VGND sg13cmos5l_tiehi
XFILLER_39_151 VPWR VGND sg13cmos5l_decap_8
XFILLER_55_655 VPWR VGND sg13cmos5l_decap_8
XFILLER_15_508 VPWR VGND sg13cmos5l_fill_1
XFILLER_83_997 VPWR VGND sg13cmos5l_fill_1
XFILLER_23_541 VPWR VGND sg13cmos5l_fill_2
XFILLER_11_758 VPWR VGND sg13cmos5l_fill_1
X_10440_ _10442_/C _19003_/Q _19045_/Q _19087_/Q _19129_/Q VPWR VGND sg13cmos5l_nor4_1
XFILLER_6_217 VPWR VGND sg13cmos5l_fill_2
X_10371_ _16860_/A _19476_/Q VPWR VGND sg13cmos5l_inv_1
X_12110_ _12111_/B _12110_/A _12287_/A VPWR VGND sg13cmos5l_nor2_1
X_13090_ _13126_/A _13098_/B _13090_/B VPWR VGND sg13cmos5l_and2_1
XFILLER_40_88 VPWR VGND sg13cmos5l_fill_1
X_12041_ _12153_/A _12041_/A _12054_/B VPWR VGND sg13cmos5l_xnor2_1
XFILLER_46_1012 VPWR VGND sg13cmos5l_fill_2
X_19061__1196 _19061_/RESET_B VPWR VGND sg13cmos5l_tiehi
X_18834__515 _18834_/D VPWR VGND sg13cmos5l_tielo
X_16780_ _16780_/X _16781_/A _16792_/B _16781_/C VPWR VGND sg13cmos5l_and3_1
XFILLER_93_728 VPWR VGND sg13cmos5l_fill_2
XFILLER_93_706 VPWR VGND sg13cmos5l_fill_1
X_15800_ _15800_/Y _16038_/B _15800_/B VPWR VGND sg13cmos5l_nand2_1
X_13992_ _14180_/A _14365_/A _14176_/A VPWR VGND sg13cmos5l_nand2_1
X_12943_ _13025_/B _12943_/A _12944_/B VPWR VGND sg13cmos5l_nor2b_1
X_15731_ _15731_/Y _15719_/B _15727_/S _15747_/A VPWR VGND sg13cmos5l_o21ai_1
X_18450_ _18451_/B _19755_/Q _18450_/B VPWR VGND sg13cmos5l_xor2_1
X_12874_ _12881_/B _12992_/A _12991_/A VPWR VGND sg13cmos5l_nor2_1
XFILLER_60_102 VPWR VGND sg13cmos5l_fill_2
X_17401_ _17407_/A _17402_/A _17402_/B _17395_/X _17400_/X _17396_/X VPWR VGND sg13cmos5l_a221oi_1
X_15662_ _15662_/Y _15644_/Y _15648_/Y _15851_/A VPWR VGND sg13cmos5l_a21oi_1
XFILLER_33_305 VPWR VGND sg13cmos5l_fill_1
X_11825_ _11825_/Y _11852_/A _11901_/B _11824_/Y VPWR VGND sg13cmos5l_o21ai_1
X_14613_ _14613_/Y _14619_/A _14619_/B VPWR VGND sg13cmos5l_nand2_1
X_15593_ _15708_/B _15608_/A _15721_/B VPWR VGND sg13cmos5l_nand2_1
X_18381_ _18386_/B _19757_/Q _19758_/Q _19759_/Q _19760_/Q VPWR VGND sg13cmos5l_nor4_1
X_11756_ _11858_/A _18754_/Q _11769_/B VPWR VGND sg13cmos5l_xnor2_1
X_17332_ _17333_/B _17301_/Y _17197_/Y _17341_/B VPWR VGND sg13cmos5l_mux2_1
XFILLER_53_1027 VPWR VGND sg13cmos5l_fill_2
X_14544_ _14544_/Y _14545_/A _14572_/A _14543_/Y VPWR VGND sg13cmos5l_a21oi_1
X_10707_ _10707_/Y _10711_/B VPWR VGND sg13cmos5l_inv_1
X_17263_ _17310_/A _19593_/Q _17263_/B VPWR VGND sg13cmos5l_xnor2_1
X_14475_ _14476_/B _14478_/B _14469_/B _14474_/Y VPWR VGND sg13cmos5l_o21ai_1
X_11687_ _18732_/D _10012_/Y fanout94/X _11686_/Y VPWR VGND sg13cmos5l_a21oi_1
X_13426_ _18994_/D _13583_/A _13527_/A VPWR VGND sg13cmos5l_and2_1
X_19002_ _19002_/Q clkload46/A _19002_/D _19002_/RESET_B VPWR VGND sg13cmos5l_dfrbpq_1
X_16214_ _16214_/Y _16255_/A _16207_/Y _16248_/B _16255_/B VPWR VGND sg13cmos5l_a22oi_1
X_17194_ _17304_/A _17009_/Y _17194_/B _17194_/C VPWR VGND sg13cmos5l_nand3b_1
X_10638_ _19794_/D _10638_/A _10642_/B VPWR VGND sg13cmos5l_nor2_1
X_13357_ _18986_/D _14070_/A _13357_/B VPWR VGND sg13cmos5l_and2_1
X_16145_ _16261_/A _16105_/Y _16141_/B _15924_/Y VPWR VGND sg13cmos5l_o21ai_1
X_10569_ _10569_/Y _10645_/A VPWR VGND sg13cmos5l_inv_1
X_12308_ _12310_/B _12288_/Y _12307_/Y _12306_/X VPWR VGND sg13cmos5l_a21oi_1
X_13288_ _18965_/D _13288_/A _13289_/B VPWR VGND sg13cmos5l_nor2_1
X_16076_ _19403_/D _09981_/Y fanout66/X _16075_/Y VPWR VGND sg13cmos5l_a21oi_1
X_12239_ _12468_/A _13337_/A _12722_/B VPWR VGND sg13cmos5l_nor2_1
XFILLER_46_4 VPWR VGND sg13cmos5l_decap_4
X_15027_ _15130_/A hold2725/X _15024_/B _14820_/Y VPWR VGND sg13cmos5l_a21oi_1
Xhold2609 _19462_/D _16556_/Y VPWR VGND sg13cmos5l_dlygate4sd3_1
Xhold1908 _12455_/B _18793_/Q VPWR VGND sg13cmos5l_dlygate4sd3_1
X_19665__1794 _19665_/RESET_B VPWR VGND sg13cmos5l_tiehi
X_16978_ _17002_/B _19552_/Q _16979_/B VPWR VGND sg13cmos5l_nor2b_1
X_19766_ _19766_/Q clkload21/A _19766_/D _19766_/RESET_B VPWR VGND sg13cmos5l_dfrbpq_1
Xhold1919 _19447_/D _16377_/Y VPWR VGND sg13cmos5l_dlygate4sd3_1
X_18717_ _18717_/Q _18902_/CLK _18717_/D _18717_/RESET_B VPWR VGND sg13cmos5l_dfrbpq_1
Xinput4 input4/X ui_in[2] VPWR VGND sg13cmos5l_buf_1
X_15929_ _15929_/X _15929_/A _15929_/B VPWR VGND sg13cmos5l_xor2_1
XFILLER_25_817 VPWR VGND sg13cmos5l_fill_2
X_19697_ _19697_/Q clkload14/A _19697_/D _19697_/RESET_B VPWR VGND sg13cmos5l_dfrbpq_1
X_18648_ _18648_/Q clkload34/A _18648_/D _18648_/RESET_B VPWR VGND sg13cmos5l_dfrbpq_1
X_18579_ _18579_/Q _18594_/CLK _18579_/D _18579_/RESET_B VPWR VGND sg13cmos5l_dfrbpq_1
X_19113__1138 _19113_/RESET_B VPWR VGND sg13cmos5l_tiehi
XFILLER_20_522 VPWR VGND sg13cmos5l_fill_2
Xheichips26_digital_project_410 uio_out[10] VPWR VGND sg13cmos5l_tielo
XFILLER_10_36 VPWR VGND sg13cmos5l_fill_1
Xheichips26_digital_project_421 uo_out[12] VPWR VGND sg13cmos5l_tielo
X_19271__971 _19271_/RESET_B VPWR VGND sg13cmos5l_tiehi
XFILLER_102_800 VPWR VGND sg13cmos5l_fill_2
X_19046__1211 _19046_/RESET_B VPWR VGND sg13cmos5l_tiehi
XFILLER_28_611 VPWR VGND sg13cmos5l_fill_2
XFILLER_71_945 VPWR VGND sg13cmos5l_fill_2
XFILLER_55_496 VPWR VGND sg13cmos5l_fill_2
X_12590_ _12688_/B _12602_/A _12602_/B VPWR VGND sg13cmos5l_nand2_1
X_11610_ _18704_/D _11628_/A _11610_/B VPWR VGND sg13cmos5l_nor2_1
X_11541_ _11541_/Y _11560_/A _11559_/B _11535_/X VPWR VGND sg13cmos5l_o21ai_1
XFILLER_11_511 VPWR VGND sg13cmos5l_fill_1
XFILLER_11_533 VPWR VGND sg13cmos5l_decap_8
X_11472_ _18698_/D _11479_/A _11591_/A VPWR VGND sg13cmos5l_nor2_1
XFILLER_7_537 VPWR VGND sg13cmos5l_fill_1
XFILLER_11_588 VPWR VGND sg13cmos5l_decap_4
X_14260_ _14260_/Y _14260_/A _14261_/B VPWR VGND sg13cmos5l_nor2b_1
X_10423_ _10432_/C _10680_/A _10402_/A _10422_/Y hold2863/X _10418_/A VPWR VGND sg13cmos5l_a221oi_1
X_13211_ _13211_/X _13292_/B _13253_/S _13210_/X VPWR VGND sg13cmos5l_a21o_1
X_14191_ _14193_/B _13998_/Y _14201_/A _14190_/Y VPWR VGND sg13cmos5l_a21o_1
X_19532__682 _19532_/RESET_B VPWR VGND sg13cmos5l_tiehi
X_13142_ _13142_/X _18969_/Q _18970_/Q VPWR VGND sg13cmos5l_or2_1
X_10354_ _17403_/A _10354_/A VPWR VGND sg13cmos5l_inv_1
X_19786__695 _19786_/RESET_B VPWR VGND sg13cmos5l_tiehi
X_10285_ _12224_/A _10285_/A VPWR VGND sg13cmos5l_inv_1
X_13073_ _13073_/Y _13053_/B _13067_/S _13290_/B VPWR VGND sg13cmos5l_o21ai_1
X_17950_ _17950_/Y _19643_/Q _19705_/Q VPWR VGND sg13cmos5l_nand2b_1
XFILLER_3_765 VPWR VGND sg13cmos5l_fill_2
X_12024_ _12024_/Y _12024_/A _12024_/B VPWR VGND sg13cmos5l_nor2_1
X_16901_ _16901_/Y _19491_/Q _16898_/Y _16899_/Y _16900_/Y VPWR VGND sg13cmos5l_a22oi_1
X_17881_ _17898_/S _17874_/Y _17878_/Y _17879_/X VPWR VGND sg13cmos5l_a21o_1
X_16832_ _16832_/Y _16982_/B _16582_/A _16586_/A _19532_/Q VPWR VGND sg13cmos5l_a22oi_1
X_19604__606 _19604_/RESET_B VPWR VGND sg13cmos5l_tiehi
X_19620_ _19620_/Q clkload25/A _19620_/D _19620_/RESET_B VPWR VGND sg13cmos5l_dfrbpq_1
X_19551_ _19551_/Q clkload41/A _19551_/D _19551_/RESET_B VPWR VGND sg13cmos5l_dfrbpq_1
X_16763_ _16764_/B _16763_/A _16763_/B VPWR VGND sg13cmos5l_xor2_1
X_18502_ _18502_/Y _18502_/A _19728_/Q VPWR VGND sg13cmos5l_nor2_1
X_13975_ _13983_/B _19083_/Q _19084_/Q _19082_/Q _19081_/Q VPWR VGND sg13cmos5l_nor4_1
X_16694_ _16716_/B _19492_/Q _16722_/A VPWR VGND sg13cmos5l_nor2_1
X_19482_ _19482_/Q clkload28/A _19482_/D _19482_/RESET_B VPWR VGND sg13cmos5l_dfrbpq_1
X_12926_ _12957_/S _12940_/A _12926_/B VPWR VGND sg13cmos5l_nor2_1
XFILLER_47_997 VPWR VGND sg13cmos5l_fill_1
X_15714_ _15718_/A _15586_/B _15698_/B _15748_/B VPWR VGND sg13cmos5l_o21ai_1
XFILLER_34_614 VPWR VGND sg13cmos5l_fill_2
X_12857_ _12857_/Y _18899_/Q _18860_/Q VPWR VGND sg13cmos5l_xnor2_1
XFILLER_62_967 VPWR VGND sg13cmos5l_fill_2
X_15645_ _15656_/B _19353_/Q _15646_/B VPWR VGND sg13cmos5l_xnor2_1
X_18433_ _18433_/Y _18433_/A VPWR VGND sg13cmos5l_inv_1
X_11808_ _11808_/Y _11800_/Y _11802_/Y _11997_/A VPWR VGND sg13cmos5l_o21ai_1
XFILLER_61_488 VPWR VGND sg13cmos5l_fill_2
X_18364_ _18364_/X _19755_/Q _18450_/B _18350_/Y VPWR VGND sg13cmos5l_a21o_1
XFILLER_15_872 VPWR VGND sg13cmos5l_fill_1
X_17315_ _17315_/Y _17303_/Y _17308_/Y _17314_/Y VPWR VGND sg13cmos5l_o21ai_1
X_12788_ _18897_/D _12771_/Y hold2372/X _13020_/B VPWR VGND sg13cmos5l_a21oi_1
X_15576_ _15576_/Y _15384_/Y _15582_/C _15574_/Y VPWR VGND sg13cmos5l_a21oi_1
X_11739_ _11741_/B _11740_/A _11740_/B VPWR VGND sg13cmos5l_and2_1
X_14527_ _14550_/B _19168_/Q _19167_/Q _14721_/A _19166_/Q VPWR VGND sg13cmos5l_nor4_1
X_18295_ _18309_/B _19695_/Q _19693_/Q _19694_/Q VPWR VGND sg13cmos5l_or3_1
X_17246_ _17455_/A _17670_/A _17246_/B VPWR VGND sg13cmos5l_xnor2_1
X_14458_ _14489_/A _19120_/Q _14459_/B VPWR VGND sg13cmos5l_xnor2_1
X_17177_ _17194_/B _17167_/Y _17172_/Y _17175_/Y VPWR VGND sg13cmos5l_a21o_1
X_13409_ _13410_/B _13394_/A _13394_/B _13408_/Y VPWR VGND sg13cmos5l_o21ai_1
X_14389_ _14408_/C _14392_/C _14389_/B VPWR VGND sg13cmos5l_and2_1
X_16128_ _16128_/Y _16129_/B VPWR VGND sg13cmos5l_inv_1
X_16059_ _16060_/B _19401_/Q _16056_/Y _16073_/A VPWR VGND sg13cmos5l_o21ai_1
Xhold2428 _10038_/A _18790_/Q VPWR VGND sg13cmos5l_dlygate4sd3_1
Xhold2417 _10285_/A _18769_/Q VPWR VGND sg13cmos5l_dlygate4sd3_1
Xhold2406 _10337_/A _19681_/Q VPWR VGND sg13cmos5l_dlygate4sd3_1
Xhold2439 _10123_/A _19337_/Q VPWR VGND sg13cmos5l_dlygate4sd3_1
XFILLER_96_385 VPWR VGND sg13cmos5l_decap_8
X_18654__1639 _18654_/RESET_B VPWR VGND sg13cmos5l_tiehi
X_19749_ _19749_/Q clkload20/A _19749_/D _19749_/RESET_B VPWR VGND sg13cmos5l_dfrbpq_1
XFILLER_80_786 VPWR VGND sg13cmos5l_fill_2
XFILLER_36_1000 VPWR VGND sg13cmos5l_fill_2
XFILLER_40_628 VPWR VGND sg13cmos5l_fill_2
X_18587__1712 _18587_/RESET_B VPWR VGND sg13cmos5l_tiehi
XFILLER_0_713 VPWR VGND sg13cmos5l_fill_1
X_10070_ _13576_/A _10070_/A VPWR VGND sg13cmos5l_inv_1
Xhold2940 hold2940/X _13237_/A VPWR VGND sg13cmos5l_dlygate4sd3_1
X_19150__485 _19150_/D VPWR VGND sg13cmos5l_tielo
Xhold2951 hold2951/X _12145_/A VPWR VGND sg13cmos5l_dlygate4sd3_1
Xhold2973 _17174_/A _19531_/Q VPWR VGND sg13cmos5l_dlygate4sd3_1
Xhold2962 _15621_/A _19352_/Q VPWR VGND sg13cmos5l_dlygate4sd3_1
Xhold2984 hold2984/X _15451_/Y VPWR VGND sg13cmos5l_dlygate4sd3_1
Xhold2995 hold2995/X _18719_/Q VPWR VGND sg13cmos5l_dlygate4sd3_1
XFILLER_47_238 VPWR VGND sg13cmos5l_fill_2
X_19720__1412 _19720_/RESET_B VPWR VGND sg13cmos5l_tiehi
X_13760_ _13761_/B _19046_/Q _13765_/B _13731_/Y VPWR VGND sg13cmos5l_a21oi_1
XFILLER_56_772 VPWR VGND sg13cmos5l_fill_1
X_10972_ _11086_/B hold2715/X _11185_/A _10991_/A VPWR VGND sg13cmos5l_mux2_1
XFILLER_16_603 VPWR VGND sg13cmos5l_fill_2
XFILLER_28_474 VPWR VGND sg13cmos5l_fill_1
X_13691_ _13720_/B _13678_/X _13685_/Y _13689_/Y VPWR VGND sg13cmos5l_a21o_1
X_12711_ _18870_/D _12603_/Y _12714_/S _12710_/Y VPWR VGND sg13cmos5l_a21oi_1
XFILLER_44_956 VPWR VGND sg13cmos5l_fill_1
X_12642_ _12658_/C _18891_/Q _12642_/B VPWR VGND sg13cmos5l_xnor2_1
X_18837__1435 _18837_/RESET_B VPWR VGND sg13cmos5l_tiehi
XFILLER_44_978 VPWR VGND sg13cmos5l_fill_1
X_15430_ _15430_/Y _15436_/A _15436_/B VPWR VGND sg13cmos5l_nand2_1
XFILLER_31_617 VPWR VGND sg13cmos5l_fill_1
XFILLER_24_680 VPWR VGND sg13cmos5l_fill_1
X_12573_ _18866_/D _12732_/A _12573_/B VPWR VGND sg13cmos5l_nor2_1
XFILLER_62_97 VPWR VGND sg13cmos5l_fill_1
X_15361_ _15361_/X _15361_/A _15361_/B _15361_/C VPWR VGND sg13cmos5l_or3_1
X_11524_ _11711_/A _11897_/A _11524_/B VPWR VGND sg13cmos5l_xnor2_1
X_17100_ _17110_/C _19579_/Q _10365_/Y _17099_/Y VPWR VGND sg13cmos5l_o21ai_1
X_18080_ _18193_/C _19711_/Q _18091_/B _18092_/A VPWR VGND sg13cmos5l_o21ai_1
X_15292_ _19284_/D _15464_/A _15292_/B VPWR VGND sg13cmos5l_nor2_1
X_14312_ _14312_/Y _14377_/B VPWR VGND sg13cmos5l_inv_1
X_17031_ _17032_/B _17089_/B _17047_/S _17030_/Y VPWR VGND sg13cmos5l_a21oi_1
X_11455_ _11457_/B _11473_/B _11454_/Y _11451_/Y VPWR VGND sg13cmos5l_a21oi_1
XFILLER_7_356 VPWR VGND sg13cmos5l_fill_1
XFILLER_7_48 VPWR VGND sg13cmos5l_fill_1
XFILLER_8_879 VPWR VGND sg13cmos5l_fill_1
X_14243_ _14243_/X _19140_/Q _14262_/D VPWR VGND sg13cmos5l_xor2_1
X_10406_ _10406_/Y input9/X _10405_/Y _10402_/Y VPWR VGND sg13cmos5l_a21oi_1
X_11386_ _11392_/A _11387_/A _11387_/B _11381_/A _10299_/Y _11385_/Y VPWR VGND sg13cmos5l_a221oi_1
X_14174_ _14178_/A _14016_/A _14166_/Y _14168_/Y _14163_/Y _14172_/Y VPWR VGND sg13cmos5l_a221oi_1
X_13125_ _18948_/D _13296_/A _13125_/B VPWR VGND sg13cmos5l_nor2_1
X_10337_ _18248_/A _10337_/A VPWR VGND sg13cmos5l_inv_1
X_18982_ _18982_/Q clkload47/A _18982_/D _18982_/RESET_B VPWR VGND sg13cmos5l_dfrbpq_1
X_10268_ _13041_/A _10268_/A VPWR VGND sg13cmos5l_inv_1
X_13056_ _13056_/Y _18898_/Q _13056_/B _13056_/C VPWR VGND sg13cmos5l_nor3_1
X_17933_ _19668_/D _17933_/A _17933_/B VPWR VGND sg13cmos5l_nor2_1
X_12007_ _12116_/B _11999_/A _11999_/B _12005_/X VPWR VGND sg13cmos5l_o21ai_1
X_19603_ _19603_/Q _19814_/CLK _19603_/D _19603_/RESET_B VPWR VGND sg13cmos5l_dfrbpq_1
X_17864_ _18056_/A _18022_/A _17875_/B VPWR VGND sg13cmos5l_and2_1
X_10199_ _16329_/A _10199_/A VPWR VGND sg13cmos5l_inv_1
X_16815_ _19495_/D _16797_/A _16812_/A _16814_/Y VPWR VGND sg13cmos5l_a21oi_1
X_17795_ _17895_/C _19647_/Q _19608_/Q _19667_/Q VPWR VGND sg13cmos5l_nand3_1
X_16746_ _16932_/A _16746_/A _16895_/B VPWR VGND sg13cmos5l_nor2_1
X_19534_ _19534_/Q clkload41/A _19534_/D _19534_/RESET_B VPWR VGND sg13cmos5l_dfrbpq_1
XFILLER_59_1022 VPWR VGND sg13cmos5l_decap_8
X_13958_ _14149_/A _19082_/Q _19081_/Q VPWR VGND sg13cmos5l_xnor2_1
XFILLER_35_901 VPWR VGND sg13cmos5l_fill_1
X_12909_ _12919_/B _10064_/Y _12901_/B _10063_/Y VPWR VGND sg13cmos5l_a21o_1
X_19465_ _19465_/Q _19679_/CLK _19465_/D _19465_/RESET_B VPWR VGND sg13cmos5l_dfrbpq_1
XFILLER_35_934 VPWR VGND sg13cmos5l_decap_8
X_16677_ _16791_/A _19502_/Q _16785_/B VPWR VGND sg13cmos5l_xnor2_1
X_13889_ _13889_/Y _18992_/Q _13891_/A VPWR VGND sg13cmos5l_xnor2_1
X_19261__981 _19261_/RESET_B VPWR VGND sg13cmos5l_tiehi
X_18416_ _18416_/Y _18339_/B _18411_/Y _18482_/B _18418_/A VPWR VGND sg13cmos5l_a22oi_1
XFILLER_35_989 VPWR VGND sg13cmos5l_decap_8
X_15628_ _15629_/B _15621_/B _15628_/B VPWR VGND sg13cmos5l_nand2b_1
X_19396_ _19396_/Q clkload6/A _19396_/D _19396_/RESET_B VPWR VGND sg13cmos5l_dfrbpq_1
X_18347_ _18347_/Y _19729_/Q _19690_/Q VPWR VGND sg13cmos5l_xnor2_1
X_15559_ _15559_/Y _15364_/Y _15551_/Y _15582_/B _15394_/B VPWR VGND sg13cmos5l_a22oi_1
X_18278_ _18278_/Y _18261_/B _18282_/S _18482_/A VPWR VGND sg13cmos5l_o21ai_1
X_17229_ _17345_/A _19587_/Q _17234_/B VPWR VGND sg13cmos5l_nor2_1
X_18900__1368 _18900_/RESET_B VPWR VGND sg13cmos5l_tiehi
X_09982_ _09982_/Y _09982_/A VPWR VGND sg13cmos5l_inv_1
Xhold2203 _10308_/A _18644_/Q VPWR VGND sg13cmos5l_dlygate4sd3_1
XFILLER_97_650 VPWR VGND sg13cmos5l_fill_1
Xhold2214 _10391_/A _18563_/Q VPWR VGND sg13cmos5l_dlygate4sd3_1
Xhold2236 _10267_/A _18894_/Q VPWR VGND sg13cmos5l_dlygate4sd3_1
Xhold2225 _17122_/B _19580_/Q VPWR VGND sg13cmos5l_dlygate4sd3_1
X_18575__1727 _18575_/RESET_B VPWR VGND sg13cmos5l_tiehi
Xhold2258 _10359_/A _19558_/Q VPWR VGND sg13cmos5l_dlygate4sd3_1
Xhold2269 hold2269/X _17729_/Y VPWR VGND sg13cmos5l_dlygate4sd3_1
Xhold2247 _10132_/A _19420_/Q VPWR VGND sg13cmos5l_dlygate4sd3_1
XFILLER_38_761 VPWR VGND sg13cmos5l_fill_2
X_18618__1678 _18618_/RESET_B VPWR VGND sg13cmos5l_tiehi
X_19522__692 _19522_/RESET_B VPWR VGND sg13cmos5l_tiehi
XFILLER_40_469 VPWR VGND sg13cmos5l_fill_2
XFILLER_21_650 VPWR VGND sg13cmos5l_fill_1
XFILLER_5_816 VPWR VGND sg13cmos5l_fill_1
X_11240_ _11242_/B _18663_/Q _18662_/Q _11437_/A VPWR VGND sg13cmos5l_nor3_1
X_11171_ _11178_/B _18614_/Q _18615_/Q _18616_/Q _11171_/D VPWR VGND sg13cmos5l_nor4_1
X_10122_ _16012_/A _10122_/A VPWR VGND sg13cmos5l_inv_1
XFILLER_102_460 VPWR VGND sg13cmos5l_fill_2
X_10053_ _13018_/A _10053_/A VPWR VGND sg13cmos5l_inv_1
X_14930_ _14930_/Y _19254_/Q _15454_/A _14948_/C VPWR VGND sg13cmos5l_nor3_1
Xhold2770 _17808_/A _19669_/Q VPWR VGND sg13cmos5l_dlygate4sd3_1
X_14861_ _14861_/X _14746_/X _14829_/Y _14871_/S VPWR VGND sg13cmos5l_mux2_1
Xhold2781 _16513_/C _16512_/Y VPWR VGND sg13cmos5l_dlygate4sd3_1
Xhold2792 _14335_/C _14334_/Y VPWR VGND sg13cmos5l_dlygate4sd3_1
X_13812_ _19051_/D _13812_/A _13813_/B VPWR VGND sg13cmos5l_and2_1
X_16600_ _16601_/B _16614_/B _16598_/Y _16860_/A VPWR VGND sg13cmos5l_o21ai_1
XFILLER_75_377 VPWR VGND sg13cmos5l_fill_2
X_17580_ _17610_/S _17593_/A _17580_/B VPWR VGND sg13cmos5l_nor2_1
X_14792_ _14815_/B _19210_/Q _19209_/Q _19207_/Q _19208_/Q VPWR VGND sg13cmos5l_nor4_1
X_16531_ _16532_/B _16531_/A _16531_/B VPWR VGND sg13cmos5l_xor2_1
X_13743_ _13770_/A _13768_/B _13768_/C _13768_/A VPWR VGND sg13cmos5l_a21oi_1
X_10955_ _10955_/Y _10955_/A _10955_/B _10955_/C VPWR VGND sg13cmos5l_nor3_1
X_13674_ _13680_/B _19041_/Q _19042_/Q _19039_/Q _19040_/Q VPWR VGND sg13cmos5l_nor4_1
X_10886_ _10918_/A _10886_/A _10886_/B VPWR VGND sg13cmos5l_and2_1
X_16462_ _16462_/X _16433_/B _16243_/B _16462_/S VPWR VGND sg13cmos5l_mux2_1
X_19250_ _19250_/Q clkload42/A _19250_/D _19250_/RESET_B VPWR VGND sg13cmos5l_dfrbpq_1
X_12625_ _12633_/B _18873_/Q _18874_/Q _18872_/Q _12625_/D VPWR VGND sg13cmos5l_nor4_1
X_18201_ _18201_/Y _18201_/A _18201_/B VPWR VGND sg13cmos5l_xnor2_1
X_19181_ _19181_/Q _19227_/CLK _19181_/D _19181_/RESET_B VPWR VGND sg13cmos5l_dfrbpq_1
X_15413_ _15413_/X _15292_/B _15404_/X _15412_/Y VPWR VGND sg13cmos5l_a21o_1
X_16393_ _16400_/B _19451_/Q _19450_/Q _16399_/D VPWR VGND sg13cmos5l_nor3_1
X_12556_ _12556_/Y _12551_/X _12553_/Y _12350_/Y VPWR VGND sg13cmos5l_a21oi_1
X_15344_ _15344_/X _15383_/A _15383_/C _15535_/A VPWR VGND sg13cmos5l_a21o_1
X_18132_ _18132_/Y _18159_/B _18157_/B VPWR VGND sg13cmos5l_nor2_1
X_11507_ _11526_/B _18717_/Q _18718_/Q _18719_/Q _18720_/Q VPWR VGND sg13cmos5l_nor4_1
XFILLER_8_643 VPWR VGND sg13cmos5l_fill_1
X_12487_ _12487_/Y _12487_/A _18814_/Q VPWR VGND sg13cmos5l_nor2_1
X_15275_ _15275_/Y _15270_/Y _15273_/Y _15274_/Y VPWR VGND sg13cmos5l_o21ai_1
X_18063_ _18195_/A _17869_/Y _18039_/X _18062_/Y VPWR VGND sg13cmos5l_o21ai_1
XFILLER_99_904 VPWR VGND sg13cmos5l_fill_2
X_17014_ _17014_/Y _17037_/A _17087_/B _17013_/Y VPWR VGND sg13cmos5l_o21ai_1
X_11438_ _11438_/X _18661_/Q _11438_/B VPWR VGND sg13cmos5l_or2_1
X_14226_ _14341_/B _19135_/Q _14226_/B VPWR VGND sg13cmos5l_and2_1
XFILLER_99_937 VPWR VGND sg13cmos5l_decap_4
XFILLER_98_60 VPWR VGND sg13cmos5l_fill_2
X_11369_ _11369_/Y _11365_/Y _11368_/Y _11367_/Y VPWR VGND sg13cmos5l_o21ai_1
X_14157_ _14157_/Y _19076_/Q _14165_/D VPWR VGND sg13cmos5l_xnor2_1
X_13108_ _13108_/Y _13108_/A _13110_/B _13108_/C VPWR VGND sg13cmos5l_nand3_1
X_18694__1596 _18694_/RESET_B VPWR VGND sg13cmos5l_tiehi
X_18965_ _18965_/Q clkload64/A _18965_/D _18965_/RESET_B VPWR VGND sg13cmos5l_dfrbpq_1
X_14088_ _14088_/Y _14086_/Y _14088_/B VPWR VGND sg13cmos5l_nand2b_1
XFILLER_79_683 VPWR VGND sg13cmos5l_fill_1
X_18896_ _18896_/Q clkload67/A _18896_/D _18896_/RESET_B VPWR VGND sg13cmos5l_dfrbpq_1
X_13039_ _13039_/Y _18956_/Q _13580_/A _13056_/C VPWR VGND sg13cmos5l_nand3_1
X_17916_ _17916_/Y _17916_/A _17916_/B VPWR VGND sg13cmos5l_nor2_1
XFILLER_39_536 VPWR VGND sg13cmos5l_decap_4
X_17847_ _17847_/Y _17847_/A _17875_/B VPWR VGND sg13cmos5l_nand2_1
XFILLER_96_1019 VPWR VGND sg13cmos5l_decap_8
XFILLER_54_528 VPWR VGND sg13cmos5l_fill_1
XFILLER_82_848 VPWR VGND sg13cmos5l_fill_1
X_19517_ _19517_/Q clkload35/A _19517_/D _19517_/RESET_B VPWR VGND sg13cmos5l_dfrbpq_1
X_17778_ _17867_/A _17600_/X _17765_/X _17781_/S _17777_/Y VPWR VGND sg13cmos5l_a22oi_1
XFILLER_54_539 VPWR VGND sg13cmos5l_fill_1
XFILLER_35_742 VPWR VGND sg13cmos5l_fill_1
X_16729_ _16730_/B _16729_/A _16708_/X VPWR VGND sg13cmos5l_nor2b_1
X_19448_ _19448_/Q clkload10/A _19448_/D _19448_/RESET_B VPWR VGND sg13cmos5l_dfrbpq_1
X_19379_ _19379_/Q clkload19/A _19379_/D _19379_/RESET_B VPWR VGND sg13cmos5l_dfrbpq_1
XFILLER_89_436 VPWR VGND sg13cmos5l_fill_1
XFILLER_104_758 VPWR VGND sg13cmos5l_fill_2
Xhold2000 hold2000/X _18901_/Q VPWR VGND sg13cmos5l_dlygate4sd3_1
X_18639__534 _18639_/D VPWR VGND sg13cmos5l_tielo
Xhold2011 hold2011/X _19278_/Q VPWR VGND sg13cmos5l_dlygate4sd3_1
XFILLER_100_920 VPWR VGND sg13cmos5l_fill_2
Xhold2033 _11691_/B _18693_/Q VPWR VGND sg13cmos5l_dlygate4sd3_1
Xhold2044 _10011_/A _18691_/Q VPWR VGND sg13cmos5l_dlygate4sd3_1
Xhold2022 _09987_/A _19321_/Q VPWR VGND sg13cmos5l_dlygate4sd3_1
Xhold2066 _13439_/A _18985_/Q VPWR VGND sg13cmos5l_dlygate4sd3_1
Xhold2077 hold2077/X _19689_/Q VPWR VGND sg13cmos5l_dlygate4sd3_1
Xhold2088 _10127_/A _19378_/Q VPWR VGND sg13cmos5l_dlygate4sd3_1
Xhold2055 _09988_/A _19320_/Q VPWR VGND sg13cmos5l_dlygate4sd3_1
XFILLER_85_686 VPWR VGND sg13cmos5l_fill_1
Xhold2099 _17365_/A _19532_/Q VPWR VGND sg13cmos5l_dlygate4sd3_1
X_18877__1392 _18877_/RESET_B VPWR VGND sg13cmos5l_tiehi
X_19678__1781 _19678_/RESET_B VPWR VGND sg13cmos5l_tiehi
XFILLER_14_904 VPWR VGND sg13cmos5l_fill_2
XFILLER_14_915 VPWR VGND sg13cmos5l_fill_2
XFILLER_81_870 VPWR VGND sg13cmos5l_fill_2
X_10740_ _10740_/Y input2/X fanout68/X _10746_/A VPWR VGND sg13cmos5l_o21ai_1
X_10671_ _10671_/Y _10393_/A _10667_/Y _10664_/Y VPWR VGND sg13cmos5l_a21oi_1
XFILLER_43_33 VPWR VGND sg13cmos5l_fill_2
XFILLER_9_407 VPWR VGND sg13cmos5l_decap_8
XFILLER_13_436 VPWR VGND sg13cmos5l_decap_4
X_12410_ _12410_/Y _12410_/A _12410_/B VPWR VGND sg13cmos5l_xnor2_1
X_13390_ _13394_/A _13380_/Y _13385_/Y _13419_/B _13393_/A _13387_/Y VPWR VGND sg13cmos5l_a221oi_1
X_12341_ _12342_/B _12728_/A _18834_/Q _12341_/C VPWR VGND sg13cmos5l_nand3_1
X_19126__1125 _19126_/RESET_B VPWR VGND sg13cmos5l_tiehi
X_12272_ _12272_/Y _18787_/Q _12294_/A _12270_/Y _12271_/Y VPWR VGND sg13cmos5l_a22oi_1
XFILLER_5_624 VPWR VGND sg13cmos5l_fill_1
X_15060_ _15061_/B _19263_/Q _19264_/Q _19265_/Q VPWR VGND sg13cmos5l_o21ai_1
XFILLER_104_0 VPWR VGND sg13cmos5l_fill_2
X_11223_ _11315_/C _18649_/Q _11223_/B _18669_/Q VPWR VGND sg13cmos5l_nand3_1
X_14011_ _14011_/Y _14010_/B _14200_/A _14010_/Y VPWR VGND sg13cmos5l_a21oi_1
X_11154_ _11171_/D _18611_/Q _18612_/Q _18613_/Q VPWR VGND sg13cmos5l_or3_1
X_19251__991 _19251_/RESET_B VPWR VGND sg13cmos5l_tiehi
X_18750_ _18750_/Q _18750_/CLK _18750_/D _18750_/RESET_B VPWR VGND sg13cmos5l_dfrbpq_1
X_11085_ _18632_/D _18499_/B _11085_/B VPWR VGND sg13cmos5l_nor2_1
X_10105_ _15188_/A _10105_/A VPWR VGND sg13cmos5l_inv_1
X_15962_ _15963_/B _16020_/B _15984_/B _15961_/Y VPWR VGND sg13cmos5l_a21oi_1
X_10036_ _10036_/Y _18699_/Q VPWR VGND sg13cmos5l_inv_1
X_18681_ _18681_/Q _19003_/CLK _18681_/D _18681_/RESET_B VPWR VGND sg13cmos5l_dfrbpq_1
X_17701_ _17707_/A _17706_/A _17706_/B _17699_/A _17944_/B _17700_/Y VPWR VGND sg13cmos5l_a221oi_1
X_14913_ _19223_/D _14913_/A _14913_/B VPWR VGND sg13cmos5l_nor2_1
XFILLER_75_163 VPWR VGND sg13cmos5l_fill_1
XFILLER_64_804 VPWR VGND sg13cmos5l_fill_2
X_17632_ _17632_/Y _17625_/A _17625_/B _17634_/A _17634_/B VPWR VGND sg13cmos5l_a22oi_1
X_15893_ _15904_/B _19389_/Q _19390_/Q _19391_/Q VPWR VGND sg13cmos5l_or3_1
X_14844_ _14844_/Y _14877_/A _14915_/B VPWR VGND sg13cmos5l_nor2_1
XFILLER_1_1012 VPWR VGND sg13cmos5l_decap_8
XFILLER_17_731 VPWR VGND sg13cmos5l_fill_2
XFILLER_36_528 VPWR VGND sg13cmos5l_fill_1
X_11987_ _12028_/A _18742_/Q _11988_/B VPWR VGND sg13cmos5l_xnor2_1
X_17563_ _17563_/Y _19636_/Q _17564_/B VPWR VGND sg13cmos5l_xnor2_1
XFILLER_51_509 VPWR VGND sg13cmos5l_fill_2
X_14775_ _14884_/A _19218_/Q _14783_/B _14774_/Y VPWR VGND sg13cmos5l_a21oi_1
X_13726_ _13727_/B _10797_/Y _13818_/B _13819_/B _13728_/A VPWR VGND sg13cmos5l_a22oi_1
X_17494_ _17494_/X _17494_/A _17494_/B VPWR VGND sg13cmos5l_and2_1
X_10938_ _10938_/Y _18633_/Q _10938_/B VPWR VGND sg13cmos5l_xnor2_1
X_19163__484 _19163_/D VPWR VGND sg13cmos5l_tielo
X_19302_ _19302_/Q _19302_/CLK _19302_/D _19302_/RESET_B VPWR VGND sg13cmos5l_dfrbpq_1
XFILLER_17_786 VPWR VGND sg13cmos5l_fill_1
X_16514_ _16521_/B _16455_/Y _16458_/X _16526_/B VPWR VGND sg13cmos5l_mux2_1
X_16445_ _16448_/C _16457_/C _16457_/D _16228_/B VPWR VGND sg13cmos5l_a21o_1
XFILLER_16_296 VPWR VGND sg13cmos5l_fill_1
X_19233_ _19233_/Q clkload43/A _19233_/D _19233_/RESET_B VPWR VGND sg13cmos5l_dfrbpq_1
XFILLER_31_244 VPWR VGND sg13cmos5l_fill_2
X_13657_ _13669_/B _19039_/Q _19040_/Q VPWR VGND sg13cmos5l_nor2_1
X_10869_ _10869_/Y _10853_/B _10865_/S _11084_/B VPWR VGND sg13cmos5l_o21ai_1
X_12608_ _12652_/B _18885_/Q _18886_/Q _18887_/Q VPWR VGND sg13cmos5l_o21ai_1
X_13588_ _13588_/Y _16822_/A _18575_/Q VPWR VGND sg13cmos5l_nor2_1
XFILLER_8_440 VPWR VGND sg13cmos5l_fill_1
XFILLER_9_952 VPWR VGND sg13cmos5l_decap_4
XFILLER_9_963 VPWR VGND sg13cmos5l_fill_1
X_19164_ _19164_/Q clkload50/A _19164_/D _19164_/RESET_B VPWR VGND sg13cmos5l_dfrbpq_1
X_16376_ _16376_/Y _19447_/Q fanout85/X _16081_/A VPWR VGND sg13cmos5l_o21ai_1
X_12539_ _12539_/Y _18824_/Q _12546_/B VPWR VGND sg13cmos5l_xnor2_1
X_19095_ _19095_/Q _19136_/CLK _19095_/D _19095_/RESET_B VPWR VGND sg13cmos5l_dfrbpq_1
X_15327_ _15327_/Y _15434_/A _15327_/B VPWR VGND sg13cmos5l_nor2_1
X_18115_ _18115_/Y _19716_/Q _19715_/Q _19700_/Q VPWR VGND sg13cmos5l_nand3b_1
X_15258_ _15272_/B _19243_/Q _19241_/Q _19242_/Q VPWR VGND sg13cmos5l_or3_1
X_18046_ _18046_/Y _18057_/B _18014_/Y VPWR VGND sg13cmos5l_nor2b_1
X_14209_ _14209_/Y _19110_/Q _19071_/Q VPWR VGND sg13cmos5l_xnor2_1
XFILLER_63_1007 VPWR VGND sg13cmos5l_fill_1
X_15189_ _19263_/D _15191_/A _15189_/B VPWR VGND sg13cmos5l_nor2_1
XFILLER_98_233 VPWR VGND sg13cmos5l_fill_1
X_18948_ _18948_/Q _18975_/CLK _18948_/D _18948_/RESET_B VPWR VGND sg13cmos5l_dfrbpq_1
X_18832__1440 _18832_/RESET_B VPWR VGND sg13cmos5l_tiehi
XFILLER_95_962 VPWR VGND sg13cmos5l_fill_2
XFILLER_67_653 VPWR VGND sg13cmos5l_fill_1
XFILLER_39_333 VPWR VGND sg13cmos5l_fill_2
X_18879_ _18879_/Q clkload63/A _18879_/D _18879_/RESET_B VPWR VGND sg13cmos5l_dfrbpq_1
XFILLER_66_141 VPWR VGND sg13cmos5l_fill_2
XFILLER_82_645 VPWR VGND sg13cmos5l_fill_1
XFILLER_82_623 VPWR VGND sg13cmos5l_fill_2
XFILLER_66_174 VPWR VGND sg13cmos5l_decap_4
XFILLER_22_200 VPWR VGND sg13cmos5l_fill_2
Xfanout26 fanout26/X _17351_/Y VPWR VGND sg13cmos5l_buf_1
Xfanout37 _15727_/S _15722_/Y VPWR VGND sg13cmos5l_buf_1
XFILLER_23_734 VPWR VGND sg13cmos5l_fill_1
Xfanout59 _10865_/S _10858_/Y VPWR VGND sg13cmos5l_buf_1
Xfanout48 _13067_/S _13064_/Y VPWR VGND sg13cmos5l_buf_1
XFILLER_104_544 VPWR VGND sg13cmos5l_fill_1
XFILLER_104_533 VPWR VGND sg13cmos5l_decap_8
XFILLER_78_918 VPWR VGND sg13cmos5l_fill_2
XFILLER_89_299 VPWR VGND sg13cmos5l_fill_2
XFILLER_79_1003 VPWR VGND sg13cmos5l_decap_8
XFILLER_58_686 VPWR VGND sg13cmos5l_fill_1
XFILLER_58_664 VPWR VGND sg13cmos5l_fill_1
X_11910_ _11910_/Y _18789_/Q _11932_/A _11907_/Y _11908_/Y _11909_/Y VPWR VGND sg13cmos5l_a221oi_1
X_12890_ _12890_/X _18930_/Q _12908_/D VPWR VGND sg13cmos5l_xor2_1
X_11841_ _11842_/A _11841_/A _11905_/B VPWR VGND sg13cmos5l_nor2_1
X_11772_ _11773_/B _11772_/A _11865_/B VPWR VGND sg13cmos5l_and2_1
XFILLER_54_54 VPWR VGND sg13cmos5l_fill_2
X_14560_ _14743_/A _14721_/A _14578_/B VPWR VGND sg13cmos5l_nor2b_1
X_10723_ _10723_/Y fanout99/X _10720_/Y _10721_/Y VPWR VGND sg13cmos5l_o21ai_1
X_18667__1626 _18667_/RESET_B VPWR VGND sg13cmos5l_tiehi
XFILLER_72_199 VPWR VGND sg13cmos5l_decap_4
X_13511_ _13511_/Y _13410_/A _13410_/B _13519_/S _13506_/X _13507_/Y VPWR VGND sg13cmos5l_a221oi_1
XFILLER_9_204 VPWR VGND sg13cmos5l_fill_1
X_14491_ _14615_/A _14586_/A VPWR VGND sg13cmos5l_inv_1
X_10654_ _10664_/B _10397_/X _10664_/A _10650_/A VPWR VGND sg13cmos5l_o21ai_1
X_13442_ _13546_/C _13441_/A _13441_/B _13452_/A VPWR VGND sg13cmos5l_o21ai_1
X_16230_ _16233_/D _16243_/A _16220_/B _16229_/Y VPWR VGND sg13cmos5l_o21ai_1
X_13373_ _13373_/X _13373_/A _13373_/B VPWR VGND sg13cmos5l_and2_1
X_16161_ _16173_/A _16161_/A _16161_/B VPWR VGND sg13cmos5l_nor2_1
X_10585_ _10647_/A _10544_/A _10584_/Y _10585_/S VPWR VGND sg13cmos5l_mux2_1
X_12324_ _12324_/X _18843_/Q _12324_/B VPWR VGND sg13cmos5l_xor2_1
Xclkload29 clkload29/Y clkload29/A VPWR VGND sg13cmos5l_inv_1
X_15112_ _15112_/Y _15025_/S _15016_/Y _15111_/A _15111_/B _15015_/Y VPWR VGND sg13cmos5l_a221oi_1
Xclkload18 clkload18/Y clkload18/A VPWR VGND sg13cmos5l_inv_4
XFILLER_10_984 VPWR VGND sg13cmos5l_decap_4
X_18570__1732 _18570_/RESET_B VPWR VGND sg13cmos5l_tiehi
XFILLER_6_988 VPWR VGND sg13cmos5l_fill_2
XFILLER_6_966 VPWR VGND sg13cmos5l_decap_4
X_16092_ _16092_/Y _19374_/Q _19367_/Q VPWR VGND sg13cmos5l_nor2_1
X_12255_ _12255_/Y hold1958/X fanout95/X _12528_/A VPWR VGND sg13cmos5l_o21ai_1
XFILLER_48_8 VPWR VGND sg13cmos5l_decap_4
XFILLER_5_498 VPWR VGND sg13cmos5l_fill_1
X_15043_ _15057_/A _15043_/A _15043_/B VPWR VGND sg13cmos5l_nor2_1
X_12186_ _12187_/B _12174_/A _12171_/A _12186_/S VPWR VGND sg13cmos5l_mux2_1
X_18917__1349 _18917_/RESET_B VPWR VGND sg13cmos5l_tiehi
X_11206_ _11208_/B _11205_/A _11205_/B _11204_/Y VPWR VGND sg13cmos5l_o21ai_1
X_18802_ _18802_/Q clkload61/A _18802_/D _18802_/RESET_B VPWR VGND sg13cmos5l_dfrbpq_1
X_11137_ _11137_/Y _11120_/B _11133_/S _11351_/B VPWR VGND sg13cmos5l_o21ai_1
X_18613__1683 _18613_/RESET_B VPWR VGND sg13cmos5l_tiehi
X_19782_ _19782_/Q clkload48/A _19782_/D _19782_/RESET_B VPWR VGND sg13cmos5l_dfrbpq_1
X_16994_ _16998_/B _16994_/A _17015_/B VPWR VGND sg13cmos5l_nor2_1
X_18733_ _18733_/Q _18733_/CLK _18733_/D _18733_/RESET_B VPWR VGND sg13cmos5l_dfrbpq_1
X_11068_ _18619_/D _11091_/A _11068_/B VPWR VGND sg13cmos5l_nor2_1
X_15945_ _15945_/Y _15943_/Y _15944_/Y _15938_/Y VPWR VGND sg13cmos5l_a21oi_1
XFILLER_0_192 VPWR VGND sg13cmos5l_decap_4
X_10019_ _10019_/Y _10019_/A VPWR VGND sg13cmos5l_inv_1
X_18664_ _18664_/Q clkload56/A _18664_/D _18664_/RESET_B VPWR VGND sg13cmos5l_dfrbpq_1
X_15876_ _15975_/C _19363_/Q _19324_/Q _19383_/Q VPWR VGND sg13cmos5l_nand3_1
X_18595_ _18595_/Q clkload30/A _18595_/D _18595_/RESET_B VPWR VGND sg13cmos5l_dfrbpq_1
X_17615_ _17679_/B _17642_/B VPWR VGND sg13cmos5l_inv_1
XFILLER_63_144 VPWR VGND sg13cmos5l_fill_1
XFILLER_52_807 VPWR VGND sg13cmos5l_fill_1
X_14827_ _14827_/Y _15183_/A _15004_/A VPWR VGND sg13cmos5l_nand2_1
X_17546_ _17546_/Y _19631_/Q _19632_/Q VPWR VGND sg13cmos5l_xnor2_1
X_14758_ _14850_/A _14731_/A _14737_/A _14757_/Y VPWR VGND sg13cmos5l_a21oi_1
XFILLER_32_520 VPWR VGND sg13cmos5l_decap_8
XFILLER_32_531 VPWR VGND sg13cmos5l_fill_1
X_13709_ _13716_/C _13709_/A _13720_/B _13720_/C VPWR VGND sg13cmos5l_nand3_1
X_17477_ _17591_/B _17470_/Y _17472_/Y _17475_/X VPWR VGND sg13cmos5l_o21ai_1
X_14689_ _14689_/Y _15181_/B _14978_/A VPWR VGND sg13cmos5l_nand2b_1
X_16428_ _16428_/Y _16227_/A _16425_/Y _16426_/Y _16427_/Y VPWR VGND sg13cmos5l_a22oi_1
X_19216_ _19216_/Q _19262_/CLK _19216_/D _19216_/RESET_B VPWR VGND sg13cmos5l_dfrbpq_1
X_19190__1058 _19190_/RESET_B VPWR VGND sg13cmos5l_tiehi
X_19147_ _19147_/Q clkload42/A _19147_/D _19147_/RESET_B VPWR VGND sg13cmos5l_dfrbpq_1
X_16359_ _16359_/Y _16358_/B _16549_/A VPWR VGND sg13cmos5l_nand2b_1
XFILLER_67_0 VPWR VGND sg13cmos5l_fill_1
X_19078_ _19078_/Q clkload54/A _19078_/D _19078_/RESET_B VPWR VGND sg13cmos5l_dfrbpq_1
X_18029_ _18029_/Y _18029_/A _18061_/A VPWR VGND sg13cmos5l_nor2_1
XFILLER_99_531 VPWR VGND sg13cmos5l_decap_4
Xfanout205 _18213_/A _18067_/A VPWR VGND sg13cmos5l_buf_1
Xfanout227 _16825_/A _16827_/A VPWR VGND sg13cmos5l_buf_1
Xfanout216 _17677_/A _17672_/B VPWR VGND sg13cmos5l_buf_1
Xfanout238 _16308_/B _16061_/Y VPWR VGND sg13cmos5l_buf_1
XFILLER_101_536 VPWR VGND sg13cmos5l_decap_4
Xfanout249 _15464_/A _15466_/A VPWR VGND sg13cmos5l_buf_1
XFILLER_39_130 VPWR VGND sg13cmos5l_fill_2
XFILLER_83_954 VPWR VGND sg13cmos5l_decap_8
XFILLER_70_637 VPWR VGND sg13cmos5l_fill_1
XFILLER_55_689 VPWR VGND sg13cmos5l_fill_2
XFILLER_70_648 VPWR VGND sg13cmos5l_fill_1
X_18993__1267 _18993_/RESET_B VPWR VGND sg13cmos5l_tiehi
X_19166__1082 _19166_/RESET_B VPWR VGND sg13cmos5l_tiehi
X_10370_ _16586_/A _10370_/A VPWR VGND sg13cmos5l_inv_1
X_12040_ _12045_/A _18796_/Q _12054_/B VPWR VGND sg13cmos5l_and2_1
XFILLER_46_1002 VPWR VGND sg13cmos5l_fill_2
XFILLER_49_54 VPWR VGND sg13cmos5l_decap_4
XFILLER_104_396 VPWR VGND sg13cmos5l_fill_2
X_13991_ _14012_/S _13991_/A _13991_/B VPWR VGND sg13cmos5l_nand2_1
XFILLER_105_71 VPWR VGND sg13cmos5l_fill_1
X_12942_ _12944_/B _12940_/A _12926_/B _12941_/Y VPWR VGND sg13cmos5l_o21ai_1
XFILLER_74_932 VPWR VGND sg13cmos5l_fill_1
X_18601__1698 _18601_/RESET_B VPWR VGND sg13cmos5l_tiehi
XFILLER_46_623 VPWR VGND sg13cmos5l_decap_8
X_15730_ _19335_/D _15690_/A _15727_/S _15729_/Y VPWR VGND sg13cmos5l_a21oi_1
X_18730__525 _18730_/D VPWR VGND sg13cmos5l_tielo
XFILLER_74_976 VPWR VGND sg13cmos5l_fill_1
X_15661_ _15851_/A _15661_/A VPWR VGND sg13cmos5l_inv_1
XFILLER_92_1000 VPWR VGND sg13cmos5l_fill_2
X_12873_ _12991_/A _18925_/Q _12875_/B VPWR VGND sg13cmos5l_nor2_1
XFILLER_74_998 VPWR VGND sg13cmos5l_fill_2
X_17400_ _17400_/X _17400_/A _17400_/B VPWR VGND sg13cmos5l_or2_1
XFILLER_46_678 VPWR VGND sg13cmos5l_fill_2
X_14612_ _14619_/B _14648_/B _14611_/B _14611_/Y VPWR VGND sg13cmos5l_o21ai_1
X_11824_ _11824_/Y _11824_/A _11824_/B _11824_/C _11824_/D VPWR VGND sg13cmos5l_nand4_1
X_15592_ _15708_/A _19344_/Q _15721_/B VPWR VGND sg13cmos5l_xnor2_1
X_19320__918 _19320_/RESET_B VPWR VGND sg13cmos5l_tiehi
XFILLER_33_339 VPWR VGND sg13cmos5l_decap_4
X_18380_ _18380_/X _18380_/A _18382_/B _18380_/C VPWR VGND sg13cmos5l_and3_1
X_11755_ _11760_/A _18754_/Q _11766_/B VPWR VGND sg13cmos5l_and2_1
X_17331_ _17333_/A _17225_/B _17347_/A _17331_/C VPWR VGND sg13cmos5l_nand3b_1
XFILLER_60_147 VPWR VGND sg13cmos5l_fill_2
X_14543_ _14543_/Y _14537_/A _14537_/B _14725_/A VPWR VGND sg13cmos5l_a21oi_1
X_10706_ _10711_/B _18571_/Q _10703_/Y _10705_/Y VPWR VGND sg13cmos5l_o21ai_1
X_17262_ _17269_/B _19593_/Q _17263_/B VPWR VGND sg13cmos5l_nor2b_1
X_14474_ _14474_/Y _14474_/A _14489_/B VPWR VGND sg13cmos5l_nor2_1
X_11686_ _11686_/Y hold1981/X fanout94/X _10860_/B VPWR VGND sg13cmos5l_o21ai_1
X_13425_ _13527_/A _13382_/Y _13419_/B _13202_/Y VPWR VGND sg13cmos5l_o21ai_1
X_19001_ _19001_/Q clkload53/A _19001_/D _19001_/RESET_B VPWR VGND sg13cmos5l_dfrbpq_1
X_16213_ _16213_/Y _16213_/A _16256_/A VPWR VGND sg13cmos5l_nor2_1
X_17193_ _17193_/Y _17155_/X _17199_/B VPWR VGND sg13cmos5l_nand2b_1
X_10637_ _19793_/D _18236_/A _10646_/B VPWR VGND sg13cmos5l_and2_1
X_13356_ _13356_/Y _10002_/Y fanout97/X _13355_/Y VPWR VGND sg13cmos5l_a21oi_1
X_16144_ _19413_/D _16320_/A _16144_/B VPWR VGND sg13cmos5l_nor2_1
X_10568_ _10645_/A _10528_/X _10917_/A _10585_/S VPWR VGND sg13cmos5l_mux2_1
X_12307_ _12307_/Y _12307_/A _12307_/B VPWR VGND sg13cmos5l_nor2_1
X_13287_ _18964_/D _13287_/A _13289_/B VPWR VGND sg13cmos5l_nor2_1
X_16075_ _16075_/Y hold1970/X fanout66/X _16081_/A VPWR VGND sg13cmos5l_o21ai_1
X_10499_ _10499_/Y _10499_/A _10499_/B _10499_/C VPWR VGND sg13cmos5l_nand3_1
X_12238_ _12238_/Y _12238_/A _12238_/B VPWR VGND sg13cmos5l_nor2_1
X_15026_ _19245_/D _15191_/A _15026_/B VPWR VGND sg13cmos5l_nor2_1
XFILLER_69_715 VPWR VGND sg13cmos5l_fill_1
XFILLER_39_4 VPWR VGND sg13cmos5l_decap_8
X_12169_ _12170_/B _12169_/A _12169_/B VPWR VGND sg13cmos5l_xor2_1
Xhold1909 _18470_/B _19707_/Q VPWR VGND sg13cmos5l_dlygate4sd3_1
X_16977_ _16979_/B _19551_/Q _16995_/B VPWR VGND sg13cmos5l_nor2b_1
X_19765_ _19765_/Q clkload21/A _19765_/D _19765_/RESET_B VPWR VGND sg13cmos5l_dfrbpq_1
X_18716_ _18716_/Q clkload56/A _18716_/D _18716_/RESET_B VPWR VGND sg13cmos5l_dfrbpq_1
Xinput5 input5/X ui_in[3] VPWR VGND sg13cmos5l_buf_1
X_15928_ _15939_/C _19395_/Q _15929_/B VPWR VGND sg13cmos5l_xnor2_1
X_19696_ _19696_/Q clkload14/A _19696_/D _19696_/RESET_B VPWR VGND sg13cmos5l_dfrbpq_1
XFILLER_80_902 VPWR VGND sg13cmos5l_fill_1
X_18647_ _18647_/Q clkload34/A _18647_/D _18647_/RESET_B VPWR VGND sg13cmos5l_dfrbpq_1
X_15859_ _19370_/D _15864_/A _15961_/A VPWR VGND sg13cmos5l_and2_1
XFILLER_36_155 VPWR VGND sg13cmos5l_decap_8
X_18578_ _18578_/Q _18594_/CLK _18578_/D _18578_/RESET_B VPWR VGND sg13cmos5l_dfrbpq_1
X_19440__788 _19440_/RESET_B VPWR VGND sg13cmos5l_tiehi
X_17529_ _17530_/B _17529_/A _17637_/B VPWR VGND sg13cmos5l_nand2_1
X_19121__1130 _19121_/RESET_B VPWR VGND sg13cmos5l_tiehi
XFILLER_32_394 VPWR VGND sg13cmos5l_fill_2
Xheichips26_digital_project_411 uio_out[11] VPWR VGND sg13cmos5l_tielo
Xheichips26_digital_project_422 uo_out[13] VPWR VGND sg13cmos5l_tielo
XFILLER_102_856 VPWR VGND sg13cmos5l_fill_1
XFILLER_102_889 VPWR VGND sg13cmos5l_decap_8
XFILLER_76_1028 VPWR VGND sg13cmos5l_fill_1
XFILLER_43_615 VPWR VGND sg13cmos5l_decap_8
XFILLER_16_829 VPWR VGND sg13cmos5l_fill_1
XFILLER_15_339 VPWR VGND sg13cmos5l_fill_2
XFILLER_27_199 VPWR VGND sg13cmos5l_fill_1
X_11540_ _11540_/Y _11540_/A _11540_/B _11540_/C VPWR VGND sg13cmos5l_nor3_1
XFILLER_51_44 VPWR VGND sg13cmos5l_fill_2
X_11471_ _11471_/X _11453_/X _11469_/X _11468_/Y VPWR VGND sg13cmos5l_a21o_1
XFILLER_7_527 VPWR VGND sg13cmos5l_fill_1
XFILLER_11_578 VPWR VGND sg13cmos5l_fill_2
X_10422_ _10422_/Y _10680_/C _10422_/B VPWR VGND sg13cmos5l_nand2_1
X_13210_ _13210_/X _13210_/A _13210_/B _13210_/C VPWR VGND sg13cmos5l_and3_1
X_14190_ _14190_/Y _14148_/Y _14185_/B _14200_/B _14200_/C VPWR VGND sg13cmos5l_a22oi_1
X_13141_ _18952_/D _13292_/A _13141_/B VPWR VGND sg13cmos5l_nor2_1
X_10353_ _17708_/B _10353_/A VPWR VGND sg13cmos5l_inv_1
X_13072_ _13072_/Y _13299_/B _13067_/S _13071_/Y VPWR VGND sg13cmos5l_a21oi_1
X_12023_ _12023_/Y _12023_/A _12023_/B _12023_/C VPWR VGND sg13cmos5l_nand3_1
XFILLER_97_309 VPWR VGND sg13cmos5l_fill_2
X_10284_ _12498_/B _10284_/A VPWR VGND sg13cmos5l_inv_1
X_16900_ _16900_/Y _19491_/Q _19484_/Q VPWR VGND sg13cmos5l_nand2b_1
X_17880_ _17904_/B _17879_/A _17943_/B _17878_/Y _17874_/Y VPWR VGND sg13cmos5l_a22oi_1
X_16831_ _16831_/Y _19534_/Q _16831_/B VPWR VGND sg13cmos5l_nand2_1
XFILLER_66_718 VPWR VGND sg13cmos5l_fill_2
X_16762_ _16763_/B _16762_/A _16762_/B VPWR VGND sg13cmos5l_or2_1
X_19550_ _19550_/Q clkload41/A _19550_/D _19550_/RESET_B VPWR VGND sg13cmos5l_dfrbpq_1
XFILLER_65_228 VPWR VGND sg13cmos5l_fill_1
XFILLER_19_612 VPWR VGND sg13cmos5l_fill_1
XFILLER_93_548 VPWR VGND sg13cmos5l_fill_2
XFILLER_76_96 VPWR VGND sg13cmos5l_fill_1
X_18501_ _18501_/Y _18501_/A VPWR VGND sg13cmos5l_inv_1
XFILLER_47_943 VPWR VGND sg13cmos5l_fill_1
X_13974_ _14010_/A _19099_/Q _13974_/B VPWR VGND sg13cmos5l_xor2_1
X_19206__1039 _19206_/RESET_B VPWR VGND sg13cmos5l_tiehi
X_15713_ _15713_/Y _15690_/Y _15707_/Y _15712_/Y VPWR VGND sg13cmos5l_o21ai_1
XFILLER_19_634 VPWR VGND sg13cmos5l_fill_2
XFILLER_19_645 VPWR VGND sg13cmos5l_fill_2
X_16693_ _16693_/X _19498_/Q _16693_/B VPWR VGND sg13cmos5l_xor2_1
X_19481_ _19481_/Q clkload28/A _19481_/D _19481_/RESET_B VPWR VGND sg13cmos5l_dfrbpq_1
X_12925_ _12925_/Y _12948_/B _12960_/B VPWR VGND sg13cmos5l_nand2_1
X_12856_ _12856_/Y _18901_/Q _18862_/Q VPWR VGND sg13cmos5l_nand2_1
X_15644_ _15644_/Y _15629_/Y _15643_/Y _15624_/Y VPWR VGND sg13cmos5l_o21ai_1
X_18432_ _18433_/A _18478_/B _18445_/B _18431_/Y VPWR VGND sg13cmos5l_a21o_1
X_11807_ _12029_/A _11992_/A _11998_/B VPWR VGND sg13cmos5l_nor2_1
X_15575_ _15577_/B _15384_/Y _15582_/C _15574_/Y VPWR VGND sg13cmos5l_a21o_1
XFILLER_33_169 VPWR VGND sg13cmos5l_decap_4
X_18363_ _18363_/Y _18451_/A _18363_/B VPWR VGND sg13cmos5l_nor2_1
X_17314_ _17314_/Y _17202_/B _17375_/B _17313_/X _17207_/B VPWR VGND sg13cmos5l_a22oi_1
X_12787_ _12787_/Y _12787_/A _12787_/B VPWR VGND sg13cmos5l_nand2_1
X_14526_ _14533_/A _19167_/Q _14721_/A _19166_/Q VPWR VGND sg13cmos5l_nor3_1
X_11738_ _11740_/B _11721_/A _11721_/B _11737_/Y VPWR VGND sg13cmos5l_o21ai_1
X_18294_ _19734_/D _18470_/A _18346_/B VPWR VGND sg13cmos5l_and2_1
X_11669_ _11669_/Y _11669_/A _11669_/B VPWR VGND sg13cmos5l_nor2_1
X_17245_ _17450_/B _19577_/Q _17246_/B VPWR VGND sg13cmos5l_xnor2_1
X_14457_ _14464_/B _19120_/Q _19119_/Q _19118_/Q _14457_/D VPWR VGND sg13cmos5l_nor4_1
X_17176_ _17203_/B _17167_/Y _17172_/Y _17175_/Y VPWR VGND sg13cmos5l_a21oi_1
X_13408_ _13408_/Y _13381_/D _13365_/C _13401_/B VPWR VGND sg13cmos5l_a21oi_1
X_14388_ _14389_/B _14910_/A _19108_/Q VPWR VGND sg13cmos5l_nand2_1
X_13339_ _13339_/Y _13321_/B _13347_/S _13569_/B1 VPWR VGND sg13cmos5l_o21ai_1
X_16127_ _16129_/B _16233_/A _16233_/B VPWR VGND sg13cmos5l_nand2_1
X_16058_ _16060_/A _16051_/Y _16055_/Y _16056_/Y _19401_/Q _16057_/Y VPWR VGND sg13cmos5l_a221oi_1
Xhold2418 _18769_/D _11955_/Y VPWR VGND sg13cmos5l_dlygate4sd3_1
Xhold2407 _10076_/A _18998_/Q VPWR VGND sg13cmos5l_dlygate4sd3_1
X_15009_ _19241_/D _15194_/A _15142_/A VPWR VGND sg13cmos5l_and2_1
X_19139__1112 _19139_/RESET_B VPWR VGND sg13cmos5l_tiehi
Xhold2429 _10060_/A _18914_/Q VPWR VGND sg13cmos5l_dlygate4sd3_1
XFILLER_99_1028 VPWR VGND sg13cmos5l_fill_1
X_18662__1631 _18662_/RESET_B VPWR VGND sg13cmos5l_tiehi
X_19748_ _19748_/Q clkload20/A _19748_/D _19748_/RESET_B VPWR VGND sg13cmos5l_dfrbpq_1
XFILLER_37_431 VPWR VGND sg13cmos5l_fill_1
XFILLER_37_420 VPWR VGND sg13cmos5l_fill_1
X_19679_ _19679_/Q _19679_/CLK _19679_/D _19679_/RESET_B VPWR VGND sg13cmos5l_dfrbpq_1
X_18912__1354 _18912_/RESET_B VPWR VGND sg13cmos5l_tiehi
XFILLER_106_447 VPWR VGND sg13cmos5l_fill_1
XFILLER_106_469 VPWR VGND sg13cmos5l_fill_1
XFILLER_0_725 VPWR VGND sg13cmos5l_decap_4
XFILLER_87_342 VPWR VGND sg13cmos5l_fill_2
Xhold2941 _13116_/A _18905_/Q VPWR VGND sg13cmos5l_dlygate4sd3_1
Xhold2930 hold2930/X _17333_/A VPWR VGND sg13cmos5l_dlygate4sd3_1
Xhold2974 hold2974/X _18971_/Q VPWR VGND sg13cmos5l_dlygate4sd3_1
Xhold2952 hold2952/X _19714_/Q VPWR VGND sg13cmos5l_dlygate4sd3_1
Xhold2963 _14765_/A _19218_/Q VPWR VGND sg13cmos5l_dlygate4sd3_1
XFILLER_29_932 VPWR VGND sg13cmos5l_fill_1
Xhold2985 _16995_/A _19551_/Q VPWR VGND sg13cmos5l_dlygate4sd3_1
XFILLER_56_740 VPWR VGND sg13cmos5l_fill_2
Xhold2996 _10944_/A _18636_/Q VPWR VGND sg13cmos5l_dlygate4sd3_1
X_10971_ _11185_/A _11351_/A _10990_/B VPWR VGND sg13cmos5l_nand2_1
XFILLER_29_987 VPWR VGND sg13cmos5l_fill_1
X_13690_ _13714_/B _13678_/X _13685_/Y _13689_/Y VPWR VGND sg13cmos5l_a21oi_1
X_12710_ _12710_/Y _12686_/Y _12714_/S _12579_/A VPWR VGND sg13cmos5l_o21ai_1
X_12641_ _12658_/B _12629_/Y _12637_/Y _12640_/Y VPWR VGND sg13cmos5l_a21o_1
X_12572_ _12675_/A _12574_/B _12570_/Y _12569_/Y VPWR VGND sg13cmos5l_a21o_1
XFILLER_62_87 VPWR VGND sg13cmos5l_fill_2
X_15360_ _15361_/C _15360_/A _15553_/A VPWR VGND sg13cmos5l_nor2_1
X_11523_ _11525_/B _18706_/Q _11524_/B VPWR VGND sg13cmos5l_xnor2_1
X_15291_ _15291_/X _15283_/X _15288_/Y _15289_/Y VPWR VGND sg13cmos5l_a21o_1
XFILLER_11_364 VPWR VGND sg13cmos5l_fill_2
X_19319__920 _19319_/RESET_B VPWR VGND sg13cmos5l_tiehi
X_14311_ _14377_/B _14303_/A _14266_/A _14310_/Y VPWR VGND sg13cmos5l_a21oi_1
X_17030_ _17030_/Y _17030_/A _17047_/S VPWR VGND sg13cmos5l_nor2_1
X_11454_ _11454_/Y _11454_/A _11474_/B VPWR VGND sg13cmos5l_nor2_1
X_14242_ _14257_/B _19137_/Q _19138_/Q _19139_/Q _19140_/Q VPWR VGND sg13cmos5l_nor4_1
X_10405_ _10405_/Y _10403_/Y _10419_/A VPWR VGND sg13cmos5l_nand2b_1
X_11385_ _11385_/Y _18683_/Q _11381_/Y _11384_/Y _18682_/Q VPWR VGND sg13cmos5l_a22oi_1
X_14173_ _14173_/Y _14016_/A _14166_/Y _14199_/B _14176_/A VPWR VGND sg13cmos5l_a22oi_1
X_13124_ _13125_/B _13124_/A _13124_/B VPWR VGND sg13cmos5l_and2_1
X_10336_ _17968_/A _18243_/A VPWR VGND sg13cmos5l_inv_1
X_18981_ _18981_/Q _19092_/CLK _18981_/D _18981_/RESET_B VPWR VGND sg13cmos5l_dfrbpq_1
XFILLER_97_117 VPWR VGND sg13cmos5l_fill_2
X_10267_ _12764_/A _10267_/A VPWR VGND sg13cmos5l_inv_1
X_13055_ _13055_/Y _13055_/A _13055_/B _13055_/C VPWR VGND sg13cmos5l_nor3_1
X_17932_ _19667_/D _17932_/A _17937_/B VPWR VGND sg13cmos5l_nor2_1
Xclkbuf_4_9_0_clk clkbuf_4_9_0_clk/X clkbuf_0_clk/X VPWR VGND sg13cmos5l_buf_8
X_12006_ _12116_/A _12006_/A _12023_/B _12023_/C VPWR VGND sg13cmos5l_nand3_1
X_17863_ _17863_/Y _17863_/A _17863_/B _17863_/C VPWR VGND sg13cmos5l_nor3_1
X_19602_ _19602_/Q clkload12/A _19602_/D _19602_/RESET_B VPWR VGND sg13cmos5l_dfrbpq_1
X_10198_ _16344_/A _10198_/A VPWR VGND sg13cmos5l_inv_1
X_16814_ _16814_/Y _16797_/B _16812_/A _16655_/A VPWR VGND sg13cmos5l_o21ai_1
XFILLER_93_356 VPWR VGND sg13cmos5l_decap_4
X_17794_ _17895_/B _17806_/A _17808_/B VPWR VGND sg13cmos5l_nand2_1
X_16745_ _16745_/Y _16660_/B _16737_/Y _16744_/A _16663_/B _16739_/Y VPWR VGND sg13cmos5l_a221oi_1
X_18788__1487 _18788_/RESET_B VPWR VGND sg13cmos5l_tiehi
X_19533_ _19533_/Q clkload41/A _19533_/D _19533_/RESET_B VPWR VGND sg13cmos5l_dfrbpq_1
XFILLER_47_784 VPWR VGND sg13cmos5l_fill_2
X_13957_ _13970_/B _19082_/Q _19081_/Q VPWR VGND sg13cmos5l_nor2_1
X_16676_ _16800_/A _16676_/A _16785_/B VPWR VGND sg13cmos5l_nor2_1
X_12908_ _12916_/B _18930_/Q _18932_/Q _18931_/Q _12908_/D VPWR VGND sg13cmos5l_nor4_1
X_19153__1096 _19153_/RESET_B VPWR VGND sg13cmos5l_tiehi
X_19464_ _19464_/Q _19679_/CLK _19464_/D _19464_/RESET_B VPWR VGND sg13cmos5l_dfrbpq_1
X_13888_ _13920_/A _18992_/Q _13891_/A VPWR VGND sg13cmos5l_xor2_1
X_15627_ _15628_/B _19350_/Q _15640_/B _19351_/Q VPWR VGND sg13cmos5l_o21ai_1
X_18415_ _18482_/B _10580_/B _18402_/S _18414_/X VPWR VGND sg13cmos5l_a21oi_1
XFILLER_34_445 VPWR VGND sg13cmos5l_fill_2
XFILLER_35_968 VPWR VGND sg13cmos5l_decap_4
X_12839_ _12839_/Y _12839_/A _12850_/B VPWR VGND sg13cmos5l_nor2_1
X_19395_ _19395_/Q clkload8/A _19395_/D _19395_/RESET_B VPWR VGND sg13cmos5l_dfrbpq_1
X_18346_ _18346_/Y _18346_/A _18346_/B VPWR VGND sg13cmos5l_nand2_1
X_15558_ _15569_/B _15582_/B VPWR VGND sg13cmos5l_inv_1
X_18743__524 _18743_/D VPWR VGND sg13cmos5l_tielo
X_18277_ _19723_/D _18483_/A _18277_/B VPWR VGND sg13cmos5l_nor2_1
X_19439__790 _19439_/RESET_B VPWR VGND sg13cmos5l_tiehi
X_15489_ _15489_/Y _15489_/A VPWR VGND sg13cmos5l_inv_1
X_14509_ _14617_/A _19176_/Q _14512_/B _14508_/Y VPWR VGND sg13cmos5l_a21oi_1
X_17228_ _17346_/A _17217_/A _17221_/B _17227_/Y VPWR VGND sg13cmos5l_a21oi_1
X_17159_ _17159_/Y _19533_/Q _17187_/A _17157_/Y _17158_/Y VPWR VGND sg13cmos5l_a22oi_1
X_09981_ _09981_/Y _09981_/A VPWR VGND sg13cmos5l_inv_1
XFILLER_88_139 VPWR VGND sg13cmos5l_fill_1
XFILLER_85_802 VPWR VGND sg13cmos5l_fill_2
Xhold2204 _18644_/D _11142_/Y VPWR VGND sg13cmos5l_dlygate4sd3_1
Xhold2215 _10666_/B _10665_/Y VPWR VGND sg13cmos5l_dlygate4sd3_1
Xhold2237 _18894_/D _12782_/Y VPWR VGND sg13cmos5l_dlygate4sd3_1
Xhold2226 _15205_/A _19230_/Q VPWR VGND sg13cmos5l_dlygate4sd3_1
Xhold2259 _19558_/D _17141_/Y VPWR VGND sg13cmos5l_dlygate4sd3_1
Xhold2248 _19460_/D _16554_/Y VPWR VGND sg13cmos5l_dlygate4sd3_1
XFILLER_93_890 VPWR VGND sg13cmos5l_fill_2
XFILLER_80_562 VPWR VGND sg13cmos5l_fill_1
X_18626__1670 _18626_/RESET_B VPWR VGND sg13cmos5l_tiehi
XFILLER_32_35 VPWR VGND sg13cmos5l_fill_1
XFILLER_32_46 VPWR VGND sg13cmos5l_fill_1
XFILLER_10_1026 VPWR VGND sg13cmos5l_fill_2
X_11170_ _11170_/Y _11169_/A _11170_/B VPWR VGND sg13cmos5l_nand2b_1
X_10121_ _16011_/A _15655_/A VPWR VGND sg13cmos5l_inv_1
XFILLER_103_962 VPWR VGND sg13cmos5l_fill_2
XFILLER_103_951 VPWR VGND sg13cmos5l_decap_8
X_10052_ _10052_/Y _10052_/A VPWR VGND sg13cmos5l_inv_1
XFILLER_0_555 VPWR VGND sg13cmos5l_fill_1
X_18743__1535 _18743_/RESET_B VPWR VGND sg13cmos5l_tiehi
XFILLER_48_515 VPWR VGND sg13cmos5l_fill_1
Xhold2771 _17810_/B _17809_/Y VPWR VGND sg13cmos5l_dlygate4sd3_1
XFILLER_48_537 VPWR VGND sg13cmos5l_fill_2
X_14860_ _14860_/Y _14876_/B _14860_/B VPWR VGND sg13cmos5l_nand2_1
Xhold2760 _16358_/B _21227_/A VPWR VGND sg13cmos5l_dlygate4sd3_1
Xhold2782 hold2782/X _16521_/A VPWR VGND sg13cmos5l_dlygate4sd3_1
X_13811_ _19050_/D _13811_/A _13813_/B VPWR VGND sg13cmos5l_and2_1
X_14791_ _14798_/A _19209_/Q _19207_/Q _19208_/Q VPWR VGND sg13cmos5l_nor3_1
XFILLER_29_762 VPWR VGND sg13cmos5l_fill_2
Xhold2793 hold2793/X _14345_/A VPWR VGND sg13cmos5l_dlygate4sd3_1
XFILLER_90_337 VPWR VGND sg13cmos5l_fill_2
XFILLER_90_326 VPWR VGND sg13cmos5l_fill_2
XFILLER_90_315 VPWR VGND sg13cmos5l_fill_1
X_13742_ _13768_/C _19027_/Q _18582_/Q _19047_/Q VPWR VGND sg13cmos5l_nand3_1
X_16530_ _16531_/B _16530_/A _16530_/B VPWR VGND sg13cmos5l_or2_1
XFILLER_71_551 VPWR VGND sg13cmos5l_decap_8
X_10954_ _10955_/C _10954_/A _10984_/A VPWR VGND sg13cmos5l_nor2_1
XFILLER_16_467 VPWR VGND sg13cmos5l_fill_2
X_13673_ _13720_/A _19057_/Q _13673_/B VPWR VGND sg13cmos5l_xnor2_1
XFILLER_43_275 VPWR VGND sg13cmos5l_fill_2
X_18200_ _18201_/B _18200_/A _18200_/B VPWR VGND sg13cmos5l_xor2_1
XFILLER_16_478 VPWR VGND sg13cmos5l_fill_1
X_16461_ _16461_/Y _16448_/Y _16452_/Y _16455_/Y _16459_/Y _16460_/Y VPWR VGND sg13cmos5l_a221oi_1
X_10885_ _10886_/B _19777_/Q _19778_/Q _19779_/Q VPWR VGND sg13cmos5l_o21ai_1
XFILLER_106_1010 VPWR VGND sg13cmos5l_decap_8
X_12624_ _12630_/A _18889_/Q _12624_/B VPWR VGND sg13cmos5l_xor2_1
X_15412_ _15412_/Y _15405_/A _15405_/B _15380_/Y VPWR VGND sg13cmos5l_a21oi_1
X_19180_ _19180_/Q _19227_/CLK _19180_/D _19180_/RESET_B VPWR VGND sg13cmos5l_dfrbpq_1
X_16392_ _16402_/A _19466_/Q _16396_/A VPWR VGND sg13cmos5l_xor2_1
X_12555_ _12555_/X _12551_/X _12553_/Y _12554_/Y VPWR VGND sg13cmos5l_a21o_1
XFILLER_12_651 VPWR VGND sg13cmos5l_fill_2
X_15343_ _15535_/A _19292_/Q _15351_/C VPWR VGND sg13cmos5l_xnor2_1
X_18131_ _18131_/Y _18472_/A _18157_/B VPWR VGND sg13cmos5l_nand2_1
XFILLER_89_1027 VPWR VGND sg13cmos5l_fill_2
X_11506_ _11534_/A _18717_/Q _18718_/Q _18719_/Q VPWR VGND sg13cmos5l_or3_1
XFILLER_40_993 VPWR VGND sg13cmos5l_fill_1
XFILLER_7_121 VPWR VGND sg13cmos5l_fill_1
XFILLER_7_110 VPWR VGND sg13cmos5l_fill_2
XFILLER_8_633 VPWR VGND sg13cmos5l_fill_2
X_18062_ _18062_/Y _18045_/B _18039_/B _18061_/Y VPWR VGND sg13cmos5l_o21ai_1
X_17013_ _17013_/Y _17013_/A _17013_/B _17013_/C _17013_/D VPWR VGND sg13cmos5l_nand4_1
X_12486_ _12486_/Y _12486_/A VPWR VGND sg13cmos5l_inv_1
X_15274_ _15274_/Y _15077_/Y _15262_/X _15272_/Y _15071_/Y VPWR VGND sg13cmos5l_a22oi_1
X_11437_ _11437_/X _11437_/A _11438_/B VPWR VGND sg13cmos5l_and2_1
X_14225_ _14227_/B _14342_/A _14341_/A VPWR VGND sg13cmos5l_nor2_1
XFILLER_99_916 VPWR VGND sg13cmos5l_decap_8
X_11368_ _11368_/Y _11895_/A _18642_/Q _18641_/Q _11894_/A _11366_/Y VPWR VGND sg13cmos5l_a221oi_1
X_14156_ _14195_/A _19076_/Q _14165_/D VPWR VGND sg13cmos5l_xor2_1
X_13107_ _13107_/Y _12953_/A _13101_/Y _13106_/Y _12960_/A VPWR VGND sg13cmos5l_a22oi_1
X_10319_ _10844_/A _10319_/A VPWR VGND sg13cmos5l_inv_1
X_18964_ _18964_/Q clkload67/A _18964_/D _18964_/RESET_B VPWR VGND sg13cmos5l_dfrbpq_1
X_11299_ _11299_/Y _11289_/Y _11294_/Y _11298_/Y VPWR VGND sg13cmos5l_o21ai_1
X_14087_ _14088_/B _14639_/A _19062_/Q _19061_/Q _14638_/A VPWR VGND sg13cmos5l_a22oi_1
X_18895_ _18895_/Q clkload67/A _18895_/D _18895_/RESET_B VPWR VGND sg13cmos5l_dfrbpq_1
X_13038_ _13056_/C _18960_/Q _12787_/A _13045_/B VPWR VGND sg13cmos5l_o21ai_1
X_17915_ _17915_/Y _17916_/A _17916_/B _17914_/Y VPWR VGND sg13cmos5l_a21oi_1
X_17846_ _17846_/Y _17815_/Y _18032_/A _17845_/Y VPWR VGND sg13cmos5l_o21ai_1
XFILLER_93_197 VPWR VGND sg13cmos5l_fill_2
XFILLER_93_186 VPWR VGND sg13cmos5l_fill_1
XFILLER_93_175 VPWR VGND sg13cmos5l_fill_1
X_19516_ _19516_/Q clkload34/A _19516_/D _19516_/RESET_B VPWR VGND sg13cmos5l_dfrbpq_1
X_17777_ _17777_/Y _17777_/A _17780_/B VPWR VGND sg13cmos5l_nor2_1
X_14989_ _14995_/C _19199_/Q _19200_/Q _19201_/Q VPWR VGND sg13cmos5l_o21ai_1
X_16728_ _16728_/Y _16712_/Y _16726_/Y _16727_/Y VPWR VGND sg13cmos5l_o21ai_1
X_16659_ _16659_/X _13695_/Y _16656_/Y _16659_/S VPWR VGND sg13cmos5l_mux2_1
XFILLER_62_584 VPWR VGND sg13cmos5l_fill_1
XFILLER_62_573 VPWR VGND sg13cmos5l_fill_1
X_19447_ _19447_/Q clkload10/A _19447_/D _19447_/RESET_B VPWR VGND sg13cmos5l_dfrbpq_1
XFILLER_34_275 VPWR VGND sg13cmos5l_fill_1
XFILLER_35_787 VPWR VGND sg13cmos5l_fill_2
XFILLER_97_0 VPWR VGND sg13cmos5l_fill_1
X_19378_ _19378_/Q clkload18/A _19378_/D _19378_/RESET_B VPWR VGND sg13cmos5l_dfrbpq_1
X_18329_ _19736_/D _18480_/A _18329_/B VPWR VGND sg13cmos5l_nor2_1
XFILLER_98_960 VPWR VGND sg13cmos5l_decap_8
XFILLER_89_459 VPWR VGND sg13cmos5l_fill_1
Xhold2001 _10010_/A _18773_/Q VPWR VGND sg13cmos5l_dlygate4sd3_1
X_19201__1044 _19201_/RESET_B VPWR VGND sg13cmos5l_tiehi
Xhold2012 _09992_/A _19235_/Q VPWR VGND sg13cmos5l_dlygate4sd3_1
Xhold2034 _10003_/A _18942_/Q VPWR VGND sg13cmos5l_dlygate4sd3_1
Xhold2045 _18691_/D _11421_/Y VPWR VGND sg13cmos5l_dlygate4sd3_1
Xhold2023 _19321_/D _15525_/Y VPWR VGND sg13cmos5l_dlygate4sd3_1
Xhold2067 hold2067/X _18900_/Q VPWR VGND sg13cmos5l_dlygate4sd3_1
Xhold2078 _14909_/A _19169_/Q VPWR VGND sg13cmos5l_dlygate4sd3_1
Xhold2056 _19362_/D _15805_/Y VPWR VGND sg13cmos5l_dlygate4sd3_1
Xhold2089 _10144_/A _19494_/Q VPWR VGND sg13cmos5l_dlygate4sd3_1
XFILLER_84_131 VPWR VGND sg13cmos5l_fill_2
X_19309__930 _19309_/RESET_B VPWR VGND sg13cmos5l_tiehi
XFILLER_45_529 VPWR VGND sg13cmos5l_fill_1
XFILLER_53_540 VPWR VGND sg13cmos5l_fill_1
XFILLER_80_370 VPWR VGND sg13cmos5l_fill_2
X_10670_ _10670_/Y _10392_/A _10667_/Y _10669_/Y _10663_/A _10683_/A VPWR VGND sg13cmos5l_a221oi_1
X_12340_ _12342_/A _12728_/A _12341_/C _18834_/Q VPWR VGND sg13cmos5l_a21o_1
X_19316__923 _19316_/RESET_B VPWR VGND sg13cmos5l_tiehi
X_12271_ _12271_/Y _18787_/Q _18780_/Q VPWR VGND sg13cmos5l_nand2b_1
X_18961__1302 _18961_/RESET_B VPWR VGND sg13cmos5l_tiehi
XFILLER_5_636 VPWR VGND sg13cmos5l_decap_4
X_11222_ _11315_/B _11234_/A _11234_/B VPWR VGND sg13cmos5l_nand2_1
XFILLER_49_1022 VPWR VGND sg13cmos5l_decap_8
X_14010_ _14010_/Y _14010_/A _14010_/B VPWR VGND sg13cmos5l_nor2_1
XFILLER_4_135 VPWR VGND sg13cmos5l_fill_1
X_11153_ _18652_/D _11423_/A _11223_/B VPWR VGND sg13cmos5l_and2_1
X_11084_ _18631_/D _11084_/A _11084_/B VPWR VGND sg13cmos5l_and2_1
X_15961_ _15961_/Y _15961_/A _15984_/B VPWR VGND sg13cmos5l_nor2_1
X_10104_ _15187_/A _10104_/A VPWR VGND sg13cmos5l_inv_1
X_10035_ _10035_/Y _18700_/Q VPWR VGND sg13cmos5l_inv_1
X_18680_ _18680_/Q _19087_/CLK _18680_/D _18680_/RESET_B VPWR VGND sg13cmos5l_dfrbpq_1
X_17700_ _17700_/Y _19638_/Q _17692_/Y _17699_/Y _19639_/Q VPWR VGND sg13cmos5l_a22oi_1
X_14912_ _19222_/D _14913_/A _14912_/B VPWR VGND sg13cmos5l_nor2_1
XFILLER_0_385 VPWR VGND sg13cmos5l_decap_4
X_15892_ _15963_/A _15991_/A _15892_/B VPWR VGND sg13cmos5l_nand2_1
Xhold2590 hold2590/X _10767_/Y VPWR VGND sg13cmos5l_dlygate4sd3_1
X_17631_ _17634_/B _17676_/B _17488_/B _17639_/B VPWR VGND sg13cmos5l_mux2_1
X_14843_ _14915_/B _14842_/Y _14795_/A _14843_/S VPWR VGND sg13cmos5l_mux2_1
XFILLER_36_507 VPWR VGND sg13cmos5l_fill_2
XFILLER_76_698 VPWR VGND sg13cmos5l_fill_2
X_11986_ _11993_/B _18742_/Q _18741_/Q _18740_/Q _11986_/D VPWR VGND sg13cmos5l_nor4_1
X_17562_ _17571_/B _19634_/Q _19636_/Q _19635_/Q _17562_/D VPWR VGND sg13cmos5l_nor4_1
X_14774_ _14774_/Y _14875_/B _14875_/C _14875_/A VPWR VGND sg13cmos5l_a21oi_1
X_13725_ _13819_/B hold2869/X _13720_/C _13688_/Y VPWR VGND sg13cmos5l_a21oi_1
X_17493_ _19612_/D _17678_/A _17493_/B VPWR VGND sg13cmos5l_nor2_1
X_10937_ _10937_/X _10977_/A _10977_/B _11159_/A VPWR VGND sg13cmos5l_a21o_1
XFILLER_16_275 VPWR VGND sg13cmos5l_fill_2
X_19301_ _19301_/Q clkload44/A _19301_/D _19301_/RESET_B VPWR VGND sg13cmos5l_dfrbpq_1
X_16513_ _16521_/A _16494_/B _16532_/A _16513_/C VPWR VGND sg13cmos5l_nand3b_1
X_13656_ _13709_/A _13666_/B _13664_/B VPWR VGND sg13cmos5l_nand2_1
X_16444_ _16462_/S _16457_/C _16457_/D VPWR VGND sg13cmos5l_nand2_1
X_19232_ _19232_/Q clkload44/A _19232_/D _19232_/RESET_B VPWR VGND sg13cmos5l_dfrbpq_1
X_12607_ _12652_/A _18885_/Q _18886_/Q _18887_/Q VPWR VGND sg13cmos5l_or3_1
X_10868_ _10868_/Y _11116_/A _10865_/S _10867_/Y VPWR VGND sg13cmos5l_a21oi_1
X_19163_ _19163_/Q _19227_/CLK _19163_/D _19163_/RESET_B VPWR VGND sg13cmos5l_dfrbpq_1
X_13587_ _13587_/Y _19044_/Q _13587_/B VPWR VGND sg13cmos5l_nand2_1
X_10799_ _18559_/B _10775_/A _10784_/Y _10797_/Y _10784_/B VPWR VGND sg13cmos5l_a22oi_1
X_19077__1177 _19077_/RESET_B VPWR VGND sg13cmos5l_tiehi
X_16375_ _19446_/D _09980_/Y fanout83/X _16374_/Y VPWR VGND sg13cmos5l_a21oi_1
X_18114_ _18114_/Y _19700_/Q _19715_/Q VPWR VGND sg13cmos5l_nand2_1
X_12538_ _12538_/Y _12334_/A _12575_/A VPWR VGND sg13cmos5l_nand2b_1
X_19094_ _19094_/Q clkload53/A _19094_/D _19094_/RESET_B VPWR VGND sg13cmos5l_dfrbpq_1
X_15326_ _15327_/B _19303_/Q _15433_/B VPWR VGND sg13cmos5l_nor2_1
X_12469_ _12469_/Y _13021_/A _18813_/Q VPWR VGND sg13cmos5l_nor2_1
X_15257_ _19282_/D _15735_/A _15257_/B VPWR VGND sg13cmos5l_and2_1
X_18045_ _18045_/Y _18045_/A _18045_/B VPWR VGND sg13cmos5l_nor2_1
X_14208_ _14208_/Y _19109_/Q _19070_/Q VPWR VGND sg13cmos5l_xnor2_1
X_15188_ _19262_/D _15188_/A _15188_/B VPWR VGND sg13cmos5l_nor2_1
X_14139_ _14139_/Y hold2003/X fanout91/X _14364_/A VPWR VGND sg13cmos5l_o21ai_1
X_18947_ _18947_/Q _18975_/CLK _18947_/D _18947_/RESET_B VPWR VGND sg13cmos5l_dfrbpq_1
XFILLER_67_621 VPWR VGND sg13cmos5l_fill_2
XFILLER_66_120 VPWR VGND sg13cmos5l_decap_8
XFILLER_94_440 VPWR VGND sg13cmos5l_fill_1
X_18878_ _18878_/Q clkload63/A _18878_/D _18878_/RESET_B VPWR VGND sg13cmos5l_dfrbpq_1
XFILLER_39_356 VPWR VGND sg13cmos5l_fill_2
XFILLER_12_0 VPWR VGND sg13cmos5l_fill_1
X_17829_ _17829_/X _19658_/Q _19673_/Q VPWR VGND sg13cmos5l_and2_1
Xfanout27 fanout27/X _17351_/Y VPWR VGND sg13cmos5l_buf_1
X_19402__461 _19402_/D VPWR VGND sg13cmos5l_tielo
Xfanout38 _15238_/B _15241_/S VPWR VGND sg13cmos5l_buf_1
Xfanout49 _13007_/A _13011_/A VPWR VGND sg13cmos5l_buf_1
X_19219__1026 _19219_/RESET_B VPWR VGND sg13cmos5l_tiehi
X_18783__1492 _18783_/RESET_B VPWR VGND sg13cmos5l_tiehi
XFILLER_104_589 VPWR VGND sg13cmos5l_fill_1
XFILLER_104_578 VPWR VGND sg13cmos5l_fill_2
XFILLER_89_289 VPWR VGND sg13cmos5l_fill_2
XFILLER_79_1026 VPWR VGND sg13cmos5l_fill_2
X_11840_ _11852_/B _11831_/Y _11835_/Y _11839_/Y VPWR VGND sg13cmos5l_a21o_1
XFILLER_54_22 VPWR VGND sg13cmos5l_decap_8
X_11771_ _11771_/Y _11858_/B _11874_/A _11771_/C VPWR VGND sg13cmos5l_nand3_1
X_19032__1225 _19032_/RESET_B VPWR VGND sg13cmos5l_tiehi
X_10722_ _10722_/Y _13807_/B _16624_/A VPWR VGND sg13cmos5l_nand2b_1
X_13510_ _13510_/Y _13500_/Y _13505_/Y _13583_/B _13412_/B _13509_/Y VPWR VGND sg13cmos5l_a221oi_1
X_14490_ _14586_/A _14468_/A _14266_/A _14489_/Y VPWR VGND sg13cmos5l_a21oi_1
X_10653_ _10663_/A _10673_/B _10673_/C _10658_/B VPWR VGND sg13cmos5l_a21oi_1
X_13441_ _13453_/A _13441_/A _13441_/B VPWR VGND sg13cmos5l_nor2_1
X_13372_ _13372_/Y _13373_/B _13370_/Y _13373_/A VPWR VGND sg13cmos5l_o21ai_1
XFILLER_10_952 VPWR VGND sg13cmos5l_fill_1
X_16160_ _16161_/B _16273_/B _16273_/C _16273_/A VPWR VGND sg13cmos5l_a21oi_1
X_10584_ _10584_/Y _10906_/A _10898_/A VPWR VGND sg13cmos5l_nand2_1
X_12323_ _12323_/X _18828_/Q _18843_/Q VPWR VGND sg13cmos5l_and2_1
X_15111_ _15191_/B _15111_/A _15111_/B VPWR VGND sg13cmos5l_and2_1
XFILLER_5_411 VPWR VGND sg13cmos5l_fill_1
X_16091_ _16091_/X _16104_/D _16090_/C _16090_/A VPWR VGND sg13cmos5l_a21o_1
Xclkload19 clkload19/Y clkload19/A VPWR VGND sg13cmos5l_inv_2
X_15042_ _15043_/B _15147_/B _15041_/Y _15147_/A VPWR VGND sg13cmos5l_a21oi_1
X_12254_ _12254_/Y _10010_/Y fanout97/X _12253_/Y VPWR VGND sg13cmos5l_a21oi_1
X_12185_ _18790_/D hold2862/X _12186_/S _12184_/Y VPWR VGND sg13cmos5l_a21oi_1
X_18925__1341 _18925_/RESET_B VPWR VGND sg13cmos5l_tiehi
X_11205_ _11205_/Y _11205_/A _11205_/B VPWR VGND sg13cmos5l_nor2_1
X_18801_ _18801_/Q clkload60/A _18801_/D _18801_/RESET_B VPWR VGND sg13cmos5l_dfrbpq_1
X_11136_ _18641_/D _10305_/Y _11133_/S _11135_/Y VPWR VGND sg13cmos5l_a21oi_1
X_19781_ _19781_/Q clkload48/A _19781_/D _19781_/RESET_B VPWR VGND sg13cmos5l_dfrbpq_1
X_16993_ _16998_/A _16983_/X _16988_/Y _16994_/A _17015_/B _16989_/X VPWR VGND sg13cmos5l_a221oi_1
XFILLER_77_930 VPWR VGND sg13cmos5l_decap_8
X_18732_ _18732_/Q _18733_/CLK _18732_/D _18732_/RESET_B VPWR VGND sg13cmos5l_dfrbpq_1
X_11067_ _11068_/B _11034_/A _11037_/Y _11076_/B VPWR VGND sg13cmos5l_mux2_1
X_15944_ _15944_/Y _15944_/A _15944_/B _15944_/C _15944_/D VPWR VGND sg13cmos5l_nand4_1
X_10018_ _10392_/A _10018_/A VPWR VGND sg13cmos5l_inv_1
X_18663_ _18663_/Q clkload56/A _18663_/D _18663_/RESET_B VPWR VGND sg13cmos5l_dfrbpq_1
XFILLER_49_687 VPWR VGND sg13cmos5l_fill_1
X_15875_ _15975_/B _15887_/A _15887_/B VPWR VGND sg13cmos5l_nand2_1
X_18594_ _18594_/Q _18594_/CLK _18594_/D _18594_/RESET_B VPWR VGND sg13cmos5l_dfrbpq_1
X_17614_ _17642_/B _17563_/Y _17607_/B _17613_/Y VPWR VGND sg13cmos5l_o21ai_1
X_14826_ _14911_/B _14825_/Y hold2759/X _14843_/S VPWR VGND sg13cmos5l_mux2_1
XFILLER_36_337 VPWR VGND sg13cmos5l_fill_2
X_17545_ _17549_/B _17544_/Y _17932_/A VPWR VGND sg13cmos5l_nand2b_1
X_14757_ _14757_/Y _14757_/A _14757_/B VPWR VGND sg13cmos5l_nor2_1
X_13708_ _13716_/B _13714_/B _13714_/C _13707_/X VPWR VGND sg13cmos5l_o21ai_1
X_11969_ _11969_/X _18744_/Q _18737_/Q _18738_/Q VPWR VGND sg13cmos5l_or3_1
X_19397__836 _19397_/RESET_B VPWR VGND sg13cmos5l_tiehi
X_17476_ _17591_/A _17292_/B _17494_/B _17481_/C VPWR VGND sg13cmos5l_nand3b_1
X_14688_ _14688_/Y _15234_/A _15181_/B VPWR VGND sg13cmos5l_nor2_1
X_13639_ _13639_/Y _10795_/A fanout86/X _13638_/Y VPWR VGND sg13cmos5l_a21oi_1
X_16427_ _16427_/Y _16227_/A _19410_/Q VPWR VGND sg13cmos5l_nand2b_1
X_19215_ _19215_/Q _19262_/CLK _19215_/D _19215_/RESET_B VPWR VGND sg13cmos5l_dfrbpq_1
X_19146_ _19146_/Q _19262_/CLK _19146_/D _19146_/RESET_B VPWR VGND sg13cmos5l_dfrbpq_1
X_16358_ _16358_/Y _18272_/A _16358_/B VPWR VGND sg13cmos5l_nor2_1
X_15309_ _15309_/Y _19277_/Q _19238_/Q VPWR VGND sg13cmos5l_xnor2_1
X_19686__434 _19686_/D VPWR VGND sg13cmos5l_tielo
X_19077_ _19077_/Q clkload54/A _19077_/D _19077_/RESET_B VPWR VGND sg13cmos5l_dfrbpq_1
X_16289_ _16290_/A _16289_/A _16289_/B VPWR VGND sg13cmos5l_nand2_1
X_18028_ _18032_/B _19656_/Q _18028_/B VPWR VGND sg13cmos5l_xor2_1
Xfanout228 _16827_/A _16823_/B VPWR VGND sg13cmos5l_buf_1
XFILLER_101_504 VPWR VGND sg13cmos5l_decap_4
XFILLER_87_727 VPWR VGND sg13cmos5l_fill_2
Xfanout217 _17370_/B _17373_/A VPWR VGND sg13cmos5l_buf_1
Xfanout206 _18067_/A _17984_/Y VPWR VGND sg13cmos5l_buf_1
XFILLER_8_1019 VPWR VGND sg13cmos5l_fill_2
XFILLER_86_215 VPWR VGND sg13cmos5l_fill_1
Xfanout239 _16020_/A _15789_/Y VPWR VGND sg13cmos5l_buf_1
X_19306__933 _19306_/RESET_B VPWR VGND sg13cmos5l_tiehi
XFILLER_70_605 VPWR VGND sg13cmos5l_decap_4
X_19658__547 _19658_/RESET_B VPWR VGND sg13cmos5l_tiehi
XFILLER_51_830 VPWR VGND sg13cmos5l_fill_2
XFILLER_23_521 VPWR VGND sg13cmos5l_fill_1
XFILLER_23_532 VPWR VGND sg13cmos5l_fill_1
X_19519__698 _19519_/RESET_B VPWR VGND sg13cmos5l_tiehi
XFILLER_6_219 VPWR VGND sg13cmos5l_fill_1
XFILLER_40_57 VPWR VGND sg13cmos5l_fill_2
X_19313__926 _19313_/RESET_B VPWR VGND sg13cmos5l_tiehi
X_18706__1584 _18706_/RESET_B VPWR VGND sg13cmos5l_tiehi
XFILLER_59_952 VPWR VGND sg13cmos5l_fill_1
X_13990_ _13991_/B _19101_/Q _13990_/B VPWR VGND sg13cmos5l_xnor2_1
X_12941_ _12941_/Y _12941_/A _12954_/B VPWR VGND sg13cmos5l_nor2_1
X_12872_ _12992_/A _18924_/Q _12875_/B _12871_/Y VPWR VGND sg13cmos5l_a21oi_1
X_15660_ _15661_/A _15840_/A _15821_/A VPWR VGND sg13cmos5l_and2_1
X_11823_ _11902_/B _11824_/C _11824_/D VPWR VGND sg13cmos5l_nand2_1
XFILLER_61_627 VPWR VGND sg13cmos5l_fill_2
X_14611_ _14611_/Y _14611_/A _14611_/B VPWR VGND sg13cmos5l_nand2_1
X_17330_ _17330_/Y _17330_/A _17330_/B _17330_/C VPWR VGND sg13cmos5l_nand3_1
X_15591_ _15591_/Y _19346_/Q _15721_/B VPWR VGND sg13cmos5l_nor2_1
X_11754_ _11865_/B _11754_/A _11766_/B VPWR VGND sg13cmos5l_nand2_1
X_14542_ _14542_/Y _14542_/A _14542_/B _14542_/C VPWR VGND sg13cmos5l_nand3_1
X_10705_ _10705_/Y _10705_/A VPWR VGND sg13cmos5l_inv_1
X_17261_ _17464_/A _17671_/A _17261_/B VPWR VGND sg13cmos5l_xnor2_1
X_11685_ _18731_/D _10013_/Y fanout94/X _11684_/Y VPWR VGND sg13cmos5l_a21oi_1
X_14473_ _14476_/A _14473_/A _14473_/B VPWR VGND sg13cmos5l_nand2_1
X_17192_ _19568_/D _17377_/A _17192_/B VPWR VGND sg13cmos5l_nor2_1
X_13424_ _18993_/D _13585_/A _13424_/B VPWR VGND sg13cmos5l_nor2_1
X_19000_ _19000_/Q _19092_/CLK _19000_/D _19000_/RESET_B VPWR VGND sg13cmos5l_dfrbpq_1
X_10636_ _19792_/D _18253_/B _10642_/B VPWR VGND sg13cmos5l_nor2_1
X_16212_ _16244_/B _19437_/Q _16212_/B VPWR VGND sg13cmos5l_xor2_1
X_18823__1449 _18823_/RESET_B VPWR VGND sg13cmos5l_tiehi
X_16143_ _16282_/A _16118_/Y _16141_/Y _16140_/X VPWR VGND sg13cmos5l_a21o_1
X_13355_ _13355_/Y _18985_/Q fanout97/X _13573_/A VPWR VGND sg13cmos5l_o21ai_1
XFILLER_60_8 VPWR VGND sg13cmos5l_fill_2
X_10567_ _10917_/A _10906_/A _10567_/B VPWR VGND sg13cmos5l_nand2_1
X_12306_ _12306_/X _12306_/A _12306_/B VPWR VGND sg13cmos5l_and2_1
X_13286_ _18963_/D _13286_/A _13289_/B VPWR VGND sg13cmos5l_nor2_1
X_16074_ _16074_/Y _16056_/Y hold2423/X _16312_/B VPWR VGND sg13cmos5l_a21oi_1
X_10498_ _10499_/C _10497_/A _10497_/B _10510_/B VPWR VGND sg13cmos5l_o21ai_1
X_12237_ _12238_/B _18813_/Q _12235_/Y _12483_/B VPWR VGND sg13cmos5l_o21ai_1
XFILLER_5_296 VPWR VGND sg13cmos5l_fill_2
X_15025_ _15026_/B _14842_/Y _15024_/Y _15025_/S VPWR VGND sg13cmos5l_mux2_1
X_12168_ _12169_/B _12168_/A _12168_/B VPWR VGND sg13cmos5l_or2_1
X_12099_ _12104_/A _12084_/Y _12092_/Y _12137_/B _12136_/B _12097_/Y VPWR VGND sg13cmos5l_a221oi_1
X_16976_ _16995_/B _19547_/Q _19548_/Q _19549_/Q _19550_/Q VPWR VGND sg13cmos5l_nor4_1
X_11119_ _11121_/B _11388_/A _11119_/B VPWR VGND sg13cmos5l_nor2_1
XFILLER_68_248 VPWR VGND sg13cmos5l_fill_1
X_19764_ _19764_/Q clkload21/A _19764_/D _19764_/RESET_B VPWR VGND sg13cmos5l_dfrbpq_1
XFILLER_49_440 VPWR VGND sg13cmos5l_fill_1
X_18715_ _18715_/Q clkload56/A _18715_/D _18715_/RESET_B VPWR VGND sg13cmos5l_dfrbpq_1
Xinput6 input6/X ui_in[4] VPWR VGND sg13cmos5l_buf_1
XFILLER_65_911 VPWR VGND sg13cmos5l_fill_1
X_15927_ _15939_/B _15915_/X _15922_/Y _15925_/Y VPWR VGND sg13cmos5l_a21o_1
X_19695_ _19695_/Q clkload14/A _19695_/D _19695_/RESET_B VPWR VGND sg13cmos5l_dfrbpq_1
X_18646_ _18646_/Q clkload38/A _18646_/D _18646_/RESET_B VPWR VGND sg13cmos5l_dfrbpq_1
XFILLER_64_487 VPWR VGND sg13cmos5l_fill_2
X_15858_ _15961_/A _15669_/Y _15851_/B _15857_/Y VPWR VGND sg13cmos5l_o21ai_1
X_18577_ _18577_/Q clkload27/A _18577_/D _18577_/RESET_B VPWR VGND sg13cmos5l_dfrbpq_1
X_14809_ _14809_/Y _14810_/A _14997_/A _14833_/A _14802_/Y VPWR VGND sg13cmos5l_a22oi_1
X_15789_ _15789_/Y _16307_/B _16307_/A VPWR VGND sg13cmos5l_nand2b_1
X_18756__1522 _18756_/RESET_B VPWR VGND sg13cmos5l_tiehi
X_17528_ _17650_/A _17528_/A _17528_/B VPWR VGND sg13cmos5l_nand2_1
X_17459_ _17459_/Y _17450_/Y _17454_/Y _17495_/A _17464_/A _17455_/X VPWR VGND sg13cmos5l_a221oi_1
X_19129_ _19129_/Q clkload58/A _19129_/D _19129_/RESET_B VPWR VGND sg13cmos5l_dfrbpq_1
Xheichips26_digital_project_412 uio_out[12] VPWR VGND sg13cmos5l_tielo
Xheichips26_digital_project_423 uo_out[14] VPWR VGND sg13cmos5l_tielo
XFILLER_99_384 VPWR VGND sg13cmos5l_decap_8
XFILLER_19_36 VPWR VGND sg13cmos5l_fill_2
XFILLER_56_977 VPWR VGND sg13cmos5l_fill_2
X_19072__1182 _19072_/RESET_B VPWR VGND sg13cmos5l_tiehi
X_11470_ _11591_/A _11453_/X _11469_/X _11468_/Y VPWR VGND sg13cmos5l_a21oi_1
XFILLER_13_1024 VPWR VGND sg13cmos5l_decap_4
X_10421_ _10422_/B _19809_/Q _10426_/A _10680_/A VPWR VGND sg13cmos5l_a21oi_1
X_13140_ _13266_/A _13207_/A VPWR VGND sg13cmos5l_inv_1
X_10352_ _17693_/B _19602_/Q VPWR VGND sg13cmos5l_inv_1
X_19415__460 _19415_/D VPWR VGND sg13cmos5l_tielo
X_13071_ _13071_/Y _13054_/B _13067_/S _13290_/B VPWR VGND sg13cmos5l_o21ai_1
X_12022_ _12024_/B _12022_/A _12028_/B VPWR VGND sg13cmos5l_nor2_1
X_10283_ _12483_/B _18814_/Q VPWR VGND sg13cmos5l_inv_1
XFILLER_3_767 VPWR VGND sg13cmos5l_fill_1
X_19387__846 _19387_/RESET_B VPWR VGND sg13cmos5l_tiehi
XFILLER_2_266 VPWR VGND sg13cmos5l_fill_1
X_16830_ _16830_/Y _17370_/A _19475_/Q VPWR VGND sg13cmos5l_nor2_1
XFILLER_66_708 VPWR VGND sg13cmos5l_fill_2
X_16761_ _16797_/A _16829_/B _16761_/B VPWR VGND sg13cmos5l_nor2_1
X_13973_ _13984_/A _13973_/A _13974_/B VPWR VGND sg13cmos5l_xnor2_1
X_12924_ _12926_/B _12954_/B _13114_/A VPWR VGND sg13cmos5l_nor2_1
X_18500_ _18501_/A _18514_/C _18499_/Y _18498_/Y VPWR VGND sg13cmos5l_o21ai_1
X_15712_ _15712_/Y _15719_/A _15719_/B VPWR VGND sg13cmos5l_nand2_1
X_16692_ _16692_/Y _16676_/A _16693_/B _16691_/Y VPWR VGND sg13cmos5l_a21oi_1
X_19480_ _19480_/Q _19814_/CLK _19480_/D _19480_/RESET_B VPWR VGND sg13cmos5l_dfrbpq_1
XFILLER_47_988 VPWR VGND sg13cmos5l_decap_8
X_19214__1031 _19214_/RESET_B VPWR VGND sg13cmos5l_tiehi
XFILLER_34_616 VPWR VGND sg13cmos5l_fill_1
X_12855_ _18910_/D _13027_/A _12962_/A VPWR VGND sg13cmos5l_nor2_1
X_15643_ _15643_/Y _15676_/B _15629_/B _15637_/Y _15641_/Y _15642_/Y VPWR VGND sg13cmos5l_a221oi_1
XFILLER_33_126 VPWR VGND sg13cmos5l_fill_1
X_18431_ _18431_/Y _18431_/A _18431_/B _18431_/C VPWR VGND sg13cmos5l_nor3_1
X_11806_ _11998_/B _12195_/A _11806_/B VPWR VGND sg13cmos5l_xnor2_1
X_12786_ _18896_/D _13020_/B _12786_/B VPWR VGND sg13cmos5l_nor2_1
X_19637__439 _19637_/D VPWR VGND sg13cmos5l_tielo
X_15574_ _15574_/Y _15534_/Y _15569_/B _15570_/B _15570_/C VPWR VGND sg13cmos5l_a22oi_1
X_18362_ _18363_/B _19755_/Q _18450_/B VPWR VGND sg13cmos5l_nor2_1
X_11737_ _11737_/Y _11737_/A _11742_/B VPWR VGND sg13cmos5l_nor2_1
X_17313_ _17313_/X _17310_/Y _17494_/A _17313_/S VPWR VGND sg13cmos5l_mux2_1
XFILLER_70_991 VPWR VGND sg13cmos5l_fill_1
X_14525_ _14577_/A _14548_/B _14524_/Y VPWR VGND sg13cmos5l_nor2b_1
X_19394__839 _19394_/RESET_B VPWR VGND sg13cmos5l_tiehi
X_18293_ _19733_/D _18540_/A _18293_/B VPWR VGND sg13cmos5l_and2_1
XFILLER_41_170 VPWR VGND sg13cmos5l_fill_2
X_11668_ _11669_/B _18729_/Q _11665_/Y _11922_/B VPWR VGND sg13cmos5l_o21ai_1
X_17244_ _17261_/B _19577_/Q _19576_/Q _19575_/Q VPWR VGND sg13cmos5l_nor3_1
X_14456_ _14456_/Y _14455_/A _14456_/B VPWR VGND sg13cmos5l_nand2b_1
XFILLER_30_877 VPWR VGND sg13cmos5l_fill_1
X_17175_ _17175_/Y _16972_/Y _17199_/B _17173_/Y VPWR VGND sg13cmos5l_o21ai_1
X_11599_ _11599_/Y _11611_/A _11592_/Y _11598_/Y VPWR VGND sg13cmos5l_a21oi_1
X_13407_ _13410_/A _13407_/A _13420_/B VPWR VGND sg13cmos5l_nand2_1
X_10619_ _10619_/Y _10611_/A _10614_/Y _10615_/Y _10607_/X _10618_/Y VPWR VGND sg13cmos5l_a221oi_1
XFILLER_10_590 VPWR VGND sg13cmos5l_decap_8
X_14387_ _14387_/X _14387_/A _14392_/C VPWR VGND sg13cmos5l_and2_1
X_13338_ _13338_/Y _14070_/B _14070_/A VPWR VGND sg13cmos5l_nand2b_1
X_16126_ _16233_/B _16117_/A _16117_/B _16124_/Y VPWR VGND sg13cmos5l_o21ai_1
XFILLER_51_4 VPWR VGND sg13cmos5l_fill_1
X_16057_ _16057_/Y _16349_/B _16057_/B VPWR VGND sg13cmos5l_nor2_1
X_13269_ _13282_/B _13216_/Y _13228_/Y _13262_/Y _13268_/Y VPWR VGND sg13cmos5l_a22oi_1
X_19648__557 _19648_/RESET_B VPWR VGND sg13cmos5l_tiehi
X_15008_ _15142_/A _15025_/S _15006_/Y _15007_/Y VPWR VGND sg13cmos5l_a21o_1
Xhold2419 _10176_/A _19660_/Q VPWR VGND sg13cmos5l_dlygate4sd3_1
Xhold2408 _15800_/B _19359_/Q VPWR VGND sg13cmos5l_dlygate4sd3_1
X_19747_ _19747_/Q clkload22/A _19747_/D _19747_/RESET_B VPWR VGND sg13cmos5l_dfrbpq_1
X_16959_ _16960_/B _19545_/Q _16966_/B VPWR VGND sg13cmos5l_nor2_1
XFILLER_53_925 VPWR VGND sg13cmos5l_decap_4
X_19678_ _19678_/Q _19679_/CLK _19678_/D _19678_/RESET_B VPWR VGND sg13cmos5l_dfrbpq_1
X_18629_ _18629_/Q _19790_/CLK _18629_/D _18629_/RESET_B VPWR VGND sg13cmos5l_dfrbpq_1
X_19303__936 _19303_/RESET_B VPWR VGND sg13cmos5l_tiehi
X_19060__1197 _19060_/RESET_B VPWR VGND sg13cmos5l_tiehi
XFILLER_21_833 VPWR VGND sg13cmos5l_fill_1
X_19310__929 _19310_/RESET_B VPWR VGND sg13cmos5l_tiehi
Xhold2920 hold2920/X _17499_/Y VPWR VGND sg13cmos5l_dlygate4sd3_1
Xhold2931 _15608_/A _19343_/Q VPWR VGND sg13cmos5l_dlygate4sd3_1
XFILLER_87_365 VPWR VGND sg13cmos5l_fill_2
Xhold2975 _12863_/A _18923_/Q VPWR VGND sg13cmos5l_dlygate4sd3_1
Xhold2953 _17216_/A _19588_/Q VPWR VGND sg13cmos5l_dlygate4sd3_1
Xhold2964 _11173_/A _18616_/Q VPWR VGND sg13cmos5l_dlygate4sd3_1
X_19699__433 _19699_/D VPWR VGND sg13cmos5l_tielo
Xhold2942 _16407_/A _19468_/Q VPWR VGND sg13cmos5l_dlygate4sd3_1
XFILLER_46_34 VPWR VGND sg13cmos5l_decap_8
Xhold2997 _14790_/A _19225_/Q VPWR VGND sg13cmos5l_dlygate4sd3_1
Xhold2986 _10540_/A _19803_/Q VPWR VGND sg13cmos5l_dlygate4sd3_1
X_10970_ _10991_/A _10989_/B _10989_/C VPWR VGND sg13cmos5l_nand2_1
XFILLER_83_582 VPWR VGND sg13cmos5l_decap_8
X_12640_ _12640_/Y _12633_/Y _12635_/Y _12824_/A VPWR VGND sg13cmos5l_o21ai_1
XFILLER_44_969 VPWR VGND sg13cmos5l_fill_2
X_12571_ _12573_/B _12574_/B _12570_/Y _12569_/Y VPWR VGND sg13cmos5l_a21oi_1
Xclkbuf_leaf_50_clk _18975_/CLK clkbuf_4_14_0_clk/X VPWR VGND sg13cmos5l_buf_8
XFILLER_62_77 VPWR VGND sg13cmos5l_fill_1
X_19664__1795 _19664_/RESET_B VPWR VGND sg13cmos5l_tiehi
XFILLER_11_310 VPWR VGND sg13cmos5l_fill_2
XFILLER_11_321 VPWR VGND sg13cmos5l_fill_2
X_14310_ _14310_/Y _14310_/A _14310_/B VPWR VGND sg13cmos5l_nor2_1
X_11522_ _11522_/X _11522_/A _11522_/B VPWR VGND sg13cmos5l_or2_1
X_15290_ _15292_/B _15283_/X _15288_/Y _15289_/Y VPWR VGND sg13cmos5l_a21oi_1
X_11453_ _11453_/X _11446_/X _11450_/Y _11452_/Y VPWR VGND sg13cmos5l_a21o_1
XFILLER_7_336 VPWR VGND sg13cmos5l_decap_8
X_14241_ _14262_/D _19137_/Q _19138_/Q _19139_/Q VPWR VGND sg13cmos5l_or3_1
X_10404_ _10419_/A _19808_/Q _10404_/B VPWR VGND sg13cmos5l_nand2_1
X_14172_ _14172_/Y _14177_/A _14185_/B VPWR VGND sg13cmos5l_nor2_1
X_11384_ _11384_/Y _11374_/B _11382_/Y _11383_/Y _11393_/C VPWR VGND sg13cmos5l_a22oi_1
X_13123_ _13124_/B _13115_/A _13115_/B _13122_/X VPWR VGND sg13cmos5l_o21ai_1
XFILLER_106_971 VPWR VGND sg13cmos5l_fill_1
X_10335_ _18257_/A _10335_/A VPWR VGND sg13cmos5l_inv_1
X_18980_ _18980_/Q _19092_/CLK _18980_/D _18980_/RESET_B VPWR VGND sg13cmos5l_dfrbpq_1
X_10266_ _13050_/A _10266_/A VPWR VGND sg13cmos5l_inv_1
X_13054_ _13055_/C _13299_/B _13054_/B VPWR VGND sg13cmos5l_nor2_1
X_17931_ _19666_/D _17931_/A _17943_/A VPWR VGND sg13cmos5l_and2_1
X_19112__1139 _19112_/RESET_B VPWR VGND sg13cmos5l_tiehi
X_12005_ _12005_/X _12005_/A _12018_/B VPWR VGND sg13cmos5l_or2_1
XFILLER_87_85 VPWR VGND sg13cmos5l_fill_2
X_17862_ _17863_/C _17862_/A _17939_/B VPWR VGND sg13cmos5l_nor2_1
X_16813_ _19494_/D _16823_/B _16813_/B _16813_/C VPWR VGND sg13cmos5l_nor3_1
XFILLER_94_825 VPWR VGND sg13cmos5l_fill_1
X_10197_ _10658_/A _19808_/Q VPWR VGND sg13cmos5l_inv_1
X_19601_ _19601_/Q clkload12/A _19601_/D _19601_/RESET_B VPWR VGND sg13cmos5l_dfrbpq_1
XFILLER_94_858 VPWR VGND sg13cmos5l_fill_1
X_17793_ _17895_/A _19668_/Q _17808_/B VPWR VGND sg13cmos5l_xnor2_1
X_16744_ _16826_/B _16744_/A VPWR VGND sg13cmos5l_inv_1
X_19532_ _19532_/Q clkload41/A _19532_/D _19532_/RESET_B VPWR VGND sg13cmos5l_dfrbpq_1
X_13956_ _13956_/X _13967_/B _13956_/B VPWR VGND sg13cmos5l_and2_1
X_16675_ _16675_/Y _16673_/Y _16674_/Y _16672_/Y VPWR VGND sg13cmos5l_a21oi_1
X_12907_ _12907_/Y _12899_/Y _12900_/Y _12906_/Y VPWR VGND sg13cmos5l_o21ai_1
X_13887_ _13887_/X _13899_/A _13923_/A VPWR VGND sg13cmos5l_and2_1
X_19463_ _19463_/Q clkload6/A _19463_/D _19463_/RESET_B VPWR VGND sg13cmos5l_dfrbpq_1
X_12838_ _12838_/Y _12838_/A _12838_/B VPWR VGND sg13cmos5l_nor2_1
X_15626_ _15831_/A _16014_/A _15626_/B VPWR VGND sg13cmos5l_xnor2_1
X_18414_ _18414_/X _18414_/A _18414_/B _18414_/C VPWR VGND sg13cmos5l_and3_1
X_19394_ _19394_/Q clkload8/A _19394_/D _19394_/RESET_B VPWR VGND sg13cmos5l_dfrbpq_1
XFILLER_34_479 VPWR VGND sg13cmos5l_decap_8
Xclkbuf_leaf_41_clk clkload61/A clkload3/A VPWR VGND sg13cmos5l_buf_8
X_12769_ _12769_/Y _12769_/A VPWR VGND sg13cmos5l_inv_1
X_15557_ _15582_/B _19289_/Q _15557_/B VPWR VGND sg13cmos5l_xor2_1
X_18345_ _19740_/D _18482_/A _18449_/A VPWR VGND sg13cmos5l_and2_1
X_18276_ _18277_/B _18251_/Y _18502_/A _18282_/S VPWR VGND sg13cmos5l_mux2_1
X_15488_ _15489_/A _15487_/Y _15486_/Y _15498_/C VPWR VGND sg13cmos5l_mux2_1
X_14508_ _14508_/Y _14609_/B _14609_/C _14609_/A VPWR VGND sg13cmos5l_a21oi_1
X_17227_ _17227_/Y _17339_/B _17339_/C _17339_/A VPWR VGND sg13cmos5l_a21oi_1
X_14439_ _14457_/D _19117_/Q _19115_/Q _19116_/Q VPWR VGND sg13cmos5l_or3_1
X_19045__1212 _19045_/RESET_B VPWR VGND sg13cmos5l_tiehi
X_17158_ _17158_/Y _19533_/Q _19526_/Q VPWR VGND sg13cmos5l_nand2b_1
XFILLER_7_881 VPWR VGND sg13cmos5l_fill_1
X_17089_ _19550_/D _17091_/A _17089_/B VPWR VGND sg13cmos5l_nor2_1
X_16109_ _16109_/X _16110_/A _16110_/B _16107_/Y VPWR VGND sg13cmos5l_a21o_1
XFILLER_6_391 VPWR VGND sg13cmos5l_decap_8
X_09980_ _09980_/Y _09980_/A VPWR VGND sg13cmos5l_inv_1
Xhold2216 _10260_/A _18937_/Q VPWR VGND sg13cmos5l_dlygate4sd3_1
Xhold2205 _14135_/B _19107_/Q VPWR VGND sg13cmos5l_dlygate4sd3_1
Xhold2227 _19230_/D _14963_/Y VPWR VGND sg13cmos5l_dlygate4sd3_1
Xhold2238 _14370_/A _19085_/Q VPWR VGND sg13cmos5l_dlygate4sd3_1
Xhold2249 _10130_/A _19379_/Q VPWR VGND sg13cmos5l_dlygate4sd3_1
XFILLER_53_722 VPWR VGND sg13cmos5l_fill_1
XFILLER_53_711 VPWR VGND sg13cmos5l_decap_8
XFILLER_80_552 VPWR VGND sg13cmos5l_fill_2
XFILLER_80_585 VPWR VGND sg13cmos5l_decap_8
Xclkbuf_leaf_32_clk clkload41/A clkload1/A VPWR VGND sg13cmos5l_buf_8
XFILLER_80_596 VPWR VGND sg13cmos5l_fill_2
X_19377__856 _19377_/RESET_B VPWR VGND sg13cmos5l_tiehi
XFILLER_106_256 VPWR VGND sg13cmos5l_decap_8
XFILLER_106_267 VPWR VGND sg13cmos5l_fill_1
X_10120_ _16014_/A _10120_/A VPWR VGND sg13cmos5l_inv_1
X_10051_ _13020_/A _10051_/A VPWR VGND sg13cmos5l_inv_1
XFILLER_102_462 VPWR VGND sg13cmos5l_fill_1
XFILLER_102_440 VPWR VGND sg13cmos5l_fill_1
XFILLER_57_44 VPWR VGND sg13cmos5l_fill_2
X_19384__849 _19384_/RESET_B VPWR VGND sg13cmos5l_tiehi
Xhold2750 _10557_/A _19735_/Q VPWR VGND sg13cmos5l_dlygate4sd3_1
Xhold2783 _14497_/A _19178_/Q VPWR VGND sg13cmos5l_dlygate4sd3_1
Xhold2761 _19452_/D _16546_/Y VPWR VGND sg13cmos5l_dlygate4sd3_1
Xhold2772 _14229_/A _19130_/Q VPWR VGND sg13cmos5l_dlygate4sd3_1
Xhold2794 _12414_/A _18836_/Q VPWR VGND sg13cmos5l_dlygate4sd3_1
X_13810_ _19049_/D _13810_/A _13813_/B VPWR VGND sg13cmos5l_and2_1
X_14790_ _14795_/A _14790_/A _14790_/B VPWR VGND sg13cmos5l_xnor2_1
X_13741_ _13768_/B _13765_/A _13765_/B VPWR VGND sg13cmos5l_nand2_1
X_10953_ _10955_/B _10989_/A _11174_/A VPWR VGND sg13cmos5l_nor2_1
X_13672_ _13684_/B _19057_/Q _13673_/B VPWR VGND sg13cmos5l_nor2b_1
X_16460_ _16460_/Y _16448_/A _16448_/B _16448_/C _16448_/D VPWR VGND sg13cmos5l_a22oi_1
X_10884_ _10924_/A _10884_/A _10886_/A VPWR VGND sg13cmos5l_xor2_1
X_12623_ _12636_/B _12623_/A _12624_/B VPWR VGND sg13cmos5l_nor2b_1
Xclkbuf_leaf_23_clk _18594_/CLK clkbuf_4_5_0_clk/X VPWR VGND sg13cmos5l_buf_8
X_15411_ _15411_/Y _15411_/A VPWR VGND sg13cmos5l_inv_1
XFILLER_31_449 VPWR VGND sg13cmos5l_fill_1
X_16391_ _16391_/Y _16417_/C _16389_/Y _16390_/Y _16399_/D VPWR VGND sg13cmos5l_a22oi_1
X_12554_ _12554_/Y _12554_/A _12575_/B VPWR VGND sg13cmos5l_nor2_1
X_15342_ _15383_/C _19305_/Q _19306_/Q _19307_/Q VPWR VGND sg13cmos5l_o21ai_1
X_18130_ _18130_/Y _18159_/B _18157_/B _18129_/Y VPWR VGND sg13cmos5l_a21oi_1
X_11505_ _11601_/A _11596_/B _11505_/B VPWR VGND sg13cmos5l_nand2b_1
X_15273_ _15273_/Y _15071_/Y _15272_/Y _15271_/Y VPWR VGND sg13cmos5l_o21ai_1
X_18061_ _18061_/Y _18061_/A _18061_/B VPWR VGND sg13cmos5l_nor2_1
X_17012_ _17088_/B _17013_/C _17013_/D VPWR VGND sg13cmos5l_nand2_1
X_12485_ _12486_/A _12498_/C _12483_/Y _12484_/Y VPWR VGND sg13cmos5l_o21ai_1
X_14224_ _14341_/A _19135_/Q _14226_/B VPWR VGND sg13cmos5l_nor2_1
X_11436_ _11459_/A _18653_/Q _18654_/Q VPWR VGND sg13cmos5l_xnor2_1
XFILLER_98_405 VPWR VGND sg13cmos5l_decap_8
XFILLER_98_62 VPWR VGND sg13cmos5l_fill_1
X_11367_ _11367_/Y _18705_/Q _18643_/Q VPWR VGND sg13cmos5l_nand2b_1
X_14155_ _14160_/B _19075_/Q _19076_/Q _19073_/Q _19074_/Q VPWR VGND sg13cmos5l_nor4_1
X_13106_ _13106_/Y _13110_/B _13108_/C VPWR VGND sg13cmos5l_nand2_1
X_18963_ _18963_/Q clkload67/A _18963_/D _18963_/RESET_B VPWR VGND sg13cmos5l_dfrbpq_1
X_10318_ _11623_/A _10318_/A VPWR VGND sg13cmos5l_inv_1
X_14086_ _14086_/Y _19123_/Q _10249_/Y _10250_/Y _19122_/Q VPWR VGND sg13cmos5l_a22oi_1
X_19469__751 _19469_/RESET_B VPWR VGND sg13cmos5l_tiehi
X_13037_ _13037_/Y _18894_/Q _13045_/B VPWR VGND sg13cmos5l_nand2_1
X_11298_ _11298_/Y _11202_/B _11304_/A _11296_/Y _11208_/B VPWR VGND sg13cmos5l_a22oi_1
X_17914_ _17914_/Y _17914_/A _17914_/B VPWR VGND sg13cmos5l_nor2_1
XFILLER_26_1023 VPWR VGND sg13cmos5l_decap_4
XFILLER_67_803 VPWR VGND sg13cmos5l_fill_2
X_18894_ _18894_/Q clkload67/A _18894_/D _18894_/RESET_B VPWR VGND sg13cmos5l_dfrbpq_1
X_10249_ _10249_/Y _10249_/A VPWR VGND sg13cmos5l_inv_1
X_17845_ _17845_/Y _17845_/A _17875_/B VPWR VGND sg13cmos5l_nand2_1
X_17776_ _19653_/D _17942_/A _17861_/A VPWR VGND sg13cmos5l_nor2_1
X_16727_ _16727_/Y _16708_/X _16729_/A VPWR VGND sg13cmos5l_nand2b_1
X_19515_ _19515_/Q clkload35/A _19515_/D _19515_/RESET_B VPWR VGND sg13cmos5l_dfrbpq_1
X_14988_ _14988_/X _14997_/A _15021_/A VPWR VGND sg13cmos5l_or2_1
X_13939_ _13939_/Y _14036_/B _14036_/C _14036_/A VPWR VGND sg13cmos5l_a21oi_1
X_16658_ _16660_/B _13695_/Y _16659_/S _16657_/Y VPWR VGND sg13cmos5l_o21ai_1
XFILLER_16_980 VPWR VGND sg13cmos5l_fill_2
X_19446_ _19446_/Q _19738_/CLK _19446_/D _19446_/RESET_B VPWR VGND sg13cmos5l_dfrbpq_1
XFILLER_34_254 VPWR VGND sg13cmos5l_fill_2
X_16589_ _16589_/Y _17082_/A _19496_/Q VPWR VGND sg13cmos5l_nor2_1
X_18586__1713 _18586_/RESET_B VPWR VGND sg13cmos5l_tiehi
X_19476__744 _19476_/RESET_B VPWR VGND sg13cmos5l_tiehi
X_19377_ _19377_/Q clkload8/A _19377_/D _19377_/RESET_B VPWR VGND sg13cmos5l_dfrbpq_1
X_15609_ _15609_/Y _15609_/A _15609_/B VPWR VGND sg13cmos5l_xnor2_1
X_19300__939 _19300_/RESET_B VPWR VGND sg13cmos5l_tiehi
Xclkbuf_leaf_14_clk clkload36/A clkbuf_4_6_0_clk/X VPWR VGND sg13cmos5l_buf_8
X_18328_ _18428_/A _18340_/B _18326_/Y _18325_/Y VPWR VGND sg13cmos5l_a21o_1
X_18259_ _18260_/B _18264_/C _18257_/Y _18258_/Y VPWR VGND sg13cmos5l_a21o_1
X_19009__1251 _19009_/RESET_B VPWR VGND sg13cmos5l_tiehi
XFILLER_103_226 VPWR VGND sg13cmos5l_fill_2
X_18836__1436 _18836_/RESET_B VPWR VGND sg13cmos5l_tiehi
Xhold2002 _18815_/D _12254_/Y VPWR VGND sg13cmos5l_dlygate4sd3_1
XFILLER_103_259 VPWR VGND sg13cmos5l_decap_8
XFILLER_100_900 VPWR VGND sg13cmos5l_fill_1
Xhold2024 _11102_/A _18598_/Q VPWR VGND sg13cmos5l_dlygate4sd3_1
Xhold2035 hold2035/X _19446_/Q VPWR VGND sg13cmos5l_dlygate4sd3_1
Xhold2013 _19277_/D _15250_/Y VPWR VGND sg13cmos5l_dlygate4sd3_1
Xhold2079 _10154_/A _19537_/Q VPWR VGND sg13cmos5l_dlygate4sd3_1
Xhold2068 _11690_/B _18692_/Q VPWR VGND sg13cmos5l_dlygate4sd3_1
Xhold2046 hold2046/X _18733_/Q VPWR VGND sg13cmos5l_dlygate4sd3_1
Xhold2057 _16009_/B _19339_/Q VPWR VGND sg13cmos5l_dlygate4sd3_1
X_19600__611 _19600_/RESET_B VPWR VGND sg13cmos5l_tiehi
XFILLER_80_393 VPWR VGND sg13cmos5l_fill_2
Xclkbuf_4_8_0_clk clkbuf_4_8_0_clk/X clkbuf_0_clk/X VPWR VGND sg13cmos5l_buf_8
XFILLER_43_79 VPWR VGND sg13cmos5l_fill_2
XFILLER_21_471 VPWR VGND sg13cmos5l_fill_2
X_12270_ _12270_/Y _18786_/Q _18779_/Q VPWR VGND sg13cmos5l_nor2_1
X_11221_ _11315_/A _18670_/Q _11234_/B VPWR VGND sg13cmos5l_xnor2_1
X_11152_ _18651_/D _11152_/A _11152_/B VPWR VGND sg13cmos5l_and2_1
XFILLER_68_54 VPWR VGND sg13cmos5l_decap_4
XFILLER_68_43 VPWR VGND sg13cmos5l_fill_2
XFILLER_0_320 VPWR VGND sg13cmos5l_decap_8
X_10103_ _15184_/A _10103_/A VPWR VGND sg13cmos5l_inv_1
XFILLER_95_408 VPWR VGND sg13cmos5l_decap_4
XFILLER_89_994 VPWR VGND sg13cmos5l_fill_1
XFILLER_68_87 VPWR VGND sg13cmos5l_decap_8
X_11083_ _18630_/D _18514_/B _11085_/B VPWR VGND sg13cmos5l_nor2_1
X_15960_ _15984_/B _15969_/B _15969_/C VPWR VGND sg13cmos5l_nand2_1
XFILLER_102_270 VPWR VGND sg13cmos5l_fill_1
X_10034_ _12195_/A _10034_/A VPWR VGND sg13cmos5l_inv_1
XFILLER_75_121 VPWR VGND sg13cmos5l_fill_2
XFILLER_48_313 VPWR VGND sg13cmos5l_fill_1
X_14911_ _19221_/D _14913_/A _14911_/B VPWR VGND sg13cmos5l_nor2_1
X_15891_ _15892_/B _15891_/A _15891_/B VPWR VGND sg13cmos5l_xnor2_1
Xhold2580 _10027_/A _18663_/Q VPWR VGND sg13cmos5l_dlygate4sd3_1
X_17630_ _17634_/A _17638_/B _17630_/B VPWR VGND sg13cmos5l_and2_1
XFILLER_49_869 VPWR VGND sg13cmos5l_fill_1
X_14842_ _14842_/Y _14842_/A _15004_/A VPWR VGND sg13cmos5l_nand2_1
XFILLER_64_839 VPWR VGND sg13cmos5l_fill_2
Xhold1890 _09981_/A _19403_/Q VPWR VGND sg13cmos5l_dlygate4sd3_1
XFILLER_36_519 VPWR VGND sg13cmos5l_decap_8
X_11985_ _11985_/Y _11984_/A _11985_/B VPWR VGND sg13cmos5l_nand2b_1
X_17561_ _17561_/Y _17548_/X _17551_/X _17559_/Y VPWR VGND sg13cmos5l_o21ai_1
X_14773_ _14875_/C _19217_/Q _14783_/B _14784_/A VPWR VGND sg13cmos5l_o21ai_1
X_19300_ _19300_/Q clkload44/A _19300_/D _19300_/RESET_B VPWR VGND sg13cmos5l_dfrbpq_1
X_13724_ _13727_/A _13712_/Y _13717_/Y _13723_/Y VPWR VGND sg13cmos5l_o21ai_1
X_17492_ _17493_/B _17492_/A _17492_/B VPWR VGND sg13cmos5l_and2_1
XFILLER_56_1027 VPWR VGND sg13cmos5l_fill_2
XFILLER_56_1016 VPWR VGND sg13cmos5l_decap_8
X_10936_ _10977_/B _18633_/Q _18634_/Q hold3055/X VPWR VGND sg13cmos5l_o21ai_1
X_16512_ _16512_/Y _16512_/A _16512_/B _16512_/C VPWR VGND sg13cmos5l_nand3_1
X_13655_ _13664_/B _19053_/Q _19054_/Q hold3032/X VPWR VGND sg13cmos5l_o21ai_1
X_10867_ _10867_/Y _10846_/X _10865_/S _11084_/B VPWR VGND sg13cmos5l_o21ai_1
X_16443_ _16469_/C _19415_/Q _16443_/B VPWR VGND sg13cmos5l_xor2_1
X_19231_ _19231_/Q clkload43/A _19231_/D _19231_/RESET_B VPWR VGND sg13cmos5l_dfrbpq_1
X_12606_ _12677_/A _12704_/A _12606_/B VPWR VGND sg13cmos5l_nand2_1
X_19162_ _19162_/Q _19227_/CLK _19162_/D _19162_/RESET_B VPWR VGND sg13cmos5l_dfrbpq_1
X_10798_ _13652_/A _13649_/B _10798_/B VPWR VGND sg13cmos5l_or2_1
X_18574__1728 _18574_/RESET_B VPWR VGND sg13cmos5l_tiehi
X_13586_ _19016_/D _13586_/A _13586_/B VPWR VGND sg13cmos5l_nor2_1
XFILLER_12_460 VPWR VGND sg13cmos5l_decap_8
XFILLER_13_994 VPWR VGND sg13cmos5l_fill_1
X_16374_ _16374_/Y hold2035/X fanout83/X _16307_/A VPWR VGND sg13cmos5l_o21ai_1
X_18113_ _18135_/A _19715_/Q _19716_/Q VPWR VGND sg13cmos5l_xnor2_1
X_12537_ _12537_/X _18825_/Q _12537_/B VPWR VGND sg13cmos5l_xor2_1
X_19093_ _19093_/Q clkload53/A _19093_/D _19093_/RESET_B VPWR VGND sg13cmos5l_dfrbpq_1
X_15325_ _15434_/A _19302_/Q _15433_/B _15324_/Y VPWR VGND sg13cmos5l_a21oi_1
X_12468_ _18848_/D _12468_/A _12468_/B VPWR VGND sg13cmos5l_and2_1
X_19436__794 _19436_/RESET_B VPWR VGND sg13cmos5l_tiehi
XFILLER_9_998 VPWR VGND sg13cmos5l_fill_2
X_15256_ _19281_/D _15528_/A _15256_/B VPWR VGND sg13cmos5l_and2_1
X_18044_ _19693_/D _18233_/A _18044_/B VPWR VGND sg13cmos5l_nor2_1
X_11419_ _11419_/Y _10012_/Y fanout76/X _11418_/Y VPWR VGND sg13cmos5l_a21oi_1
X_15187_ _19261_/D _15187_/A _15188_/B VPWR VGND sg13cmos5l_nor2_1
X_14207_ _14207_/Y _19111_/Q _19072_/Q VPWR VGND sg13cmos5l_nand2_1
X_12399_ _12399_/Y _12399_/A _12399_/B _12434_/B VPWR VGND sg13cmos5l_nor3_1
X_18617__1679 _18617_/RESET_B VPWR VGND sg13cmos5l_tiehi
X_14138_ _19109_/D _09998_/Y fanout91/X _14137_/Y VPWR VGND sg13cmos5l_a21oi_1
X_18946_ _18946_/Q _19087_/CLK _18946_/D _18946_/RESET_B VPWR VGND sg13cmos5l_dfrbpq_1
X_14069_ _14069_/Y hold2821/X _14057_/Y _14068_/Y VPWR VGND sg13cmos5l_a21oi_1
Xclkbuf_leaf_3_clk clkload10/A clkbuf_4_1_0_clk/X VPWR VGND sg13cmos5l_buf_8
XFILLER_95_953 VPWR VGND sg13cmos5l_decap_4
XFILLER_95_931 VPWR VGND sg13cmos5l_fill_2
X_18877_ _18877_/Q _18902_/CLK _18877_/D _18877_/RESET_B VPWR VGND sg13cmos5l_dfrbpq_1
XFILLER_67_633 VPWR VGND sg13cmos5l_fill_2
XFILLER_67_611 VPWR VGND sg13cmos5l_fill_1
XFILLER_39_335 VPWR VGND sg13cmos5l_fill_1
X_19367__866 _19367_/RESET_B VPWR VGND sg13cmos5l_tiehi
X_17828_ _17828_/Y _17837_/A _17837_/B _18012_/A VPWR VGND sg13cmos5l_a21oi_1
XFILLER_82_625 VPWR VGND sg13cmos5l_fill_1
X_17759_ _17759_/Y _17759_/A _17780_/A VPWR VGND sg13cmos5l_nor2_1
XFILLER_62_360 VPWR VGND sg13cmos5l_fill_1
Xfanout28 _17070_/S _17065_/Y VPWR VGND sg13cmos5l_buf_1
X_19429_ _19429_/Q clkload8/A _19429_/D _19429_/RESET_B VPWR VGND sg13cmos5l_dfrbpq_1
XFILLER_50_555 VPWR VGND sg13cmos5l_fill_2
Xfanout39 _15173_/S _15168_/Y VPWR VGND sg13cmos5l_buf_1
X_19374__859 _19374_/RESET_B VPWR VGND sg13cmos5l_tiehi
XFILLER_2_618 VPWR VGND sg13cmos5l_fill_1
XFILLER_97_290 VPWR VGND sg13cmos5l_fill_2
X_11770_ _11770_/X _11858_/B _11874_/A _11771_/C VPWR VGND sg13cmos5l_and3_1
XFILLER_54_56 VPWR VGND sg13cmos5l_fill_1
X_10721_ _10721_/Y _10748_/A _13807_/B VPWR VGND sg13cmos5l_nor2_1
X_13440_ _13441_/B _13539_/B _13539_/C _13539_/A VPWR VGND sg13cmos5l_a21oi_1
X_19459__761 _19459_/RESET_B VPWR VGND sg13cmos5l_tiehi
X_10652_ _10664_/A _19808_/Q _10652_/B VPWR VGND sg13cmos5l_or2_1
X_18693__1597 _18693_/RESET_B VPWR VGND sg13cmos5l_tiehi
X_13371_ _13371_/X _13381_/D _13365_/C _13365_/A VPWR VGND sg13cmos5l_a21o_1
X_19338__467 _19338_/D VPWR VGND sg13cmos5l_tielo
X_10583_ _10583_/Y _18546_/A VPWR VGND sg13cmos5l_inv_1
X_12322_ _12322_/Y _12336_/D _12322_/B _12546_/A VPWR VGND sg13cmos5l_nand3_1
X_15110_ _15111_/B _15108_/A _15108_/B _15109_/Y VPWR VGND sg13cmos5l_o21ai_1
X_16090_ _16090_/X _16090_/A _16104_/D _16090_/C VPWR VGND sg13cmos5l_and3_1
X_12253_ _12253_/Y _18815_/Q fanout95/X _11691_/A VPWR VGND sg13cmos5l_o21ai_1
X_15041_ _15041_/Y _15041_/A _19198_/Q _19257_/Q VPWR VGND sg13cmos5l_nand3_1
XFILLER_79_42 VPWR VGND sg13cmos5l_fill_1
X_11204_ _11204_/Y _11204_/A _11204_/B _11204_/C VPWR VGND sg13cmos5l_nand3_1
X_12184_ _12184_/Y _12172_/B _12186_/S _12192_/B VPWR VGND sg13cmos5l_o21ai_1
XFILLER_69_909 VPWR VGND sg13cmos5l_fill_2
X_18800_ _18800_/Q clkload60/A _18800_/D _18800_/RESET_B VPWR VGND sg13cmos5l_dfrbpq_1
X_16992_ _17015_/B _16996_/B _16992_/B VPWR VGND sg13cmos5l_nand2b_1
X_11135_ _11135_/Y _11113_/A _11133_/S _11351_/B VPWR VGND sg13cmos5l_o21ai_1
X_19780_ _19780_/Q clkload48/A _19780_/D _19780_/RESET_B VPWR VGND sg13cmos5l_dfrbpq_1
X_18731_ _18731_/Q _18733_/CLK _18731_/D _18731_/RESET_B VPWR VGND sg13cmos5l_dfrbpq_1
X_11066_ _18618_/D _11002_/X _11076_/B _11065_/Y VPWR VGND sg13cmos5l_a21oi_1
X_15943_ _15943_/Y _15844_/A _15844_/B _15942_/A _15942_/B VPWR VGND sg13cmos5l_a22oi_1
X_19466__754 _19466_/RESET_B VPWR VGND sg13cmos5l_tiehi
X_10017_ _10017_/Y _10384_/B VPWR VGND sg13cmos5l_inv_1
XFILLER_64_603 VPWR VGND sg13cmos5l_fill_2
X_18662_ _18662_/Q clkload55/A _18662_/D _18662_/RESET_B VPWR VGND sg13cmos5l_dfrbpq_1
X_15874_ _15975_/A _19384_/Q _15887_/B VPWR VGND sg13cmos5l_xnor2_1
XFILLER_36_305 VPWR VGND sg13cmos5l_fill_2
XFILLER_36_316 VPWR VGND sg13cmos5l_fill_1
X_18593_ _18593_/Q _18594_/CLK _18593_/D _18593_/RESET_B VPWR VGND sg13cmos5l_dfrbpq_1
X_17613_ _17613_/Y _17613_/A _17613_/B VPWR VGND sg13cmos5l_nand2_1
X_14825_ _14825_/Y _15182_/A _15004_/A VPWR VGND sg13cmos5l_nand2_1
X_17544_ _17544_/Y _19616_/Q _19631_/Q VPWR VGND sg13cmos5l_nand2_1
XFILLER_51_319 VPWR VGND sg13cmos5l_fill_2
X_14756_ _19203_/D _14916_/A _14877_/A VPWR VGND sg13cmos5l_and2_1
X_13707_ _13707_/X _16641_/A _16648_/A VPWR VGND sg13cmos5l_and2_1
X_11968_ _18778_/D _12188_/A _12043_/B VPWR VGND sg13cmos5l_and2_1
X_11899_ _18758_/D _11899_/A _11899_/B VPWR VGND sg13cmos5l_nor2_1
X_17475_ _17475_/X _19567_/Q _17495_/B VPWR VGND sg13cmos5l_or2_1
X_10919_ _10982_/B _10917_/B _10907_/B _10918_/Y VPWR VGND sg13cmos5l_o21ai_1
X_14687_ _14687_/Y _14687_/A _14687_/B VPWR VGND sg13cmos5l_nor2_1
X_19214_ _19214_/Q _19262_/CLK _19214_/D _19214_/RESET_B VPWR VGND sg13cmos5l_dfrbpq_1
X_19473__747 _19473_/RESET_B VPWR VGND sg13cmos5l_tiehi
X_13638_ _13638_/Y _19025_/Q fanout86/X _10746_/A VPWR VGND sg13cmos5l_o21ai_1
X_16426_ _16426_/Y _19416_/Q _19409_/Q VPWR VGND sg13cmos5l_nor2_1
X_19715__1500 _19715_/RESET_B VPWR VGND sg13cmos5l_tiehi
X_13569_ _13569_/Y _13557_/B fanout47/X _13569_/B1 VPWR VGND sg13cmos5l_o21ai_1
X_16357_ _16370_/B _19444_/Q _16357_/B _16357_/C VPWR VGND sg13cmos5l_nor3_1
X_19145_ _19145_/Q clkload42/A _19145_/D _19145_/RESET_B VPWR VGND sg13cmos5l_dfrbpq_1
X_19076_ _19076_/Q clkload54/A _19076_/D _19076_/RESET_B VPWR VGND sg13cmos5l_dfrbpq_1
X_15308_ _15308_/Y _19279_/Q _19240_/Q VPWR VGND sg13cmos5l_nand2_1
X_16288_ _16289_/B _16288_/A _16288_/B VPWR VGND sg13cmos5l_xor2_1
X_18027_ _18027_/Y _19656_/Q _18028_/B VPWR VGND sg13cmos5l_xnor2_1
X_18876__1393 _18876_/RESET_B VPWR VGND sg13cmos5l_tiehi
X_15239_ _15239_/Y _15486_/A _15238_/B _15466_/A VPWR VGND sg13cmos5l_a21oi_1
X_19677__1782 _19677_/RESET_B VPWR VGND sg13cmos5l_tiehi
XFILLER_5_61 VPWR VGND sg13cmos5l_fill_1
Xfanout229 _16823_/B _16609_/A VPWR VGND sg13cmos5l_buf_1
XFILLER_87_706 VPWR VGND sg13cmos5l_fill_2
Xfanout218 _17373_/A _17377_/A VPWR VGND sg13cmos5l_buf_1
Xfanout207 _18231_/A _17983_/Y VPWR VGND sg13cmos5l_buf_1
XFILLER_87_739 VPWR VGND sg13cmos5l_fill_2
X_18929_ _18929_/Q _18931_/CLK _18929_/D _18929_/RESET_B VPWR VGND sg13cmos5l_dfrbpq_1
XFILLER_68_931 VPWR VGND sg13cmos5l_fill_1
XFILLER_68_964 VPWR VGND sg13cmos5l_decap_4
XFILLER_27_305 VPWR VGND sg13cmos5l_fill_1
X_19125__1126 _19125_/RESET_B VPWR VGND sg13cmos5l_tiehi
XFILLER_70_628 VPWR VGND sg13cmos5l_fill_2
XFILLER_51_820 VPWR VGND sg13cmos5l_fill_1
XFILLER_51_897 VPWR VGND sg13cmos5l_fill_2
XFILLER_10_249 VPWR VGND sg13cmos5l_fill_1
XFILLER_40_36 VPWR VGND sg13cmos5l_decap_4
XFILLER_3_927 VPWR VGND sg13cmos5l_fill_2
XFILLER_49_67 VPWR VGND sg13cmos5l_fill_2
X_19741__429 _19741_/D VPWR VGND sg13cmos5l_tielo
XFILLER_92_208 VPWR VGND sg13cmos5l_fill_1
X_12940_ _12943_/A _12940_/A _12940_/B VPWR VGND sg13cmos5l_nor2_1
X_12871_ _12871_/Y _12984_/B _12984_/C _12984_/A VPWR VGND sg13cmos5l_a21oi_1
XFILLER_74_967 VPWR VGND sg13cmos5l_fill_1
XFILLER_65_66 VPWR VGND sg13cmos5l_fill_2
XFILLER_46_658 VPWR VGND sg13cmos5l_fill_2
XFILLER_46_647 VPWR VGND sg13cmos5l_decap_8
X_11822_ _11824_/D _11827_/B _11827_/C _11821_/Y VPWR VGND sg13cmos5l_o21ai_1
XFILLER_65_88 VPWR VGND sg13cmos5l_decap_8
X_14610_ _14619_/A _14508_/Y _14610_/B _14610_/C VPWR VGND sg13cmos5l_nand3b_1
XFILLER_14_500 VPWR VGND sg13cmos5l_decap_8
X_15590_ _15590_/Y _15588_/Y _15589_/Y _15587_/Y VPWR VGND sg13cmos5l_a21oi_1
X_11753_ _11772_/A _18755_/Q _11766_/B VPWR VGND sg13cmos5l_or2_1
XFILLER_81_43 VPWR VGND sg13cmos5l_fill_1
X_14541_ _14542_/C _14380_/A _14541_/B _14541_/C VPWR VGND sg13cmos5l_nand3b_1
X_10704_ _10705_/A _18570_/Q _10695_/Y _10703_/Y _18571_/Q VPWR VGND sg13cmos5l_a22oi_1
X_17260_ _17271_/B _19577_/Q _19578_/Q _19576_/Q _19575_/Q VPWR VGND sg13cmos5l_nor4_1
X_11684_ _11684_/Y hold1980/X fanout94/X _11423_/A VPWR VGND sg13cmos5l_o21ai_1
X_14472_ _19157_/D _14637_/B _14599_/A VPWR VGND sg13cmos5l_and2_1
X_17191_ _17191_/Y _17192_/B VPWR VGND sg13cmos5l_inv_1
X_13423_ _13548_/A _13420_/A _13421_/A _13421_/Y VPWR VGND sg13cmos5l_a21oi_1
X_10635_ _19791_/D _18273_/B _18272_/B VPWR VGND sg13cmos5l_and2_1
X_16211_ _16256_/B _16556_/A _16211_/B VPWR VGND sg13cmos5l_xnor2_1
X_18831__1441 _18831_/RESET_B VPWR VGND sg13cmos5l_tiehi
X_13354_ _18984_/D _10003_/Y fanout97/X _13353_/Y VPWR VGND sg13cmos5l_a21oi_1
X_16142_ _16144_/B _16118_/Y _16141_/Y _16140_/X VPWR VGND sg13cmos5l_a21oi_1
X_12305_ _18824_/D _12452_/A _12305_/B VPWR VGND sg13cmos5l_nor2_1
X_10566_ _18544_/A _10564_/A _10565_/Y _10564_/Y VPWR VGND sg13cmos5l_a21oi_1
X_13285_ _18962_/D _13285_/A _13289_/B VPWR VGND sg13cmos5l_nor2_1
X_16073_ _16073_/Y _16073_/A _16073_/B VPWR VGND sg13cmos5l_nand2_1
X_10497_ _10499_/B _10497_/A _10497_/B VPWR VGND sg13cmos5l_nand2_1
X_12236_ _12238_/A _10284_/A _12233_/Y _12235_/Y _18813_/Q _12234_/Y VPWR VGND sg13cmos5l_a221oi_1
X_15024_ _15024_/Y _15024_/A _15024_/B VPWR VGND sg13cmos5l_nand2_1
X_19433__797 _19433_/RESET_B VPWR VGND sg13cmos5l_tiehi
X_12167_ _12174_/A _12167_/A _12167_/B VPWR VGND sg13cmos5l_nor2_1
X_11118_ _11119_/B _11123_/C _11116_/Y _11117_/Y VPWR VGND sg13cmos5l_a21o_1
X_12098_ _12098_/Y _12136_/A _12137_/A _12137_/B _12136_/B VPWR VGND sg13cmos5l_a22oi_1
X_16975_ _17011_/A _19547_/Q _19548_/Q _19549_/Q VPWR VGND sg13cmos5l_or3_1
X_19763_ _19763_/Q clkload23/A _19763_/D _19763_/RESET_B VPWR VGND sg13cmos5l_dfrbpq_1
Xinput7 input7/X ui_in[5] VPWR VGND sg13cmos5l_buf_1
X_18714_ _18714_/Q clkload55/A _18714_/D _18714_/RESET_B VPWR VGND sg13cmos5l_dfrbpq_1
X_11049_ _11049_/Y _11049_/A _11049_/B _11049_/C VPWR VGND sg13cmos5l_nand3_1
X_15926_ _15926_/Y _15915_/X _15922_/Y _15925_/Y VPWR VGND sg13cmos5l_a21oi_1
X_19364__869 _19364_/RESET_B VPWR VGND sg13cmos5l_tiehi
X_19694_ _19694_/Q clkload14/A _19694_/D _19694_/RESET_B VPWR VGND sg13cmos5l_dfrbpq_1
X_18645_ _18645_/Q clkload38/A _18645_/D _18645_/RESET_B VPWR VGND sg13cmos5l_dfrbpq_1
XFILLER_37_636 VPWR VGND sg13cmos5l_fill_1
X_15857_ _15857_/Y _15851_/B _15841_/B _15856_/Y VPWR VGND sg13cmos5l_o21ai_1
XFILLER_91_252 VPWR VGND sg13cmos5l_fill_2
X_14808_ _14808_/X _14799_/Y _14995_/A _14807_/Y VPWR VGND sg13cmos5l_a21o_1
X_18576_ _18576_/Q clkload29/A _18576_/D _18576_/RESET_B VPWR VGND sg13cmos5l_dfrbpq_1
X_15788_ _16021_/A _18272_/A _16307_/B VPWR VGND sg13cmos5l_nor2_1
XFILLER_36_179 VPWR VGND sg13cmos5l_fill_2
X_17527_ _17627_/A _17628_/B _17638_/B _17527_/C VPWR VGND sg13cmos5l_nand3_1
X_14739_ _14755_/S _14735_/A _14735_/B _14737_/Y VPWR VGND sg13cmos5l_a21o_1
X_17458_ _17458_/Y _17455_/A _17490_/A _17495_/A _17464_/A VPWR VGND sg13cmos5l_a22oi_1
XFILLER_32_374 VPWR VGND sg13cmos5l_fill_1
X_16409_ _16410_/A _16409_/A _16409_/B VPWR VGND sg13cmos5l_xnor2_1
XFILLER_72_0 VPWR VGND sg13cmos5l_fill_2
X_17389_ _17408_/C _19622_/Q _17392_/B _17397_/B VPWR VGND sg13cmos5l_o21ai_1
X_19128_ _19128_/Q _19136_/CLK _19128_/D _19128_/RESET_B VPWR VGND sg13cmos5l_dfrbpq_1
X_19059_ _19059_/Q clkload30/A _19059_/D _19059_/RESET_B VPWR VGND sg13cmos5l_dfrbpq_1
Xheichips26_digital_project_413 uio_out[13] VPWR VGND sg13cmos5l_tielo
Xheichips26_digital_project_424 uo_out[15] VPWR VGND sg13cmos5l_tielo
XFILLER_102_814 VPWR VGND sg13cmos5l_fill_1
X_18666__1627 _18666_/RESET_B VPWR VGND sg13cmos5l_tiehi
XFILLER_101_357 VPWR VGND sg13cmos5l_fill_2
X_19449__771 _19449_/RESET_B VPWR VGND sg13cmos5l_tiehi
XFILLER_101_379 VPWR VGND sg13cmos5l_fill_1
XFILLER_83_797 VPWR VGND sg13cmos5l_fill_2
XFILLER_35_69 VPWR VGND sg13cmos5l_fill_2
X_19737__1099 _19737_/RESET_B VPWR VGND sg13cmos5l_tiehi
X_18612__1684 _18612_/RESET_B VPWR VGND sg13cmos5l_tiehi
XFILLER_11_525 VPWR VGND sg13cmos5l_fill_1
X_19456__764 _19456_/RESET_B VPWR VGND sg13cmos5l_tiehi
X_10420_ _10426_/A input8/X input9/X VPWR VGND sg13cmos5l_nor2_1
XFILLER_7_518 VPWR VGND sg13cmos5l_decap_8
XFILLER_7_507 VPWR VGND sg13cmos5l_fill_1
X_18599__1700 _18599_/RESET_B VPWR VGND sg13cmos5l_tiehi
X_10351_ _17400_/A _17688_/A VPWR VGND sg13cmos5l_inv_1
XFILLER_3_702 VPWR VGND sg13cmos5l_fill_2
X_10282_ _12487_/A _10282_/A VPWR VGND sg13cmos5l_inv_1
X_13070_ _13070_/Y _10262_/Y _13067_/S _13069_/Y VPWR VGND sg13cmos5l_a21oi_1
XFILLER_2_212 VPWR VGND sg13cmos5l_decap_4
X_12021_ _18782_/D _12200_/A _12021_/B VPWR VGND sg13cmos5l_nor2_1
X_19311__470 _19311_/D VPWR VGND sg13cmos5l_tielo
X_16760_ _16761_/B _16756_/Y _16759_/Y _16770_/A VPWR VGND sg13cmos5l_a21oi_1
X_13972_ _13980_/B _19099_/Q _13974_/B VPWR VGND sg13cmos5l_nor2b_1
X_19463__757 _19463_/RESET_B VPWR VGND sg13cmos5l_tiehi
XFILLER_101_880 VPWR VGND sg13cmos5l_fill_1
X_12923_ _12927_/B _13285_/A _12960_/B VPWR VGND sg13cmos5l_nor2_1
XFILLER_47_967 VPWR VGND sg13cmos5l_fill_2
XFILLER_47_956 VPWR VGND sg13cmos5l_fill_2
X_15711_ _15719_/B _15584_/B _15710_/B _15710_/Y VPWR VGND sg13cmos5l_o21ai_1
X_18849__1423 _18849_/RESET_B VPWR VGND sg13cmos5l_tiehi
X_16691_ _16691_/Y _16800_/A _16800_/B _16762_/B VPWR VGND sg13cmos5l_nor3_1
X_18430_ _18430_/X _18479_/B _18445_/B _18428_/Y VPWR VGND sg13cmos5l_a21o_1
X_12854_ _12962_/A _12633_/Y _12824_/A _12816_/X _12827_/B VPWR VGND sg13cmos5l_a22oi_1
X_15642_ _15642_/Y _15642_/A _15671_/A VPWR VGND sg13cmos5l_nor2_1
X_11805_ _11997_/A _18750_/Q _11806_/B VPWR VGND sg13cmos5l_xnor2_1
XFILLER_92_64 VPWR VGND sg13cmos5l_fill_1
X_12785_ _12786_/B _12769_/Y _13056_/B _12785_/S VPWR VGND sg13cmos5l_mux2_1
X_18361_ _18451_/A _19754_/Q _18450_/B _18444_/A VPWR VGND sg13cmos5l_a21oi_1
X_15573_ _19326_/D _15747_/A _15695_/A VPWR VGND sg13cmos5l_and2_1
XFILLER_33_138 VPWR VGND sg13cmos5l_decap_4
XFILLER_33_149 VPWR VGND sg13cmos5l_decap_8
X_11736_ _11740_/A _11736_/A _11736_/B VPWR VGND sg13cmos5l_nand2_1
X_17312_ _17376_/B _17313_/S _17494_/A _17311_/Y VPWR VGND sg13cmos5l_a21oi_1
X_18292_ _19732_/D _18470_/A _18292_/B VPWR VGND sg13cmos5l_and2_1
X_14524_ _14524_/Y _19182_/Q _14537_/A _19183_/Q VPWR VGND sg13cmos5l_o21ai_1
X_17243_ _17246_/B _19576_/Q _19575_/Q VPWR VGND sg13cmos5l_nor2_1
X_11667_ _11669_/A _11660_/Y _11664_/Y _11665_/Y _18729_/Q _11666_/Y VPWR VGND sg13cmos5l_a221oi_1
X_14455_ _14455_/Y _14455_/A _14456_/B VPWR VGND sg13cmos5l_nor2b_1
X_17174_ _17174_/X _17174_/A _17174_/B VPWR VGND sg13cmos5l_xor2_1
X_11598_ _11598_/Y _11598_/A _11614_/A VPWR VGND sg13cmos5l_nor2_1
X_13406_ _18990_/D _13585_/A _13406_/B VPWR VGND sg13cmos5l_nor2_1
X_10618_ _10618_/Y _10624_/B _10465_/X VPWR VGND sg13cmos5l_nor2b_1
X_14386_ _14392_/C _19169_/Q _10245_/Y _14385_/Y VPWR VGND sg13cmos5l_o21ai_1
X_13337_ _13337_/Y _13337_/A _14070_/B VPWR VGND sg13cmos5l_nor2_1
X_10549_ _10549_/Y _10906_/A _10549_/B VPWR VGND sg13cmos5l_nand2_1
XFILLER_6_551 VPWR VGND sg13cmos5l_decap_8
X_16125_ _16233_/A _16125_/A _16140_/B _16125_/C VPWR VGND sg13cmos5l_nand3_1
XFILLER_6_573 VPWR VGND sg13cmos5l_decap_8
X_16056_ _16056_/Y _19421_/Q _16556_/A _16038_/B _15800_/B VPWR VGND sg13cmos5l_a22oi_1
X_13268_ _13268_/Y _13282_/A _13270_/B _13267_/Y VPWR VGND sg13cmos5l_a21oi_1
XFILLER_44_4 VPWR VGND sg13cmos5l_decap_8
X_15007_ _15007_/Y _14999_/Y _15003_/Y _14825_/Y VPWR VGND sg13cmos5l_a21oi_1
X_12219_ _12219_/X _12219_/A _12219_/B VPWR VGND sg13cmos5l_and2_1
X_13199_ _13296_/B _13151_/A _13420_/A _13199_/S VPWR VGND sg13cmos5l_mux2_1
Xhold2409 hold2409/X _15800_/Y VPWR VGND sg13cmos5l_dlygate4sd3_1
XFILLER_96_344 VPWR VGND sg13cmos5l_fill_1
XFILLER_57_709 VPWR VGND sg13cmos5l_fill_2
X_16958_ _17059_/A _19544_/Q _16966_/B _16957_/Y VPWR VGND sg13cmos5l_a21oi_1
X_19746_ _19746_/Q clkload20/A _19746_/D _19746_/RESET_B VPWR VGND sg13cmos5l_dfrbpq_1
X_19165__1083 _19165_/RESET_B VPWR VGND sg13cmos5l_tiehi
X_18992__1268 _18992_/RESET_B VPWR VGND sg13cmos5l_tiehi
X_15909_ _15915_/B _15909_/A _16100_/A VPWR VGND sg13cmos5l_nor2_1
XFILLER_92_561 VPWR VGND sg13cmos5l_fill_2
X_16889_ _19522_/D _16889_/A _16889_/B VPWR VGND sg13cmos5l_and2_1
X_19677_ _19677_/Q _19679_/CLK _19677_/D _19677_/RESET_B VPWR VGND sg13cmos5l_dfrbpq_1
XFILLER_53_948 VPWR VGND sg13cmos5l_fill_2
XFILLER_52_414 VPWR VGND sg13cmos5l_fill_2
X_18628_ _18628_/Q _19790_/CLK _18628_/D _18628_/RESET_B VPWR VGND sg13cmos5l_dfrbpq_1
X_18559_ _18595_/D _18560_/A _18559_/B VPWR VGND sg13cmos5l_nor2_1
XFILLER_33_672 VPWR VGND sg13cmos5l_fill_2
X_18600__1699 _18600_/RESET_B VPWR VGND sg13cmos5l_tiehi
XFILLER_106_416 VPWR VGND sg13cmos5l_decap_4
XFILLER_0_738 VPWR VGND sg13cmos5l_decap_8
XFILLER_87_344 VPWR VGND sg13cmos5l_fill_1
Xhold2921 _13109_/A _18911_/Q VPWR VGND sg13cmos5l_dlygate4sd3_1
Xhold2910 _16155_/A _19427_/Q VPWR VGND sg13cmos5l_dlygate4sd3_1
Xhold2932 _15709_/C _15708_/Y VPWR VGND sg13cmos5l_dlygate4sd3_1
Xhold2954 hold2954/X _17322_/A VPWR VGND sg13cmos5l_dlygate4sd3_1
Xhold2965 _17526_/A _19624_/Q VPWR VGND sg13cmos5l_dlygate4sd3_1
Xhold2943 _13980_/A _19100_/Q VPWR VGND sg13cmos5l_dlygate4sd3_1
XFILLER_68_580 VPWR VGND sg13cmos5l_fill_2
Xhold2998 _10900_/A _19782_/Q VPWR VGND sg13cmos5l_dlygate4sd3_1
Xhold2976 _18041_/A _19651_/Q VPWR VGND sg13cmos5l_dlygate4sd3_1
Xhold2987 hold2987/X _19181_/Q VPWR VGND sg13cmos5l_dlygate4sd3_1
X_19595__443 _19595_/D VPWR VGND sg13cmos5l_tielo
X_12570_ _12570_/Y _12575_/B _12539_/Y VPWR VGND sg13cmos5l_nor2b_1
XFILLER_62_89 VPWR VGND sg13cmos5l_fill_1
X_11521_ _11631_/B _11521_/A _11522_/B VPWR VGND sg13cmos5l_nor2_1
XFILLER_7_304 VPWR VGND sg13cmos5l_fill_2
X_19393__840 _19393_/RESET_B VPWR VGND sg13cmos5l_tiehi
XFILLER_23_193 VPWR VGND sg13cmos5l_fill_2
X_11452_ _11452_/Y _11452_/A _11474_/B VPWR VGND sg13cmos5l_nor2_1
X_14240_ _14297_/B _14640_/A _14240_/B VPWR VGND sg13cmos5l_xnor2_1
X_11383_ _11383_/Y _18708_/Q _18702_/Q VPWR VGND sg13cmos5l_nor2b_1
X_10403_ _10403_/Y input8/X _10673_/B VPWR VGND sg13cmos5l_nor2_1
X_14171_ _14199_/B _19079_/Q _14171_/B VPWR VGND sg13cmos5l_xor2_1
X_13122_ _13122_/X _13122_/A _13122_/B VPWR VGND sg13cmos5l_and2_1
X_10334_ _18514_/B _10334_/A VPWR VGND sg13cmos5l_inv_1
XFILLER_3_554 VPWR VGND sg13cmos5l_decap_8
X_17930_ _19665_/D _17930_/A _17930_/B VPWR VGND sg13cmos5l_and2_1
X_13053_ _13055_/B _13323_/A _13053_/B VPWR VGND sg13cmos5l_nor2_1
X_10265_ _10265_/Y _13328_/B VPWR VGND sg13cmos5l_inv_1
XFILLER_3_565 VPWR VGND sg13cmos5l_fill_2
X_19120__1131 _19120_/RESET_B VPWR VGND sg13cmos5l_tiehi
X_12004_ _18779_/D _12192_/B _12004_/B VPWR VGND sg13cmos5l_and2_1
X_10196_ _10400_/A input9/X VPWR VGND sg13cmos5l_inv_1
X_17861_ _17863_/B _17861_/A _17861_/B VPWR VGND sg13cmos5l_and2_1
X_16812_ _16813_/C _16812_/A _16792_/Y VPWR VGND sg13cmos5l_nor2b_1
XFILLER_66_528 VPWR VGND sg13cmos5l_fill_2
X_19600_ _19600_/Q clkload12/A _19600_/D _19600_/RESET_B VPWR VGND sg13cmos5l_dfrbpq_1
X_19531_ _19531_/Q clkload38/A _19531_/D _19531_/RESET_B VPWR VGND sg13cmos5l_dfrbpq_1
Xfanout390 _11423_/A _10860_/B VPWR VGND sg13cmos5l_buf_1
XFILLER_59_580 VPWR VGND sg13cmos5l_fill_2
X_17792_ _17797_/A _19668_/Q _17808_/B VPWR VGND sg13cmos5l_nand2_1
XFILLER_47_731 VPWR VGND sg13cmos5l_fill_2
X_16743_ _16744_/A _16743_/A _16742_/Y VPWR VGND sg13cmos5l_nor2b_1
X_13955_ _13956_/B _19095_/Q _19096_/Q hold3034/X VPWR VGND sg13cmos5l_o21ai_1
X_16674_ _16674_/Y _19478_/Q _19029_/Q VPWR VGND sg13cmos5l_xnor2_1
X_12906_ _12906_/Y _12947_/A _12890_/X _12954_/A _12905_/Y VPWR VGND sg13cmos5l_a22oi_1
X_13886_ _13923_/A _18993_/Q _13886_/B VPWR VGND sg13cmos5l_xnor2_1
X_19462_ _19462_/Q _19462_/CLK _19462_/D _19462_/RESET_B VPWR VGND sg13cmos5l_dfrbpq_1
XFILLER_35_948 VPWR VGND sg13cmos5l_fill_1
X_12837_ _18906_/D _13025_/A _12837_/B VPWR VGND sg13cmos5l_nor2_1
X_19393_ _19393_/Q clkload8/A _19393_/D _19393_/RESET_B VPWR VGND sg13cmos5l_dfrbpq_1
X_15625_ _15676_/B _19336_/Q _15626_/B VPWR VGND sg13cmos5l_xnor2_1
X_18413_ _18413_/Y _18403_/Y _18408_/X _18412_/Y VPWR VGND sg13cmos5l_o21ai_1
XFILLER_34_447 VPWR VGND sg13cmos5l_fill_1
XFILLER_50_918 VPWR VGND sg13cmos5l_fill_2
X_18344_ _18449_/A _18315_/B _18341_/B _18163_/Y VPWR VGND sg13cmos5l_o21ai_1
X_12768_ _12769_/A _12767_/C _12766_/Y _12767_/Y VPWR VGND sg13cmos5l_a21o_1
X_19654__551 _19654_/RESET_B VPWR VGND sg13cmos5l_tiehi
X_15556_ _15556_/Y _15556_/A _15556_/B VPWR VGND sg13cmos5l_nor2_1
X_12699_ _12699_/Y _12706_/A _12706_/B VPWR VGND sg13cmos5l_nand2_1
X_11719_ _11725_/A _11546_/Y _11736_/B VPWR VGND sg13cmos5l_nand2b_1
X_18275_ _19722_/D _18483_/A _18275_/B VPWR VGND sg13cmos5l_nor2_1
X_15487_ _15487_/Y _16011_/A _19338_/Q VPWR VGND sg13cmos5l_nor2_1
X_14507_ _14609_/C _14506_/A _14506_/B _14518_/A VPWR VGND sg13cmos5l_o21ai_1
X_17226_ _17339_/C _17225_/A _17225_/B _17236_/A VPWR VGND sg13cmos5l_o21ai_1
X_14438_ _19156_/D _14710_/A _14438_/B VPWR VGND sg13cmos5l_and2_1
X_17157_ _17157_/Y _19532_/Q _19525_/Q VPWR VGND sg13cmos5l_nor2_1
X_14369_ _19134_/D _14369_/A _14371_/B VPWR VGND sg13cmos5l_nor2_1
X_16108_ _16108_/Y _16110_/A _16110_/B _16107_/Y VPWR VGND sg13cmos5l_a21oi_1
X_17088_ _19549_/D _17091_/A _17088_/B VPWR VGND sg13cmos5l_nor2_1
X_16039_ _16039_/Y _16227_/A _16556_/A _16052_/C VPWR VGND sg13cmos5l_nand3_1
Xhold2217 _18937_/D _13074_/Y VPWR VGND sg13cmos5l_dlygate4sd3_1
Xhold2228 _10353_/A _19600_/Q VPWR VGND sg13cmos5l_dlygate4sd3_1
Xhold2206 hold2206/X _14135_/Y VPWR VGND sg13cmos5l_dlygate4sd3_1
X_19661__544 _19661_/RESET_B VPWR VGND sg13cmos5l_tiehi
Xhold2239 _14094_/A _19062_/Q VPWR VGND sg13cmos5l_dlygate4sd3_1
XFILLER_96_185 VPWR VGND sg13cmos5l_fill_1
X_19729_ _19729_/Q clkload35/A _19729_/D _19729_/RESET_B VPWR VGND sg13cmos5l_dfrbpq_1
XFILLER_80_542 VPWR VGND sg13cmos5l_fill_1
X_19453__767 _19453_/RESET_B VPWR VGND sg13cmos5l_tiehi
XFILLER_106_224 VPWR VGND sg13cmos5l_fill_1
XFILLER_10_1028 VPWR VGND sg13cmos5l_fill_1
XFILLER_106_235 VPWR VGND sg13cmos5l_fill_2
XFILLER_106_6 VPWR VGND sg13cmos5l_fill_2
X_10050_ _12723_/A _12350_/A VPWR VGND sg13cmos5l_inv_1
XFILLER_0_546 VPWR VGND sg13cmos5l_decap_8
XFILLER_57_12 VPWR VGND sg13cmos5l_fill_1
Xhold2740 _18176_/A _19709_/Q VPWR VGND sg13cmos5l_dlygate4sd3_1
X_18889__1380 _18889_/RESET_B VPWR VGND sg13cmos5l_tiehi
XFILLER_75_314 VPWR VGND sg13cmos5l_fill_1
Xhold2751 hold2751/X _19095_/Q VPWR VGND sg13cmos5l_dlygate4sd3_1
Xhold2762 _15653_/A _19347_/Q VPWR VGND sg13cmos5l_dlygate4sd3_1
Xhold2773 _14321_/C _14320_/Y VPWR VGND sg13cmos5l_dlygate4sd3_1
Xhold2795 _15104_/A _19263_/Q VPWR VGND sg13cmos5l_dlygate4sd3_1
Xhold2784 _14634_/A _14622_/B VPWR VGND sg13cmos5l_dlygate4sd3_1
X_13740_ _13768_/A _19048_/Q _13765_/B VPWR VGND sg13cmos5l_xnor2_1
X_10952_ _11174_/A _11355_/A _10952_/B VPWR VGND sg13cmos5l_xnor2_1
XFILLER_71_531 VPWR VGND sg13cmos5l_fill_2
XFILLER_71_520 VPWR VGND sg13cmos5l_fill_2
X_13671_ _13678_/B _13714_/A _13671_/B VPWR VGND sg13cmos5l_nor2_1
XFILLER_71_575 VPWR VGND sg13cmos5l_fill_1
XFILLER_71_564 VPWR VGND sg13cmos5l_fill_1
X_10883_ _10895_/B _19777_/Q _19779_/Q _19778_/Q _19780_/Q VPWR VGND sg13cmos5l_nor4_1
X_15410_ _15411_/A _15435_/A _15410_/B VPWR VGND sg13cmos5l_nand2b_1
XFILLER_16_469 VPWR VGND sg13cmos5l_fill_1
X_12622_ _12622_/Y _12658_/A _12657_/A _12616_/Y VPWR VGND sg13cmos5l_o21ai_1
XFILLER_71_597 VPWR VGND sg13cmos5l_decap_4
X_16390_ _16390_/Y _19464_/Q _19463_/Q _19448_/Q VPWR VGND sg13cmos5l_nand3b_1
X_12553_ _12553_/Y _12535_/A _12535_/B _12575_/B _12554_/A VPWR VGND sg13cmos5l_a22oi_1
X_15341_ _15378_/A _15389_/A VPWR VGND sg13cmos5l_inv_1
X_19138__1113 _19138_/RESET_B VPWR VGND sg13cmos5l_tiehi
X_11504_ _11504_/Y _11504_/A _11504_/B VPWR VGND sg13cmos5l_xnor2_1
X_15272_ _15272_/Y _19244_/Q _15272_/B VPWR VGND sg13cmos5l_xnor2_1
X_18060_ _19696_/D _18213_/A _18060_/B VPWR VGND sg13cmos5l_nor2_1
X_12484_ _12484_/Y _12625_/D _13022_/A _12498_/C VPWR VGND sg13cmos5l_nand3_1
X_17011_ _17013_/D _17011_/A _17011_/B _17011_/C _17011_/D VPWR VGND sg13cmos5l_nand4_1
X_18661__1632 _18661_/RESET_B VPWR VGND sg13cmos5l_tiehi
XFILLER_7_156 VPWR VGND sg13cmos5l_decap_4
X_14223_ _14342_/A hold2895/X _14226_/B _14222_/Y VPWR VGND sg13cmos5l_a21oi_1
X_11435_ _11438_/B _18653_/Q _18660_/Q VPWR VGND sg13cmos5l_nor2_1
XFILLER_99_929 VPWR VGND sg13cmos5l_fill_2
X_11366_ _11366_/Y _11533_/B _10305_/Y _11382_/A _18702_/Q VPWR VGND sg13cmos5l_a22oi_1
X_18918__507 _18918_/D VPWR VGND sg13cmos5l_tielo
X_14154_ _14154_/Y _14165_/D _14149_/C _14149_/A VPWR VGND sg13cmos5l_a21oi_1
XFILLER_4_830 VPWR VGND sg13cmos5l_fill_1
X_13105_ _13108_/C _18909_/Q _13104_/C _18910_/Q VPWR VGND sg13cmos5l_o21ai_1
X_18962_ _18962_/Q clkload67/A _18962_/D _18962_/RESET_B VPWR VGND sg13cmos5l_dfrbpq_1
X_11297_ _11362_/B _11473_/A _11295_/B _11295_/Y VPWR VGND sg13cmos5l_a21o_1
X_10317_ _11122_/B _10317_/A VPWR VGND sg13cmos5l_inv_1
XFILLER_4_885 VPWR VGND sg13cmos5l_fill_1
X_14085_ _14085_/Y _19124_/Q _14085_/B VPWR VGND sg13cmos5l_nand2_1
XFILLER_79_631 VPWR VGND sg13cmos5l_fill_2
X_13036_ _13045_/B _13032_/Y _13034_/Y _13035_/Y VPWR VGND sg13cmos5l_o21ai_1
X_17913_ _17913_/Y _17916_/B VPWR VGND sg13cmos5l_inv_1
X_10248_ _14085_/B _14094_/A VPWR VGND sg13cmos5l_inv_1
X_18893_ _18893_/Q clkload67/A _18893_/D _18893_/RESET_B VPWR VGND sg13cmos5l_dfrbpq_1
XFILLER_67_815 VPWR VGND sg13cmos5l_fill_2
XFILLER_39_506 VPWR VGND sg13cmos5l_decap_8
X_10179_ _18221_/A _17847_/A VPWR VGND sg13cmos5l_inv_1
X_17844_ _18038_/A _18227_/A _17844_/B VPWR VGND sg13cmos5l_xnor2_1
X_18911__1355 _18911_/RESET_B VPWR VGND sg13cmos5l_tiehi
X_17775_ _17861_/A _17593_/B _17774_/X _17781_/S VPWR VGND sg13cmos5l_mux2_1
X_14987_ _15021_/A _19202_/Q _14995_/B VPWR VGND sg13cmos5l_xnor2_1
X_16726_ _16726_/Y _16910_/A _16712_/B _16714_/Y _16906_/A _16725_/Y VPWR VGND sg13cmos5l_a221oi_1
X_19514_ _19514_/Q clkload36/A _19514_/D _19514_/RESET_B VPWR VGND sg13cmos5l_dfrbpq_1
X_13938_ _14036_/C _13938_/A _13938_/B _19089_/Q VPWR VGND sg13cmos5l_nand3_1
XFILLER_47_572 VPWR VGND sg13cmos5l_fill_2
X_19445_ _19445_/Q _19738_/CLK _19445_/D _19445_/RESET_B VPWR VGND sg13cmos5l_dfrbpq_1
X_16657_ _16657_/Y _16656_/A _16664_/A _16659_/S VPWR VGND sg13cmos5l_o21ai_1
X_13869_ _13869_/Y _14098_/B _13869_/B VPWR VGND sg13cmos5l_nand2_1
X_16588_ _16588_/Y _16588_/A _19024_/Q _16593_/C VPWR VGND sg13cmos5l_nor3_1
X_19376_ _19376_/Q clkload18/A _19376_/D _19376_/RESET_B VPWR VGND sg13cmos5l_dfrbpq_1
X_15608_ _15609_/B _15608_/A _15608_/B VPWR VGND sg13cmos5l_xor2_1
X_15539_ _15542_/B _15351_/C _15569_/A _15537_/Y _15538_/Y VPWR VGND sg13cmos5l_a22oi_1
X_18327_ _18329_/B _18340_/B _18326_/Y _18325_/Y VPWR VGND sg13cmos5l_a21oi_1
X_18258_ _18258_/Y _18258_/A _19748_/Q _18264_/C VPWR VGND sg13cmos5l_nor3_1
X_17209_ _17209_/Y _17344_/A VPWR VGND sg13cmos5l_inv_1
X_18189_ _18191_/B _18230_/B _18055_/B _18195_/B VPWR VGND sg13cmos5l_mux2_1
Xhold2003 hold2003/X _19110_/Q VPWR VGND sg13cmos5l_dlygate4sd3_1
XFILLER_97_461 VPWR VGND sg13cmos5l_fill_2
XFILLER_97_450 VPWR VGND sg13cmos5l_decap_8
Xhold2036 _10018_/A _18564_/Q VPWR VGND sg13cmos5l_dlygate4sd3_1
Xhold2025 _18598_/D _10862_/Y VPWR VGND sg13cmos5l_dlygate4sd3_1
Xhold2014 _13829_/A _18976_/Q VPWR VGND sg13cmos5l_dlygate4sd3_1
XFILLER_100_945 VPWR VGND sg13cmos5l_fill_2
XFILLER_69_174 VPWR VGND sg13cmos5l_fill_2
Xhold2047 hold2047/X _18649_/Q VPWR VGND sg13cmos5l_dlygate4sd3_1
X_19383__850 _19383_/RESET_B VPWR VGND sg13cmos5l_tiehi
Xhold2069 hold2069/X _19279_/Q VPWR VGND sg13cmos5l_dlygate4sd3_1
Xhold2058 hold2058/X _19193_/Q VPWR VGND sg13cmos5l_dlygate4sd3_1
XFILLER_100_978 VPWR VGND sg13cmos5l_fill_2
XFILLER_69_196 VPWR VGND sg13cmos5l_decap_4
XFILLER_72_328 VPWR VGND sg13cmos5l_fill_2
XFILLER_38_561 VPWR VGND sg13cmos5l_fill_2
XFILLER_38_594 VPWR VGND sg13cmos5l_fill_1
XFILLER_80_372 VPWR VGND sg13cmos5l_fill_1
X_19390__843 _19390_/RESET_B VPWR VGND sg13cmos5l_tiehi
XFILLER_4_115 VPWR VGND sg13cmos5l_fill_1
X_18787__1488 _18787_/RESET_B VPWR VGND sg13cmos5l_tiehi
X_11220_ _11225_/A _18670_/Q _11234_/B VPWR VGND sg13cmos5l_and2_1
X_11151_ _18650_/D _11152_/A _11151_/B VPWR VGND sg13cmos5l_and2_1
X_10102_ _15183_/A _10102_/A VPWR VGND sg13cmos5l_inv_1
XFILLER_89_962 VPWR VGND sg13cmos5l_fill_1
XFILLER_88_450 VPWR VGND sg13cmos5l_fill_1
XFILLER_68_77 VPWR VGND sg13cmos5l_fill_1
X_11082_ _18629_/D _18509_/A _11085_/B VPWR VGND sg13cmos5l_nor2_1
X_10033_ _12194_/A _10033_/A VPWR VGND sg13cmos5l_inv_1
XFILLER_76_623 VPWR VGND sg13cmos5l_fill_1
XFILLER_0_365 VPWR VGND sg13cmos5l_decap_8
X_15890_ _15891_/B _15890_/A _15982_/B VPWR VGND sg13cmos5l_and2_1
X_14910_ _19220_/D _14910_/A _14915_/A VPWR VGND sg13cmos5l_nor2_1
X_19761__785 _19761_/RESET_B VPWR VGND sg13cmos5l_tiehi
Xhold2592 _10059_/A _12751_/A VPWR VGND sg13cmos5l_dlygate4sd3_1
Xhold2570 _13240_/B _13239_/X VPWR VGND sg13cmos5l_dlygate4sd3_1
Xhold2581 _17806_/A _19666_/Q VPWR VGND sg13cmos5l_dlygate4sd3_1
X_14841_ _14841_/Y _14750_/B _14835_/A _14840_/X VPWR VGND sg13cmos5l_o21ai_1
XFILLER_95_1000 VPWR VGND sg13cmos5l_fill_2
X_17560_ _17560_/Y _17549_/Y _17550_/Y _17759_/A _17607_/A _17552_/Y VPWR VGND sg13cmos5l_a221oi_1
Xhold1880 _14977_/B _19197_/Q VPWR VGND sg13cmos5l_dlygate4sd3_1
XFILLER_29_561 VPWR VGND sg13cmos5l_fill_2
X_11984_ _11984_/Y _11984_/A _11985_/B VPWR VGND sg13cmos5l_nor2b_1
XFILLER_95_1022 VPWR VGND sg13cmos5l_decap_8
X_18679__1614 _18679_/RESET_B VPWR VGND sg13cmos5l_tiehi
XFILLER_1_1026 VPWR VGND sg13cmos5l_fill_2
X_14772_ _14784_/A _14772_/A _14870_/A VPWR VGND sg13cmos5l_nand2_1
Xhold1891 _19445_/D _16373_/Y VPWR VGND sg13cmos5l_dlygate4sd3_1
X_16511_ _16511_/Y _16505_/Y _16507_/X _16510_/X VPWR VGND sg13cmos5l_o21ai_1
XFILLER_29_594 VPWR VGND sg13cmos5l_fill_2
X_13723_ _13723_/Y _13651_/A _13817_/B _13780_/A _13652_/A VPWR VGND sg13cmos5l_a22oi_1
X_17491_ _17492_/B _17470_/Y _17472_/Y _17490_/Y VPWR VGND sg13cmos5l_o21ai_1
XFILLER_56_1006 VPWR VGND sg13cmos5l_fill_2
X_10935_ _10977_/A _18633_/Q _18634_/Q _18635_/Q VPWR VGND sg13cmos5l_or3_1
X_13654_ _13666_/B _19053_/Q _19054_/Q _19055_/Q VPWR VGND sg13cmos5l_or3_1
XFILLER_72_895 VPWR VGND sg13cmos5l_fill_1
X_10866_ _18600_/D _11085_/B _10866_/B VPWR VGND sg13cmos5l_nor2_1
X_16442_ _16457_/D _19415_/Q _16443_/B VPWR VGND sg13cmos5l_xnor2_1
X_19230_ _19230_/Q clkload44/A _19230_/D _19230_/RESET_B VPWR VGND sg13cmos5l_dfrbpq_1
X_12605_ _12606_/B _12605_/A _12605_/B VPWR VGND sg13cmos5l_xnor2_1
X_19161_ _19161_/Q _19227_/CLK _19161_/D _19161_/RESET_B VPWR VGND sg13cmos5l_dfrbpq_1
XFILLER_13_962 VPWR VGND sg13cmos5l_decap_4
X_16373_ _16373_/Y _09981_/Y fanout83/X _16372_/Y VPWR VGND sg13cmos5l_a21oi_1
X_10797_ _10797_/Y _13649_/B _10798_/B VPWR VGND sg13cmos5l_nor2_1
X_13585_ _19015_/D _13585_/A _13585_/B VPWR VGND sg13cmos5l_nor2_1
X_15324_ _15324_/Y _15426_/B _15426_/C _15426_/A VPWR VGND sg13cmos5l_a21oi_1
X_18112_ _18112_/X _18120_/B _18117_/B _18309_/A VPWR VGND sg13cmos5l_a21o_1
X_12536_ _12575_/A _18825_/Q _12537_/B VPWR VGND sg13cmos5l_xnor2_1
X_19092_ _19092_/Q _19092_/CLK _19092_/D _19092_/RESET_B VPWR VGND sg13cmos5l_dfrbpq_1
X_19651__554 _19651_/RESET_B VPWR VGND sg13cmos5l_tiehi
XFILLER_8_432 VPWR VGND sg13cmos5l_fill_2
X_12467_ _18847_/D _12467_/A _12467_/B VPWR VGND sg13cmos5l_nor2_1
X_15255_ _19280_/D _15528_/A _15255_/B VPWR VGND sg13cmos5l_and2_1
X_18043_ _18044_/B _18043_/A _18043_/B VPWR VGND sg13cmos5l_and2_1
X_18929__1337 _18929_/RESET_B VPWR VGND sg13cmos5l_tiehi
X_11418_ _11418_/Y _18648_/Q fanout76/X _11423_/A VPWR VGND sg13cmos5l_o21ai_1
X_15186_ _19260_/D _15186_/A _15188_/B VPWR VGND sg13cmos5l_nor2_1
X_14206_ _19120_/D _14374_/A _14315_/A VPWR VGND sg13cmos5l_and2_1
X_12398_ _12434_/B _18841_/Q _12398_/B VPWR VGND sg13cmos5l_and2_1
X_18625__1671 _18625_/RESET_B VPWR VGND sg13cmos5l_tiehi
X_14137_ _14137_/Y hold1964/X fanout91/X _14436_/A VPWR VGND sg13cmos5l_o21ai_1
X_11349_ _18665_/D _11336_/B _11337_/Y _11348_/Y VPWR VGND sg13cmos5l_a21oi_1
X_18945_ _18945_/Q _19087_/CLK _18945_/D _18945_/RESET_B VPWR VGND sg13cmos5l_dfrbpq_1
X_14068_ _14068_/Y _14056_/A _14057_/Y _13925_/A VPWR VGND sg13cmos5l_o21ai_1
XFILLER_3_192 VPWR VGND sg13cmos5l_fill_1
X_18876_ _18876_/Q _18931_/CLK _18876_/D _18876_/RESET_B VPWR VGND sg13cmos5l_dfrbpq_1
X_13019_ _18923_/D _13019_/A _13019_/B VPWR VGND sg13cmos5l_and2_1
XFILLER_67_623 VPWR VGND sg13cmos5l_fill_1
X_17827_ _18012_/A _17831_/A _19660_/Q VPWR VGND sg13cmos5l_xnor2_1
XFILLER_95_987 VPWR VGND sg13cmos5l_decap_4
XFILLER_94_464 VPWR VGND sg13cmos5l_fill_2
XFILLER_67_689 VPWR VGND sg13cmos5l_fill_2
X_17758_ _17758_/X _19614_/Q _17758_/B VPWR VGND sg13cmos5l_xor2_1
X_16709_ _16829_/B _16707_/A _16708_/X _16941_/A VPWR VGND sg13cmos5l_a21o_1
X_17689_ _17690_/B _18227_/A _19602_/Q VPWR VGND sg13cmos5l_nand2_1
Xfanout29 fanout29/X _16868_/Y VPWR VGND sg13cmos5l_buf_1
X_19428_ _19428_/Q clkload8/A _19428_/D _19428_/RESET_B VPWR VGND sg13cmos5l_dfrbpq_1
XFILLER_22_258 VPWR VGND sg13cmos5l_fill_1
X_19359_ _19359_/Q _19462_/CLK _19359_/D _19359_/RESET_B VPWR VGND sg13cmos5l_dfrbpq_1
X_18742__1536 _18742_/RESET_B VPWR VGND sg13cmos5l_tiehi
XFILLER_30_280 VPWR VGND sg13cmos5l_fill_2
XFILLER_104_514 VPWR VGND sg13cmos5l_fill_1
XFILLER_79_1028 VPWR VGND sg13cmos5l_fill_1
X_10720_ _10720_/Y _10734_/A hold2510/X VPWR VGND sg13cmos5l_nor2b_1
X_19178__1070 _19178_/RESET_B VPWR VGND sg13cmos5l_tiehi
XFILLER_16_1001 VPWR VGND sg13cmos5l_fill_1
X_10651_ _10673_/C _19808_/Q _10652_/B VPWR VGND sg13cmos5l_nor2_1
XFILLER_9_218 VPWR VGND sg13cmos5l_fill_1
X_13370_ _13370_/Y _13381_/D _13365_/C _13365_/A VPWR VGND sg13cmos5l_a21oi_1
XFILLER_6_903 VPWR VGND sg13cmos5l_decap_4
X_10582_ _18546_/A _10582_/A _10582_/B VPWR VGND sg13cmos5l_nand2_1
X_12321_ _12546_/A _18830_/Q _18829_/Q VPWR VGND sg13cmos5l_xnor2_1
XFILLER_6_936 VPWR VGND sg13cmos5l_decap_4
X_12252_ _12252_/Y _12235_/Y hold2300/X _12462_/B VPWR VGND sg13cmos5l_a21oi_1
XFILLER_6_947 VPWR VGND sg13cmos5l_fill_2
X_15040_ _15147_/B _15053_/A _15053_/B VPWR VGND sg13cmos5l_nand2_1
X_11203_ _11205_/B _11203_/A _11203_/B VPWR VGND sg13cmos5l_nor2_1
X_12183_ _18789_/D hold2951/X _12175_/Y _12182_/Y VPWR VGND sg13cmos5l_a21oi_1
X_19234__477 _19234_/D VPWR VGND sg13cmos5l_tielo
XFILLER_96_718 VPWR VGND sg13cmos5l_fill_1
X_16991_ _16992_/B _19534_/Q _16982_/B _19535_/Q VPWR VGND sg13cmos5l_o21ai_1
X_11134_ _18640_/D _11355_/B _11134_/B VPWR VGND sg13cmos5l_nor2_1
XFILLER_89_781 VPWR VGND sg13cmos5l_fill_2
X_18730_ _18730_/Q clkload62/A _18730_/D _18730_/RESET_B VPWR VGND sg13cmos5l_dfrbpq_1
X_11065_ _11065_/Y _11040_/Y _11076_/B _11090_/A VPWR VGND sg13cmos5l_o21ai_1
X_15942_ _15942_/Y _15942_/A _15942_/B VPWR VGND sg13cmos5l_nand2_1
XFILLER_103_591 VPWR VGND sg13cmos5l_decap_4
X_18661_ _18661_/Q clkload58/A _18661_/D _18661_/RESET_B VPWR VGND sg13cmos5l_dfrbpq_1
X_10016_ _10016_/Y _10016_/A VPWR VGND sg13cmos5l_inv_1
XFILLER_23_1027 VPWR VGND sg13cmos5l_fill_2
X_15873_ _15878_/A _19384_/Q _15887_/B VPWR VGND sg13cmos5l_and2_1
X_18592_ _18592_/Q _18594_/CLK _18592_/D _18592_/RESET_B VPWR VGND sg13cmos5l_dfrbpq_1
X_17612_ _17612_/Y _17599_/Y _17605_/X _17611_/Y VPWR VGND sg13cmos5l_o21ai_1
X_14824_ _14843_/S _14817_/Y _14821_/Y _14823_/Y VPWR VGND sg13cmos5l_a21oi_1
XFILLER_91_467 VPWR VGND sg13cmos5l_fill_2
XFILLER_91_456 VPWR VGND sg13cmos5l_fill_2
X_11967_ _18777_/D _12528_/A _11967_/B VPWR VGND sg13cmos5l_and2_1
XFILLER_63_158 VPWR VGND sg13cmos5l_fill_2
X_17543_ _17543_/Y _17562_/D _17542_/B _17592_/A VPWR VGND sg13cmos5l_a21oi_1
X_14755_ _14877_/A _14578_/X _14754_/Y _14755_/S VPWR VGND sg13cmos5l_mux2_1
X_13706_ _13706_/Y _13700_/B _13700_/C _13700_/A VPWR VGND sg13cmos5l_a21oi_1
X_17474_ _17474_/Y _17494_/B _17481_/C VPWR VGND sg13cmos5l_nand2_1
X_10918_ _10918_/Y _10918_/A _10928_/B VPWR VGND sg13cmos5l_nor2_1
XFILLER_32_501 VPWR VGND sg13cmos5l_fill_2
X_11898_ _18757_/D _11898_/A _11899_/B VPWR VGND sg13cmos5l_nor2_1
X_16425_ _16425_/Y _19409_/Q _19410_/Q VPWR VGND sg13cmos5l_xnor2_1
X_19200__1045 _19200_/RESET_B VPWR VGND sg13cmos5l_tiehi
X_14686_ _14687_/B _19191_/Q _14683_/Y _14932_/B VPWR VGND sg13cmos5l_o21ai_1
X_19213_ _19213_/Q _19302_/CLK _19213_/D _19213_/RESET_B VPWR VGND sg13cmos5l_dfrbpq_1
X_13637_ _19023_/D _13619_/Y hold2377/X _13801_/A VPWR VGND sg13cmos5l_a21oi_1
X_10849_ _10849_/Y _19770_/Q _10849_/B VPWR VGND sg13cmos5l_nor2_1
X_13568_ _18999_/D hold2956/X _13571_/S _13567_/Y VPWR VGND sg13cmos5l_a21oi_1
X_16356_ _16357_/C _16370_/A _16356_/B VPWR VGND sg13cmos5l_nor2_1
X_19144_ _19144_/Q clkload42/A _19144_/D _19144_/RESET_B VPWR VGND sg13cmos5l_dfrbpq_1
X_12519_ _12519_/Y _12754_/B _12519_/B VPWR VGND sg13cmos5l_nand2_1
X_19075_ _19075_/Q clkload54/A _19075_/D _19075_/RESET_B VPWR VGND sg13cmos5l_dfrbpq_1
X_15307_ _19288_/D _15465_/A _15403_/A VPWR VGND sg13cmos5l_and2_1
X_19373__860 _19373_/RESET_B VPWR VGND sg13cmos5l_tiehi
X_16287_ _16288_/B _16287_/A _16287_/B VPWR VGND sg13cmos5l_or2_1
X_13499_ _13499_/Y _13582_/B VPWR VGND sg13cmos5l_inv_1
X_15238_ _15240_/A _15238_/A _15238_/B VPWR VGND sg13cmos5l_nor2_1
X_18026_ _18033_/B _19656_/Q _19655_/Q _19654_/Q _18026_/D VPWR VGND sg13cmos5l_nor4_1
X_15169_ _15169_/Y _15144_/Y _15173_/S _15194_/A VPWR VGND sg13cmos5l_o21ai_1
Xfanout219 _17377_/A _17137_/A VPWR VGND sg13cmos5l_buf_1
Xfanout208 _17942_/A _17937_/B VPWR VGND sg13cmos5l_buf_1
Xclkbuf_4_7_0_clk clkload1/A clkbuf_0_clk/X VPWR VGND sg13cmos5l_buf_8
X_18928_ _18928_/Q _18931_/CLK _18928_/D _18928_/RESET_B VPWR VGND sg13cmos5l_dfrbpq_1
XFILLER_83_902 VPWR VGND sg13cmos5l_fill_1
XFILLER_68_954 VPWR VGND sg13cmos5l_fill_1
X_18859_ _18859_/Q clkload68/A _18859_/D _18859_/RESET_B VPWR VGND sg13cmos5l_dfrbpq_1
X_19380__853 _19380_/RESET_B VPWR VGND sg13cmos5l_tiehi
X_18960__1303 _18960_/RESET_B VPWR VGND sg13cmos5l_tiehi
XFILLER_35_372 VPWR VGND sg13cmos5l_fill_1
X_19296__471 _19296_/D VPWR VGND sg13cmos5l_tielo
XFILLER_40_59 VPWR VGND sg13cmos5l_fill_1
XFILLER_2_416 VPWR VGND sg13cmos5l_decap_4
XFILLER_49_35 VPWR VGND sg13cmos5l_fill_2
XFILLER_86_762 VPWR VGND sg13cmos5l_fill_1
XFILLER_58_475 VPWR VGND sg13cmos5l_fill_1
Xheichips26_digital_project_1797 uio_oe[0] VPWR VGND sg13cmos5l_tiehi
X_19076__1178 _19076_/RESET_B VPWR VGND sg13cmos5l_tiehi
X_12870_ _12984_/C _12869_/A _12869_/B _12882_/A VPWR VGND sg13cmos5l_o21ai_1
X_11821_ _11821_/Y _11975_/A _11997_/A VPWR VGND sg13cmos5l_nand2_1
XFILLER_61_629 VPWR VGND sg13cmos5l_fill_1
XFILLER_54_692 VPWR VGND sg13cmos5l_fill_2
XFILLER_54_681 VPWR VGND sg13cmos5l_decap_8
X_14540_ _14542_/B _19164_/Q _19179_/Q _14540_/C VPWR VGND sg13cmos5l_nand3_1
X_11752_ _11865_/A _18756_/Q _11766_/B VPWR VGND sg13cmos5l_xnor2_1
XFILLER_53_1009 VPWR VGND sg13cmos5l_fill_1
XFILLER_42_843 VPWR VGND sg13cmos5l_fill_2
XFILLER_14_534 VPWR VGND sg13cmos5l_fill_2
X_11683_ _18729_/D _11665_/Y hold2405/X _11673_/A VPWR VGND sg13cmos5l_a21oi_1
X_10703_ _10703_/Y _13813_/A _13808_/A VPWR VGND sg13cmos5l_nand2b_1
XFILLER_42_876 VPWR VGND sg13cmos5l_fill_2
XFILLER_41_364 VPWR VGND sg13cmos5l_fill_2
X_14471_ _14599_/A _14278_/A _14470_/Y _14487_/S VPWR VGND sg13cmos5l_mux2_1
X_17190_ _17192_/B _17290_/A _17290_/B VPWR VGND sg13cmos5l_nand2_1
X_13422_ _13424_/B _13421_/A _13421_/B _13420_/Y VPWR VGND sg13cmos5l_o21ai_1
X_10634_ _19789_/D _10642_/B _10634_/B _10634_/C VPWR VGND sg13cmos5l_nor3_1
X_16210_ _16248_/B _19422_/Q _16211_/B VPWR VGND sg13cmos5l_xnor2_1
X_18969__1294 _18969_/RESET_B VPWR VGND sg13cmos5l_tiehi
X_13353_ _13353_/Y hold2029/X fanout97/X _14070_/A VPWR VGND sg13cmos5l_o21ai_1
X_16141_ _16141_/Y _16141_/A _16141_/B VPWR VGND sg13cmos5l_nor2_1
X_12304_ _12305_/B _12122_/Y _12299_/B _12288_/Y _12303_/Y VPWR VGND sg13cmos5l_a22oi_1
X_10565_ _10565_/Y _10565_/A _10590_/B VPWR VGND sg13cmos5l_nor2_1
X_13284_ _18961_/D _13284_/A _13284_/B VPWR VGND sg13cmos5l_and2_1
XFILLER_5_232 VPWR VGND sg13cmos5l_fill_2
X_16072_ _16072_/Y _16349_/B _16063_/S _16071_/Y VPWR VGND sg13cmos5l_a21oi_1
X_10496_ _10510_/B _19735_/Q _10496_/B VPWR VGND sg13cmos5l_xnor2_1
X_12235_ _12235_/Y _18833_/Q _12729_/A _12210_/B _18771_/Q VPWR VGND sg13cmos5l_a22oi_1
XFILLER_5_298 VPWR VGND sg13cmos5l_fill_1
XFILLER_5_276 VPWR VGND sg13cmos5l_fill_2
X_15023_ _19244_/D _15194_/A _15132_/A VPWR VGND sg13cmos5l_and2_1
X_12166_ _12167_/B _12135_/Y _12141_/Y _12140_/A VPWR VGND sg13cmos5l_a21oi_1
XFILLER_46_8 VPWR VGND sg13cmos5l_fill_2
X_11117_ _11117_/Y _11622_/A _18666_/Q _11123_/C VPWR VGND sg13cmos5l_nor3_1
X_12097_ _12097_/Y _12097_/A _12097_/B VPWR VGND sg13cmos5l_nor2_1
X_16974_ _16974_/Y _17179_/A _16974_/B VPWR VGND sg13cmos5l_nor2_1
X_19218__1027 _19218_/RESET_B VPWR VGND sg13cmos5l_tiehi
X_19762_ _19762_/Q clkload23/A _19762_/D _19762_/RESET_B VPWR VGND sg13cmos5l_dfrbpq_1
Xinput8 input8/X ui_in[6] VPWR VGND sg13cmos5l_buf_1
X_18713_ _18713_/Q clkload56/A _18713_/D _18713_/RESET_B VPWR VGND sg13cmos5l_dfrbpq_1
X_11048_ _11048_/Y _11030_/A _11030_/B _11041_/Y _11046_/Y _11047_/Y VPWR VGND sg13cmos5l_a221oi_1
X_15925_ _15925_/Y _15924_/A _15921_/A _16116_/A VPWR VGND sg13cmos5l_o21ai_1
X_19693_ _19693_/Q clkload14/A _19693_/D _19693_/RESET_B VPWR VGND sg13cmos5l_dfrbpq_1
X_18644_ _18644_/Q clkload38/A _18644_/D _18644_/RESET_B VPWR VGND sg13cmos5l_dfrbpq_1
X_15856_ _15856_/Y _15856_/A _15856_/B VPWR VGND sg13cmos5l_nor2_1
X_14807_ _14807_/Y _19207_/Q _14804_/Y _14828_/A _14803_/Y VPWR VGND sg13cmos5l_a22oi_1
XFILLER_36_136 VPWR VGND sg13cmos5l_fill_1
XFILLER_36_169 VPWR VGND sg13cmos5l_decap_4
X_18575_ _18575_/Q clkload33/A _18575_/D _18575_/RESET_B VPWR VGND sg13cmos5l_dfrbpq_1
X_12999_ _13001_/A _13007_/A _12999_/B VPWR VGND sg13cmos5l_nand2b_1
X_15787_ _15798_/S _15787_/A _15787_/B VPWR VGND sg13cmos5l_nor2_1
X_17526_ _17527_/C _17526_/A _17526_/B VPWR VGND sg13cmos5l_or2_1
X_14738_ _14743_/B _14735_/A _14735_/B _14737_/Y VPWR VGND sg13cmos5l_a21oi_1
XFILLER_32_331 VPWR VGND sg13cmos5l_decap_8
X_18782__1493 _18782_/RESET_B VPWR VGND sg13cmos5l_tiehi
X_17457_ _17495_/A _19571_/Q _17457_/B VPWR VGND sg13cmos5l_xnor2_1
X_14669_ _14669_/Y _19212_/Q _19206_/Q VPWR VGND sg13cmos5l_nor2b_1
X_17388_ _17388_/Y _19556_/Q _17397_/B VPWR VGND sg13cmos5l_nand2_1
X_16408_ _16408_/Y _16401_/A _16467_/A _16406_/Y _16411_/B _16414_/B VPWR VGND sg13cmos5l_a221oi_1
X_16339_ _16339_/X _16339_/A _16339_/B VPWR VGND sg13cmos5l_and2_1
X_19127_ _19127_/Q _19136_/CLK _19127_/D _19127_/RESET_B VPWR VGND sg13cmos5l_dfrbpq_1
XFILLER_9_593 VPWR VGND sg13cmos5l_decap_8
X_19058_ _19058_/Q clkload30/A _19058_/D _19058_/RESET_B VPWR VGND sg13cmos5l_dfrbpq_1
Xheichips26_digital_project_414 uio_out[14] VPWR VGND sg13cmos5l_tielo
X_18009_ _18009_/Y _18022_/A _18057_/A VPWR VGND sg13cmos5l_nor2_1
XFILLER_0_909 VPWR VGND sg13cmos5l_decap_4
X_19031__1226 _19031_/RESET_B VPWR VGND sg13cmos5l_tiehi
XFILLER_68_795 VPWR VGND sg13cmos5l_fill_2
XFILLER_70_404 VPWR VGND sg13cmos5l_fill_1
XFILLER_43_629 VPWR VGND sg13cmos5l_decap_4
X_18924__1342 _18924_/RESET_B VPWR VGND sg13cmos5l_tiehi
X_10350_ _17696_/A _10350_/A VPWR VGND sg13cmos5l_inv_1
X_10281_ _10281_/Y _12483_/A VPWR VGND sg13cmos5l_inv_1
XFILLER_3_736 VPWR VGND sg13cmos5l_fill_2
X_12020_ _12021_/B _12020_/A _12020_/B VPWR VGND sg13cmos5l_and2_1
XFILLER_47_913 VPWR VGND sg13cmos5l_fill_2
X_13971_ _13971_/Y _13956_/X _14149_/A _13966_/X _13970_/Y VPWR VGND sg13cmos5l_a22oi_1
X_16690_ _16762_/B _19503_/Q _16785_/B VPWR VGND sg13cmos5l_and2_1
XFILLER_100_380 VPWR VGND sg13cmos5l_decap_8
X_12922_ _12933_/A _12907_/Y _12914_/Y _12920_/Y VPWR VGND sg13cmos5l_a21o_1
X_15710_ _15710_/Y _15747_/B _15710_/B VPWR VGND sg13cmos5l_nand2_1
XFILLER_62_905 VPWR VGND sg13cmos5l_fill_2
X_15641_ _15641_/Y _15631_/X _15821_/A _15642_/A _15671_/A VPWR VGND sg13cmos5l_a22oi_1
X_12853_ _18909_/D _13025_/A _12853_/B VPWR VGND sg13cmos5l_nor2_1
XFILLER_62_938 VPWR VGND sg13cmos5l_fill_2
XFILLER_62_927 VPWR VGND sg13cmos5l_fill_2
X_11804_ _11804_/Y _11796_/A _11989_/A _11800_/Y _11802_/Y VPWR VGND sg13cmos5l_a22oi_1
X_12784_ _12784_/Y _13050_/A fanout50/X _12783_/Y VPWR VGND sg13cmos5l_a21oi_1
X_18360_ _18444_/A _18443_/B _18443_/C _18443_/A VPWR VGND sg13cmos5l_a21oi_1
X_15572_ _15695_/A _15572_/A _15572_/B VPWR VGND sg13cmos5l_and2_1
X_11735_ _18739_/D _11905_/A _11735_/B VPWR VGND sg13cmos5l_nor2_1
X_17311_ _17311_/Y _17313_/S _17310_/Y VPWR VGND sg13cmos5l_nor2b_1
X_18291_ _19731_/D _09967_/Y fanout67/X _18290_/Y VPWR VGND sg13cmos5l_a21oi_1
X_14523_ _14548_/B _19182_/Q _19183_/Q _14537_/A VPWR VGND sg13cmos5l_nor3_1
X_17242_ _17259_/A _19592_/Q _17267_/D VPWR VGND sg13cmos5l_xnor2_1
X_14454_ _14456_/B _14297_/B _14482_/A _14486_/A _14303_/B VPWR VGND sg13cmos5l_a22oi_1
X_11666_ _11666_/Y _11937_/B _11666_/B VPWR VGND sg13cmos5l_nor2_1
X_13405_ _13405_/Y _13406_/B VPWR VGND sg13cmos5l_inv_1
X_17173_ _17173_/Y _16974_/B _17174_/B _17173_/C VPWR VGND sg13cmos5l_nand3b_1
X_11597_ _11614_/A _11630_/B _11476_/Y _11597_/S VPWR VGND sg13cmos5l_mux2_1
X_14385_ _14385_/Y _19170_/Q _14392_/B _14384_/Y VPWR VGND sg13cmos5l_a21oi_1
X_10617_ _10624_/B _10586_/Y _10616_/B _10616_/Y VPWR VGND sg13cmos5l_o21ai_1
X_13336_ _13347_/S _13336_/A _13336_/B VPWR VGND sg13cmos5l_nor2_1
XFILLER_6_530 VPWR VGND sg13cmos5l_fill_1
X_16124_ _16124_/Y _16136_/B _16124_/B VPWR VGND sg13cmos5l_nand2b_1
X_10548_ _10548_/Y _10904_/A _10547_/X _10544_/Y VPWR VGND sg13cmos5l_o21ai_1
X_13267_ _13267_/Y _13267_/A _13267_/B VPWR VGND sg13cmos5l_nor2_1
X_19370__863 _19370_/RESET_B VPWR VGND sg13cmos5l_tiehi
X_16055_ _16055_/Y _16344_/A _16049_/Y _16057_/B _16349_/B VPWR VGND sg13cmos5l_a22oi_1
X_12218_ _12218_/Y _12218_/A VPWR VGND sg13cmos5l_inv_1
X_15006_ _15006_/Y _15006_/A _15011_/B VPWR VGND sg13cmos5l_nor2_1
X_10479_ _10590_/A _10479_/A _10479_/B VPWR VGND sg13cmos5l_xnor2_1
X_13198_ _13420_/A _13384_/A _13202_/B VPWR VGND sg13cmos5l_nand2_1
XFILLER_37_4 VPWR VGND sg13cmos5l_decap_4
X_12149_ _12157_/A _12149_/A VPWR VGND sg13cmos5l_inv_1
X_19814_ _19814_/Q _19814_/CLK _19814_/D _19814_/RESET_B VPWR VGND sg13cmos5l_dfrbpq_1
X_16957_ _16957_/Y _17051_/B _17051_/C _17051_/A VPWR VGND sg13cmos5l_a21oi_1
X_19745_ _19745_/Q clkload22/A _19745_/D _19745_/RESET_B VPWR VGND sg13cmos5l_dfrbpq_1
X_15908_ _15915_/A _15897_/X _15901_/Y _15909_/A _16100_/A _15902_/X VPWR VGND sg13cmos5l_a221oi_1
X_16888_ _16888_/Y _09976_/Y fanout87/X _16887_/Y VPWR VGND sg13cmos5l_a21oi_1
XFILLER_80_702 VPWR VGND sg13cmos5l_fill_1
X_19247__476 _19247_/D VPWR VGND sg13cmos5l_tielo
X_19676_ _19676_/Q clkload11/A _19676_/D _19676_/RESET_B VPWR VGND sg13cmos5l_dfrbpq_1
XFILLER_65_798 VPWR VGND sg13cmos5l_fill_1
X_18627_ _18627_/Q _19790_/CLK _18627_/D _18627_/RESET_B VPWR VGND sg13cmos5l_dfrbpq_1
XFILLER_37_489 VPWR VGND sg13cmos5l_fill_2
X_15839_ _15844_/A _15617_/Y _15846_/B VPWR VGND sg13cmos5l_nand2b_1
X_18558_ _18594_/D _18558_/A _18558_/B VPWR VGND sg13cmos5l_nor2_1
X_18705__1585 _18705_/RESET_B VPWR VGND sg13cmos5l_tiehi
XFILLER_24_139 VPWR VGND sg13cmos5l_fill_1
X_17509_ _17529_/A _19627_/Q _17522_/B VPWR VGND sg13cmos5l_or2_1
XFILLER_21_813 VPWR VGND sg13cmos5l_fill_1
X_19049__1208 _19049_/RESET_B VPWR VGND sg13cmos5l_tiehi
X_18489_ _18489_/Y _18509_/A _19725_/Q _19726_/Q _18514_/B _18488_/Y VPWR VGND sg13cmos5l_a221oi_1
XFILLER_106_406 VPWR VGND sg13cmos5l_fill_1
XFILLER_102_612 VPWR VGND sg13cmos5l_fill_2
XFILLER_99_183 VPWR VGND sg13cmos5l_fill_1
Xhold2922 _13141_/B _13207_/A VPWR VGND sg13cmos5l_dlygate4sd3_1
Xhold2900 _13951_/A _19091_/Q VPWR VGND sg13cmos5l_dlygate4sd3_1
Xhold2911 _16281_/C _16280_/Y VPWR VGND sg13cmos5l_dlygate4sd3_1
XFILLER_101_133 VPWR VGND sg13cmos5l_fill_2
Xhold2955 _13432_/A _19010_/Q VPWR VGND sg13cmos5l_dlygate4sd3_1
Xhold2966 hold2966/X _19094_/Q VPWR VGND sg13cmos5l_dlygate4sd3_1
Xhold2944 _14083_/B _14049_/B VPWR VGND sg13cmos5l_dlygate4sd3_1
Xhold2933 hold2933/X _15719_/A VPWR VGND sg13cmos5l_dlygate4sd3_1
Xhold2977 _11588_/A _18713_/Q VPWR VGND sg13cmos5l_dlygate4sd3_1
XFILLER_68_570 VPWR VGND sg13cmos5l_fill_1
Xhold2999 _11257_/B _18676_/Q VPWR VGND sg13cmos5l_dlygate4sd3_1
Xhold2988 _15842_/A _19325_/Q VPWR VGND sg13cmos5l_dlygate4sd3_1
XFILLER_83_551 VPWR VGND sg13cmos5l_decap_4
XFILLER_55_253 VPWR VGND sg13cmos5l_fill_2
XFILLER_102_64 VPWR VGND sg13cmos5l_fill_1
XFILLER_43_448 VPWR VGND sg13cmos5l_fill_1
XFILLER_102_86 VPWR VGND sg13cmos5l_fill_2
XFILLER_102_75 VPWR VGND sg13cmos5l_fill_2
X_11520_ _11522_/B _11548_/B _11713_/A VPWR VGND sg13cmos5l_nor2_1
XFILLER_11_312 VPWR VGND sg13cmos5l_fill_1
X_11451_ _11451_/Y _11446_/X _11450_/Y _11281_/Y VPWR VGND sg13cmos5l_a21oi_1
XFILLER_7_316 VPWR VGND sg13cmos5l_fill_2
X_11382_ _11382_/Y _11382_/A _18646_/Q VPWR VGND sg13cmos5l_nor2_1
X_10402_ _10402_/Y _10402_/A _10680_/A VPWR VGND sg13cmos5l_nor2b_1
X_14170_ _14185_/B _19079_/Q _14171_/B VPWR VGND sg13cmos5l_xnor2_1
X_13121_ _13124_/A _13121_/A _13130_/B VPWR VGND sg13cmos5l_nand2_1
X_10333_ _18513_/B _10333_/A VPWR VGND sg13cmos5l_inv_1
X_18755__1523 _18755_/RESET_B VPWR VGND sg13cmos5l_tiehi
X_13052_ _13053_/B _13056_/C _13051_/Y _13050_/Y VPWR VGND sg13cmos5l_a21o_1
X_10264_ _13328_/A _18940_/Q VPWR VGND sg13cmos5l_inv_1
X_12003_ _12004_/B _12109_/A _12109_/B VPWR VGND sg13cmos5l_and2_1
XFILLER_87_65 VPWR VGND sg13cmos5l_fill_1
X_17860_ _17940_/B _17861_/B VPWR VGND sg13cmos5l_inv_1
X_10195_ _10195_/Y _14708_/A VPWR VGND sg13cmos5l_inv_1
X_16811_ _16813_/B _16811_/A _16809_/S VPWR VGND sg13cmos5l_nor2b_1
XFILLER_87_87 VPWR VGND sg13cmos5l_fill_1
X_19530_ _19530_/Q clkload40/A _19530_/D _19530_/RESET_B VPWR VGND sg13cmos5l_dfrbpq_1
Xfanout391 _10860_/B _13807_/A VPWR VGND sg13cmos5l_buf_1
Xfanout380 _15735_/A fanout403/X VPWR VGND sg13cmos5l_buf_1
X_17791_ _17902_/B _17808_/A _17803_/B VPWR VGND sg13cmos5l_nand2_1
X_16742_ _16742_/Y _16742_/A _16742_/B _16753_/A VPWR VGND sg13cmos5l_nand3_1
X_13954_ _13967_/B _19095_/Q _19096_/Q _19097_/Q VPWR VGND sg13cmos5l_or3_1
X_16673_ _16673_/Y _19477_/Q _19028_/Q VPWR VGND sg13cmos5l_xnor2_1
X_12905_ _12905_/Y _13289_/A _12905_/B VPWR VGND sg13cmos5l_xnor2_1
X_13885_ _13885_/Y _13902_/A _13902_/B VPWR VGND sg13cmos5l_nand2_1
X_19461_ _19461_/Q _19462_/CLK _19461_/D _19461_/RESET_B VPWR VGND sg13cmos5l_dfrbpq_1
XFILLER_34_415 VPWR VGND sg13cmos5l_fill_2
X_12836_ _12836_/Y _12837_/B VPWR VGND sg13cmos5l_inv_1
XFILLER_74_595 VPWR VGND sg13cmos5l_fill_2
XFILLER_46_297 VPWR VGND sg13cmos5l_fill_1
X_15624_ _15624_/Y _15647_/A _15834_/A VPWR VGND sg13cmos5l_nand2_1
X_19392_ _19392_/Q clkload18/A _19392_/D _19392_/RESET_B VPWR VGND sg13cmos5l_dfrbpq_1
X_18412_ _18412_/Y _18333_/X _18480_/B _18481_/B _18338_/X VPWR VGND sg13cmos5l_a22oi_1
X_15555_ _15555_/X _15556_/A _15556_/B _15553_/Y VPWR VGND sg13cmos5l_a21o_1
X_18343_ _19739_/D _18480_/A _18418_/A VPWR VGND sg13cmos5l_nor2_1
X_12767_ _12767_/Y _13289_/A _18918_/Q _12767_/C VPWR VGND sg13cmos5l_nor3_1
X_14506_ _14519_/A _14506_/A _14506_/B VPWR VGND sg13cmos5l_nor2_1
X_12698_ _12706_/B _12577_/B _12697_/B _12697_/Y VPWR VGND sg13cmos5l_o21ai_1
X_11718_ _11736_/B _11707_/Y _11712_/Y _11716_/Y VPWR VGND sg13cmos5l_a21o_1
X_18274_ _18274_/X _18254_/Y _10329_/Y _18282_/S VPWR VGND sg13cmos5l_mux2_1
X_15486_ _15486_/Y _15486_/A _19276_/Q VPWR VGND sg13cmos5l_nor2_1
XFILLER_30_654 VPWR VGND sg13cmos5l_fill_1
X_11649_ _11649_/Y _11649_/A VPWR VGND sg13cmos5l_inv_1
X_17225_ _17237_/A _17225_/A _17225_/B VPWR VGND sg13cmos5l_nor2_1
X_14437_ _19155_/D _14978_/A _14437_/B VPWR VGND sg13cmos5l_and2_1
X_17156_ _17187_/A _19525_/Q _19526_/Q VPWR VGND sg13cmos5l_xnor2_1
X_14368_ _19133_/D _14368_/A _14371_/B VPWR VGND sg13cmos5l_nor2_1
X_13319_ _13319_/Y _14077_/A _18996_/Q _13329_/C VPWR VGND sg13cmos5l_nand3_1
X_16107_ _16107_/Y _16107_/A _16141_/A VPWR VGND sg13cmos5l_nor2_1
X_17087_ _19548_/D _17087_/A _17087_/B VPWR VGND sg13cmos5l_nor2_1
X_19071__1183 _19071_/RESET_B VPWR VGND sg13cmos5l_tiehi
X_14299_ _14299_/Y _14291_/A _14291_/B _14298_/Y VPWR VGND sg13cmos5l_a21oi_1
X_16038_ _16038_/Y _16038_/A _16038_/B VPWR VGND sg13cmos5l_nand2_1
Xhold2218 _11642_/A _18684_/Q VPWR VGND sg13cmos5l_dlygate4sd3_1
Xhold2207 _19107_/D _14136_/Y VPWR VGND sg13cmos5l_dlygate4sd3_1
XFILLER_57_518 VPWR VGND sg13cmos5l_fill_1
Xhold2229 _19600_/D _17428_/Y VPWR VGND sg13cmos5l_dlygate4sd3_1
XFILLER_57_529 VPWR VGND sg13cmos5l_fill_1
X_17989_ _17989_/Y _17968_/B _17993_/S _18231_/A VPWR VGND sg13cmos5l_o21ai_1
X_19728_ _19728_/Q _19790_/CLK _19728_/D _19728_/RESET_B VPWR VGND sg13cmos5l_dfrbpq_1
XFILLER_53_702 VPWR VGND sg13cmos5l_fill_1
X_19659_ _19659_/Q clkload12/A _19659_/D _19659_/RESET_B VPWR VGND sg13cmos5l_dfrbpq_1
XFILLER_80_598 VPWR VGND sg13cmos5l_fill_1
XFILLER_21_643 VPWR VGND sg13cmos5l_fill_2
X_19213__1032 _19213_/RESET_B VPWR VGND sg13cmos5l_tiehi
Xhold2730 _10448_/A _19798_/Q VPWR VGND sg13cmos5l_dlygate4sd3_1
Xhold2741 hold2741/X _19757_/Q VPWR VGND sg13cmos5l_dlygate4sd3_1
XFILLER_57_46 VPWR VGND sg13cmos5l_fill_1
Xhold2763 _11010_/A _18629_/Q VPWR VGND sg13cmos5l_dlygate4sd3_1
Xhold2752 _15034_/A _19262_/Q VPWR VGND sg13cmos5l_dlygate4sd3_1
Xhold2774 hold2774/X _14323_/A VPWR VGND sg13cmos5l_dlygate4sd3_1
Xhold2785 _11848_/A _18753_/Q VPWR VGND sg13cmos5l_dlygate4sd3_1
Xhold2796 _15872_/A _19385_/Q VPWR VGND sg13cmos5l_dlygate4sd3_1
XFILLER_56_551 VPWR VGND sg13cmos5l_fill_2
X_10951_ _10958_/B _18621_/Q _18622_/Q _18620_/Q _18619_/Q VPWR VGND sg13cmos5l_nor4_1
XFILLER_28_242 VPWR VGND sg13cmos5l_fill_1
X_13670_ _13678_/A _13659_/X _13663_/Y _13714_/A _13671_/B _13664_/X VPWR VGND sg13cmos5l_a221oi_1
XFILLER_44_735 VPWR VGND sg13cmos5l_fill_2
XFILLER_16_426 VPWR VGND sg13cmos5l_fill_1
X_12621_ _12621_/X _18873_/Q _12621_/B VPWR VGND sg13cmos5l_xor2_1
X_10882_ _10886_/A _19777_/Q _19779_/Q _19778_/Q VPWR VGND sg13cmos5l_or3_1
XFILLER_25_982 VPWR VGND sg13cmos5l_fill_2
XFILLER_106_1024 VPWR VGND sg13cmos5l_decap_4
X_12552_ _12575_/B _18827_/Q _12552_/B VPWR VGND sg13cmos5l_xor2_1
X_15340_ _15389_/A _19311_/Q _15340_/B VPWR VGND sg13cmos5l_xnor2_1
X_12483_ _12483_/Y _12483_/A _12483_/B VPWR VGND sg13cmos5l_nand2_1
X_11503_ _11504_/B _11503_/A _11503_/B VPWR VGND sg13cmos5l_xor2_1
X_15271_ _15271_/Y _15271_/A _15272_/B _15271_/C VPWR VGND sg13cmos5l_nand3_1
X_17010_ _17013_/C _17011_/C _17011_/D _17009_/Y VPWR VGND sg13cmos5l_a21o_1
X_11434_ _11434_/Y _11434_/A _11434_/B _11434_/C VPWR VGND sg13cmos5l_nand3_1
X_14222_ _14222_/Y _14334_/B _14334_/C _14334_/A VPWR VGND sg13cmos5l_a21oi_1
XFILLER_98_53 VPWR VGND sg13cmos5l_fill_2
X_11365_ _11365_/Y _11895_/A _18642_/Q VPWR VGND sg13cmos5l_nor2_1
X_14153_ _14153_/Y _14150_/X _14151_/X _14152_/X _14366_/A VPWR VGND sg13cmos5l_a22oi_1
XFILLER_98_429 VPWR VGND sg13cmos5l_fill_1
X_18961_ _18961_/Q _19003_/CLK _18961_/D _18961_/RESET_B VPWR VGND sg13cmos5l_dfrbpq_1
X_13104_ _13110_/B _18910_/Q _18909_/Q _13104_/C VPWR VGND sg13cmos5l_or3_1
X_11296_ _11296_/Y _11473_/A _11295_/B _11295_/Y VPWR VGND sg13cmos5l_a21oi_1
X_10316_ _11625_/A _10316_/A VPWR VGND sg13cmos5l_inv_1
X_14084_ _14084_/Y _14642_/A _19065_/Q VPWR VGND sg13cmos5l_nor2_1
XFILLER_106_792 VPWR VGND sg13cmos5l_fill_1
X_13035_ _13035_/Y _18960_/Q _12787_/A _18897_/Q _13579_/A VPWR VGND sg13cmos5l_a22oi_1
X_17912_ _17916_/B _17912_/A _17912_/B VPWR VGND sg13cmos5l_and2_1
X_10247_ _14108_/A _10247_/A VPWR VGND sg13cmos5l_inv_1
X_18814__517 _18814_/D VPWR VGND sg13cmos5l_tielo
X_18892_ _18892_/Q _19087_/CLK _18892_/D _18892_/RESET_B VPWR VGND sg13cmos5l_dfrbpq_1
X_19789__1767 _19789_/RESET_B VPWR VGND sg13cmos5l_tiehi
X_10178_ _18227_/A _17691_/A VPWR VGND sg13cmos5l_inv_1
X_17843_ _17845_/A _19679_/Q _17843_/B VPWR VGND sg13cmos5l_xor2_1
XFILLER_93_123 VPWR VGND sg13cmos5l_fill_2
XFILLER_82_819 VPWR VGND sg13cmos5l_fill_2
X_18719__1562 _18719_/RESET_B VPWR VGND sg13cmos5l_tiehi
X_17774_ _17774_/X _17774_/A _17780_/B VPWR VGND sg13cmos5l_or2_1
X_14986_ _14986_/Y _14986_/A _15024_/A VPWR VGND sg13cmos5l_nor2_1
X_16725_ _16725_/Y _16714_/A _16895_/B _16719_/Y _16723_/Y _16724_/Y VPWR VGND sg13cmos5l_a221oi_1
X_19513_ _19513_/Q clkload36/A _19513_/D _19513_/RESET_B VPWR VGND sg13cmos5l_dfrbpq_1
X_13937_ _14036_/B _13949_/A _13951_/B VPWR VGND sg13cmos5l_nand2_1
XFILLER_75_893 VPWR VGND sg13cmos5l_fill_2
X_19444_ _19444_/Q clkload5/A _19444_/D _19444_/RESET_B VPWR VGND sg13cmos5l_dfrbpq_1
XFILLER_34_223 VPWR VGND sg13cmos5l_fill_2
XFILLER_35_735 VPWR VGND sg13cmos5l_fill_2
X_16656_ _16656_/Y _16656_/A _16664_/A VPWR VGND sg13cmos5l_nor2_1
X_13868_ _13868_/Y _14114_/B _13856_/Y _13867_/Y VPWR VGND sg13cmos5l_a21oi_1
X_13799_ _13801_/B _13803_/A _13775_/A VPWR VGND sg13cmos5l_nor2b_1
X_12819_ _12827_/B _18869_/Q _12820_/B VPWR VGND sg13cmos5l_xnor2_1
X_16587_ _16587_/Y _16831_/B _16577_/A _16581_/X _16586_/X _16582_/X VPWR VGND sg13cmos5l_a221oi_1
X_19089__1165 _19089_/RESET_B VPWR VGND sg13cmos5l_tiehi
X_19375_ _19375_/Q clkload18/A _19375_/D _19375_/RESET_B VPWR VGND sg13cmos5l_dfrbpq_1
XFILLER_15_470 VPWR VGND sg13cmos5l_fill_2
X_15607_ _15607_/Y _15701_/B _15717_/A _15607_/C VPWR VGND sg13cmos5l_nand3_1
X_15538_ _15538_/Y _15351_/C _19284_/Q VPWR VGND sg13cmos5l_nand2b_1
X_18326_ _18326_/Y _18326_/A _18341_/B VPWR VGND sg13cmos5l_nor2_1
X_18257_ _18257_/Y _18257_/A _19686_/Q VPWR VGND sg13cmos5l_nor2_1
X_15469_ _15469_/Y _16012_/A _19272_/Q _19271_/Q _16011_/A VPWR VGND sg13cmos5l_a22oi_1
XFILLER_31_974 VPWR VGND sg13cmos5l_fill_2
X_17208_ _17344_/A _17170_/Y _17174_/X _16974_/Y VPWR VGND sg13cmos5l_a21oi_1
XFILLER_30_484 VPWR VGND sg13cmos5l_decap_4
X_18188_ _18191_/A _18188_/A VPWR VGND sg13cmos5l_inv_1
X_17139_ _17139_/Y _17403_/A _17136_/S _17138_/Y VPWR VGND sg13cmos5l_a21oi_1
XFILLER_103_228 VPWR VGND sg13cmos5l_fill_1
Xhold2026 _17079_/A _19490_/Q VPWR VGND sg13cmos5l_dlygate4sd3_1
XFILLER_69_131 VPWR VGND sg13cmos5l_decap_8
Xhold2004 hold2004/X _19772_/Q VPWR VGND sg13cmos5l_dlygate4sd3_1
Xhold2015 _18976_/D _13340_/Y VPWR VGND sg13cmos5l_dlygate4sd3_1
Xhold2037 _18564_/D _10670_/Y VPWR VGND sg13cmos5l_dlygate4sd3_1
X_19663__1796 _19663_/RESET_B VPWR VGND sg13cmos5l_tiehi
Xhold2059 hold2059/X _19277_/Q VPWR VGND sg13cmos5l_dlygate4sd3_1
Xhold2048 _16549_/B _19423_/Q VPWR VGND sg13cmos5l_dlygate4sd3_1
XFILLER_27_16 VPWR VGND sg13cmos5l_fill_2
X_19731__1230 _19731_/RESET_B VPWR VGND sg13cmos5l_tiehi
X_18876__511 _18876_/D VPWR VGND sg13cmos5l_tielo
X_19152__1098 _19152_/RESET_B VPWR VGND sg13cmos5l_tiehi
X_18795__1480 _18795_/RESET_B VPWR VGND sg13cmos5l_tiehi
X_11150_ _18649_/D _10014_/Y fanout93/X _11149_/Y VPWR VGND sg13cmos5l_a21oi_1
XFILLER_68_45 VPWR VGND sg13cmos5l_fill_1
X_10101_ _15186_/A _10101_/A VPWR VGND sg13cmos5l_inv_1
X_11081_ _18628_/D _11081_/A _11085_/B VPWR VGND sg13cmos5l_nor2_1
X_10032_ _12191_/A _11644_/A VPWR VGND sg13cmos5l_inv_1
Xhold2582 _10034_/A _18750_/Q VPWR VGND sg13cmos5l_dlygate4sd3_1
X_18700__1590 _18700_/RESET_B VPWR VGND sg13cmos5l_tiehi
Xhold2571 hold2571/X _13241_/A VPWR VGND sg13cmos5l_dlygate4sd3_1
X_14840_ _14840_/X _14840_/A _14914_/B VPWR VGND sg13cmos5l_or2_1
Xhold2560 _16505_/B _16504_/X VPWR VGND sg13cmos5l_dlygate4sd3_1
Xhold1870 _18346_/B _19692_/Q VPWR VGND sg13cmos5l_dlygate4sd3_1
XFILLER_1_1005 VPWR VGND sg13cmos5l_decap_8
X_14771_ _14870_/A _14868_/B _14868_/C _14868_/A VPWR VGND sg13cmos5l_a21o_1
Xhold2593 _15136_/A _19257_/Q VPWR VGND sg13cmos5l_dlygate4sd3_1
Xhold1881 _15030_/B _19198_/Q VPWR VGND sg13cmos5l_dlygate4sd3_1
X_13722_ _13818_/B _13694_/Y _13719_/A _13720_/X VPWR VGND sg13cmos5l_a21o_1
X_11983_ _11985_/B _11791_/B _12018_/A _12022_/A _11989_/A VPWR VGND sg13cmos5l_a22oi_1
X_19044__1213 _19044_/RESET_B VPWR VGND sg13cmos5l_tiehi
Xhold1892 _13358_/B _18945_/Q VPWR VGND sg13cmos5l_dlygate4sd3_1
X_16510_ _16510_/X _16510_/A _16510_/B VPWR VGND sg13cmos5l_and2_1
X_17490_ _17490_/Y _17490_/A _17499_/B VPWR VGND sg13cmos5l_nor2_1
X_10934_ _11159_/A _18620_/Q _10945_/C VPWR VGND sg13cmos5l_xnor2_1
XFILLER_44_554 VPWR VGND sg13cmos5l_fill_1
XFILLER_17_60 VPWR VGND sg13cmos5l_fill_2
X_13653_ _19036_/D _13653_/A _13653_/B _13804_/A VPWR VGND sg13cmos5l_nor3_1
X_10865_ _10866_/B _10833_/Y _10311_/Y _10865_/S VPWR VGND sg13cmos5l_mux2_1
X_16441_ _16457_/C _16434_/X _16438_/Y _16439_/Y VPWR VGND sg13cmos5l_a21o_1
X_12604_ _12605_/B _12604_/A _12695_/B VPWR VGND sg13cmos5l_and2_1
X_13584_ _19014_/D _13585_/A _13584_/B VPWR VGND sg13cmos5l_nor2_1
X_19160_ _19160_/Q _19227_/CLK _19160_/D _19160_/RESET_B VPWR VGND sg13cmos5l_dfrbpq_1
X_16372_ _16372_/Y _19445_/Q fanout83/X _16082_/A VPWR VGND sg13cmos5l_o21ai_1
X_12535_ _12535_/Y _12535_/A _12535_/B VPWR VGND sg13cmos5l_nor2_1
X_10796_ _10807_/C _10796_/A _10796_/B VPWR VGND sg13cmos5l_xnor2_1
XFILLER_8_400 VPWR VGND sg13cmos5l_fill_2
X_15323_ _15426_/C _15322_/A _15419_/A _15333_/A VPWR VGND sg13cmos5l_o21ai_1
X_18111_ _18309_/A _19702_/Q _19701_/Q VPWR VGND sg13cmos5l_xnor2_1
X_19091_ _19091_/Q _19092_/CLK _19091_/D _19091_/RESET_B VPWR VGND sg13cmos5l_dfrbpq_1
XFILLER_9_956 VPWR VGND sg13cmos5l_fill_1
XFILLER_33_81 VPWR VGND sg13cmos5l_fill_2
X_12466_ _18846_/D _12468_/A _12466_/B VPWR VGND sg13cmos5l_and2_1
X_15254_ _19279_/D _09990_/Y fanout90/X _15253_/Y VPWR VGND sg13cmos5l_a21oi_1
X_18042_ _18043_/B _18045_/B _18039_/B _18041_/Y VPWR VGND sg13cmos5l_o21ai_1
X_12397_ _12441_/A _12399_/A _12399_/B VPWR VGND sg13cmos5l_nand2_1
X_11417_ _11417_/Y _10013_/Y fanout76/X _11416_/Y VPWR VGND sg13cmos5l_a21oi_1
X_14205_ _14315_/A _14166_/Y _14199_/B _14016_/Y VPWR VGND sg13cmos5l_o21ai_1
X_15185_ _19259_/D _15185_/A _15185_/B VPWR VGND sg13cmos5l_and2_1
XFILLER_99_727 VPWR VGND sg13cmos5l_fill_2
X_11348_ _11348_/Y _11336_/A _11337_/Y _11360_/A VPWR VGND sg13cmos5l_o21ai_1
X_14136_ _14136_/Y _14118_/Y hold2206/X _14371_/B VPWR VGND sg13cmos5l_a21oi_1
XFILLER_3_171 VPWR VGND sg13cmos5l_fill_2
X_19508__709 _19508_/RESET_B VPWR VGND sg13cmos5l_tiehi
X_18944_ _18944_/Q _19087_/CLK _18944_/D _18944_/RESET_B VPWR VGND sg13cmos5l_dfrbpq_1
X_11279_ _11359_/B hold3000/X _11278_/Y _11295_/B VPWR VGND sg13cmos5l_mux2_1
X_14067_ _19084_/D hold2902/X _14062_/S _14066_/Y VPWR VGND sg13cmos5l_a21oi_1
X_18875_ _18875_/Q clkload63/A _18875_/D _18875_/RESET_B VPWR VGND sg13cmos5l_dfrbpq_1
X_13018_ _18922_/D _13018_/A _13020_/B VPWR VGND sg13cmos5l_nor2_1
XFILLER_67_635 VPWR VGND sg13cmos5l_fill_1
XFILLER_67_646 VPWR VGND sg13cmos5l_decap_8
XFILLER_66_134 VPWR VGND sg13cmos5l_decap_8
X_17826_ _17837_/B _19673_/Q _19674_/Q _19675_/Q VPWR VGND sg13cmos5l_o21ai_1
XFILLER_66_178 VPWR VGND sg13cmos5l_fill_1
XFILLER_66_167 VPWR VGND sg13cmos5l_decap_8
XFILLER_66_189 VPWR VGND sg13cmos5l_decap_4
XFILLER_63_830 VPWR VGND sg13cmos5l_fill_1
X_17757_ _17761_/B _19614_/Q _19613_/Q _19612_/Q _17757_/D VPWR VGND sg13cmos5l_nor4_1
X_14969_ _14969_/Y _14952_/Y hold2374/X _15192_/A VPWR VGND sg13cmos5l_a21oi_1
X_16708_ _16708_/X _19510_/Q _16708_/B VPWR VGND sg13cmos5l_xor2_1
X_17688_ _17688_/X _17688_/A _17693_/C VPWR VGND sg13cmos5l_and2_1
XFILLER_35_565 VPWR VGND sg13cmos5l_fill_2
X_16639_ _16640_/C _16818_/A _16637_/B _16656_/A VPWR VGND sg13cmos5l_a21oi_1
X_19427_ _19427_/Q clkload8/A _19427_/D _19427_/RESET_B VPWR VGND sg13cmos5l_dfrbpq_1
XFILLER_95_0 VPWR VGND sg13cmos5l_fill_2
XFILLER_50_557 VPWR VGND sg13cmos5l_fill_1
X_19358_ _19358_/Q clkload7/A _19358_/D _19358_/RESET_B VPWR VGND sg13cmos5l_dfrbpq_1
X_18309_ _18309_/Y _18309_/A _18309_/B _18309_/C VPWR VGND sg13cmos5l_nand3_1
X_19289_ _19289_/Q clkload17/A _19289_/D _19289_/RESET_B VPWR VGND sg13cmos5l_dfrbpq_1
XFILLER_100_721 VPWR VGND sg13cmos5l_fill_2
X_10650_ _10658_/B _10650_/A VPWR VGND sg13cmos5l_inv_1
XFILLER_41_568 VPWR VGND sg13cmos5l_fill_2
XFILLER_10_922 VPWR VGND sg13cmos5l_fill_1
X_10581_ _10582_/B _10501_/A _10590_/B _10564_/A VPWR VGND sg13cmos5l_o21ai_1
X_12320_ _12320_/X _12336_/D _12322_/B VPWR VGND sg13cmos5l_and2_1
X_12251_ _12251_/Y _12483_/B _12251_/B VPWR VGND sg13cmos5l_nand2_1
XFILLER_6_959 VPWR VGND sg13cmos5l_decap_8
XFILLER_5_425 VPWR VGND sg13cmos5l_fill_2
X_11202_ _18656_/D _11358_/A _11202_/B VPWR VGND sg13cmos5l_nor2_1
X_12182_ _12182_/Y _12145_/B _12175_/Y _12192_/B VPWR VGND sg13cmos5l_o21ai_1
X_18585__1714 _18585_/RESET_B VPWR VGND sg13cmos5l_tiehi
X_16990_ _16994_/A _16990_/A _17011_/A VPWR VGND sg13cmos5l_xor2_1
X_11133_ _11133_/X _11106_/Y _11382_/A _11133_/S VPWR VGND sg13cmos5l_mux2_1
XFILLER_62_1000 VPWR VGND sg13cmos5l_fill_1
XFILLER_0_130 VPWR VGND sg13cmos5l_fill_1
XFILLER_103_570 VPWR VGND sg13cmos5l_fill_1
X_11064_ _11076_/B _11054_/Y _11060_/Y _11062_/Y VPWR VGND sg13cmos5l_a21o_1
X_15941_ _15942_/B _15926_/Y _15929_/X _16120_/A VPWR VGND sg13cmos5l_o21ai_1
X_18660_ _18660_/Q clkload55/A _18660_/D _18660_/RESET_B VPWR VGND sg13cmos5l_dfrbpq_1
X_10015_ _10015_/Y _10015_/A VPWR VGND sg13cmos5l_inv_1
XFILLER_0_196 VPWR VGND sg13cmos5l_fill_1
X_17611_ _17611_/Y _17493_/B _17677_/B _17610_/X _17498_/B VPWR VGND sg13cmos5l_a22oi_1
Xhold2390 _18138_/A _19700_/Q VPWR VGND sg13cmos5l_dlygate4sd3_1
X_15872_ _15982_/B _15872_/A _15884_/B VPWR VGND sg13cmos5l_nand2_1
XFILLER_36_307 VPWR VGND sg13cmos5l_fill_1
X_18591_ _18591_/Q _18594_/CLK _18591_/D _18591_/RESET_B VPWR VGND sg13cmos5l_dfrbpq_1
XFILLER_76_487 VPWR VGND sg13cmos5l_fill_2
X_14823_ _14823_/Y _14823_/A VPWR VGND sg13cmos5l_inv_1
X_11966_ _18776_/D _12188_/A _11966_/B VPWR VGND sg13cmos5l_and2_1
X_17542_ _17549_/A _17562_/D _17542_/B _17592_/A VPWR VGND sg13cmos5l_nand3_1
X_14754_ _14754_/Y _14754_/A _14757_/B VPWR VGND sg13cmos5l_nor2_1
X_13705_ _13705_/Y _13705_/A _13705_/B _13705_/C VPWR VGND sg13cmos5l_nand3_1
X_17473_ _17481_/C _17473_/A _17495_/B VPWR VGND sg13cmos5l_or2_1
X_10917_ _10982_/A _10917_/A _10917_/B VPWR VGND sg13cmos5l_or2_1
XFILLER_17_587 VPWR VGND sg13cmos5l_fill_1
X_14685_ _14687_/A _14678_/Y _14682_/Y _14683_/Y _19191_/Q _14684_/Y VPWR VGND sg13cmos5l_a221oi_1
XFILLER_32_513 VPWR VGND sg13cmos5l_decap_8
X_13636_ _13636_/Y _16578_/B _13636_/B VPWR VGND sg13cmos5l_nand2_1
X_18835__1437 _18835_/RESET_B VPWR VGND sg13cmos5l_tiehi
X_11897_ _18756_/D _11897_/A _11899_/B VPWR VGND sg13cmos5l_nor2_1
X_19008__1252 _19008_/RESET_B VPWR VGND sg13cmos5l_tiehi
X_16424_ _16424_/X _16457_/A _16457_/B _16423_/A VPWR VGND sg13cmos5l_a21o_1
X_19212_ _19212_/Q _19304_/CLK _19212_/D _19212_/RESET_B VPWR VGND sg13cmos5l_dfrbpq_1
X_10848_ _10848_/Y _11116_/A _10846_/X _10847_/Y VPWR VGND sg13cmos5l_o21ai_1
X_10779_ _10781_/B _10779_/A _10779_/B VPWR VGND sg13cmos5l_xor2_1
X_13567_ _13567_/Y _13531_/B _13571_/S _13569_/B1 VPWR VGND sg13cmos5l_o21ai_1
X_16355_ _16357_/B _19442_/Q _16352_/Y _16356_/B _19443_/Q _16353_/Y VPWR VGND sg13cmos5l_a221oi_1
X_19143_ _19143_/Q clkload49/A _19143_/D _19143_/RESET_B VPWR VGND sg13cmos5l_dfrbpq_1
X_12518_ _12518_/Y _12766_/B _12506_/Y _12517_/Y VPWR VGND sg13cmos5l_a21oi_1
X_13498_ _13582_/B _13500_/C _13500_/D VPWR VGND sg13cmos5l_and2_1
X_19074_ _19074_/Q clkload54/A _19074_/D _19074_/RESET_B VPWR VGND sg13cmos5l_dfrbpq_1
X_16286_ _16293_/A _16261_/A _16260_/Y _16258_/Y VPWR VGND sg13cmos5l_a21oi_1
X_15306_ _15403_/A _15278_/B _15303_/B _15125_/Y VPWR VGND sg13cmos5l_o21ai_1
X_12449_ _18831_/D _12452_/A _12449_/B VPWR VGND sg13cmos5l_nor2_1
X_18025_ _18025_/Y _18009_/Y _18018_/Y _18023_/Y VPWR VGND sg13cmos5l_o21ai_1
X_15237_ _15237_/Y _15218_/A _15238_/B _15236_/Y VPWR VGND sg13cmos5l_a21oi_1
XFILLER_99_502 VPWR VGND sg13cmos5l_decap_8
XFILLER_99_535 VPWR VGND sg13cmos5l_fill_1
XFILLER_99_513 VPWR VGND sg13cmos5l_fill_2
X_15168_ _15168_/Y _15050_/A _15050_/B _15159_/Y _15165_/Y _15167_/Y VPWR VGND sg13cmos5l_a221oi_1
XFILLER_87_708 VPWR VGND sg13cmos5l_fill_1
Xfanout209 _17937_/B _17933_/B VPWR VGND sg13cmos5l_buf_1
X_15099_ _15099_/Y _15099_/A _15121_/B VPWR VGND sg13cmos5l_nor2_1
X_14119_ _14119_/Y _14407_/B _14119_/B VPWR VGND sg13cmos5l_nor2_1
XFILLER_101_529 VPWR VGND sg13cmos5l_decap_8
X_18927_ _18927_/Q _18931_/CLK _18927_/D _18927_/RESET_B VPWR VGND sg13cmos5l_dfrbpq_1
XFILLER_94_240 VPWR VGND sg13cmos5l_fill_2
X_18858_ _18858_/Q clkload57/A _18858_/D _18858_/RESET_B VPWR VGND sg13cmos5l_dfrbpq_1
XFILLER_39_145 VPWR VGND sg13cmos5l_fill_2
X_18768__1510 _18768_/RESET_B VPWR VGND sg13cmos5l_tiehi
X_18789_ _18789_/Q clkload61/A _18789_/D _18789_/RESET_B VPWR VGND sg13cmos5l_dfrbpq_1
XFILLER_82_413 VPWR VGND sg13cmos5l_fill_2
X_17809_ _17809_/Y _17809_/A _17809_/B VPWR VGND sg13cmos5l_xnor2_1
XFILLER_36_896 VPWR VGND sg13cmos5l_fill_2
X_18827__516 _18827_/D VPWR VGND sg13cmos5l_tielo
XFILLER_51_899 VPWR VGND sg13cmos5l_fill_1
XFILLER_85_1000 VPWR VGND sg13cmos5l_fill_2
X_19192__481 _19192_/D VPWR VGND sg13cmos5l_tielo
XFILLER_49_69 VPWR VGND sg13cmos5l_fill_1
XFILLER_49_58 VPWR VGND sg13cmos5l_fill_2
XFILLER_49_47 VPWR VGND sg13cmos5l_fill_2
X_18573__1729 _18573_/RESET_B VPWR VGND sg13cmos5l_tiehi
Xheichips26_digital_project_1798 uio_oe[1] VPWR VGND sg13cmos5l_tiehi
X_19084__1170 _19084_/RESET_B VPWR VGND sg13cmos5l_tiehi
XFILLER_100_595 VPWR VGND sg13cmos5l_fill_2
X_11820_ _11824_/C _11820_/A _11820_/B _11820_/C _11820_/D VPWR VGND sg13cmos5l_nand4_1
X_11751_ _11767_/A _11751_/A _11766_/B VPWR VGND sg13cmos5l_nor2_1
X_10702_ _10716_/B _13812_/A _10708_/B VPWR VGND sg13cmos5l_nand2_1
Xclkbuf_leaf_80_clk clkload22/A clkload0/A VPWR VGND sg13cmos5l_buf_8
X_11682_ _11682_/Y _11922_/B _11682_/B VPWR VGND sg13cmos5l_nand2_1
X_14470_ _14470_/Y _19115_/Q _14489_/B VPWR VGND sg13cmos5l_nor2_1
X_13421_ _13421_/Y _13421_/A _13421_/B VPWR VGND sg13cmos5l_nor2_1
X_10633_ _10634_/C _10633_/A _10623_/Y VPWR VGND sg13cmos5l_nor2b_1
X_13352_ _13352_/Y _10004_/Y fanout95/X _13351_/Y VPWR VGND sg13cmos5l_a21oi_1
X_19788__1574 _19788_/RESET_B VPWR VGND sg13cmos5l_tiehi
X_16140_ _16140_/X _16140_/A _16140_/B VPWR VGND sg13cmos5l_and2_1
X_10564_ _10564_/Y _10564_/A _10564_/B VPWR VGND sg13cmos5l_nor2_1
X_12303_ _12303_/Y _12303_/A _12307_/B VPWR VGND sg13cmos5l_nor2_1
X_16071_ _16071_/Y _16057_/B _16063_/S _16318_/A VPWR VGND sg13cmos5l_o21ai_1
X_13283_ _18959_/D _13270_/B _13282_/Y _13296_/A VPWR VGND sg13cmos5l_a21oi_1
X_15022_ _15132_/A _15025_/S _15021_/X _15020_/Y VPWR VGND sg13cmos5l_a21o_1
X_10495_ _10497_/B _19742_/Q _19735_/Q VPWR VGND sg13cmos5l_nor2_1
X_12234_ _12234_/Y _12492_/A _12227_/B _12233_/A _12498_/B _12229_/Y VPWR VGND sg13cmos5l_a221oi_1
X_12165_ _12165_/Y _12145_/Y _12159_/Y _12164_/Y VPWR VGND sg13cmos5l_o21ai_1
X_11116_ _11116_/Y _11116_/A _18604_/Q VPWR VGND sg13cmos5l_nor2_1
X_19761_ _19761_/Q clkload23/A _19761_/D _19761_/RESET_B VPWR VGND sg13cmos5l_dfrbpq_1
X_12096_ _12096_/X _18807_/Q _12096_/B VPWR VGND sg13cmos5l_xor2_1
X_16973_ _16974_/B _19537_/Q _16973_/B VPWR VGND sg13cmos5l_xnor2_1
X_18712_ _18712_/Q _18733_/CLK _18712_/D _18712_/RESET_B VPWR VGND sg13cmos5l_dfrbpq_1
XFILLER_76_251 VPWR VGND sg13cmos5l_fill_2
X_19692_ _19692_/Q _19756_/CLK _19692_/D _19692_/RESET_B VPWR VGND sg13cmos5l_dfrbpq_1
XFILLER_49_476 VPWR VGND sg13cmos5l_fill_2
X_11047_ _11047_/Y _11047_/A _11047_/B VPWR VGND sg13cmos5l_nor2_1
X_15924_ _15924_/Y _15924_/A _16116_/A VPWR VGND sg13cmos5l_nand2_1
Xinput9 input9/X ui_in[7] VPWR VGND sg13cmos5l_buf_1
X_18643_ _18643_/Q clkload38/A _18643_/D _18643_/RESET_B VPWR VGND sg13cmos5l_dfrbpq_1
X_15855_ _19369_/D _16022_/A _15855_/B VPWR VGND sg13cmos5l_nor2_1
X_18574_ _18574_/Q clkload29/A _18574_/D _18574_/RESET_B VPWR VGND sg13cmos5l_dfrbpq_1
X_14806_ _14806_/Y _14828_/A VPWR VGND sg13cmos5l_inv_1
X_12998_ _13011_/A _12998_/A _13013_/C _12998_/C VPWR VGND sg13cmos5l_nand3_1
X_17525_ _17638_/B _17507_/A _17522_/B _17523_/Y VPWR VGND sg13cmos5l_a21oi_1
X_15786_ _15787_/B _19359_/Q _15784_/Y _16038_/B VPWR VGND sg13cmos5l_o21ai_1
X_11949_ _11949_/Y _10288_/Y fanout55/X _11948_/Y VPWR VGND sg13cmos5l_a21oi_1
XFILLER_44_181 VPWR VGND sg13cmos5l_fill_2
X_14737_ _14737_/Y _14737_/A _14757_/B VPWR VGND sg13cmos5l_nor2_1
Xclkbuf_leaf_71_clk clkload42/A clkbuf_4_8_0_clk/X VPWR VGND sg13cmos5l_buf_8
X_17456_ _17463_/B _19571_/Q _17457_/B VPWR VGND sg13cmos5l_nor2b_1
X_14668_ _14668_/Y _14668_/A _19150_/Q VPWR VGND sg13cmos5l_nor2_1
X_13619_ _13619_/Y _10083_/A _16823_/A _10696_/Y VPWR VGND sg13cmos5l_a21oi_1
X_17387_ _17397_/B _17378_/Y _17385_/Y _17386_/Y VPWR VGND sg13cmos5l_o21ai_1
XFILLER_20_538 VPWR VGND sg13cmos5l_fill_2
X_16407_ _16411_/B _16407_/A _16407_/B VPWR VGND sg13cmos5l_xnor2_1
XFILLER_32_387 VPWR VGND sg13cmos5l_fill_2
X_16338_ _16338_/Y _16338_/A VPWR VGND sg13cmos5l_inv_1
X_14599_ _14599_/Y _14599_/A _14599_/B _14599_/C VPWR VGND sg13cmos5l_nand3_1
X_19126_ _19126_/Q clkload49/A _19126_/D _19126_/RESET_B VPWR VGND sg13cmos5l_dfrbpq_1
X_19057_ _19057_/Q clkload30/A _19057_/D _19057_/RESET_B VPWR VGND sg13cmos5l_dfrbpq_1
X_16269_ _16277_/A _16269_/A VPWR VGND sg13cmos5l_inv_1
Xheichips26_digital_project_404 uio_out[4] VPWR VGND sg13cmos5l_tielo
XFILLER_58_0 VPWR VGND sg13cmos5l_fill_1
Xheichips26_digital_project_415 uio_out[15] VPWR VGND sg13cmos5l_tielo
X_18008_ _18057_/A _19654_/Q _18026_/D VPWR VGND sg13cmos5l_xor2_1
XFILLER_102_805 VPWR VGND sg13cmos5l_fill_2
X_19169__1079 _19169_/RESET_B VPWR VGND sg13cmos5l_tiehi
X_18692__1598 _18692_/RESET_B VPWR VGND sg13cmos5l_tiehi
XFILLER_83_788 VPWR VGND sg13cmos5l_fill_1
XFILLER_70_416 VPWR VGND sg13cmos5l_fill_2
XFILLER_64_991 VPWR VGND sg13cmos5l_fill_1
Xclkbuf_leaf_62_clk clkload53/A clkload2/A VPWR VGND sg13cmos5l_buf_8
X_10280_ _12228_/A _10280_/A VPWR VGND sg13cmos5l_inv_1
X_19428__802 _19428_/RESET_B VPWR VGND sg13cmos5l_tiehi
XFILLER_86_560 VPWR VGND sg13cmos5l_fill_1
X_13970_ _13970_/Y _14368_/A _13970_/B VPWR VGND sg13cmos5l_xnor2_1
X_12921_ _12940_/A _12907_/Y _12914_/Y _12920_/Y VPWR VGND sg13cmos5l_a21oi_1
XFILLER_73_210 VPWR VGND sg13cmos5l_fill_2
X_15640_ _15671_/A _19350_/Q _15640_/B VPWR VGND sg13cmos5l_xor2_1
X_19363__871 _19363_/RESET_B VPWR VGND sg13cmos5l_tiehi
X_12852_ _12986_/A _12826_/Y _12850_/Y _12849_/X VPWR VGND sg13cmos5l_a21o_1
X_11803_ _11803_/X _11803_/A _11803_/B VPWR VGND sg13cmos5l_xor2_1
X_18875__1394 _18875_/RESET_B VPWR VGND sg13cmos5l_tiehi
Xclkbuf_leaf_53_clk clkload67/A clkbuf_4_14_0_clk/X VPWR VGND sg13cmos5l_buf_8
X_12783_ _12783_/Y _12763_/B fanout50/X _13019_/B VPWR VGND sg13cmos5l_o21ai_1
X_19676__1783 _19676_/RESET_B VPWR VGND sg13cmos5l_tiehi
X_15571_ _15572_/B _15564_/A _15564_/B _15569_/Y VPWR VGND sg13cmos5l_o21ai_1
X_11734_ _11734_/Y _11824_/A _11824_/B VPWR VGND sg13cmos5l_nand2_1
X_17310_ _17310_/Y _17310_/A _17310_/B VPWR VGND sg13cmos5l_nor2_1
XFILLER_70_950 VPWR VGND sg13cmos5l_fill_2
X_18290_ _18290_/Y hold2077/X fanout67/X _18273_/B VPWR VGND sg13cmos5l_o21ai_1
X_14522_ _14537_/A _19179_/Q _19180_/Q _19181_/Q VPWR VGND sg13cmos5l_or3_1
XFILLER_25_60 VPWR VGND sg13cmos5l_fill_2
X_11665_ _11665_/Y _10033_/A _12195_/A _11646_/B _11414_/B VPWR VGND sg13cmos5l_a22oi_1
X_17241_ _17306_/A _19592_/Q _17267_/D VPWR VGND sg13cmos5l_xor2_1
X_14453_ _14453_/Y _14486_/A VPWR VGND sg13cmos5l_inv_1
Xclkbuf_4_6_0_clk clkbuf_4_6_0_clk/X clkbuf_0_clk/X VPWR VGND sg13cmos5l_buf_8
X_13404_ _13406_/B _13500_/A _13500_/B VPWR VGND sg13cmos5l_nand2_1
X_10616_ _10616_/Y _18546_/A _10616_/B VPWR VGND sg13cmos5l_nand2_1
X_17172_ _17172_/Y _16974_/B _17170_/Y _17171_/Y VPWR VGND sg13cmos5l_a21oi_1
X_11596_ _11598_/A _11596_/A _11596_/B _11596_/C VPWR VGND sg13cmos5l_or3_1
X_14384_ _14384_/Y _19169_/Q _10245_/Y _14407_/B _19168_/Q _14383_/Y VPWR VGND sg13cmos5l_a221oi_1
X_13335_ _13336_/B _18981_/Q _13333_/Y _13848_/A VPWR VGND sg13cmos5l_o21ai_1
X_16123_ _19409_/D _16318_/A _16123_/B VPWR VGND sg13cmos5l_and2_1
X_10547_ _10547_/X _19804_/Q _10547_/B VPWR VGND sg13cmos5l_xor2_1
X_13266_ _13270_/B _13266_/A _13297_/B VPWR VGND sg13cmos5l_nor2_1
X_16054_ _16057_/B _16052_/C _16053_/Y _16052_/Y VPWR VGND sg13cmos5l_a21o_1
X_10478_ _10504_/B _19740_/Q _10479_/B VPWR VGND sg13cmos5l_nor2b_1
X_19124__1127 _19124_/RESET_B VPWR VGND sg13cmos5l_tiehi
X_12217_ _12218_/A _12231_/C _12215_/Y _12216_/Y VPWR VGND sg13cmos5l_a21o_1
X_15005_ _15025_/S _14999_/Y _15003_/Y _15004_/Y VPWR VGND sg13cmos5l_a21o_1
XFILLER_29_1023 VPWR VGND sg13cmos5l_decap_4
X_19813_ _19813_/Q clkload27/A _19813_/D _19813_/RESET_B VPWR VGND sg13cmos5l_dfrbpq_1
X_13197_ _13197_/Y _13187_/X _13192_/Y _13295_/B _13235_/A _13196_/Y VPWR VGND sg13cmos5l_a221oi_1
XFILLER_96_335 VPWR VGND sg13cmos5l_fill_2
X_12148_ _12148_/Y _12148_/A _12148_/B _12148_/C VPWR VGND sg13cmos5l_nor3_1
X_12079_ _12088_/B _18805_/Q _12080_/B VPWR VGND sg13cmos5l_nor2b_1
X_16956_ _17051_/C _19543_/Q _16966_/B _16967_/A VPWR VGND sg13cmos5l_o21ai_1
X_19744_ _19744_/Q clkload22/A _19744_/D _19744_/RESET_B VPWR VGND sg13cmos5l_dfrbpq_1
XFILLER_77_571 VPWR VGND sg13cmos5l_fill_2
X_19675_ _19675_/Q clkload11/A _19675_/D _19675_/RESET_B VPWR VGND sg13cmos5l_dfrbpq_1
X_15907_ _16100_/A _15913_/B _15907_/B VPWR VGND sg13cmos5l_nand2b_1
X_16887_ _16887_/Y _19521_/Q fanout87/X _17152_/A VPWR VGND sg13cmos5l_o21ai_1
XFILLER_65_744 VPWR VGND sg13cmos5l_fill_1
X_18626_ _18626_/Q clkload45/A _18626_/D _18626_/RESET_B VPWR VGND sg13cmos5l_dfrbpq_1
XFILLER_64_276 VPWR VGND sg13cmos5l_fill_1
XFILLER_52_416 VPWR VGND sg13cmos5l_fill_1
X_15838_ _15846_/B _15826_/Y _15833_/X _15836_/Y VPWR VGND sg13cmos5l_o21ai_1
Xclkbuf_leaf_44_clk clkload69/A clkload4/A VPWR VGND sg13cmos5l_buf_8
X_18557_ _18593_/D _18558_/A _18557_/B VPWR VGND sg13cmos5l_nor2_1
X_15769_ _15769_/Y _19312_/Q _15769_/B VPWR VGND sg13cmos5l_nand2_1
X_17508_ _17637_/A _19628_/Q _17522_/B VPWR VGND sg13cmos5l_xnor2_1
X_18488_ _18488_/Y _19787_/Q _18508_/A _18261_/A _19786_/Q _18487_/Y VPWR VGND sg13cmos5l_a221oi_1
X_19143__486 _19143_/D VPWR VGND sg13cmos5l_tielo
XFILLER_33_674 VPWR VGND sg13cmos5l_fill_1
X_17439_ _19608_/D _17439_/A _17439_/B VPWR VGND sg13cmos5l_and2_1
X_19057__1200 _19057_/RESET_B VPWR VGND sg13cmos5l_tiehi
XFILLER_32_195 VPWR VGND sg13cmos5l_fill_2
X_19109_ _19109_/Q clkload47/A _19109_/D _19109_/RESET_B VPWR VGND sg13cmos5l_dfrbpq_1
XFILLER_88_825 VPWR VGND sg13cmos5l_fill_2
XFILLER_0_718 VPWR VGND sg13cmos5l_decap_8
XFILLER_0_729 VPWR VGND sg13cmos5l_fill_1
Xhold2901 _14044_/C _14043_/Y VPWR VGND sg13cmos5l_dlygate4sd3_1
Xhold2912 hold2912/X _16291_/A VPWR VGND sg13cmos5l_dlygate4sd3_1
Xhold2923 hold2923/X _19260_/Q VPWR VGND sg13cmos5l_dlygate4sd3_1
Xhold2956 hold2956/X _13531_/A VPWR VGND sg13cmos5l_dlygate4sd3_1
Xhold2945 _16154_/A _19427_/Q VPWR VGND sg13cmos5l_dlygate4sd3_1
Xhold2934 _16159_/C _19425_/Q VPWR VGND sg13cmos5l_dlygate4sd3_1
Xhold2967 hold2967/X _19053_/Q VPWR VGND sg13cmos5l_dlygate4sd3_1
XFILLER_68_582 VPWR VGND sg13cmos5l_fill_1
Xhold2978 _17886_/A _19667_/Q VPWR VGND sg13cmos5l_dlygate4sd3_1
Xhold2989 hold2989/X _19659_/Q VPWR VGND sg13cmos5l_dlygate4sd3_1
X_18830__1442 _18830_/RESET_B VPWR VGND sg13cmos5l_tiehi
XFILLER_83_541 VPWR VGND sg13cmos5l_fill_1
XFILLER_46_48 VPWR VGND sg13cmos5l_decap_4
Xclkbuf_leaf_35_clk clkload55/A clkbuf_4_12_0_clk/X VPWR VGND sg13cmos5l_buf_8
XFILLER_11_302 VPWR VGND sg13cmos5l_fill_2
XFILLER_7_306 VPWR VGND sg13cmos5l_fill_1
XFILLER_8_829 VPWR VGND sg13cmos5l_fill_2
XFILLER_23_195 VPWR VGND sg13cmos5l_fill_1
X_11450_ _11450_/Y _11452_/A _11474_/B _11447_/Y VPWR VGND sg13cmos5l_a21oi_1
X_11381_ _11381_/Y _11381_/A VPWR VGND sg13cmos5l_inv_1
X_10401_ _19808_/D _10680_/C _10400_/Y _10683_/A VPWR VGND sg13cmos5l_a21oi_1
X_13120_ _18947_/D _13296_/A _13210_/A VPWR VGND sg13cmos5l_nor2_1
X_10332_ _10332_/Y _19727_/Q VPWR VGND sg13cmos5l_inv_1
XFILLER_106_930 VPWR VGND sg13cmos5l_decap_4
X_13051_ _13051_/Y _13577_/A _18960_/Q VPWR VGND sg13cmos5l_nor2_1
X_12002_ _12109_/B _11999_/A _11999_/B _12000_/X VPWR VGND sg13cmos5l_o21ai_1
X_10263_ _10263_/Y _10263_/A VPWR VGND sg13cmos5l_inv_1
XFILLER_79_836 VPWR VGND sg13cmos5l_fill_1
X_10194_ _18496_/A _10560_/A VPWR VGND sg13cmos5l_inv_1
X_16810_ _19493_/D _16827_/A _16810_/B VPWR VGND sg13cmos5l_nor2_1
X_17790_ _17902_/A _17790_/A _17803_/B VPWR VGND sg13cmos5l_xnor2_1
X_16741_ _16743_/A _16753_/A _16925_/A VPWR VGND sg13cmos5l_nor2_1
Xfanout392 _13807_/A fanout403/X VPWR VGND sg13cmos5l_buf_1
Xfanout370 _16889_/A _17150_/A VPWR VGND sg13cmos5l_buf_1
Xfanout381 _18541_/A fanout403/X VPWR VGND sg13cmos5l_buf_1
XFILLER_93_349 VPWR VGND sg13cmos5l_decap_8
XFILLER_47_733 VPWR VGND sg13cmos5l_fill_1
X_13953_ _14024_/A _13952_/Y _14052_/A VPWR VGND sg13cmos5l_nand2b_1
XFILLER_19_457 VPWR VGND sg13cmos5l_fill_2
X_16672_ _16672_/Y _19479_/Q _19030_/Q VPWR VGND sg13cmos5l_nand2_1
X_12904_ _12953_/A _18916_/Q _12905_/B VPWR VGND sg13cmos5l_xnor2_1
X_13884_ _13902_/B _18994_/Q _13884_/B VPWR VGND sg13cmos5l_xor2_1
X_19460_ _19460_/Q _19462_/CLK _19460_/D _19460_/RESET_B VPWR VGND sg13cmos5l_dfrbpq_1
X_12835_ _12837_/B _12938_/A _12938_/B VPWR VGND sg13cmos5l_nand2_1
XFILLER_61_224 VPWR VGND sg13cmos5l_fill_1
X_19391_ _19391_/Q clkload18/A _19391_/D _19391_/RESET_B VPWR VGND sg13cmos5l_dfrbpq_1
X_15623_ _15681_/B _16015_/A _15623_/B VPWR VGND sg13cmos5l_xnor2_1
X_18411_ _18411_/Y _18481_/B VPWR VGND sg13cmos5l_inv_1
Xclkbuf_leaf_26_clk clkload32/A clkbuf_4_5_0_clk/X VPWR VGND sg13cmos5l_buf_8
X_15554_ _15554_/Y _15556_/A _15556_/B _15553_/Y VPWR VGND sg13cmos5l_a21oi_1
X_18342_ _18418_/A _18340_/B _18341_/Y _18340_/Y VPWR VGND sg13cmos5l_a21oi_1
X_12766_ _12766_/Y _18856_/Q _12766_/B VPWR VGND sg13cmos5l_nor2_1
X_18665__1628 _18665_/RESET_B VPWR VGND sg13cmos5l_tiehi
XFILLER_42_471 VPWR VGND sg13cmos5l_fill_1
XFILLER_15_696 VPWR VGND sg13cmos5l_fill_1
X_14505_ _14506_/B _14602_/B _14602_/C _14602_/A VPWR VGND sg13cmos5l_a21oi_1
X_12697_ _12697_/Y _12734_/B _12697_/B VPWR VGND sg13cmos5l_nand2_1
X_11717_ _11721_/A _11707_/Y _11712_/Y _11716_/Y VPWR VGND sg13cmos5l_a21oi_1
X_18273_ _18273_/Y _18272_/B _18273_/B VPWR VGND sg13cmos5l_nand2b_1
X_15485_ _15485_/Y _15485_/A VPWR VGND sg13cmos5l_inv_1
X_11648_ _11649_/A _11661_/C _11646_/Y _11647_/Y VPWR VGND sg13cmos5l_o21ai_1
X_17224_ _17225_/B _17330_/B _17330_/C _17330_/A VPWR VGND sg13cmos5l_a21oi_1
X_14436_ _19154_/D _14436_/A _14436_/B VPWR VGND sg13cmos5l_and2_1
X_17155_ _17155_/X _17163_/B _17155_/B VPWR VGND sg13cmos5l_and2_1
X_11579_ _11579_/Y _11578_/X _11586_/A VPWR VGND sg13cmos5l_nand2b_1
X_14367_ _19132_/D _14367_/A _14371_/B VPWR VGND sg13cmos5l_nor2_1
X_13318_ _13318_/Y _18934_/Q _13318_/B VPWR VGND sg13cmos5l_nand2_1
XFILLER_7_895 VPWR VGND sg13cmos5l_fill_1
X_16106_ _16110_/B _19372_/Q _16106_/B VPWR VGND sg13cmos5l_xor2_1
X_17086_ _19547_/D _17087_/A _17086_/B VPWR VGND sg13cmos5l_nor2_1
X_14298_ _14298_/Y _14285_/B _14298_/B VPWR VGND sg13cmos5l_nand2b_1
X_13249_ _13249_/X _13241_/A _13243_/Y _13248_/Y VPWR VGND sg13cmos5l_a21o_1
X_16037_ _16037_/Y _16037_/A VPWR VGND sg13cmos5l_inv_1
Xhold2219 _18684_/D _11409_/Y VPWR VGND sg13cmos5l_dlygate4sd3_1
Xhold2208 _17959_/A _19640_/Q VPWR VGND sg13cmos5l_dlygate4sd3_1
X_18611__1685 _18611_/RESET_B VPWR VGND sg13cmos5l_tiehi
X_17988_ _19681_/D _18248_/A _17993_/S _17987_/Y VPWR VGND sg13cmos5l_a21oi_1
XFILLER_42_1020 VPWR VGND sg13cmos5l_decap_8
X_19727_ _19727_/Q _19790_/CLK _19727_/D _19727_/RESET_B VPWR VGND sg13cmos5l_dfrbpq_1
X_19446__776 _19446_/RESET_B VPWR VGND sg13cmos5l_tiehi
X_16939_ _19529_/D _16939_/A _17053_/A VPWR VGND sg13cmos5l_and2_1
XFILLER_38_755 VPWR VGND sg13cmos5l_fill_1
X_18598__1701 _18598_/RESET_B VPWR VGND sg13cmos5l_tiehi
X_19658_ _19658_/Q clkload12/A _19658_/D _19658_/RESET_B VPWR VGND sg13cmos5l_dfrbpq_1
XFILLER_80_511 VPWR VGND sg13cmos5l_fill_1
X_19589_ _19589_/Q clkload36/A _19589_/D _19589_/RESET_B VPWR VGND sg13cmos5l_dfrbpq_1
X_18609_ _18609_/Q clkload34/A _18609_/D _18609_/RESET_B VPWR VGND sg13cmos5l_dfrbpq_1
XFILLER_37_287 VPWR VGND sg13cmos5l_fill_2
Xclkbuf_leaf_17_clk clkload25/A clkbuf_4_4_0_clk/X VPWR VGND sg13cmos5l_buf_8
XFILLER_33_482 VPWR VGND sg13cmos5l_decap_4
X_19418__812 _19418_/RESET_B VPWR VGND sg13cmos5l_tiehi
X_18848__1424 _18848_/RESET_B VPWR VGND sg13cmos5l_tiehi
XFILLER_103_911 VPWR VGND sg13cmos5l_decap_4
XFILLER_103_900 VPWR VGND sg13cmos5l_fill_1
XFILLER_103_944 VPWR VGND sg13cmos5l_decap_8
XFILLER_0_515 VPWR VGND sg13cmos5l_decap_4
Xhold2731 _19786_/D _18554_/Y VPWR VGND sg13cmos5l_dlygate4sd3_1
Xhold2720 _10092_/A _19123_/Q VPWR VGND sg13cmos5l_dlygate4sd3_1
Xhold2742 _13735_/A _19052_/Q VPWR VGND sg13cmos5l_dlygate4sd3_1
Xhold2764 _11050_/C _11049_/Y VPWR VGND sg13cmos5l_dlygate4sd3_1
Xhold2753 hold2753/X _15164_/A VPWR VGND sg13cmos5l_dlygate4sd3_1
X_19425__805 _19425_/RESET_B VPWR VGND sg13cmos5l_tiehi
Xhold2786 _12860_/A _18926_/Q VPWR VGND sg13cmos5l_dlygate4sd3_1
Xhold2775 hold2775/X _18969_/Q VPWR VGND sg13cmos5l_dlygate4sd3_1
Xhold2797 _15983_/C _15982_/Y VPWR VGND sg13cmos5l_dlygate4sd3_1
X_10950_ _10989_/A _18637_/Q _10950_/B VPWR VGND sg13cmos5l_xnor2_1
XFILLER_71_533 VPWR VGND sg13cmos5l_fill_1
X_10881_ _18610_/D _15735_/A _11014_/B VPWR VGND sg13cmos5l_and2_1
X_12620_ _12657_/A _18873_/Q _12621_/B VPWR VGND sg13cmos5l_xnor2_1
XFILLER_43_246 VPWR VGND sg13cmos5l_fill_2
XFILLER_19_1000 VPWR VGND sg13cmos5l_fill_2
XFILLER_31_408 VPWR VGND sg13cmos5l_fill_1
XFILLER_106_1003 VPWR VGND sg13cmos5l_decap_8
X_12551_ _12551_/X _12538_/Y _12550_/Y _12535_/Y VPWR VGND sg13cmos5l_a21o_1
X_12482_ _12482_/Y _18814_/Q _12479_/Y _12481_/Y VPWR VGND sg13cmos5l_o21ai_1
X_11502_ _11581_/B _11582_/B _11502_/B VPWR VGND sg13cmos5l_nand2_1
X_15270_ _15270_/Y _15270_/A _15270_/B _15270_/C VPWR VGND sg13cmos5l_nor3_1
X_11433_ _11464_/A _11434_/B _11434_/C VPWR VGND sg13cmos5l_nand2_1
X_18991__1269 _18991_/RESET_B VPWR VGND sg13cmos5l_tiehi
X_19164__1084 _19164_/RESET_B VPWR VGND sg13cmos5l_tiehi
X_14221_ _14334_/C _14220_/A _14220_/B _14230_/A VPWR VGND sg13cmos5l_o21ai_1
X_14152_ _14152_/X _19080_/Q _19073_/Q _19074_/Q VPWR VGND sg13cmos5l_or3_1
X_11364_ _11364_/Y _11898_/A _18645_/Q VPWR VGND sg13cmos5l_nor2_1
XFILLER_98_419 VPWR VGND sg13cmos5l_fill_2
XFILLER_79_600 VPWR VGND sg13cmos5l_fill_1
X_13103_ _13103_/Y _13095_/Y _13099_/Y _13102_/Y VPWR VGND sg13cmos5l_o21ai_1
X_11295_ _11295_/Y _11295_/A _11295_/B VPWR VGND sg13cmos5l_nor2_1
X_10315_ _11107_/B _18604_/Q VPWR VGND sg13cmos5l_inv_1
X_18960_ _18960_/Q _19087_/CLK _18960_/D _18960_/RESET_B VPWR VGND sg13cmos5l_dfrbpq_1
X_14083_ _19100_/D _14083_/A _14083_/B VPWR VGND sg13cmos5l_nor2_1
X_18891_ _18891_/Q clkload71/A _18891_/D _18891_/RESET_B VPWR VGND sg13cmos5l_dfrbpq_1
XFILLER_79_611 VPWR VGND sg13cmos5l_fill_1
XFILLER_78_110 VPWR VGND sg13cmos5l_fill_1
X_13034_ _13034_/Y _13579_/A _18897_/Q _13033_/Y VPWR VGND sg13cmos5l_o21ai_1
X_17911_ _17912_/B _17911_/A _17911_/B VPWR VGND sg13cmos5l_xor2_1
X_10246_ _14407_/B _10246_/A VPWR VGND sg13cmos5l_inv_1
XFILLER_105_292 VPWR VGND sg13cmos5l_fill_1
XFILLER_78_121 VPWR VGND sg13cmos5l_fill_1
X_17842_ _17870_/B _19679_/Q _17843_/B VPWR VGND sg13cmos5l_xnor2_1
X_10177_ _18226_/A _10177_/A VPWR VGND sg13cmos5l_inv_1
X_17773_ _19652_/D _17943_/A _17862_/A VPWR VGND sg13cmos5l_and2_1
X_14985_ _15024_/A _14982_/B _14985_/B VPWR VGND sg13cmos5l_nand2b_1
X_16724_ _16724_/Y _16742_/A _16742_/B _16897_/A VPWR VGND sg13cmos5l_a21oi_1
X_19512_ _19512_/Q clkload36/A _19512_/D _19512_/RESET_B VPWR VGND sg13cmos5l_dfrbpq_1
X_13936_ _14036_/A _19090_/Q _13951_/B VPWR VGND sg13cmos5l_xnor2_1
X_16655_ _19483_/D _16655_/A _16655_/B VPWR VGND sg13cmos5l_and2_1
X_19443_ _19443_/Q clkload6/A _19443_/D _19443_/RESET_B VPWR VGND sg13cmos5l_dfrbpq_1
X_15606_ _15607_/C _15606_/A _15608_/B VPWR VGND sg13cmos5l_or2_1
X_13867_ _13867_/Y _13851_/A _13859_/S _14071_/B VPWR VGND sg13cmos5l_o21ai_1
X_13798_ _19040_/D _13772_/Y _13803_/A _13797_/Y VPWR VGND sg13cmos5l_a21oi_1
X_12818_ _12818_/X _12818_/A _12820_/B _12818_/C VPWR VGND sg13cmos5l_or3_1
X_16586_ _16586_/X _16586_/A _16586_/B VPWR VGND sg13cmos5l_or2_1
X_19374_ _19374_/Q clkload19/A _19374_/D _19374_/RESET_B VPWR VGND sg13cmos5l_dfrbpq_1
XFILLER_15_460 VPWR VGND sg13cmos5l_fill_2
X_12749_ _12764_/B _12767_/C _12748_/Y _12745_/Y VPWR VGND sg13cmos5l_o21ai_1
XFILLER_63_90 VPWR VGND sg13cmos5l_decap_4
X_19517__700 _19517_/RESET_B VPWR VGND sg13cmos5l_tiehi
X_15537_ _15537_/Y _19290_/Q _19283_/Q VPWR VGND sg13cmos5l_nor2_1
X_18325_ _18325_/Y _18316_/X _18318_/Y _18131_/Y VPWR VGND sg13cmos5l_a21oi_1
X_18256_ _18262_/A _18261_/A _18261_/B _18251_/A _18502_/A _18255_/Y VPWR VGND sg13cmos5l_a221oi_1
X_15468_ _15468_/Y _16010_/A _19270_/Q _15467_/Y VPWR VGND sg13cmos5l_o21ai_1
X_17207_ _19571_/D _17377_/A _17207_/B VPWR VGND sg13cmos5l_nor2_1
X_14419_ _19144_/D _14639_/B _14419_/B VPWR VGND sg13cmos5l_nor2_1
XFILLER_30_496 VPWR VGND sg13cmos5l_fill_1
X_18629__1667 _18629_/RESET_B VPWR VGND sg13cmos5l_tiehi
X_18187_ _18188_/A _18078_/Y _18202_/A _18187_/C VPWR VGND sg13cmos5l_nand3b_1
X_15399_ _15466_/B _15389_/A _15366_/X _15394_/B _15364_/Y VPWR VGND sg13cmos5l_a22oi_1
X_17138_ _17138_/Y _17119_/A _17136_/S _17375_/A VPWR VGND sg13cmos5l_o21ai_1
XFILLER_7_692 VPWR VGND sg13cmos5l_decap_4
X_17069_ _19533_/D _17071_/A _17069_/B VPWR VGND sg13cmos5l_nor2_1
Xclkbuf_leaf_6_clk clkload12/A clkbuf_4_1_0_clk/X VPWR VGND sg13cmos5l_buf_8
XFILLER_98_942 VPWR VGND sg13cmos5l_fill_1
Xhold2016 _12043_/A _18775_/Q VPWR VGND sg13cmos5l_dlygate4sd3_1
Xhold2005 hold2005/X _19604_/Q VPWR VGND sg13cmos5l_dlygate4sd3_1
Xhold2027 hold2027/X _19605_/Q VPWR VGND sg13cmos5l_dlygate4sd3_1
XFILLER_98_997 VPWR VGND sg13cmos5l_fill_2
Xhold2038 hold2038/X _19521_/Q VPWR VGND sg13cmos5l_dlygate4sd3_1
XFILLER_58_839 VPWR VGND sg13cmos5l_fill_1
XFILLER_57_305 VPWR VGND sg13cmos5l_fill_2
Xhold2049 _16370_/A _19443_/Q VPWR VGND sg13cmos5l_dlygate4sd3_1
XFILLER_38_530 VPWR VGND sg13cmos5l_fill_1
XFILLER_65_382 VPWR VGND sg13cmos5l_fill_1
XFILLER_81_853 VPWR VGND sg13cmos5l_fill_2
XFILLER_53_577 VPWR VGND sg13cmos5l_fill_1
XFILLER_13_408 VPWR VGND sg13cmos5l_fill_1
XFILLER_40_238 VPWR VGND sg13cmos5l_fill_2
X_11080_ _18627_/D _18486_/A _11084_/B VPWR VGND sg13cmos5l_and2_1
X_10100_ _14904_/A _14564_/A VPWR VGND sg13cmos5l_inv_1
X_10031_ _12190_/A _10031_/A VPWR VGND sg13cmos5l_inv_1
X_18772__521 _18772_/D VPWR VGND sg13cmos5l_tielo
XFILLER_0_334 VPWR VGND sg13cmos5l_decap_4
XFILLER_0_389 VPWR VGND sg13cmos5l_fill_2
XFILLER_0_378 VPWR VGND sg13cmos5l_decap_8
XFILLER_102_295 VPWR VGND sg13cmos5l_fill_2
Xhold2572 _10020_/A _18621_/Q VPWR VGND sg13cmos5l_dlygate4sd3_1
Xhold2583 _13949_/A _19088_/Q VPWR VGND sg13cmos5l_dlygate4sd3_1
Xhold2561 hold2561/X _16505_/Y VPWR VGND sg13cmos5l_dlygate4sd3_1
Xhold2550 _19464_/D _16558_/Y VPWR VGND sg13cmos5l_dlygate4sd3_1
Xhold1860 _10880_/B _19775_/Q VPWR VGND sg13cmos5l_dlygate4sd3_1
XFILLER_57_861 VPWR VGND sg13cmos5l_fill_2
Xhold2594 _15137_/B _15136_/X VPWR VGND sg13cmos5l_dlygate4sd3_1
Xhold1871 _15809_/B _19323_/Q VPWR VGND sg13cmos5l_dlygate4sd3_1
X_14770_ _14868_/C _19195_/Q _19156_/Q _19215_/Q VPWR VGND sg13cmos5l_nand3_1
XFILLER_29_563 VPWR VGND sg13cmos5l_fill_1
X_11982_ _12022_/A _18741_/Q _11982_/B VPWR VGND sg13cmos5l_xnor2_1
X_13721_ _13780_/A _13694_/Y _13719_/A _13720_/X VPWR VGND sg13cmos5l_a21oi_1
Xhold1882 _11618_/B _18667_/Q VPWR VGND sg13cmos5l_dlygate4sd3_1
Xhold1893 _18272_/B _19749_/Q VPWR VGND sg13cmos5l_dlygate4sd3_1
XFILLER_1_1028 VPWR VGND sg13cmos5l_fill_1
XFILLER_29_596 VPWR VGND sg13cmos5l_fill_1
X_10933_ _10947_/B _18620_/Q _10945_/C VPWR VGND sg13cmos5l_nor2_1
X_13652_ _19035_/D _13652_/A _13804_/A VPWR VGND sg13cmos5l_nor2_1
X_10864_ _10864_/Y _11110_/A _10865_/S _10863_/Y VPWR VGND sg13cmos5l_a21oi_1
X_16440_ _16469_/B _16434_/X _16438_/Y _16439_/Y VPWR VGND sg13cmos5l_a21oi_1
X_12603_ _12603_/Y _12688_/B _12704_/A _12603_/C VPWR VGND sg13cmos5l_nand3_1
X_10795_ _10807_/B _10795_/A input5/X _10795_/C VPWR VGND sg13cmos5l_and3_1
X_13583_ _19013_/D _13583_/A _13583_/B VPWR VGND sg13cmos5l_and2_1
X_16371_ _16371_/Y _16356_/B hold2050/X _16555_/B VPWR VGND sg13cmos5l_a21oi_1
X_12534_ _12535_/B _18826_/Q _12534_/B VPWR VGND sg13cmos5l_xnor2_1
X_19090_ _19090_/Q _19092_/CLK _19090_/D _19090_/RESET_B VPWR VGND sg13cmos5l_dfrbpq_1
X_15322_ _15334_/A _15322_/A _15419_/A VPWR VGND sg13cmos5l_nor2_1
X_18110_ _18117_/B _19715_/Q _19716_/Q _19717_/Q VPWR VGND sg13cmos5l_o21ai_1
XFILLER_8_434 VPWR VGND sg13cmos5l_fill_1
XFILLER_12_474 VPWR VGND sg13cmos5l_decap_4
X_18041_ _18041_/Y _18041_/A _18057_/B VPWR VGND sg13cmos5l_nor2_1
X_12465_ _18845_/D _12467_/A _12465_/B VPWR VGND sg13cmos5l_nor2_1
XFILLER_8_456 VPWR VGND sg13cmos5l_fill_1
X_15253_ _15253_/Y hold2069/X fanout90/X _14708_/A VPWR VGND sg13cmos5l_o21ai_1
X_12396_ _12399_/B _12435_/A _12434_/A VPWR VGND sg13cmos5l_nor2_1
X_11416_ _11416_/Y _18647_/Q fanout76/X _11152_/A VPWR VGND sg13cmos5l_o21ai_1
X_15184_ _19258_/D _15184_/A _15188_/B VPWR VGND sg13cmos5l_nor2_1
X_14204_ _19119_/D _14377_/A _14204_/B VPWR VGND sg13cmos5l_nor2_1
X_11347_ _18664_/D hold2809/X _11342_/S _11346_/Y VPWR VGND sg13cmos5l_a21oi_1
XFILLER_4_662 VPWR VGND sg13cmos5l_decap_4
X_14135_ _14135_/Y _14392_/B _14135_/B VPWR VGND sg13cmos5l_nand2_1
X_18943_ _18943_/Q _19003_/CLK _18943_/D _18943_/RESET_B VPWR VGND sg13cmos5l_dfrbpq_1
X_11278_ _11278_/Y _11620_/A _11452_/A VPWR VGND sg13cmos5l_nand2_1
X_14066_ _14066_/Y _14054_/B _14062_/S _14071_/B VPWR VGND sg13cmos5l_o21ai_1
XFILLER_3_183 VPWR VGND sg13cmos5l_fill_1
X_13017_ _18921_/D _13017_/A _13020_/B VPWR VGND sg13cmos5l_nor2_1
X_18874_ _18874_/Q _18931_/CLK _18874_/D _18874_/RESET_B VPWR VGND sg13cmos5l_dfrbpq_1
X_10229_ _10229_/Y _14932_/A VPWR VGND sg13cmos5l_inv_1
XFILLER_66_113 VPWR VGND sg13cmos5l_decap_8
X_17825_ _17825_/Y _17870_/A _18029_/A VPWR VGND sg13cmos5l_nand2b_1
X_19408__822 _19408_/RESET_B VPWR VGND sg13cmos5l_tiehi
X_17756_ _17756_/X _17752_/X _17754_/Y _17755_/Y VPWR VGND sg13cmos5l_a21o_1
X_16707_ _16707_/Y _16707_/A VPWR VGND sg13cmos5l_inv_1
X_14968_ _14968_/Y _15210_/B _14968_/B VPWR VGND sg13cmos5l_nand2_1
XFILLER_35_522 VPWR VGND sg13cmos5l_fill_2
X_13919_ _19075_/D _14080_/A _13919_/B VPWR VGND sg13cmos5l_nor2_1
X_17687_ _17693_/C _17683_/Y _17685_/Y _17686_/Y VPWR VGND sg13cmos5l_o21ai_1
X_14899_ _14899_/Y _14887_/B _14895_/S _14916_/A VPWR VGND sg13cmos5l_o21ai_1
XFILLER_35_555 VPWR VGND sg13cmos5l_fill_2
X_16638_ _16656_/A _19031_/Q _19032_/Q VPWR VGND sg13cmos5l_xor2_1
X_19426_ _19426_/Q clkload7/A _19426_/D _19426_/RESET_B VPWR VGND sg13cmos5l_dfrbpq_1
X_16569_ _16569_/Y _19493_/Q _16588_/A _16593_/B _19494_/Q _16568_/Y VPWR VGND sg13cmos5l_a221oi_1
X_19357_ _19357_/Q _19462_/CLK _19357_/D _19357_/RESET_B VPWR VGND sg13cmos5l_dfrbpq_1
X_18308_ _18308_/Y _18472_/A _18305_/X _18326_/A _18307_/X VPWR VGND sg13cmos5l_a22oi_1
X_19288_ _19288_/Q clkload16/A _19288_/D _19288_/RESET_B VPWR VGND sg13cmos5l_dfrbpq_1
X_18888__1381 _18888_/RESET_B VPWR VGND sg13cmos5l_tiehi
X_18239_ _18239_/Y _18258_/A _19683_/Q _19684_/Q _18264_/A _18238_/Y VPWR VGND sg13cmos5l_a221oi_1
X_19415__815 _19415_/RESET_B VPWR VGND sg13cmos5l_tiehi
XFILLER_98_750 VPWR VGND sg13cmos5l_fill_2
XFILLER_98_761 VPWR VGND sg13cmos5l_fill_1
XFILLER_58_647 VPWR VGND sg13cmos5l_fill_1
X_19137__1114 _19137_/RESET_B VPWR VGND sg13cmos5l_tiehi
X_19598__613 _19598_/RESET_B VPWR VGND sg13cmos5l_tiehi
X_18660__1633 _18660_/RESET_B VPWR VGND sg13cmos5l_tiehi
X_19422__808 _19422_/RESET_B VPWR VGND sg13cmos5l_tiehi
XFILLER_54_864 VPWR VGND sg13cmos5l_decap_4
XFILLER_26_599 VPWR VGND sg13cmos5l_fill_1
XFILLER_103_1017 VPWR VGND sg13cmos5l_fill_1
X_10580_ _10582_/A _10580_/A _10580_/B VPWR VGND sg13cmos5l_nand2_1
X_12250_ _12250_/Y _12498_/B _12238_/Y _12249_/Y VPWR VGND sg13cmos5l_a21oi_1
X_18910__1356 _18910_/RESET_B VPWR VGND sg13cmos5l_tiehi
X_12181_ _12181_/Y hold2855/X _12175_/Y _12180_/Y VPWR VGND sg13cmos5l_a21oi_1
X_11201_ _11202_/B _11201_/A _11201_/B VPWR VGND sg13cmos5l_nor2_1
X_11132_ _11132_/Y _11618_/B _12528_/A VPWR VGND sg13cmos5l_nand2b_1
XFILLER_95_208 VPWR VGND sg13cmos5l_fill_2
X_11063_ _11063_/Y _11054_/Y _11060_/Y _11062_/Y VPWR VGND sg13cmos5l_a21oi_1
X_15940_ _16120_/A _16308_/A _15951_/B VPWR VGND sg13cmos5l_nand2_1
X_19507__710 _19507_/RESET_B VPWR VGND sg13cmos5l_tiehi
X_10014_ _10014_/Y _11014_/A VPWR VGND sg13cmos5l_inv_1
XFILLER_49_636 VPWR VGND sg13cmos5l_fill_2
XFILLER_0_186 VPWR VGND sg13cmos5l_fill_1
X_15871_ _15890_/A _19385_/Q _15884_/B VPWR VGND sg13cmos5l_or2_1
XFILLER_92_915 VPWR VGND sg13cmos5l_fill_1
Xhold2391 _10367_/A _19473_/Q VPWR VGND sg13cmos5l_dlygate4sd3_1
X_17610_ _17610_/X _17607_/Y _17606_/X _17610_/S VPWR VGND sg13cmos5l_mux2_1
Xhold2380 _18939_/D _13078_/Y VPWR VGND sg13cmos5l_dlygate4sd3_1
X_14822_ _14823_/A _19227_/Q _14822_/B VPWR VGND sg13cmos5l_xnor2_1
X_18590_ _18590_/Q _19814_/CLK _18590_/D _18590_/RESET_B VPWR VGND sg13cmos5l_dfrbpq_1
XFILLER_91_469 VPWR VGND sg13cmos5l_fill_1
X_11965_ _18775_/D _10008_/Y fanout79/X _11964_/Y VPWR VGND sg13cmos5l_a21oi_1
X_17541_ _17592_/A _19618_/Q _17751_/A VPWR VGND sg13cmos5l_xnor2_1
XFILLER_45_842 VPWR VGND sg13cmos5l_fill_1
X_14753_ _19202_/D _14913_/A _14840_/A VPWR VGND sg13cmos5l_nor2_1
X_13704_ _13814_/B _13705_/B _13705_/C VPWR VGND sg13cmos5l_and2_1
X_17472_ _17472_/Y _17473_/A _17495_/B VPWR VGND sg13cmos5l_nor2_1
X_10916_ _18612_/D _11084_/B _11036_/A VPWR VGND sg13cmos5l_and2_1
X_14684_ _14684_/Y _14947_/B _14684_/B VPWR VGND sg13cmos5l_nor2_1
XFILLER_32_503 VPWR VGND sg13cmos5l_fill_1
X_13635_ _19022_/D _16593_/B _13632_/S _13634_/Y VPWR VGND sg13cmos5l_a21oi_1
X_11896_ _18755_/D _11896_/A _11904_/A VPWR VGND sg13cmos5l_and2_1
X_19211_ _19211_/Q _19304_/CLK _19211_/D _19211_/RESET_B VPWR VGND sg13cmos5l_dfrbpq_1
X_16423_ _16423_/X _16423_/A _16457_/A _16457_/B VPWR VGND sg13cmos5l_and3_1
X_10847_ _10847_/Y _18600_/Q _10833_/Y _10843_/Y VPWR VGND sg13cmos5l_a21oi_1
X_19142_ _19142_/Q clkload49/A _19142_/D _19142_/RESET_B VPWR VGND sg13cmos5l_dfrbpq_1
X_10778_ _13653_/B _13812_/A _10778_/B VPWR VGND sg13cmos5l_xnor2_1
X_19514__703 _19514_/RESET_B VPWR VGND sg13cmos5l_tiehi
X_13566_ _18998_/D hold2880/X fanout47/X _13565_/Y VPWR VGND sg13cmos5l_a21oi_1
X_16354_ _16356_/B _19453_/Q _16409_/A _16073_/A _19401_/Q VPWR VGND sg13cmos5l_a22oi_1
X_12517_ _12517_/Y _12503_/B _12509_/S _12579_/A VPWR VGND sg13cmos5l_o21ai_1
X_13497_ _13500_/D _13497_/A _13503_/B _13503_/C VPWR VGND sg13cmos5l_nand3_1
X_19073_ _19073_/Q clkload54/A _19073_/D _19073_/RESET_B VPWR VGND sg13cmos5l_dfrbpq_1
X_16285_ _16285_/Y _16265_/Y _16279_/Y _16284_/Y VPWR VGND sg13cmos5l_o21ai_1
X_15305_ _19287_/D _15464_/A _15398_/A VPWR VGND sg13cmos5l_nor2_1
X_12448_ _12449_/B _12408_/A _12407_/Y _12451_/A VPWR VGND sg13cmos5l_mux2_1
X_18024_ _18024_/Y _18010_/Y _18019_/X _18061_/A _18029_/A _18022_/X VPWR VGND sg13cmos5l_a221oi_1
X_15236_ _15236_/Y _15218_/B _15238_/B _15465_/A VPWR VGND sg13cmos5l_o21ai_1
X_12379_ _12379_/Y _18815_/Q _18776_/Q VPWR VGND sg13cmos5l_xnor2_1
X_15167_ _15167_/Y _15179_/A _15167_/B VPWR VGND sg13cmos5l_nor2_1
X_15098_ _15101_/A _15108_/A _15098_/B VPWR VGND sg13cmos5l_nor2_1
X_14118_ _14118_/Y _10094_/A _14643_/A _14098_/B _19065_/Q VPWR VGND sg13cmos5l_a22oi_1
XFILLER_101_508 VPWR VGND sg13cmos5l_fill_2
X_18926_ _18926_/Q _18931_/CLK _18926_/D _18926_/RESET_B VPWR VGND sg13cmos5l_dfrbpq_1
XFILLER_86_208 VPWR VGND sg13cmos5l_fill_2
X_14049_ _14056_/A _14048_/Y _14049_/B VPWR VGND sg13cmos5l_nand2b_1
X_18857_ _18857_/Q _18902_/CLK _18857_/D _18857_/RESET_B VPWR VGND sg13cmos5l_dfrbpq_1
X_18788_ _18788_/Q clkload61/A _18788_/D _18788_/RESET_B VPWR VGND sg13cmos5l_dfrbpq_1
X_17808_ _17809_/B _17808_/A _17808_/B VPWR VGND sg13cmos5l_xnor2_1
XFILLER_36_831 VPWR VGND sg13cmos5l_fill_2
XFILLER_82_447 VPWR VGND sg13cmos5l_fill_1
XFILLER_70_609 VPWR VGND sg13cmos5l_fill_2
X_17739_ _19650_/D _17739_/A _17739_/B VPWR VGND sg13cmos5l_and2_1
XFILLER_35_341 VPWR VGND sg13cmos5l_decap_8
X_18786__1489 _18786_/RESET_B VPWR VGND sg13cmos5l_tiehi
X_19409_ _19409_/Q clkload5/A _19409_/D _19409_/RESET_B VPWR VGND sg13cmos5l_dfrbpq_1
X_18723__526 _18723_/D VPWR VGND sg13cmos5l_tielo
X_18678__1615 _18678_/RESET_B VPWR VGND sg13cmos5l_tiehi
XFILLER_2_407 VPWR VGND sg13cmos5l_fill_1
XFILLER_58_411 VPWR VGND sg13cmos5l_fill_1
XFILLER_100_563 VPWR VGND sg13cmos5l_fill_1
XFILLER_59_989 VPWR VGND sg13cmos5l_decap_4
XFILLER_59_978 VPWR VGND sg13cmos5l_decap_8
Xheichips26_digital_project_1799 uio_oe[2] VPWR VGND sg13cmos5l_tiehi
X_11750_ _11750_/Y _11748_/Y _11749_/Y _11747_/Y VPWR VGND sg13cmos5l_a21oi_1
X_18928__1338 _18928_/RESET_B VPWR VGND sg13cmos5l_tiehi
XFILLER_54_661 VPWR VGND sg13cmos5l_fill_1
XFILLER_26_341 VPWR VGND sg13cmos5l_fill_1
XFILLER_26_374 VPWR VGND sg13cmos5l_fill_2
X_10701_ _10708_/B _13813_/A _10758_/B _10695_/Y VPWR VGND sg13cmos5l_o21ai_1
X_18624__1672 _18624_/RESET_B VPWR VGND sg13cmos5l_tiehi
X_11681_ _11681_/Y _11937_/B _11669_/Y _11680_/Y VPWR VGND sg13cmos5l_a21oi_1
X_13420_ _13420_/Y _13420_/A _13420_/B _13420_/C VPWR VGND sg13cmos5l_nand3_1
X_10632_ _10634_/B _10632_/A _10633_/A VPWR VGND sg13cmos5l_nor2b_1
X_13351_ _13351_/Y _18983_/Q fanout97/X _13573_/A VPWR VGND sg13cmos5l_o21ai_1
X_19357__879 _19357_/RESET_B VPWR VGND sg13cmos5l_tiehi
X_10563_ _10564_/B _10579_/A _18380_/A VPWR VGND sg13cmos5l_nand2_1
X_12302_ _18823_/D _12462_/B _12302_/B VPWR VGND sg13cmos5l_nor2_1
X_16070_ _19399_/D _16344_/A _16063_/S _16069_/Y VPWR VGND sg13cmos5l_a21oi_1
X_13282_ _13282_/Y _13282_/A _13282_/B VPWR VGND sg13cmos5l_nand2_1
X_15021_ _15021_/X _15021_/A _15024_/B VPWR VGND sg13cmos5l_and2_1
X_10494_ _10499_/A _10493_/A _10493_/B _18380_/A VPWR VGND sg13cmos5l_a21o_1
X_12233_ _12233_/Y _12233_/A VPWR VGND sg13cmos5l_inv_1
X_12164_ _12164_/Y _12172_/A _12172_/B VPWR VGND sg13cmos5l_nand2_1
X_12095_ _12287_/A _12462_/A _12095_/B VPWR VGND sg13cmos5l_xnor2_1
X_16972_ _16972_/Y _19538_/Q _16972_/B VPWR VGND sg13cmos5l_xnor2_1
X_11115_ _11121_/A _11120_/A _11120_/B _11113_/A _10305_/Y _11114_/Y VPWR VGND sg13cmos5l_a221oi_1
XFILLER_49_400 VPWR VGND sg13cmos5l_fill_2
X_19760_ _19760_/Q clkload23/A _19760_/D _19760_/RESET_B VPWR VGND sg13cmos5l_dfrbpq_1
XFILLER_89_580 VPWR VGND sg13cmos5l_fill_1
X_18711_ _18711_/Q _18733_/CLK _18711_/D _18711_/RESET_B VPWR VGND sg13cmos5l_dfrbpq_1
X_11046_ _11046_/Y _11034_/Y _11037_/Y _11047_/A _11047_/B VPWR VGND sg13cmos5l_a22oi_1
X_15923_ _15923_/Y _16314_/A _15923_/B VPWR VGND sg13cmos5l_xnor2_1
X_19691_ _19691_/Q clkload35/A _19691_/D _19691_/RESET_B VPWR VGND sg13cmos5l_dfrbpq_1
X_18741__1537 _18741_/RESET_B VPWR VGND sg13cmos5l_tiehi
XFILLER_77_786 VPWR VGND sg13cmos5l_fill_2
X_18642_ _18642_/Q _18733_/CLK _18642_/D _18642_/RESET_B VPWR VGND sg13cmos5l_dfrbpq_1
XFILLER_37_617 VPWR VGND sg13cmos5l_fill_1
X_15854_ _15933_/A _15841_/X _15852_/Y _15851_/Y VPWR VGND sg13cmos5l_a21o_1
XFILLER_18_820 VPWR VGND sg13cmos5l_fill_2
X_18573_ _18573_/Q clkload29/A _18573_/D _18573_/RESET_B VPWR VGND sg13cmos5l_dfrbpq_1
X_14805_ _14828_/A _19221_/Q _14805_/B VPWR VGND sg13cmos5l_xnor2_1
X_15785_ _15787_/A _19358_/Q _15782_/Y _15784_/Y _19359_/Q _15783_/Y VPWR VGND sg13cmos5l_a221oi_1
X_18785__520 _18785_/D VPWR VGND sg13cmos5l_tielo
XFILLER_91_266 VPWR VGND sg13cmos5l_fill_1
X_12997_ _12998_/C _12997_/A _13013_/B VPWR VGND sg13cmos5l_or2_1
XFILLER_73_970 VPWR VGND sg13cmos5l_decap_4
X_17524_ _17645_/A _17507_/A _17522_/B _17523_/Y VPWR VGND sg13cmos5l_a21o_1
X_14736_ _14736_/X _14735_/A _14735_/B _14564_/Y VPWR VGND sg13cmos5l_a21o_1
XFILLER_33_801 VPWR VGND sg13cmos5l_fill_1
X_11948_ _11948_/Y _11921_/Y fanout55/X _12199_/A VPWR VGND sg13cmos5l_o21ai_1
X_11879_ _11879_/Y _11767_/A _11767_/B _11870_/Y _11877_/Y _11878_/Y VPWR VGND sg13cmos5l_a221oi_1
X_17455_ _17455_/X _17455_/A _17490_/A VPWR VGND sg13cmos5l_and2_1
X_14667_ _14667_/Y _14667_/A VPWR VGND sg13cmos5l_inv_1
X_13618_ _13618_/Y _16588_/A _13613_/A _13617_/A _16593_/B _13614_/Y VPWR VGND sg13cmos5l_a221oi_1
X_17386_ _17386_/Y _19622_/Q _17392_/B _19559_/Q _17936_/A VPWR VGND sg13cmos5l_a22oi_1
X_14598_ _14598_/Y _14477_/B _14611_/B _14594_/B _14610_/B _14596_/Y VPWR VGND sg13cmos5l_a221oi_1
X_16406_ _16406_/Y _16406_/A VPWR VGND sg13cmos5l_inv_1
XFILLER_71_90 VPWR VGND sg13cmos5l_fill_2
X_13549_ _13557_/B _13585_/B _13548_/B _13548_/Y VPWR VGND sg13cmos5l_o21ai_1
XFILLER_9_551 VPWR VGND sg13cmos5l_decap_8
XFILLER_13_591 VPWR VGND sg13cmos5l_fill_2
X_16337_ _16338_/A _16336_/Y _16335_/Y _16350_/C VPWR VGND sg13cmos5l_mux2_1
X_19125_ _19125_/Q clkload49/A _19125_/D _19125_/RESET_B VPWR VGND sg13cmos5l_dfrbpq_1
X_19056_ _19056_/Q clkload30/A _19056_/D _19056_/RESET_B VPWR VGND sg13cmos5l_dfrbpq_1
X_19588__623 _19588_/RESET_B VPWR VGND sg13cmos5l_tiehi
X_19412__818 _19412_/RESET_B VPWR VGND sg13cmos5l_tiehi
X_16268_ _16268_/Y _16268_/A _16268_/B _16268_/C VPWR VGND sg13cmos5l_nor3_1
X_18007_ _18021_/B _19653_/Q _19654_/Q _19651_/Q _19652_/Q VPWR VGND sg13cmos5l_nor4_1
Xheichips26_digital_project_416 uo_out[7] VPWR VGND sg13cmos5l_tielo
X_16199_ _16199_/Y _16182_/X _16192_/Y _16432_/A _16249_/A _16197_/X VPWR VGND sg13cmos5l_a221oi_1
X_15219_ _15219_/Y _10217_/Y _15209_/A _15213_/X _15218_/X _15214_/X VPWR VGND sg13cmos5l_a221oi_1
Xheichips26_digital_project_405 uio_out[5] VPWR VGND sg13cmos5l_tielo
XFILLER_5_790 VPWR VGND sg13cmos5l_decap_4
X_19177__1071 _19177_/RESET_B VPWR VGND sg13cmos5l_tiehi
X_18909_ _18909_/Q clkload64/A _18909_/D _18909_/RESET_B VPWR VGND sg13cmos5l_dfrbpq_1
XFILLER_67_252 VPWR VGND sg13cmos5l_fill_2
X_19595__616 _19595_/RESET_B VPWR VGND sg13cmos5l_tiehi
XFILLER_35_39 VPWR VGND sg13cmos5l_fill_2
XFILLER_35_182 VPWR VGND sg13cmos5l_decap_8
XFILLER_51_16 VPWR VGND sg13cmos5l_fill_2
XFILLER_13_1028 VPWR VGND sg13cmos5l_fill_1
XFILLER_2_204 VPWR VGND sg13cmos5l_fill_1
XFILLER_105_644 VPWR VGND sg13cmos5l_fill_2
XFILLER_105_677 VPWR VGND sg13cmos5l_fill_2
XFILLER_76_57 VPWR VGND sg13cmos5l_fill_2
X_19714__1502 _19714_/RESET_B VPWR VGND sg13cmos5l_tiehi
X_19504__713 _19504_/RESET_B VPWR VGND sg13cmos5l_tiehi
X_12920_ _12920_/Y _12948_/B _12960_/B _12919_/Y VPWR VGND sg13cmos5l_o21ai_1
X_12851_ _12853_/B _12826_/Y _12850_/Y _12849_/X VPWR VGND sg13cmos5l_a21oi_1
XFILLER_62_907 VPWR VGND sg13cmos5l_fill_1
X_11802_ _11802_/Y _18764_/Q _11803_/B VPWR VGND sg13cmos5l_xnor2_1
XFILLER_55_970 VPWR VGND sg13cmos5l_fill_1
XFILLER_46_469 VPWR VGND sg13cmos5l_fill_2
X_12782_ _12782_/Y _12764_/A fanout50/X _12781_/Y VPWR VGND sg13cmos5l_a21oi_1
X_15570_ _15572_/A _15570_/A _15570_/B _15570_/C VPWR VGND sg13cmos5l_nand3_1
XFILLER_27_683 VPWR VGND sg13cmos5l_fill_1
X_11733_ _11735_/B _11824_/A _11824_/B VPWR VGND sg13cmos5l_and2_1
X_14521_ _14541_/B _19179_/Q _19180_/Q VPWR VGND sg13cmos5l_or2_1
X_11664_ _11664_/Y _11932_/A _11658_/A _11666_/B _11937_/B VPWR VGND sg13cmos5l_a22oi_1
X_17240_ _17263_/B _19589_/Q _19590_/Q _19591_/Q _19592_/Q VPWR VGND sg13cmos5l_nor4_1
XFILLER_42_697 VPWR VGND sg13cmos5l_fill_1
X_14452_ _14486_/A _19119_/Q _14452_/B VPWR VGND sg13cmos5l_xnor2_1
XFILLER_30_826 VPWR VGND sg13cmos5l_fill_2
X_17171_ _17171_/Y _17171_/A _17204_/A VPWR VGND sg13cmos5l_nor2_1
X_13403_ _13500_/B _13394_/A _13394_/B _13401_/X VPWR VGND sg13cmos5l_o21ai_1
X_10615_ _10615_/Y _10605_/A _10605_/B _10611_/Y _10614_/A VPWR VGND sg13cmos5l_a22oi_1
X_11595_ _11596_/C _11595_/A _11595_/B _11595_/C VPWR VGND sg13cmos5l_and3_1
X_16122_ _16123_/B _16226_/A _16226_/B VPWR VGND sg13cmos5l_and2_1
X_14383_ _14383_/Y _14907_/A _19105_/Q _19106_/Q _14908_/A _14382_/Y VPWR VGND sg13cmos5l_a221oi_1
X_19511__706 _19511_/RESET_B VPWR VGND sg13cmos5l_tiehi
X_13334_ _13336_/A _18980_/Q _13331_/Y _13333_/Y _18981_/Q _13332_/Y VPWR VGND sg13cmos5l_a221oi_1
X_10546_ _10549_/B _19789_/Q _10546_/B VPWR VGND sg13cmos5l_xor2_1
X_18759__1519 _18759_/RESET_B VPWR VGND sg13cmos5l_tiehi
X_13265_ _13282_/A _13265_/A _13264_/Y VPWR VGND sg13cmos5l_nor2b_1
XFILLER_6_587 VPWR VGND sg13cmos5l_decap_4
XFILLER_6_565 VPWR VGND sg13cmos5l_fill_1
X_16053_ _16053_/Y _16554_/A _19422_/Q VPWR VGND sg13cmos5l_nor2_1
X_10477_ _10479_/B _19739_/Q _10483_/B VPWR VGND sg13cmos5l_nor2b_1
X_12216_ _12216_/Y _12724_/A _18834_/Q _12231_/C VPWR VGND sg13cmos5l_nor3_1
X_15004_ _15004_/Y _15004_/A _15011_/B VPWR VGND sg13cmos5l_nor2_1
X_19812_ _19812_/Q clkload27/A _19812_/D _19812_/RESET_B VPWR VGND sg13cmos5l_dfrbpq_1
X_13196_ _13196_/Y _13196_/A _13196_/B VPWR VGND sg13cmos5l_nor2_1
X_12147_ _12148_/C _12147_/A _12147_/B VPWR VGND sg13cmos5l_xnor2_1
X_12078_ _12078_/Y _12460_/A _12078_/B VPWR VGND sg13cmos5l_xnor2_1
X_16955_ _16967_/A _19542_/Q _17058_/B _16954_/Y VPWR VGND sg13cmos5l_a21o_1
X_19743_ _19743_/Q clkload22/A _19743_/D _19743_/RESET_B VPWR VGND sg13cmos5l_dfrbpq_1
X_16886_ _16886_/Y _09977_/Y fanout87/X _16885_/Y VPWR VGND sg13cmos5l_a21oi_1
X_11029_ _11030_/B _11089_/B _11051_/B _11028_/Y VPWR VGND sg13cmos5l_a21oi_1
X_19674_ _19674_/Q clkload11/A _19674_/D _19674_/RESET_B VPWR VGND sg13cmos5l_dfrbpq_1
X_15906_ _15907_/B _15912_/C _19376_/Q _19377_/Q VPWR VGND sg13cmos5l_o21ai_1
XFILLER_92_531 VPWR VGND sg13cmos5l_decap_8
XFILLER_66_90 VPWR VGND sg13cmos5l_fill_2
X_18625_ _18625_/Q clkload21/A _18625_/D _18625_/RESET_B VPWR VGND sg13cmos5l_dfrbpq_1
XFILLER_37_436 VPWR VGND sg13cmos5l_fill_1
X_15837_ _15851_/B _15827_/Y _15832_/Y _15856_/B _15840_/A _15834_/Y VPWR VGND sg13cmos5l_a221oi_1
XFILLER_53_929 VPWR VGND sg13cmos5l_fill_1
XFILLER_46_981 VPWR VGND sg13cmos5l_fill_2
X_18556_ _19787_/D _10614_/A _10627_/Y _18555_/Y VPWR VGND sg13cmos5l_a21oi_1
XFILLER_17_160 VPWR VGND sg13cmos5l_fill_2
X_15768_ _15768_/X _15768_/A _15768_/B VPWR VGND sg13cmos5l_and2_1
XFILLER_61_962 VPWR VGND sg13cmos5l_decap_8
X_17507_ _17528_/A _17507_/A _17522_/B VPWR VGND sg13cmos5l_nor2_1
X_18487_ _18487_/Y _19724_/Q _11081_/A _18484_/Y _18485_/Y _18486_/Y VPWR VGND sg13cmos5l_a221oi_1
X_14719_ _14724_/A _14725_/B _14725_/C _14725_/A VPWR VGND sg13cmos5l_a21o_1
X_15699_ _15699_/Y _15743_/B _15710_/B _15698_/Y VPWR VGND sg13cmos5l_a21oi_1
XFILLER_60_483 VPWR VGND sg13cmos5l_fill_2
X_17438_ _19607_/D _17439_/A _17438_/B VPWR VGND sg13cmos5l_and2_1
X_17369_ _19586_/D _17369_/A _17370_/B VPWR VGND sg13cmos5l_nor2_1
XFILLER_70_0 VPWR VGND sg13cmos5l_fill_2
X_19075__1179 _19075_/RESET_B VPWR VGND sg13cmos5l_tiehi
X_19108_ _19108_/Q _19262_/CLK _19108_/D _19108_/RESET_B VPWR VGND sg13cmos5l_dfrbpq_1
X_19039_ _19039_/Q clkload31/A _19039_/D _19039_/RESET_B VPWR VGND sg13cmos5l_dfrbpq_1
Xhold2913 _11273_/A _18681_/Q VPWR VGND sg13cmos5l_dlygate4sd3_1
Xhold2902 hold2902/X _14054_/A VPWR VGND sg13cmos5l_dlygate4sd3_1
Xhold2957 _12618_/A _18888_/Q VPWR VGND sg13cmos5l_dlygate4sd3_1
Xhold2946 _13229_/A _18968_/Q VPWR VGND sg13cmos5l_dlygate4sd3_1
Xhold2924 hold2924/X _15179_/Y VPWR VGND sg13cmos5l_dlygate4sd3_1
Xhold2935 _16274_/C _16273_/Y VPWR VGND sg13cmos5l_dlygate4sd3_1
Xhold2968 _18369_/A _19753_/Q VPWR VGND sg13cmos5l_dlygate4sd3_1
Xhold2979 _10884_/A _19780_/Q VPWR VGND sg13cmos5l_dlygate4sd3_1
X_18968__1295 _18968_/RESET_B VPWR VGND sg13cmos5l_tiehi
XFILLER_68_594 VPWR VGND sg13cmos5l_fill_1
X_19347__889 _19347_/RESET_B VPWR VGND sg13cmos5l_tiehi
XFILLER_44_918 VPWR VGND sg13cmos5l_fill_2
XFILLER_83_597 VPWR VGND sg13cmos5l_fill_2
XFILLER_102_88 VPWR VGND sg13cmos5l_fill_1
XFILLER_51_472 VPWR VGND sg13cmos5l_fill_2
XFILLER_12_859 VPWR VGND sg13cmos5l_fill_2
XFILLER_7_329 VPWR VGND sg13cmos5l_decap_8
X_19217__1028 _19217_/RESET_B VPWR VGND sg13cmos5l_tiehi
X_11380_ _11381_/A _11393_/C _11378_/Y _11379_/Y VPWR VGND sg13cmos5l_o21ai_1
X_10400_ _10400_/Y _10400_/A _10400_/B VPWR VGND sg13cmos5l_nand2_1
X_10331_ _18499_/B _10331_/A VPWR VGND sg13cmos5l_inv_1
X_13050_ _13050_/Y _13050_/A _18898_/Q _13056_/C VPWR VGND sg13cmos5l_nor3_1
X_10262_ _10262_/Y _13313_/A VPWR VGND sg13cmos5l_inv_1
X_12001_ _12109_/A _12001_/A _12023_/B _12023_/C VPWR VGND sg13cmos5l_nand3_1
X_10193_ _18509_/A _10535_/A VPWR VGND sg13cmos5l_inv_1
X_18781__1494 _18781_/RESET_B VPWR VGND sg13cmos5l_tiehi
X_16740_ _16925_/A _16916_/A _16897_/A VPWR VGND sg13cmos5l_and2_1
Xfanout371 _16624_/A _17150_/A VPWR VGND sg13cmos5l_buf_1
Xfanout393 _14070_/A _13573_/A VPWR VGND sg13cmos5l_buf_1
X_13952_ _13952_/Y _13952_/A _13952_/B VPWR VGND sg13cmos5l_xnor2_1
XFILLER_19_403 VPWR VGND sg13cmos5l_fill_1
Xfanout360 _10859_/A _10195_/Y VPWR VGND sg13cmos5l_buf_1
Xfanout382 _15453_/A _14708_/A VPWR VGND sg13cmos5l_buf_1
X_12903_ _12912_/B _18916_/Q _18915_/Q _12932_/A _18914_/Q VPWR VGND sg13cmos5l_nor4_1
XFILLER_4_1026 VPWR VGND sg13cmos5l_fill_2
X_16671_ _19488_/D _16825_/A _16770_/A VPWR VGND sg13cmos5l_nor2_1
X_13883_ _13904_/B _18994_/Q _13884_/B VPWR VGND sg13cmos5l_nor2b_1
X_12834_ _12938_/B _12849_/B _12833_/C _12832_/Y VPWR VGND sg13cmos5l_a21o_1
X_19578__633 _19578_/RESET_B VPWR VGND sg13cmos5l_tiehi
X_19390_ _19390_/Q clkload18/A _19390_/D _19390_/RESET_B VPWR VGND sg13cmos5l_dfrbpq_1
X_15622_ _15834_/A _19337_/Q _15623_/B VPWR VGND sg13cmos5l_xnor2_1
X_18410_ _18481_/B _10572_/Y _18402_/S hold2840/X VPWR VGND sg13cmos5l_a21oi_1
XFILLER_34_417 VPWR VGND sg13cmos5l_fill_1
X_12765_ _12765_/Y _12765_/A _12765_/B _12765_/C VPWR VGND sg13cmos5l_nor3_1
X_15553_ _15553_/Y _15553_/A _15582_/A VPWR VGND sg13cmos5l_nor2_1
X_18341_ _18341_/Y _18341_/A _18341_/B VPWR VGND sg13cmos5l_nor2_1
X_19030__1227 _19030_/RESET_B VPWR VGND sg13cmos5l_tiehi
X_11716_ _11716_/Y _11548_/B _11727_/B _11713_/X VPWR VGND sg13cmos5l_o21ai_1
X_18272_ _18272_/Y _18272_/A _18272_/B VPWR VGND sg13cmos5l_nor2_1
X_14504_ _14602_/C _19153_/Q _19114_/Q _19173_/Q VPWR VGND sg13cmos5l_nand3_1
X_12696_ _12706_/A _12595_/Y _12704_/A _12696_/C VPWR VGND sg13cmos5l_nand3b_1
X_17223_ _17330_/C _17223_/A _19524_/Q _19583_/Q VPWR VGND sg13cmos5l_nand3_1
X_18673__1620 _18673_/RESET_B VPWR VGND sg13cmos5l_tiehi
XFILLER_14_185 VPWR VGND sg13cmos5l_fill_1
X_15484_ _15485_/A _15498_/C _15483_/Y _15482_/Y VPWR VGND sg13cmos5l_o21ai_1
X_11647_ _11647_/Y _18745_/Q _12195_/A _11661_/C VPWR VGND sg13cmos5l_nand3_1
X_14435_ _19153_/D _09993_/Y fanout72/X _14434_/Y VPWR VGND sg13cmos5l_a21oi_1
X_17154_ _17155_/B _19525_/Q _19526_/Q _19527_/Q VPWR VGND sg13cmos5l_o21ai_1
X_11578_ _11578_/X _11551_/Y _11462_/B _11597_/S VPWR VGND sg13cmos5l_mux2_1
X_14366_ _19131_/D _14366_/A _14371_/B VPWR VGND sg13cmos5l_nor2_1
X_17085_ _19546_/D _17085_/A _17087_/A VPWR VGND sg13cmos5l_nor2_1
X_13317_ _13317_/X _13836_/A _13317_/B VPWR VGND sg13cmos5l_and2_1
X_16105_ _16105_/Y _19372_/Q _16106_/B VPWR VGND sg13cmos5l_xnor2_1
X_10529_ _10529_/Y _19799_/Q _19784_/Q VPWR VGND sg13cmos5l_nand2_1
X_16036_ _16037_/A _19360_/Q _16033_/Y _16035_/Y VPWR VGND sg13cmos5l_o21ai_1
X_14297_ _14297_/X _14468_/A _14297_/B VPWR VGND sg13cmos5l_and2_1
X_19585__626 _19585_/RESET_B VPWR VGND sg13cmos5l_tiehi
X_13248_ _13248_/Y _13292_/B _13253_/S _13250_/B _13247_/B _13210_/X VPWR VGND sg13cmos5l_a221oi_1
XFILLER_97_612 VPWR VGND sg13cmos5l_fill_2
X_13179_ _13179_/Y _13179_/A _13179_/B VPWR VGND sg13cmos5l_xnor2_1
Xhold2209 _19640_/D _17724_/Y VPWR VGND sg13cmos5l_dlygate4sd3_1
XFILLER_96_122 VPWR VGND sg13cmos5l_fill_2
X_18923__1343 _18923_/RESET_B VPWR VGND sg13cmos5l_tiehi
XFILLER_96_166 VPWR VGND sg13cmos5l_fill_2
XFILLER_96_155 VPWR VGND sg13cmos5l_fill_2
X_17987_ _17987_/Y _17965_/A _17993_/S _18231_/A VPWR VGND sg13cmos5l_o21ai_1
X_19726_ _19726_/Q _19790_/CLK _19726_/D _19726_/RESET_B VPWR VGND sg13cmos5l_dfrbpq_1
X_16938_ _17053_/A _16937_/Y _16753_/B _16938_/S VPWR VGND sg13cmos5l_mux2_1
XFILLER_65_520 VPWR VGND sg13cmos5l_fill_2
X_16869_ _16869_/Y _17417_/A _17364_/B VPWR VGND sg13cmos5l_nor2_1
XFILLER_25_406 VPWR VGND sg13cmos5l_fill_2
X_19657_ _19657_/Q _19679_/CLK _19657_/D _19657_/RESET_B VPWR VGND sg13cmos5l_dfrbpq_1
X_19588_ _19588_/Q clkload38/A _19588_/D _19588_/RESET_B VPWR VGND sg13cmos5l_dfrbpq_1
X_18608_ _18608_/Q clkload34/A _18608_/D _18608_/RESET_B VPWR VGND sg13cmos5l_dfrbpq_1
XFILLER_19_992 VPWR VGND sg13cmos5l_fill_2
X_19592__619 _19592_/RESET_B VPWR VGND sg13cmos5l_tiehi
X_18539_ _19774_/D _18541_/A _18539_/B VPWR VGND sg13cmos5l_and2_1
XFILLER_60_291 VPWR VGND sg13cmos5l_fill_2
XFILLER_60_280 VPWR VGND sg13cmos5l_fill_1
XFILLER_106_249 VPWR VGND sg13cmos5l_decap_8
Xhold2721 _12106_/A _18801_/Q VPWR VGND sg13cmos5l_dlygate4sd3_1
XFILLER_76_818 VPWR VGND sg13cmos5l_fill_1
Xhold2710 _17293_/A _19589_/Q VPWR VGND sg13cmos5l_dlygate4sd3_1
Xhold2732 _16382_/A _19469_/Q VPWR VGND sg13cmos5l_dlygate4sd3_1
Xhold2743 _13805_/A _13791_/A VPWR VGND sg13cmos5l_dlygate4sd3_1
Xclkbuf_4_5_0_clk clkbuf_4_5_0_clk/X clkbuf_0_clk/X VPWR VGND sg13cmos5l_buf_8
Xhold2754 _10467_/A _19793_/Q VPWR VGND sg13cmos5l_dlygate4sd3_1
Xhold2765 hold2765/X _11059_/A VPWR VGND sg13cmos5l_dlygate4sd3_1
Xhold2787 _13013_/A _12998_/A VPWR VGND sg13cmos5l_dlygate4sd3_1
Xhold2798 hold2798/X _15993_/A VPWR VGND sg13cmos5l_dlygate4sd3_1
Xhold2776 _18140_/A _19715_/Q VPWR VGND sg13cmos5l_dlygate4sd3_1
XFILLER_56_553 VPWR VGND sg13cmos5l_fill_1
X_19501__716 _19501_/RESET_B VPWR VGND sg13cmos5l_tiehi
X_10880_ _18609_/D _11152_/A _10880_/B VPWR VGND sg13cmos5l_and2_1
X_12550_ _12550_/Y _12547_/Y _12548_/Y _12549_/Y VPWR VGND sg13cmos5l_o21ai_1
X_12481_ _12481_/Y _18872_/Q _13022_/A _12498_/C VPWR VGND sg13cmos5l_nand3_1
X_11501_ _11502_/B _11596_/B _11501_/B VPWR VGND sg13cmos5l_nor2_1
XFILLER_11_144 VPWR VGND sg13cmos5l_fill_2
X_18799__1476 _18799_/RESET_B VPWR VGND sg13cmos5l_tiehi
X_11432_ _11434_/C _18653_/Q _18654_/Q _18655_/Q VPWR VGND sg13cmos5l_o21ai_1
X_14220_ _14231_/A _14220_/A _14220_/B VPWR VGND sg13cmos5l_nor2_1
X_14151_ _14151_/X _19073_/Q _19074_/Q VPWR VGND sg13cmos5l_xor2_1
X_13102_ _13102_/Y _12947_/A _13131_/A _13136_/A _12905_/Y VPWR VGND sg13cmos5l_a22oi_1
X_11363_ _18680_/D _11363_/A _11363_/B VPWR VGND sg13cmos5l_nor2_1
X_11294_ _11294_/Y _11318_/A _11360_/B _11293_/Y VPWR VGND sg13cmos5l_o21ai_1
X_10314_ _10841_/A _11102_/A VPWR VGND sg13cmos5l_inv_1
X_14082_ _19099_/D _14083_/A _14082_/B VPWR VGND sg13cmos5l_nor2_1
XFILLER_106_783 VPWR VGND sg13cmos5l_decap_4
X_18890_ _18890_/Q clkload71/A _18890_/D _18890_/RESET_B VPWR VGND sg13cmos5l_dfrbpq_1
XFILLER_98_88 VPWR VGND sg13cmos5l_fill_1
X_18704__1586 _18704_/RESET_B VPWR VGND sg13cmos5l_tiehi
X_13033_ _13033_/Y _18958_/Q _13056_/B VPWR VGND sg13cmos5l_nand2_1
X_17910_ _17911_/B _17910_/A _17910_/B VPWR VGND sg13cmos5l_or2_1
X_10245_ _10245_/Y _19107_/Q VPWR VGND sg13cmos5l_inv_1
X_10176_ _18223_/A _10176_/A VPWR VGND sg13cmos5l_inv_1
X_17841_ _17841_/Y _17815_/Y _18032_/A _17825_/Y _17840_/Y VPWR VGND sg13cmos5l_a22oi_1
XFILLER_3_398 VPWR VGND sg13cmos5l_decap_4
XFILLER_26_1027 VPWR VGND sg13cmos5l_fill_2
X_19048__1209 _19048_/RESET_B VPWR VGND sg13cmos5l_tiehi
XFILLER_66_306 VPWR VGND sg13cmos5l_fill_2
Xfanout190 _11769_/B _11750_/Y VPWR VGND sg13cmos5l_buf_1
X_17772_ _17862_/A _17581_/B _17771_/Y _17781_/S VPWR VGND sg13cmos5l_mux2_1
X_14984_ _14985_/B _19202_/Q _14995_/B _19203_/Q VPWR VGND sg13cmos5l_o21ai_1
X_19511_ _19511_/Q clkload39/A _19511_/D _19511_/RESET_B VPWR VGND sg13cmos5l_dfrbpq_1
X_16723_ _16723_/Y _17080_/A _16721_/X _16722_/Y _16720_/X VPWR VGND sg13cmos5l_a22oi_1
X_13935_ _14043_/B _13951_/A _13951_/B VPWR VGND sg13cmos5l_nand2_1
XFILLER_47_81 VPWR VGND sg13cmos5l_fill_2
X_16654_ _16655_/B _13701_/X _16653_/Y _16659_/S VPWR VGND sg13cmos5l_mux2_1
X_19442_ _19442_/Q clkload6/A _19442_/D _19442_/RESET_B VPWR VGND sg13cmos5l_dfrbpq_1
X_13866_ _13866_/Y _14108_/A _13859_/S _13865_/Y VPWR VGND sg13cmos5l_a21oi_1
X_12817_ _12817_/Y _12663_/A _12811_/Y _12816_/X _12818_/A VPWR VGND sg13cmos5l_a22oi_1
X_15605_ _15717_/A _19346_/Q _15721_/B _15721_/C _15604_/Y VPWR VGND sg13cmos5l_a22oi_1
XFILLER_34_236 VPWR VGND sg13cmos5l_decap_8
XFILLER_34_247 VPWR VGND sg13cmos5l_decap_8
X_13797_ _13797_/Y _13770_/Y _13803_/A _13817_/A VPWR VGND sg13cmos5l_o21ai_1
XFILLER_90_898 VPWR VGND sg13cmos5l_fill_2
X_16585_ _16586_/B _19024_/Q _16583_/Y _16584_/Y VPWR VGND sg13cmos5l_o21ai_1
X_19373_ _19373_/Q clkload9/A _19373_/D _19373_/RESET_B VPWR VGND sg13cmos5l_dfrbpq_1
XFILLER_34_269 VPWR VGND sg13cmos5l_fill_1
XFILLER_97_5 VPWR VGND sg13cmos5l_fill_1
X_12748_ _12748_/Y _18914_/Q _13291_/A VPWR VGND sg13cmos5l_nand2_1
X_15536_ _15569_/A _19283_/Q _19284_/Q VPWR VGND sg13cmos5l_xnor2_1
X_18324_ _19735_/D _18482_/A _18431_/A VPWR VGND sg13cmos5l_and2_1
X_12679_ _12680_/B _12679_/A _12679_/B VPWR VGND sg13cmos5l_xor2_1
X_18255_ _18255_/Y _19723_/Q _18251_/Y _18254_/Y _19722_/Q VPWR VGND sg13cmos5l_a22oi_1
X_15467_ _15467_/Y _19333_/Q _15486_/A VPWR VGND sg13cmos5l_nand2_1
X_17206_ _17341_/A _17200_/S _17204_/Y _17203_/Y VPWR VGND sg13cmos5l_a21o_1
X_18186_ _18187_/C _18186_/A _18186_/B _18186_/C VPWR VGND sg13cmos5l_nand3_1
X_14418_ _14418_/X _14391_/Y _14668_/A _14424_/S VPWR VGND sg13cmos5l_mux2_1
X_17137_ _19556_/D _17137_/A _17137_/B VPWR VGND sg13cmos5l_nor2_1
X_15398_ _15398_/Y _15398_/A _15465_/B VPWR VGND sg13cmos5l_nor2_1
X_19337__899 _19337_/RESET_B VPWR VGND sg13cmos5l_tiehi
X_14349_ _14349_/X _14350_/A _14350_/B VPWR VGND sg13cmos5l_and2_1
X_17068_ _17069_/B _17038_/X _17036_/A _17070_/S VPWR VGND sg13cmos5l_mux2_1
XFILLER_98_921 VPWR VGND sg13cmos5l_fill_2
XFILLER_69_100 VPWR VGND sg13cmos5l_decap_8
X_16019_ _19391_/D _16020_/A _16019_/B VPWR VGND sg13cmos5l_nor2_1
XFILLER_69_144 VPWR VGND sg13cmos5l_fill_2
XFILLER_69_111 VPWR VGND sg13cmos5l_fill_2
Xhold2017 _11014_/A _18607_/Q VPWR VGND sg13cmos5l_dlygate4sd3_1
Xhold2006 _09997_/A _19068_/Q VPWR VGND sg13cmos5l_dlygate4sd3_1
XFILLER_33_0 VPWR VGND sg13cmos5l_fill_1
Xhold2028 _10009_/A _18774_/Q VPWR VGND sg13cmos5l_dlygate4sd3_1
Xhold2039 _10114_/A _19294_/Q VPWR VGND sg13cmos5l_dlygate4sd3_1
XFILLER_84_147 VPWR VGND sg13cmos5l_fill_2
X_19709_ _19709_/Q clkload13/A _19709_/D _19709_/RESET_B VPWR VGND sg13cmos5l_dfrbpq_1
XFILLER_93_681 VPWR VGND sg13cmos5l_fill_1
XFILLER_66_884 VPWR VGND sg13cmos5l_fill_1
XFILLER_81_865 VPWR VGND sg13cmos5l_fill_1
X_18754__1524 _18754_/RESET_B VPWR VGND sg13cmos5l_tiehi
X_19637__571 _19637_/RESET_B VPWR VGND sg13cmos5l_tiehi
XFILLER_21_464 VPWR VGND sg13cmos5l_fill_2
XFILLER_22_965 VPWR VGND sg13cmos5l_fill_2
XFILLER_33_291 VPWR VGND sg13cmos5l_fill_1
XFILLER_22_998 VPWR VGND sg13cmos5l_decap_4
X_19568__643 _19568_/RESET_B VPWR VGND sg13cmos5l_tiehi
X_10030_ _12193_/A _10030_/A VPWR VGND sg13cmos5l_inv_1
Xhold2540 _12584_/A _18884_/Q VPWR VGND sg13cmos5l_dlygate4sd3_1
XFILLER_89_987 VPWR VGND sg13cmos5l_fill_2
X_19644__564 _19644_/RESET_B VPWR VGND sg13cmos5l_tiehi
Xhold2562 _10357_/A _19554_/Q VPWR VGND sg13cmos5l_dlygate4sd3_1
Xhold2573 _15869_/A _19388_/Q VPWR VGND sg13cmos5l_dlygate4sd3_1
Xhold2551 _10237_/A _19144_/Q VPWR VGND sg13cmos5l_dlygate4sd3_1
X_11981_ _11988_/B _18741_/Q _11982_/B VPWR VGND sg13cmos5l_nor2b_1
Xhold1872 _13646_/B _18582_/Q VPWR VGND sg13cmos5l_dlygate4sd3_1
Xhold1850 _11423_/B _18651_/Q VPWR VGND sg13cmos5l_dlygate4sd3_1
Xhold1861 _18292_/B _19690_/Q VPWR VGND sg13cmos5l_dlygate4sd3_1
Xhold2584 hold2584/X _13950_/Y VPWR VGND sg13cmos5l_dlygate4sd3_1
Xhold2595 hold2595/X _15138_/A VPWR VGND sg13cmos5l_dlygate4sd3_1
X_13720_ _13720_/X _13720_/A _13720_/B _13720_/C VPWR VGND sg13cmos5l_and3_1
Xhold1883 _12043_/B _18736_/Q VPWR VGND sg13cmos5l_dlygate4sd3_1
X_10932_ _18616_/D _11084_/B _10999_/A VPWR VGND sg13cmos5l_and2_1
Xhold1894 _15257_/B _19240_/Q VPWR VGND sg13cmos5l_dlygate4sd3_1
XFILLER_71_320 VPWR VGND sg13cmos5l_fill_1
X_13651_ _19034_/D _13651_/A _13819_/A VPWR VGND sg13cmos5l_nor2_1
X_19575__636 _19575_/RESET_B VPWR VGND sg13cmos5l_tiehi
X_10863_ _10863_/Y _10837_/A _10865_/S _11084_/B VPWR VGND sg13cmos5l_o21ai_1
X_19070__1184 _19070_/RESET_B VPWR VGND sg13cmos5l_tiehi
X_12602_ _12603_/C _12602_/A _12602_/B VPWR VGND sg13cmos5l_or2_1
X_10794_ _10807_/A _10794_/A _10794_/B _18560_/B _10794_/D VPWR VGND sg13cmos5l_nand4_1
X_13582_ _19012_/D _13585_/A _13582_/B VPWR VGND sg13cmos5l_nor2_1
X_16370_ _16370_/Y _16370_/A _16370_/B VPWR VGND sg13cmos5l_nand2_1
X_12533_ _12552_/B _18826_/Q _12534_/B VPWR VGND sg13cmos5l_nor2b_1
XFILLER_12_431 VPWR VGND sg13cmos5l_fill_1
X_15321_ _15419_/A _15418_/B _15418_/C _15418_/A VPWR VGND sg13cmos5l_a21oi_1
X_18040_ _18043_/A _17847_/Y _18056_/B VPWR VGND sg13cmos5l_nand2b_1
X_15252_ _19278_/D _09991_/Y fanout92/X _15251_/Y VPWR VGND sg13cmos5l_a21oi_1
X_12464_ _18844_/D _12467_/A _12464_/B VPWR VGND sg13cmos5l_nor2_1
X_14203_ _14336_/A _14200_/A _14201_/A _14201_/Y VPWR VGND sg13cmos5l_a21oi_1
X_12395_ _12434_/A _18841_/Q _12398_/B VPWR VGND sg13cmos5l_nor2_1
X_11415_ _11415_/Y _11398_/Y hold2386/X _11629_/A VPWR VGND sg13cmos5l_a21oi_1
X_15183_ _19257_/D _15183_/A _15188_/B VPWR VGND sg13cmos5l_nor2_1
X_11346_ _11346_/Y _11334_/B _11342_/S _11360_/A VPWR VGND sg13cmos5l_o21ai_1
XFILLER_4_641 VPWR VGND sg13cmos5l_decap_4
X_14134_ _14134_/Y _14407_/B _14122_/Y _14133_/Y VPWR VGND sg13cmos5l_a21oi_1
X_18942_ _18942_/Q _19003_/CLK _18942_/D _18942_/RESET_B VPWR VGND sg13cmos5l_dfrbpq_1
X_14065_ _19083_/D _14024_/A _14062_/S _14064_/Y VPWR VGND sg13cmos5l_a21oi_1
XFILLER_4_685 VPWR VGND sg13cmos5l_decap_4
X_13016_ _18920_/D _13016_/A _13019_/B VPWR VGND sg13cmos5l_and2_1
X_19582__629 _19582_/RESET_B VPWR VGND sg13cmos5l_tiehi
X_11277_ _11295_/B _11267_/Y _11272_/Y _11276_/Y VPWR VGND sg13cmos5l_o21ai_1
X_18873_ _18873_/Q _18931_/CLK _18873_/D _18873_/RESET_B VPWR VGND sg13cmos5l_dfrbpq_1
X_10228_ _14942_/A _10228_/A VPWR VGND sg13cmos5l_inv_1
XFILLER_95_968 VPWR VGND sg13cmos5l_decap_8
X_10159_ _17668_/A _10159_/A VPWR VGND sg13cmos5l_inv_1
X_17824_ _17870_/A _19677_/Q _17824_/B VPWR VGND sg13cmos5l_xor2_1
X_17755_ _17755_/Y _17755_/A _17777_/A VPWR VGND sg13cmos5l_nor2_1
X_14967_ _14967_/Y _15225_/B _14958_/S _14966_/Y VPWR VGND sg13cmos5l_a21oi_1
X_16706_ _16707_/A _19511_/Q _16706_/B VPWR VGND sg13cmos5l_xnor2_1
XFILLER_35_512 VPWR VGND sg13cmos5l_decap_4
XFILLER_63_854 VPWR VGND sg13cmos5l_fill_2
X_13918_ _13919_/B _13506_/X _13924_/S _13917_/Y VPWR VGND sg13cmos5l_o21ai_1
X_17686_ _17686_/Y _19664_/Q _17693_/B _19601_/Q _18226_/A VPWR VGND sg13cmos5l_a22oi_1
X_19212__1033 _19212_/RESET_B VPWR VGND sg13cmos5l_tiehi
X_14898_ _19209_/D hold2884/X _14895_/S _14897_/Y VPWR VGND sg13cmos5l_a21oi_1
X_16637_ _16640_/B _16818_/A _16637_/B VPWR VGND sg13cmos5l_nor2_1
X_13849_ _13849_/Y _13849_/A _14371_/A _13849_/C VPWR VGND sg13cmos5l_nand3_1
X_19425_ _19425_/Q clkload7/A _19425_/D _19425_/RESET_B VPWR VGND sg13cmos5l_dfrbpq_1
XFILLER_95_2 VPWR VGND sg13cmos5l_fill_1
X_16568_ _16568_/Y _17082_/A _19021_/Q _16564_/Y _16567_/Y VPWR VGND sg13cmos5l_a22oi_1
X_19356_ _19356_/Q clkload7/A _19356_/D _19356_/RESET_B VPWR VGND sg13cmos5l_dfrbpq_1
X_15519_ _15519_/Y _15502_/Y hold2311/X _15586_/A VPWR VGND sg13cmos5l_a21oi_1
X_18307_ _18307_/X _19700_/Q _19693_/Q VPWR VGND sg13cmos5l_or2_1
X_19287_ _19287_/Q clkload43/A _19287_/D _19287_/RESET_B VPWR VGND sg13cmos5l_dfrbpq_1
X_16499_ _16501_/B _16531_/A _16530_/A VPWR VGND sg13cmos5l_nor2_1
X_18238_ _18238_/Y _19745_/Q _18257_/A _17968_/A _19744_/Q _18237_/Y VPWR VGND sg13cmos5l_a221oi_1
X_18169_ _18170_/A _18164_/Y _18169_/B VPWR VGND sg13cmos5l_nand2b_1
XFILLER_58_637 VPWR VGND sg13cmos5l_fill_2
XFILLER_66_670 VPWR VGND sg13cmos5l_fill_2
XFILLER_13_206 VPWR VGND sg13cmos5l_fill_1
X_18718__1563 _18718_/RESET_B VPWR VGND sg13cmos5l_tiehi
XFILLER_10_957 VPWR VGND sg13cmos5l_fill_1
XFILLER_5_427 VPWR VGND sg13cmos5l_fill_1
X_12180_ _12180_/Y _12156_/B _12186_/S _12192_/B VPWR VGND sg13cmos5l_o21ai_1
X_11200_ _11201_/B _11204_/B _11204_/C _11199_/Y VPWR VGND sg13cmos5l_a21oi_1
X_11131_ _11131_/Y _13337_/A _11618_/B VPWR VGND sg13cmos5l_nor2_1
X_19088__1166 _19088_/RESET_B VPWR VGND sg13cmos5l_tiehi
XFILLER_0_121 VPWR VGND sg13cmos5l_fill_2
XFILLER_77_924 VPWR VGND sg13cmos5l_fill_1
XFILLER_62_1024 VPWR VGND sg13cmos5l_decap_4
Xhold3060 _13046_/A _18960_/Q VPWR VGND sg13cmos5l_dlygate4sd3_1
X_11062_ _11062_/Y _11076_/A _11075_/A _11061_/Y VPWR VGND sg13cmos5l_o21ai_1
X_10013_ _10013_/Y _10013_/A VPWR VGND sg13cmos5l_inv_1
X_15870_ _15982_/A _19386_/Q _15884_/B VPWR VGND sg13cmos5l_xnor2_1
Xhold2370 _10169_/A _19621_/Q VPWR VGND sg13cmos5l_dlygate4sd3_1
Xhold2381 _11084_/A _19789_/Q VPWR VGND sg13cmos5l_dlygate4sd3_1
X_14821_ _14821_/Y _14816_/A _15000_/A _14837_/B VPWR VGND sg13cmos5l_a21oi_1
Xhold2392 _19473_/D _16611_/Y VPWR VGND sg13cmos5l_dlygate4sd3_1
XFILLER_57_681 VPWR VGND sg13cmos5l_fill_2
X_19679__435 _19679_/D VPWR VGND sg13cmos5l_tielo
X_11964_ _11964_/Y hold2046/X fanout81/X _13807_/A VPWR VGND sg13cmos5l_o21ai_1
X_17540_ _17542_/B _19631_/Q _19632_/Q _19633_/Q VPWR VGND sg13cmos5l_o21ai_1
X_14752_ _14840_/A _14572_/Y _14735_/Y _14755_/S _14751_/Y VPWR VGND sg13cmos5l_a22oi_1
X_13703_ _13705_/C hold2967/X _13720_/B _13720_/C VPWR VGND sg13cmos5l_nand3b_1
X_11895_ _18754_/D _11895_/A _11899_/B VPWR VGND sg13cmos5l_nor2_1
X_17471_ _17494_/B _17459_/Y _17466_/X _17469_/Y VPWR VGND sg13cmos5l_o21ai_1
X_10915_ _11036_/A _10520_/Y _10917_/B _10914_/Y VPWR VGND sg13cmos5l_o21ai_1
X_14683_ _14683_/Y _10104_/A _15188_/A _14679_/A _14428_/B VPWR VGND sg13cmos5l_a22oi_1
X_13634_ _13634_/Y _13617_/A _13632_/S _13817_/A VPWR VGND sg13cmos5l_o21ai_1
XFILLER_71_194 VPWR VGND sg13cmos5l_fill_2
XFILLER_71_161 VPWR VGND sg13cmos5l_decap_4
X_10846_ _10846_/X _10850_/C _10844_/Y _10845_/Y VPWR VGND sg13cmos5l_a21o_1
X_16422_ _16457_/B _19409_/Q _19410_/Q _19411_/Q VPWR VGND sg13cmos5l_o21ai_1
X_19210_ _19210_/Q _19262_/CLK _19210_/D _19210_/RESET_B VPWR VGND sg13cmos5l_dfrbpq_1
X_16353_ _16353_/Y _09983_/Y _16347_/A _16352_/A _09982_/Y _16348_/Y VPWR VGND sg13cmos5l_a221oi_1
X_19297__942 _19297_/RESET_B VPWR VGND sg13cmos5l_tiehi
X_19141_ _19141_/Q clkload49/A _19141_/D _19141_/RESET_B VPWR VGND sg13cmos5l_dfrbpq_1
X_10777_ _10777_/Y _10759_/X _10801_/B _10776_/Y VPWR VGND sg13cmos5l_o21ai_1
X_13565_ _13565_/Y _13542_/B fanout47/X _13569_/B1 VPWR VGND sg13cmos5l_o21ai_1
X_15304_ _15398_/A _15283_/X _15303_/Y _15302_/Y VPWR VGND sg13cmos5l_a21oi_1
X_12516_ _12516_/Y _12760_/A _12509_/S _12515_/Y VPWR VGND sg13cmos5l_a21oi_1
X_13496_ _13500_/C _13512_/B _13512_/C _13495_/Y VPWR VGND sg13cmos5l_o21ai_1
X_16284_ _16284_/Y _16291_/A _16291_/B VPWR VGND sg13cmos5l_nand2_1
X_19072_ _19072_/Q clkload47/A _19072_/D _19072_/RESET_B VPWR VGND sg13cmos5l_dfrbpq_1
X_12447_ _18830_/D _12452_/A _12447_/B VPWR VGND sg13cmos5l_nor2_1
X_18023_ _18023_/Y _18022_/A _18057_/A _18061_/A _18029_/A VPWR VGND sg13cmos5l_a22oi_1
X_15235_ _15235_/Y _19297_/Q _15453_/A VPWR VGND sg13cmos5l_nand2b_1
X_15166_ _15179_/B _15050_/A _15050_/B _15159_/Y _15165_/Y VPWR VGND sg13cmos5l_a22oi_1
X_12378_ _12378_/Y _18817_/Q _12378_/B VPWR VGND sg13cmos5l_nand2_1
XFILLER_5_961 VPWR VGND sg13cmos5l_decap_8
X_14117_ _14117_/Y _14402_/A _14111_/A _14119_/B _14407_/B VPWR VGND sg13cmos5l_a22oi_1
X_11329_ _11336_/A _11329_/A _11363_/B VPWR VGND sg13cmos5l_nand2_1
X_15097_ _15121_/C _15108_/A _15108_/B VPWR VGND sg13cmos5l_nor2_1
X_18925_ _18925_/Q _18931_/CLK _18925_/D _18925_/RESET_B VPWR VGND sg13cmos5l_dfrbpq_1
XFILLER_68_924 VPWR VGND sg13cmos5l_decap_8
X_14048_ _14048_/Y _14015_/Y _14019_/Y _13927_/A VPWR VGND sg13cmos5l_a21oi_1
X_18856_ _18856_/Q _19003_/CLK _18856_/D _18856_/RESET_B VPWR VGND sg13cmos5l_dfrbpq_1
X_19627__581 _19627_/RESET_B VPWR VGND sg13cmos5l_tiehi
XFILLER_68_968 VPWR VGND sg13cmos5l_fill_1
X_17807_ _17807_/Y _17895_/B _17912_/A _17807_/C VPWR VGND sg13cmos5l_nand3_1
X_18787_ _18787_/Q clkload61/A _18787_/D _18787_/RESET_B VPWR VGND sg13cmos5l_dfrbpq_1
XFILLER_83_949 VPWR VGND sg13cmos5l_fill_2
X_15999_ _16000_/B _15970_/Y _15967_/A _16001_/S VPWR VGND sg13cmos5l_mux2_1
X_17738_ _19649_/D _17739_/A _17738_/B VPWR VGND sg13cmos5l_and2_1
XFILLER_35_320 VPWR VGND sg13cmos5l_decap_8
X_18794__1481 _18794_/RESET_B VPWR VGND sg13cmos5l_tiehi
X_17669_ _19626_/D _17669_/A _17671_/B VPWR VGND sg13cmos5l_nor2_1
X_19408_ _19408_/Q _19462_/CLK _19408_/D _19408_/RESET_B VPWR VGND sg13cmos5l_dfrbpq_1
XFILLER_50_345 VPWR VGND sg13cmos5l_fill_2
X_19339_ _19339_/Q clkload48/A _19339_/D _19339_/RESET_B VPWR VGND sg13cmos5l_dfrbpq_1
X_19634__574 _19634_/RESET_B VPWR VGND sg13cmos5l_tiehi
X_19043__1214 _19043_/RESET_B VPWR VGND sg13cmos5l_tiehi
X_19565__646 _19565_/RESET_B VPWR VGND sg13cmos5l_tiehi
XFILLER_49_49 VPWR VGND sg13cmos5l_fill_1
XFILLER_100_542 VPWR VGND sg13cmos5l_fill_1
XFILLER_100_586 VPWR VGND sg13cmos5l_fill_1
X_19641__567 _19641_/RESET_B VPWR VGND sg13cmos5l_tiehi
XFILLER_82_971 VPWR VGND sg13cmos5l_fill_1
X_18936__1330 _18936_/RESET_B VPWR VGND sg13cmos5l_tiehi
X_10700_ _10758_/B _13812_/A _10778_/B VPWR VGND sg13cmos5l_nor2b_1
XFILLER_41_323 VPWR VGND sg13cmos5l_fill_1
XFILLER_14_526 VPWR VGND sg13cmos5l_decap_4
X_11680_ _11680_/Y _11666_/B _11672_/S _11680_/B1 VPWR VGND sg13cmos5l_o21ai_1
XFILLER_41_345 VPWR VGND sg13cmos5l_fill_2
X_19572__639 _19572_/RESET_B VPWR VGND sg13cmos5l_tiehi
X_10631_ _19788_/D _10642_/B _10631_/B VPWR VGND sg13cmos5l_nor2_1
X_13350_ _13350_/Y _13333_/Y hold2130/X _13578_/B VPWR VGND sg13cmos5l_a21oi_1
X_10562_ _10562_/Y _18542_/A _10643_/A VPWR VGND sg13cmos5l_nand2b_1
X_12301_ _12302_/B _12301_/A _12301_/B VPWR VGND sg13cmos5l_nor2_1
X_13281_ _18958_/D _13267_/A _13276_/S _13280_/Y VPWR VGND sg13cmos5l_a21oi_1
X_12232_ _12233_/A _12231_/C _12230_/Y _12231_/Y VPWR VGND sg13cmos5l_a21o_1
X_15020_ _15020_/Y _14999_/Y _15003_/Y _14838_/Y VPWR VGND sg13cmos5l_a21oi_1
X_10493_ _10565_/A _10493_/A _10493_/B VPWR VGND sg13cmos5l_and2_1
XFILLER_5_257 VPWR VGND sg13cmos5l_fill_1
X_12163_ _12172_/B _12200_/B _12162_/B _12162_/Y VPWR VGND sg13cmos5l_o21ai_1
XFILLER_30_95 VPWR VGND sg13cmos5l_decap_8
X_12094_ _12094_/Y _18792_/Q _12095_/B VPWR VGND sg13cmos5l_xnor2_1
X_16971_ _16972_/B _17370_/A _16973_/B VPWR VGND sg13cmos5l_nand2_1
X_11114_ _11114_/Y _18640_/Q _11106_/Y _11113_/Y _18641_/Q VPWR VGND sg13cmos5l_a22oi_1
XFILLER_2_964 VPWR VGND sg13cmos5l_decap_4
XFILLER_104_892 VPWR VGND sg13cmos5l_fill_1
X_18710_ _18710_/Q _18733_/CLK _18710_/D _18710_/RESET_B VPWR VGND sg13cmos5l_dfrbpq_1
X_11045_ _11047_/B _10922_/B _11088_/B _11051_/B VPWR VGND sg13cmos5l_mux2_1
XFILLER_7_1024 VPWR VGND sg13cmos5l_decap_4
X_15922_ _15922_/Y _15914_/A _16107_/A _15924_/A _15921_/A VPWR VGND sg13cmos5l_a22oi_1
X_19690_ _19690_/Q clkload35/A _19690_/D _19690_/RESET_B VPWR VGND sg13cmos5l_dfrbpq_1
X_18641_ _18641_/Q _18733_/CLK _18641_/D _18641_/RESET_B VPWR VGND sg13cmos5l_dfrbpq_1
X_15853_ _15855_/B _15841_/X _15852_/Y _15851_/Y VPWR VGND sg13cmos5l_a21oi_1
XFILLER_91_245 VPWR VGND sg13cmos5l_fill_1
X_18572_ _18572_/Q clkload29/A _18572_/D _18572_/RESET_B VPWR VGND sg13cmos5l_dfrbpq_1
X_12996_ _13013_/C _12983_/Y _12988_/Y _12995_/Y VPWR VGND sg13cmos5l_a21o_1
XFILLER_64_437 VPWR VGND sg13cmos5l_fill_2
X_19688__1770 _19688_/RESET_B VPWR VGND sg13cmos5l_tiehi
X_14804_ _14804_/Y _19222_/Q _19221_/Q _19206_/Q VPWR VGND sg13cmos5l_nand3b_1
X_15784_ _15784_/Y _10130_/A _16314_/A _15764_/B _15518_/B VPWR VGND sg13cmos5l_a22oi_1
X_19405__826 _19405_/RESET_B VPWR VGND sg13cmos5l_tiehi
X_11947_ _11947_/Y _12455_/B _12527_/A VPWR VGND sg13cmos5l_nand2b_1
X_17523_ _17523_/Y _17528_/A _17528_/B _17643_/B VPWR VGND sg13cmos5l_nor3_1
X_14735_ _14735_/Y _14735_/A _14735_/B VPWR VGND sg13cmos5l_nand2_1
XFILLER_17_353 VPWR VGND sg13cmos5l_fill_1
XFILLER_60_632 VPWR VGND sg13cmos5l_fill_2
X_11878_ _11878_/Y _11878_/A _11878_/B VPWR VGND sg13cmos5l_nor2_1
X_17454_ _17454_/Y _17447_/B _17451_/Y _17447_/A VPWR VGND sg13cmos5l_o21ai_1
X_14666_ _14667_/A _14680_/C _14664_/Y _14665_/Y VPWR VGND sg13cmos5l_o21ai_1
X_13617_ _13617_/Y _13617_/A VPWR VGND sg13cmos5l_inv_1
X_10829_ _10830_/B _11357_/A _19770_/Q VPWR VGND sg13cmos5l_nand2_1
X_17385_ _17385_/Y _17935_/A _19558_/Q _17384_/Y VPWR VGND sg13cmos5l_a21oi_1
X_14597_ _14597_/X _14477_/B _14611_/B _14596_/Y VPWR VGND sg13cmos5l_a21o_1
X_16405_ _16406_/A _19453_/Q _16405_/B VPWR VGND sg13cmos5l_xnor2_1
X_18681__530 _18681_/D VPWR VGND sg13cmos5l_tielo
X_13548_ _13548_/Y _13548_/A _13548_/B VPWR VGND sg13cmos5l_nand2_1
X_16336_ _16336_/Y _19454_/Q _16399_/D VPWR VGND sg13cmos5l_nor2b_1
X_19124_ _19124_/Q clkload49/A _19124_/D _19124_/RESET_B VPWR VGND sg13cmos5l_dfrbpq_1
X_19055_ _19055_/Q clkload30/A _19055_/D _19055_/RESET_B VPWR VGND sg13cmos5l_dfrbpq_1
X_16267_ _16268_/C _19425_/Q _16267_/B VPWR VGND sg13cmos5l_xnor2_1
X_13479_ _13479_/X _13479_/A _13479_/B _13479_/C VPWR VGND sg13cmos5l_or3_1
X_15218_ _15218_/X _15218_/A _15218_/B VPWR VGND sg13cmos5l_or2_1
X_18006_ _18026_/D _19653_/Q _19651_/Q _19652_/Q VPWR VGND sg13cmos5l_or3_1
Xheichips26_digital_project_417 uo_out[8] VPWR VGND sg13cmos5l_tielo
X_16198_ _16198_/Y _16433_/A _16244_/A _16432_/A _16249_/A VPWR VGND sg13cmos5l_a22oi_1
Xheichips26_digital_project_406 uio_out[6] VPWR VGND sg13cmos5l_tielo
X_15149_ _15152_/A _15149_/A VPWR VGND sg13cmos5l_inv_1
XFILLER_4_290 VPWR VGND sg13cmos5l_fill_1
X_18908_ _18908_/Q _18975_/CLK _18908_/D _18908_/RESET_B VPWR VGND sg13cmos5l_dfrbpq_1
X_18839_ _18839_/Q clkload62/A _18839_/D _18839_/RESET_B VPWR VGND sg13cmos5l_dfrbpq_1
XFILLER_56_949 VPWR VGND sg13cmos5l_fill_2
XFILLER_71_908 VPWR VGND sg13cmos5l_fill_2
XFILLER_27_128 VPWR VGND sg13cmos5l_fill_2
XFILLER_70_418 VPWR VGND sg13cmos5l_fill_1
XFILLER_24_824 VPWR VGND sg13cmos5l_fill_1
X_18584__1715 _18584_/RESET_B VPWR VGND sg13cmos5l_tiehi
XFILLER_52_1001 VPWR VGND sg13cmos5l_fill_1
X_19356__880 _19356_/RESET_B VPWR VGND sg13cmos5l_tiehi
XFILLER_4_7 VPWR VGND sg13cmos5l_fill_1
XFILLER_2_216 VPWR VGND sg13cmos5l_fill_1
X_18834__1438 _18834_/RESET_B VPWR VGND sg13cmos5l_tiehi
X_19007__1253 _19007_/RESET_B VPWR VGND sg13cmos5l_tiehi
X_19287__952 _19287_/RESET_B VPWR VGND sg13cmos5l_tiehi
XFILLER_100_350 VPWR VGND sg13cmos5l_fill_1
XFILLER_47_949 VPWR VGND sg13cmos5l_decap_8
XFILLER_19_618 VPWR VGND sg13cmos5l_fill_2
X_12850_ _12850_/Y _12850_/A _12850_/B VPWR VGND sg13cmos5l_nor2_1
XFILLER_73_234 VPWR VGND sg13cmos5l_fill_1
XFILLER_73_212 VPWR VGND sg13cmos5l_fill_1
X_11801_ _11812_/B _18764_/Q _11803_/B VPWR VGND sg13cmos5l_nor2b_1
X_12781_ _12781_/Y _12764_/B fanout50/X _13019_/B VPWR VGND sg13cmos5l_o21ai_1
X_14520_ _14591_/A _14519_/Y _14610_/B VPWR VGND sg13cmos5l_nand2b_1
X_11732_ _11824_/B _11721_/A _11721_/B _11731_/Y VPWR VGND sg13cmos5l_o21ai_1
XFILLER_70_963 VPWR VGND sg13cmos5l_fill_1
XFILLER_70_952 VPWR VGND sg13cmos5l_fill_1
X_11663_ _11666_/B _11661_/C _11662_/Y _11661_/Y VPWR VGND sg13cmos5l_a21o_1
X_14451_ _14459_/B _19119_/Q _14452_/B VPWR VGND sg13cmos5l_nor2b_1
X_17170_ _17170_/Y _17174_/B _17173_/C VPWR VGND sg13cmos5l_nand2_1
X_13402_ _13500_/A _13183_/X _13420_/B _13420_/C VPWR VGND sg13cmos5l_nand3b_1
X_10614_ _10614_/Y _10614_/A VPWR VGND sg13cmos5l_inv_1
X_14382_ _14382_/Y _19167_/Q _14402_/A _10241_/Y _19166_/Q _14381_/Y VPWR VGND sg13cmos5l_a221oi_1
X_19294__945 _19294_/RESET_B VPWR VGND sg13cmos5l_tiehi
X_11594_ _11594_/Y _11611_/A _11592_/Y _11593_/Y VPWR VGND sg13cmos5l_o21ai_1
X_19617__591 _19617_/RESET_B VPWR VGND sg13cmos5l_tiehi
X_13333_ _13333_/Y _19001_/Q _14077_/A _13328_/A _18939_/Q VPWR VGND sg13cmos5l_a22oi_1
X_16121_ _16226_/B _16117_/A _16117_/B _16119_/X VPWR VGND sg13cmos5l_o21ai_1
XFILLER_10_551 VPWR VGND sg13cmos5l_fill_2
XFILLER_10_562 VPWR VGND sg13cmos5l_fill_2
X_10545_ _10904_/A _19789_/Q _10546_/B VPWR VGND sg13cmos5l_xnor2_1
XFILLER_10_573 VPWR VGND sg13cmos5l_fill_2
X_18767__1511 _18767_/RESET_B VPWR VGND sg13cmos5l_tiehi
X_13264_ _13264_/Y _13264_/A _13264_/B VPWR VGND sg13cmos5l_xnor2_1
XFILLER_51_9 VPWR VGND sg13cmos5l_decap_8
X_16052_ _16052_/Y _19360_/Q _16052_/B _16052_/C VPWR VGND sg13cmos5l_nor3_1
X_10476_ _10483_/B _19737_/Q _19738_/Q _19735_/Q _19736_/Q VPWR VGND sg13cmos5l_nor4_1
X_12215_ _12215_/Y _12215_/A _18772_/Q VPWR VGND sg13cmos5l_nor2_1
X_13195_ _13295_/B _13200_/B VPWR VGND sg13cmos5l_inv_1
X_15003_ _15003_/Y _15004_/A _15011_/B _15000_/Y VPWR VGND sg13cmos5l_a21oi_1
X_12146_ _12147_/B _12054_/A _12054_/B _12031_/Y VPWR VGND sg13cmos5l_a21oi_1
X_19811_ _19811_/Q clkload27/A _19811_/D _19811_/RESET_B VPWR VGND sg13cmos5l_dfrbpq_1
XFILLER_96_315 VPWR VGND sg13cmos5l_fill_2
XFILLER_2_794 VPWR VGND sg13cmos5l_decap_8
X_12077_ _12281_/B _18790_/Q _12078_/B VPWR VGND sg13cmos5l_xnor2_1
X_16954_ _16954_/Y _17043_/B _17043_/C _17043_/A VPWR VGND sg13cmos5l_a21oi_1
X_19742_ _19742_/Q clkload23/A _19742_/D _19742_/RESET_B VPWR VGND sg13cmos5l_dfrbpq_1
X_16885_ _16885_/Y _19520_/Q fanout87/X _17150_/A VPWR VGND sg13cmos5l_o21ai_1
XFILLER_77_573 VPWR VGND sg13cmos5l_fill_1
X_11028_ _11028_/Y _11028_/A _11051_/B VPWR VGND sg13cmos5l_nor2_1
X_19673_ _19673_/Q clkload11/A _19673_/D _19673_/RESET_B VPWR VGND sg13cmos5l_dfrbpq_1
X_15905_ _15913_/B _19377_/Q _15912_/C _19376_/Q VPWR VGND sg13cmos5l_nor3_1
XFILLER_77_595 VPWR VGND sg13cmos5l_fill_2
X_19624__584 _19624_/RESET_B VPWR VGND sg13cmos5l_tiehi
X_18624_ _18624_/Q clkload58/A _18624_/D _18624_/RESET_B VPWR VGND sg13cmos5l_dfrbpq_1
XFILLER_49_286 VPWR VGND sg13cmos5l_fill_2
X_15836_ _15836_/Y _15681_/B _15829_/Y _15856_/B _15840_/A VPWR VGND sg13cmos5l_a22oi_1
XFILLER_92_587 VPWR VGND sg13cmos5l_fill_2
X_12979_ _12979_/Y _13002_/A _12969_/Y VPWR VGND sg13cmos5l_nor2b_1
XFILLER_75_1001 VPWR VGND sg13cmos5l_fill_1
XFILLER_73_790 VPWR VGND sg13cmos5l_fill_1
X_18555_ _18555_/Y _10611_/Y _10627_/Y _10646_/B VPWR VGND sg13cmos5l_o21ai_1
XFILLER_18_673 VPWR VGND sg13cmos5l_fill_2
X_15767_ _15767_/X _15768_/A _15768_/B VPWR VGND sg13cmos5l_or2_1
X_17506_ _17506_/Y _17504_/Y _17505_/Y _17503_/Y VPWR VGND sg13cmos5l_a21oi_1
X_18486_ _18486_/Y _18486_/A _19723_/Q VPWR VGND sg13cmos5l_nor2b_1
X_15698_ _15698_/Y _15698_/A _15698_/B _15698_/C VPWR VGND sg13cmos5l_nor3_1
X_14718_ _14725_/C _19157_/Q _19158_/Q hold3046/X VPWR VGND sg13cmos5l_o21ai_1
XFILLER_33_643 VPWR VGND sg13cmos5l_fill_2
X_19770__426 _19770_/D VPWR VGND sg13cmos5l_tielo
X_17437_ _19606_/D _17739_/A _17437_/B VPWR VGND sg13cmos5l_and2_1
X_14649_ _19184_/D _14649_/A _14649_/B VPWR VGND sg13cmos5l_and2_1
XFILLER_32_153 VPWR VGND sg13cmos5l_fill_2
X_17368_ _19585_/D _17368_/A _17370_/B VPWR VGND sg13cmos5l_nor2_1
X_19107_ _19107_/Q _19220_/CLK _19107_/D _19107_/RESET_B VPWR VGND sg13cmos5l_dfrbpq_1
X_17299_ _17299_/Y _17267_/D _17249_/B _17316_/B VPWR VGND sg13cmos5l_a21oi_1
X_16319_ _19435_/D _16320_/A _16319_/B VPWR VGND sg13cmos5l_nor2_1
X_19083__1171 _19083_/RESET_B VPWR VGND sg13cmos5l_tiehi
X_19038_ _19038_/Q clkload31/A _19038_/D _19038_/RESET_B VPWR VGND sg13cmos5l_dfrbpq_1
X_19631__577 _19631_/RESET_B VPWR VGND sg13cmos5l_tiehi
XFILLER_63_0 VPWR VGND sg13cmos5l_fill_2
Xhold2914 _10960_/A _18638_/Q VPWR VGND sg13cmos5l_dlygate4sd3_1
Xhold2903 _18391_/A _19762_/Q VPWR VGND sg13cmos5l_dlygate4sd3_1
Xhold2925 _12928_/A _18927_/Q VPWR VGND sg13cmos5l_dlygate4sd3_1
Xhold2936 hold2936/X _16276_/A VPWR VGND sg13cmos5l_dlygate4sd3_1
Xhold2947 _10479_/A _19740_/Q VPWR VGND sg13cmos5l_dlygate4sd3_1
Xhold2958 hold2958/X _18863_/Q VPWR VGND sg13cmos5l_dlygate4sd3_1
Xhold2969 _14593_/A _19173_/Q VPWR VGND sg13cmos5l_dlygate4sd3_1
XFILLER_28_404 VPWR VGND sg13cmos5l_fill_2
XFILLER_83_532 VPWR VGND sg13cmos5l_fill_1
XFILLER_52_985 VPWR VGND sg13cmos5l_decap_8
XFILLER_11_304 VPWR VGND sg13cmos5l_fill_1
X_19225__1020 _19225_/RESET_B VPWR VGND sg13cmos5l_tiehi
XFILLER_106_910 VPWR VGND sg13cmos5l_fill_2
X_10330_ _18498_/B _19728_/Q VPWR VGND sg13cmos5l_inv_1
X_10261_ _13299_/B _13308_/A VPWR VGND sg13cmos5l_inv_1
X_12000_ _12000_/X _18737_/Q _12018_/B VPWR VGND sg13cmos5l_or2_1
X_10192_ _18253_/B _10555_/A VPWR VGND sg13cmos5l_inv_1
Xfanout350 _11533_/B _11548_/A VPWR VGND sg13cmos5l_buf_1
Xfanout372 _17150_/A _10750_/A VPWR VGND sg13cmos5l_buf_1
X_13951_ _13952_/B _13951_/A _13951_/B VPWR VGND sg13cmos5l_xor2_1
Xfanout361 _16081_/A _16082_/A VPWR VGND sg13cmos5l_buf_1
Xfanout383 _14708_/A _14364_/A VPWR VGND sg13cmos5l_buf_1
X_12902_ _12902_/Y _12954_/A VPWR VGND sg13cmos5l_inv_1
Xfanout394 _13573_/A fanout403/X VPWR VGND sg13cmos5l_buf_1
X_16670_ _16770_/A _16629_/Y _16651_/B _13688_/Y VPWR VGND sg13cmos5l_a21oi_1
XFILLER_74_554 VPWR VGND sg13cmos5l_decap_4
X_13882_ _13884_/B _18993_/Q _13886_/B VPWR VGND sg13cmos5l_nor2b_1
XFILLER_19_459 VPWR VGND sg13cmos5l_fill_1
XFILLER_28_960 VPWR VGND sg13cmos5l_decap_4
X_12833_ _12938_/A _12833_/A _12849_/B _12833_/C VPWR VGND sg13cmos5l_nand3_1
X_15621_ _15647_/A _15621_/A _15621_/B VPWR VGND sg13cmos5l_xor2_1
X_12764_ _12765_/C _12764_/A _12764_/B VPWR VGND sg13cmos5l_nor2_1
X_15552_ _15556_/B _19288_/Q _15552_/B VPWR VGND sg13cmos5l_xor2_1
X_18340_ _18340_/Y _18340_/A _18340_/B VPWR VGND sg13cmos5l_nor2_1
X_11715_ _11742_/B _18701_/Q _11715_/B VPWR VGND sg13cmos5l_xor2_1
X_18271_ _18282_/S _18271_/A _18271_/B VPWR VGND sg13cmos5l_nor2_1
X_14503_ _14602_/B _14516_/A _14516_/B VPWR VGND sg13cmos5l_nand2_1
X_15483_ _15483_/Y _19334_/Q _16016_/A VPWR VGND sg13cmos5l_nand2_1
X_12695_ _12695_/Y _12695_/A _12695_/B _12695_/C VPWR VGND sg13cmos5l_nand3_1
X_17222_ _17330_/B _17234_/A _17234_/B VPWR VGND sg13cmos5l_nand2_1
X_11646_ _11646_/Y _18683_/Q _11646_/B VPWR VGND sg13cmos5l_nand2_1
X_14434_ _14434_/Y _14218_/A fanout73/X _14636_/A VPWR VGND sg13cmos5l_o21ai_1
X_17153_ _17163_/B _19527_/Q _19525_/Q _19526_/Q VPWR VGND sg13cmos5l_or3_1
X_11577_ _11597_/S _11478_/Y _11522_/X _11570_/Y VPWR VGND sg13cmos5l_a21oi_1
X_14365_ _19130_/D _14365_/A _14375_/A VPWR VGND sg13cmos5l_and2_1
X_17084_ _19545_/D _17084_/A _17087_/A VPWR VGND sg13cmos5l_nor2_1
X_13316_ _13316_/X _13836_/A _13317_/B VPWR VGND sg13cmos5l_or2_1
X_16104_ _16111_/B _19372_/Q _19371_/Q _19370_/Q _16104_/D VPWR VGND sg13cmos5l_nor4_1
XFILLER_10_392 VPWR VGND sg13cmos5l_fill_1
X_19318__469 _19318_/D VPWR VGND sg13cmos5l_tielo
X_10528_ _10528_/X _10538_/B _10528_/B VPWR VGND sg13cmos5l_and2_1
X_14296_ _14302_/A _13998_/Y _14201_/A _14293_/A _14293_/B _14190_/Y VPWR VGND sg13cmos5l_a221oi_1
X_13247_ _13247_/Y _13250_/B _13247_/B VPWR VGND sg13cmos5l_nand2_1
XFILLER_6_385 VPWR VGND sg13cmos5l_fill_2
X_16035_ _16035_/Y _19418_/Q _16556_/A _16052_/C VPWR VGND sg13cmos5l_nand3_1
X_19747__962 _19747_/RESET_B VPWR VGND sg13cmos5l_tiehi
X_10459_ _10622_/A _19796_/Q _10621_/B _10465_/A VPWR VGND sg13cmos5l_a21oi_1
XFILLER_69_304 VPWR VGND sg13cmos5l_fill_2
X_13178_ _13178_/Y _13178_/A _13202_/B VPWR VGND sg13cmos5l_nor2b_1
XFILLER_35_4 VPWR VGND sg13cmos5l_decap_4
X_12129_ _12306_/A _12281_/B _12287_/A VPWR VGND sg13cmos5l_nor2_1
XFILLER_97_668 VPWR VGND sg13cmos5l_fill_1
X_17986_ _19680_/D _18067_/A _17986_/B VPWR VGND sg13cmos5l_nor2_1
X_16937_ _16937_/Y _16937_/A _16940_/B VPWR VGND sg13cmos5l_nor2_1
X_19725_ _19725_/Q _19790_/CLK _19725_/D _19725_/RESET_B VPWR VGND sg13cmos5l_dfrbpq_1
X_16868_ _16868_/Y _16868_/A _16868_/B VPWR VGND sg13cmos5l_nor2_1
XFILLER_38_768 VPWR VGND sg13cmos5l_fill_1
X_19346__890 _19346_/RESET_B VPWR VGND sg13cmos5l_tiehi
X_19656_ _19656_/Q _19679_/CLK _19656_/D _19656_/RESET_B VPWR VGND sg13cmos5l_dfrbpq_1
X_16799_ _16799_/Y _16790_/Y _16796_/Y _16798_/Y VPWR VGND sg13cmos5l_o21ai_1
XFILLER_92_362 VPWR VGND sg13cmos5l_decap_8
XFILLER_80_524 VPWR VGND sg13cmos5l_fill_1
X_19587_ _19587_/Q clkload38/A _19587_/D _19587_/RESET_B VPWR VGND sg13cmos5l_dfrbpq_1
X_18607_ _18607_/Q clkload21/A _18607_/D _18607_/RESET_B VPWR VGND sg13cmos5l_dfrbpq_1
X_15819_ _15819_/X _19332_/Q _19325_/Q _19326_/Q VPWR VGND sg13cmos5l_or3_1
XFILLER_80_568 VPWR VGND sg13cmos5l_fill_2
X_18538_ _18538_/Y _09967_/Y fanout84/X _18537_/Y VPWR VGND sg13cmos5l_a21oi_1
X_18469_ _19747_/D _18456_/A _18468_/Y _18480_/A VPWR VGND sg13cmos5l_a21oi_1
XFILLER_20_156 VPWR VGND sg13cmos5l_fill_2
X_19353__883 _19353_/RESET_B VPWR VGND sg13cmos5l_tiehi
X_18874__1395 _18874_/RESET_B VPWR VGND sg13cmos5l_tiehi
X_19675__1784 _19675_/RESET_B VPWR VGND sg13cmos5l_tiehi
Xhold2722 _16676_/A _19504_/Q VPWR VGND sg13cmos5l_dlygate4sd3_1
Xhold2700 _13535_/A _13534_/Y VPWR VGND sg13cmos5l_dlygate4sd3_1
Xhold2711 _17789_/A _19672_/Q VPWR VGND sg13cmos5l_dlygate4sd3_1
Xhold2755 _10047_/A _18829_/Q VPWR VGND sg13cmos5l_dlygate4sd3_1
Xhold2744 hold2744/X _13805_/Y VPWR VGND sg13cmos5l_dlygate4sd3_1
XFILLER_29_702 VPWR VGND sg13cmos5l_fill_1
Xhold2733 _16453_/B _16417_/B VPWR VGND sg13cmos5l_dlygate4sd3_1
Xhold2777 _12968_/A _18921_/Q VPWR VGND sg13cmos5l_dlygate4sd3_1
Xhold2788 hold2788/X _13013_/Y VPWR VGND sg13cmos5l_dlygate4sd3_1
Xhold2799 _11013_/A _18626_/Q VPWR VGND sg13cmos5l_dlygate4sd3_1
Xhold2766 _18622_/D _11074_/Y VPWR VGND sg13cmos5l_dlygate4sd3_1
X_19284__955 _19284_/RESET_B VPWR VGND sg13cmos5l_tiehi
XFILLER_29_779 VPWR VGND sg13cmos5l_fill_1
X_19123__1128 _19123_/RESET_B VPWR VGND sg13cmos5l_tiehi
X_19360__876 _19360_/RESET_B VPWR VGND sg13cmos5l_tiehi
X_11500_ _11501_/B _11500_/A _11503_/B VPWR VGND sg13cmos5l_nor2_1
X_12480_ _12498_/C _18876_/Q _12483_/B _12479_/B VPWR VGND sg13cmos5l_o21ai_1
XFILLER_8_606 VPWR VGND sg13cmos5l_fill_1
X_11431_ _11469_/A _18656_/Q _11434_/B VPWR VGND sg13cmos5l_xnor2_1
X_11362_ _18679_/D _11363_/A _11362_/B VPWR VGND sg13cmos5l_nor2_1
X_19614__594 _19614_/RESET_B VPWR VGND sg13cmos5l_tiehi
X_19291__948 _19291_/RESET_B VPWR VGND sg13cmos5l_tiehi
X_14150_ _14150_/X _19080_/Q _19073_/Q VPWR VGND sg13cmos5l_or2_1
X_13101_ _13101_/Y _13136_/A VPWR VGND sg13cmos5l_inv_1
X_10313_ _11620_/A _11437_/A VPWR VGND sg13cmos5l_inv_1
X_11293_ _11293_/Y _11201_/A _11201_/B _11361_/B VPWR VGND sg13cmos5l_o21ai_1
X_14081_ _19098_/D _14083_/A _14081_/B VPWR VGND sg13cmos5l_nor2_1
X_13032_ _13032_/Y _13577_/A _18895_/Q _18896_/Q _13578_/A _13031_/Y VPWR VGND sg13cmos5l_a221oi_1
X_10244_ _14392_/B _19108_/Q VPWR VGND sg13cmos5l_inv_1
X_10175_ _18222_/A _17831_/A VPWR VGND sg13cmos5l_inv_1
X_17840_ _17840_/Y _17836_/Y _17838_/Y _17839_/Y VPWR VGND sg13cmos5l_o21ai_1
X_19056__1201 _19056_/RESET_B VPWR VGND sg13cmos5l_tiehi
X_19510_ _19510_/Q clkload39/A _19510_/D _19510_/RESET_B VPWR VGND sg13cmos5l_dfrbpq_1
Xfanout180 _13263_/B _13215_/Y VPWR VGND sg13cmos5l_buf_1
Xfanout191 _11588_/B _11503_/B VPWR VGND sg13cmos5l_buf_1
X_17771_ _17771_/Y _17771_/A _17780_/B VPWR VGND sg13cmos5l_nor2_1
X_14983_ _14983_/Y _15000_/A _15000_/B VPWR VGND sg13cmos5l_nand2_1
X_16722_ _16722_/Y _16722_/A _19506_/Q VPWR VGND sg13cmos5l_nand2_1
X_13934_ _14043_/A _19092_/Q _14050_/B VPWR VGND sg13cmos5l_xnor2_1
XFILLER_47_543 VPWR VGND sg13cmos5l_fill_2
X_16653_ _16653_/Y _16653_/A _16664_/A VPWR VGND sg13cmos5l_nor2_1
X_19621__587 _19621_/RESET_B VPWR VGND sg13cmos5l_tiehi
X_19441_ _19441_/Q clkload5/A _19441_/D _19441_/RESET_B VPWR VGND sg13cmos5l_dfrbpq_1
X_13865_ _13865_/Y _13845_/B _13859_/S _14071_/B VPWR VGND sg13cmos5l_o21ai_1
X_12816_ _12816_/X _12820_/B _12818_/C VPWR VGND sg13cmos5l_or2_1
X_19372_ _19372_/Q clkload9/A _19372_/D _19372_/RESET_B VPWR VGND sg13cmos5l_dfrbpq_1
X_15604_ _15604_/Y _19345_/Q _15721_/B _15591_/Y VPWR VGND sg13cmos5l_a21oi_1
X_13796_ _19039_/D _13796_/A _13796_/B VPWR VGND sg13cmos5l_nor2_1
X_16584_ _16584_/Y _17085_/A _17079_/A _16593_/C VPWR VGND sg13cmos5l_nand3_1
X_18323_ _18431_/A _18340_/B _18321_/Y _18322_/Y VPWR VGND sg13cmos5l_a21o_1
X_12747_ _12767_/C _12754_/C _12747_/B VPWR VGND sg13cmos5l_and2_1
XFILLER_72_1026 VPWR VGND sg13cmos5l_fill_2
X_19591__620 _19591_/RESET_B VPWR VGND sg13cmos5l_tiehi
X_15535_ _15542_/A _15535_/A _15550_/D _15535_/C VPWR VGND sg13cmos5l_and3_1
X_12678_ _12679_/B _18878_/Q _12602_/B _12580_/Y VPWR VGND sg13cmos5l_a21oi_1
X_18254_ _18254_/Y _18243_/B _18252_/X _18253_/Y VPWR VGND sg13cmos5l_a21oi_1
X_15466_ _19310_/D _15466_/A _15466_/B VPWR VGND sg13cmos5l_nor2_1
X_11629_ _18720_/D _11629_/A _11629_/B VPWR VGND sg13cmos5l_nor2_1
X_17205_ _17207_/B _17200_/S _17204_/Y _17203_/Y VPWR VGND sg13cmos5l_a21oi_1
X_18185_ _18185_/Y _18089_/X _18184_/A _18182_/Y VPWR VGND sg13cmos5l_o21ai_1
X_14417_ _14417_/Y _14903_/B _14978_/A VPWR VGND sg13cmos5l_nand2b_1
X_17136_ _17137_/B _17109_/Y _17379_/B _17136_/S VPWR VGND sg13cmos5l_mux2_1
X_15397_ _15397_/Y _15397_/A VPWR VGND sg13cmos5l_inv_1
X_14348_ _14350_/B _14227_/A _14227_/B _14340_/Y _14344_/A VPWR VGND sg13cmos5l_a22oi_1
X_17067_ _19532_/D hold2607/X _17070_/S _17066_/Y VPWR VGND sg13cmos5l_a21oi_1
X_14279_ _14279_/Y _14279_/A _14310_/B VPWR VGND sg13cmos5l_nor2_1
X_16018_ _19390_/D _16020_/A _16018_/B VPWR VGND sg13cmos5l_nor2_1
XFILLER_97_443 VPWR VGND sg13cmos5l_fill_2
Xhold2007 hold2007/X _18983_/Q VPWR VGND sg13cmos5l_dlygate4sd3_1
Xhold2018 _18607_/D _10878_/Y VPWR VGND sg13cmos5l_dlygate4sd3_1
XFILLER_98_999 VPWR VGND sg13cmos5l_fill_1
Xhold2029 hold2029/X _18984_/Q VPWR VGND sg13cmos5l_dlygate4sd3_1
XFILLER_26_0 VPWR VGND sg13cmos5l_fill_2
XFILLER_97_498 VPWR VGND sg13cmos5l_fill_1
X_17969_ _17969_/Y _17969_/A _19644_/Q VPWR VGND sg13cmos5l_nor2_1
X_19708_ _19708_/Q clkload13/A _19708_/D _19708_/RESET_B VPWR VGND sg13cmos5l_dfrbpq_1
X_19639_ _19639_/Q clkload13/A _19639_/D _19639_/RESET_B VPWR VGND sg13cmos5l_dfrbpq_1
XFILLER_40_218 VPWR VGND sg13cmos5l_fill_2
XFILLER_4_108 VPWR VGND sg13cmos5l_decap_8
X_19783__425 _19783_/D VPWR VGND sg13cmos5l_tielo
XFILLER_89_944 VPWR VGND sg13cmos5l_fill_2
XFILLER_68_37 VPWR VGND sg13cmos5l_fill_1
X_18664__1629 _18664_/RESET_B VPWR VGND sg13cmos5l_tiehi
Xhold2530 _10099_/A _19170_/Q VPWR VGND sg13cmos5l_dlygate4sd3_1
Xhold2541 hold2541/X _12677_/A VPWR VGND sg13cmos5l_dlygate4sd3_1
XFILLER_76_638 VPWR VGND sg13cmos5l_fill_1
Xhold2563 _17133_/B _17132_/X VPWR VGND sg13cmos5l_dlygate4sd3_1
Xhold2574 hold2574/X _15995_/B VPWR VGND sg13cmos5l_dlygate4sd3_1
Xhold2552 _14419_/B _14418_/X VPWR VGND sg13cmos5l_dlygate4sd3_1
X_11980_ _11984_/A _11972_/Y _11975_/Y _11979_/Y _11826_/A _11976_/Y VPWR VGND sg13cmos5l_a221oi_1
Xhold1851 _12259_/B _18776_/Q VPWR VGND sg13cmos5l_dlygate4sd3_1
Xhold1840 _11967_/B _18735_/Q VPWR VGND sg13cmos5l_dlygate4sd3_1
Xhold1862 _13086_/B _18903_/Q VPWR VGND sg13cmos5l_dlygate4sd3_1
Xhold2596 _13179_/A _18975_/Q VPWR VGND sg13cmos5l_dlygate4sd3_1
Xhold2585 _10235_/A _19146_/Q VPWR VGND sg13cmos5l_dlygate4sd3_1
XFILLER_95_1015 VPWR VGND sg13cmos5l_decap_8
XFILLER_84_660 VPWR VGND sg13cmos5l_fill_1
Xhold1884 _11424_/B _18652_/Q VPWR VGND sg13cmos5l_dlygate4sd3_1
Xhold1895 _13929_/B _18988_/Q VPWR VGND sg13cmos5l_dlygate4sd3_1
X_10931_ _10999_/A _10900_/Y _10928_/B _10549_/Y VPWR VGND sg13cmos5l_o21ai_1
XFILLER_1_1019 VPWR VGND sg13cmos5l_decap_8
Xhold1873 _15181_/B _19213_/Q VPWR VGND sg13cmos5l_dlygate4sd3_1
X_13650_ _19033_/D _13650_/A _13819_/A VPWR VGND sg13cmos5l_nor2_1
X_10862_ _10862_/Y _10841_/A _10865_/S _10861_/Y VPWR VGND sg13cmos5l_a21oi_1
X_12601_ _12704_/A _12584_/A _12599_/B _12600_/Y VPWR VGND sg13cmos5l_a21oi_1
X_10793_ _10794_/D input5/X _10793_/B VPWR VGND sg13cmos5l_nand2b_1
X_13581_ _13581_/Y _13505_/C hold2691/X _13585_/A VPWR VGND sg13cmos5l_a21oi_1
X_12532_ _12534_/B _18825_/Q _12537_/B VPWR VGND sg13cmos5l_nor2b_1
XFILLER_13_966 VPWR VGND sg13cmos5l_fill_2
X_15320_ _15418_/C _19279_/Q _19240_/Q _15320_/C VPWR VGND sg13cmos5l_nand3_1
X_12463_ _18843_/D _12467_/A _12463_/B VPWR VGND sg13cmos5l_nor2_1
XFILLER_8_425 VPWR VGND sg13cmos5l_decap_8
X_15251_ _15251_/Y hold2011/X fanout92/X _14708_/A VPWR VGND sg13cmos5l_o21ai_1
X_11414_ _11414_/Y _11646_/B _11414_/B VPWR VGND sg13cmos5l_nand2_1
X_18610__1686 _18610_/RESET_B VPWR VGND sg13cmos5l_tiehi
XFILLER_12_498 VPWR VGND sg13cmos5l_decap_8
X_14202_ _14204_/B _14201_/A _14201_/B _14200_/Y VPWR VGND sg13cmos5l_o21ai_1
X_12394_ _12435_/A _18840_/Q _12398_/B _12393_/Y VPWR VGND sg13cmos5l_a21oi_1
X_15182_ _19256_/D _15182_/A _15185_/B VPWR VGND sg13cmos5l_and2_1
X_18597__1702 _18597_/RESET_B VPWR VGND sg13cmos5l_tiehi
X_11345_ _18663_/D hold2790/X _11342_/S _11344_/Y VPWR VGND sg13cmos5l_a21oi_1
X_14133_ _14133_/Y _14119_/B _14131_/S _14374_/A VPWR VGND sg13cmos5l_o21ai_1
XFILLER_106_570 VPWR VGND sg13cmos5l_decap_4
XFILLER_98_218 VPWR VGND sg13cmos5l_fill_2
X_18941_ _18941_/Q _19003_/CLK _18941_/D _18941_/RESET_B VPWR VGND sg13cmos5l_dfrbpq_1
X_11276_ _11276_/Y _11274_/A _11300_/B _11274_/B VPWR VGND sg13cmos5l_a21oi_1
X_14064_ _14064_/Y _14024_/B _14062_/S _14071_/B VPWR VGND sg13cmos5l_o21ai_1
XFILLER_4_675 VPWR VGND sg13cmos5l_fill_1
XFILLER_3_152 VPWR VGND sg13cmos5l_fill_2
X_13015_ _18919_/D _13284_/A _13015_/B VPWR VGND sg13cmos5l_and2_1
X_10227_ _15225_/B _10227_/A VPWR VGND sg13cmos5l_inv_1
X_18872_ _18872_/Q _18931_/CLK _18872_/D _18872_/RESET_B VPWR VGND sg13cmos5l_dfrbpq_1
X_10158_ _17669_/A _10158_/A VPWR VGND sg13cmos5l_inv_1
X_17823_ _18029_/A _18225_/A _17823_/B VPWR VGND sg13cmos5l_xnor2_1
XFILLER_66_148 VPWR VGND sg13cmos5l_fill_2
X_17754_ _17754_/Y _17592_/A _17774_/A _17777_/A _17755_/A VPWR VGND sg13cmos5l_a22oi_1
X_14966_ _14966_/Y _14950_/A _14958_/S _15185_/B VPWR VGND sg13cmos5l_o21ai_1
X_10089_ _14371_/A _10089_/A VPWR VGND sg13cmos5l_inv_1
X_16705_ _16706_/B _19510_/Q _16708_/B VPWR VGND sg13cmos5l_nor2b_1
XFILLER_63_800 VPWR VGND sg13cmos5l_fill_1
X_13917_ _13917_/Y _13891_/X _13923_/B _13924_/S VPWR VGND sg13cmos5l_o21ai_1
X_19712__1545 _19712_/RESET_B VPWR VGND sg13cmos5l_tiehi
X_18847__1425 _18847_/RESET_B VPWR VGND sg13cmos5l_tiehi
XFILLER_63_844 VPWR VGND sg13cmos5l_fill_1
XFILLER_62_321 VPWR VGND sg13cmos5l_fill_1
X_17685_ _17685_/Y _18225_/A _19600_/Q _17684_/Y VPWR VGND sg13cmos5l_o21ai_1
X_14897_ _14897_/Y _14855_/B _14895_/S _14916_/A VPWR VGND sg13cmos5l_o21ai_1
X_19424_ _19424_/Q clkload7/A _19424_/D _19424_/RESET_B VPWR VGND sg13cmos5l_dfrbpq_1
XFILLER_35_524 VPWR VGND sg13cmos5l_fill_1
X_16636_ _16637_/B _19038_/Q _19031_/Q VPWR VGND sg13cmos5l_or2_1
X_13848_ _13848_/Y _13848_/A _18980_/Q VPWR VGND sg13cmos5l_nand2_1
X_19343__893 _19343_/RESET_B VPWR VGND sg13cmos5l_tiehi
X_16567_ _16567_/Y _16565_/Y _16567_/B VPWR VGND sg13cmos5l_nand2b_1
X_13779_ _13782_/A _13746_/Y _13786_/A _13779_/C VPWR VGND sg13cmos5l_nand3b_1
X_19355_ _19355_/Q _19462_/CLK _19355_/D _19355_/RESET_B VPWR VGND sg13cmos5l_dfrbpq_1
X_15518_ _15518_/Y _15764_/B _15518_/B VPWR VGND sg13cmos5l_nand2_1
X_19286_ _19286_/Q clkload43/A _19286_/D _19286_/RESET_B VPWR VGND sg13cmos5l_dfrbpq_1
X_18306_ _18326_/A _19693_/Q _18306_/B VPWR VGND sg13cmos5l_xor2_1
X_18237_ _18237_/Y _10638_/A _19682_/Q _18234_/Y _18235_/Y _18236_/Y VPWR VGND sg13cmos5l_a221oi_1
X_16498_ _16530_/A _19461_/Q _16500_/B VPWR VGND sg13cmos5l_nor2_1
Xclkbuf_4_4_0_clk clkbuf_4_4_0_clk/X clkbuf_0_clk/X VPWR VGND sg13cmos5l_buf_8
X_15449_ _15449_/Y _15436_/B _15447_/S _15234_/Y VPWR VGND sg13cmos5l_o21ai_1
X_18168_ _18168_/X _18156_/X _18162_/Y _18166_/Y VPWR VGND sg13cmos5l_a21o_1
X_17119_ _17119_/Y _17119_/A VPWR VGND sg13cmos5l_inv_1
X_18099_ _18119_/B _19702_/Q _19701_/Q VPWR VGND sg13cmos5l_nor2_1
X_19350__886 _19350_/RESET_B VPWR VGND sg13cmos5l_tiehi
XFILLER_85_413 VPWR VGND sg13cmos5l_fill_1
XFILLER_57_115 VPWR VGND sg13cmos5l_fill_2
XFILLER_85_457 VPWR VGND sg13cmos5l_fill_1
X_19163__1085 _19163_/RESET_B VPWR VGND sg13cmos5l_tiehi
XFILLER_72_129 VPWR VGND sg13cmos5l_fill_2
X_19281__958 _19281_/RESET_B VPWR VGND sg13cmos5l_tiehi
XFILLER_81_663 VPWR VGND sg13cmos5l_fill_2
XFILLER_41_538 VPWR VGND sg13cmos5l_decap_4
XFILLER_6_918 VPWR VGND sg13cmos5l_decap_4
XFILLER_6_907 VPWR VGND sg13cmos5l_fill_1
X_19796__1760 _19796_/RESET_B VPWR VGND sg13cmos5l_tiehi
XFILLER_6_929 VPWR VGND sg13cmos5l_decap_8
X_11130_ _11130_/Y _11130_/A _11130_/B VPWR VGND sg13cmos5l_nor2_1
X_19611__597 _19611_/RESET_B VPWR VGND sg13cmos5l_tiehi
Xhold3050 _11786_/A _18762_/Q VPWR VGND sg13cmos5l_dlygate4sd3_1
X_11061_ _11061_/Y _11061_/A _11061_/B VPWR VGND sg13cmos5l_nand2_1
X_10012_ _10012_/Y _10012_/A VPWR VGND sg13cmos5l_inv_1
X_19581__630 _19581_/RESET_B VPWR VGND sg13cmos5l_tiehi
Xhold3061 _10075_/A _13476_/C VPWR VGND sg13cmos5l_dlygate4sd3_1
XFILLER_49_638 VPWR VGND sg13cmos5l_fill_1
XFILLER_49_627 VPWR VGND sg13cmos5l_fill_1
Xhold2371 _12787_/B _18897_/Q VPWR VGND sg13cmos5l_dlygate4sd3_1
Xhold2360 _10158_/A _19576_/Q VPWR VGND sg13cmos5l_dlygate4sd3_1
X_14820_ _14820_/Y _15000_/A _14837_/B VPWR VGND sg13cmos5l_nor2_1
Xhold2382 _16550_/A _19416_/Q VPWR VGND sg13cmos5l_dlygate4sd3_1
XFILLER_91_405 VPWR VGND sg13cmos5l_fill_2
Xhold2393 _10871_/B _18603_/Q VPWR VGND sg13cmos5l_dlygate4sd3_1
X_11963_ _18774_/D _10009_/Y fanout77/X _11962_/Y VPWR VGND sg13cmos5l_a21oi_1
X_18628__1668 _18628_/RESET_B VPWR VGND sg13cmos5l_tiehi
X_14751_ _14751_/Y _14757_/B _14717_/Y VPWR VGND sg13cmos5l_nor2b_1
Xclkbuf_leaf_83_clk clkload15/A clkbuf_4_2_0_clk/X VPWR VGND sg13cmos5l_buf_8
X_13702_ _13705_/B _13714_/B _13714_/C _13701_/X VPWR VGND sg13cmos5l_o21ai_1
X_11894_ _18753_/D _11894_/A _11899_/B VPWR VGND sg13cmos5l_nor2_1
XFILLER_72_652 VPWR VGND sg13cmos5l_decap_8
X_17470_ _17470_/Y _17460_/Y _17465_/Y _17495_/B _17473_/A _17467_/Y VPWR VGND sg13cmos5l_a221oi_1
X_10914_ _10914_/Y _10917_/B _10907_/B _10913_/Y VPWR VGND sg13cmos5l_o21ai_1
X_14682_ _14682_/Y _14942_/A _14676_/A _14684_/B _14947_/B VPWR VGND sg13cmos5l_a22oi_1
X_13633_ _19021_/D _13801_/A _13633_/B VPWR VGND sg13cmos5l_nor2_1
X_10845_ _10845_/Y _11354_/A _18624_/Q _10850_/C VPWR VGND sg13cmos5l_nor3_1
X_16421_ _16433_/B _19412_/Q _16457_/A VPWR VGND sg13cmos5l_xor2_1
XFILLER_32_527 VPWR VGND sg13cmos5l_decap_4
X_16352_ _16352_/Y _16352_/A VPWR VGND sg13cmos5l_inv_1
X_19140_ _19140_/Q clkload49/A _19140_/D _19140_/RESET_B VPWR VGND sg13cmos5l_dfrbpq_1
X_10776_ _10776_/Y _10771_/Y _10772_/Y _10775_/Y VPWR VGND sg13cmos5l_a21oi_1
X_19772__693 _19772_/RESET_B VPWR VGND sg13cmos5l_tiehi
X_13564_ _18997_/D _13543_/A fanout47/X _13563_/Y VPWR VGND sg13cmos5l_a21oi_1
X_15303_ _15303_/Y _15303_/A _15303_/B VPWR VGND sg13cmos5l_nor2_1
XFILLER_13_774 VPWR VGND sg13cmos5l_fill_2
XFILLER_13_785 VPWR VGND sg13cmos5l_fill_2
X_12515_ _12515_/Y _12495_/A _12509_/S _12579_/A VPWR VGND sg13cmos5l_o21ai_1
X_13495_ _13495_/Y _13495_/A _13513_/B VPWR VGND sg13cmos5l_nor2_1
X_16283_ _16291_/B _16319_/B _16282_/B _16282_/Y VPWR VGND sg13cmos5l_o21ai_1
X_19071_ _19071_/Q clkload47/A _19071_/D _19071_/RESET_B VPWR VGND sg13cmos5l_dfrbpq_1
X_12446_ _12447_/B _12420_/Y _12422_/A _12451_/A VPWR VGND sg13cmos5l_mux2_1
XFILLER_60_82 VPWR VGND sg13cmos5l_decap_4
X_18022_ _18022_/X _18022_/A _18057_/A VPWR VGND sg13cmos5l_and2_1
X_15234_ _15234_/Y _15234_/A _15735_/B VPWR VGND sg13cmos5l_nor2_1
X_12377_ _12416_/A _12463_/B _12293_/B _12429_/B VPWR VGND sg13cmos5l_mux2_1
X_15165_ _15165_/Y _15179_/A _15167_/B _15164_/Y VPWR VGND sg13cmos5l_a21oi_1
X_11328_ _11328_/Y _11306_/Y _11322_/Y _11327_/Y VPWR VGND sg13cmos5l_o21ai_1
X_14116_ _14119_/B _14114_/C _14115_/Y _14114_/Y VPWR VGND sg13cmos5l_a21o_1
X_15096_ _15108_/B _15282_/A _15121_/B VPWR VGND sg13cmos5l_nor2_1
X_18924_ _18924_/Q _18931_/CLK _18924_/D _18924_/RESET_B VPWR VGND sg13cmos5l_dfrbpq_1
X_11259_ _11259_/Y _11620_/A _11257_/X _11258_/Y _11256_/X VPWR VGND sg13cmos5l_a22oi_1
X_14047_ _14047_/Y _14024_/Y _14042_/Y _14046_/Y VPWR VGND sg13cmos5l_o21ai_1
X_18855_ _18855_/Q clkload63/A _18855_/D _18855_/RESET_B VPWR VGND sg13cmos5l_dfrbpq_1
XFILLER_39_104 VPWR VGND sg13cmos5l_decap_8
X_17806_ _17807_/C _17806_/A _17808_/B VPWR VGND sg13cmos5l_or2_1
X_18786_ _18786_/Q clkload61/A _18786_/D _18786_/RESET_B VPWR VGND sg13cmos5l_dfrbpq_1
XFILLER_94_276 VPWR VGND sg13cmos5l_fill_2
XFILLER_48_671 VPWR VGND sg13cmos5l_fill_1
X_15998_ _19374_/D _15889_/Y _16001_/S _15997_/Y VPWR VGND sg13cmos5l_a21oi_1
XFILLER_76_991 VPWR VGND sg13cmos5l_fill_2
X_17737_ _19648_/D _17739_/A _17737_/B VPWR VGND sg13cmos5l_and2_1
Xclkbuf_leaf_74_clk clkload43/A clkbuf_4_8_0_clk/X VPWR VGND sg13cmos5l_buf_8
X_14949_ _14950_/A _14948_/C _14947_/Y _14948_/Y VPWR VGND sg13cmos5l_a21o_1
X_17668_ _19625_/D _17668_/A _17671_/B VPWR VGND sg13cmos5l_nor2_1
XFILLER_39_1027 VPWR VGND sg13cmos5l_fill_2
X_16619_ _19478_/D _09977_/Y fanout69/X _16618_/Y VPWR VGND sg13cmos5l_a21oi_1
X_19727__1320 _19727_/RESET_B VPWR VGND sg13cmos5l_tiehi
X_19407_ _19407_/Q _19738_/CLK _19407_/D _19407_/RESET_B VPWR VGND sg13cmos5l_dfrbpq_1
XFILLER_93_0 VPWR VGND sg13cmos5l_fill_1
X_17599_ _17599_/Y _17585_/Y _17591_/Y _17597_/Y _17488_/B _17598_/Y VPWR VGND sg13cmos5l_a221oi_1
X_19338_ _19338_/Q clkload19/A _19338_/D _19338_/RESET_B VPWR VGND sg13cmos5l_dfrbpq_1
X_19269_ _19269_/Q _19308_/CLK _19269_/D _19269_/RESET_B VPWR VGND sg13cmos5l_dfrbpq_1
XFILLER_104_304 VPWR VGND sg13cmos5l_fill_1
XFILLER_104_359 VPWR VGND sg13cmos5l_fill_2
XFILLER_73_449 VPWR VGND sg13cmos5l_fill_2
Xclkbuf_leaf_65_clk _19136_/CLK clkload2/A VPWR VGND sg13cmos5l_buf_8
XFILLER_81_48 VPWR VGND sg13cmos5l_fill_2
X_10630_ _10631_/B _10465_/X _10624_/B _10633_/A VPWR VGND sg13cmos5l_mux2_1
XFILLER_10_744 VPWR VGND sg13cmos5l_fill_2
X_10561_ _10643_/A hold2727/X _10560_/Y _10585_/S VPWR VGND sg13cmos5l_mux2_1
X_12300_ _12301_/B _12278_/D _12267_/C _12299_/B _12137_/B _12307_/B VPWR VGND sg13cmos5l_a221oi_1
X_13280_ _13280_/Y _13267_/B _13276_/S _13290_/B VPWR VGND sg13cmos5l_o21ai_1
X_10492_ _10493_/B _19735_/Q _19736_/Q _19737_/Q VPWR VGND sg13cmos5l_o21ai_1
X_12231_ _12231_/Y _12727_/A _18834_/Q _12231_/C VPWR VGND sg13cmos5l_nor3_1
X_19767__773 _19767_/RESET_B VPWR VGND sg13cmos5l_tiehi
X_12162_ _12162_/Y _12162_/A _12162_/B VPWR VGND sg13cmos5l_nand2_1
X_12093_ _12093_/Y _12136_/A _12137_/A _12085_/Y VPWR VGND sg13cmos5l_o21ai_1
X_16970_ _16973_/B _19535_/Q _19536_/Q _19534_/Q _16982_/B VPWR VGND sg13cmos5l_nor4_1
X_11113_ _11113_/Y _11113_/A VPWR VGND sg13cmos5l_inv_1
X_11044_ _11047_/A _11044_/A VPWR VGND sg13cmos5l_inv_1
X_15921_ _15921_/Y _15921_/A VPWR VGND sg13cmos5l_inv_1
X_18640_ _18640_/Q _18733_/CLK _18640_/D _18640_/RESET_B VPWR VGND sg13cmos5l_dfrbpq_1
XFILLER_49_435 VPWR VGND sg13cmos5l_fill_1
X_18887__1382 _18887_/RESET_B VPWR VGND sg13cmos5l_tiehi
X_15852_ _15852_/Y _15828_/D _15821_/C _15856_/B VPWR VGND sg13cmos5l_a21oi_1
Xhold2190 _10230_/A _19187_/Q VPWR VGND sg13cmos5l_dlygate4sd3_1
X_18571_ _18571_/Q clkload29/A _18571_/D _18571_/RESET_B VPWR VGND sg13cmos5l_dfrbpq_1
X_12995_ _12995_/Y _12988_/A _13010_/A _12994_/Y VPWR VGND sg13cmos5l_o21ai_1
Xclkbuf_leaf_56_clk clkload58/A clkbuf_4_12_0_clk/X VPWR VGND sg13cmos5l_buf_8
X_14803_ _14803_/Y _19206_/Q _19221_/Q VPWR VGND sg13cmos5l_nand2_1
X_15783_ _15783_/Y _16047_/A _15777_/A _15782_/A _16052_/B _15778_/Y VPWR VGND sg13cmos5l_a221oi_1
X_11946_ _11946_/Y _13337_/A _12455_/B VPWR VGND sg13cmos5l_nor2_1
X_17522_ _17643_/B _19629_/Q _17522_/B VPWR VGND sg13cmos5l_and2_1
X_14734_ _14735_/B _14731_/A _14757_/A _14757_/B _14737_/A VPWR VGND sg13cmos5l_a22oi_1
X_17453_ _17453_/Y _17455_/A _17490_/A _17452_/X VPWR VGND sg13cmos5l_o21ai_1
XFILLER_33_836 VPWR VGND sg13cmos5l_fill_1
X_11877_ _11877_/Y _11878_/A _11878_/B _11876_/Y VPWR VGND sg13cmos5l_a21oi_1
X_14665_ _14665_/Y _19207_/Q _15188_/A _14680_/C VPWR VGND sg13cmos5l_nand3_1
X_16404_ _16409_/B _16404_/A _16405_/B VPWR VGND sg13cmos5l_nand2_1
X_19340__896 _19340_/RESET_B VPWR VGND sg13cmos5l_tiehi
X_13616_ _13617_/A _10734_/Y _13615_/Y _13616_/S VPWR VGND sg13cmos5l_mux2_1
X_17384_ _17384_/Y _19619_/Q _17403_/A _17408_/B _19620_/Q _17383_/Y VPWR VGND sg13cmos5l_a221oi_1
X_10828_ _10828_/Y _10828_/A _10854_/A _10838_/C VPWR VGND sg13cmos5l_nand3_1
X_14596_ _14596_/Y _14599_/B _14599_/C _14645_/B VPWR VGND sg13cmos5l_a21oi_1
X_10759_ _10759_/X _10759_/A _10764_/A VPWR VGND sg13cmos5l_xor2_1
X_13547_ _13557_/A _13443_/Y _13555_/A _13547_/C VPWR VGND sg13cmos5l_nand3b_1
X_16335_ _16335_/Y _16335_/A _19402_/Q VPWR VGND sg13cmos5l_nor2_1
X_19123_ _19123_/Q _19136_/CLK _19123_/D _19123_/RESET_B VPWR VGND sg13cmos5l_dfrbpq_1
X_19054_ _19054_/Q clkload30/A _19054_/D _19054_/RESET_B VPWR VGND sg13cmos5l_dfrbpq_1
X_16266_ _16267_/B _16170_/A _16150_/Y _16147_/Y VPWR VGND sg13cmos5l_a21oi_1
X_19136__1115 _19136_/RESET_B VPWR VGND sg13cmos5l_tiehi
X_13478_ _13479_/C _13518_/A _13899_/A VPWR VGND sg13cmos5l_nor2_1
X_18005_ _19692_/D _18005_/A _18077_/B VPWR VGND sg13cmos5l_and2_1
X_15217_ _15218_/B _19234_/Q _15215_/Y _15216_/Y VPWR VGND sg13cmos5l_o21ai_1
X_12429_ _12429_/Y _12429_/A _12429_/B VPWR VGND sg13cmos5l_nand2_1
X_16197_ _16197_/X _16433_/A _16244_/A VPWR VGND sg13cmos5l_and2_1
Xheichips26_digital_project_418 uo_out[9] VPWR VGND sg13cmos5l_tielo
Xheichips26_digital_project_407 uio_out[7] VPWR VGND sg13cmos5l_tielo
X_15148_ _15149_/A _15043_/B _15155_/B _15148_/C VPWR VGND sg13cmos5l_nand3b_1
XFILLER_99_368 VPWR VGND sg13cmos5l_fill_2
X_15079_ _15086_/B _19267_/Q _15080_/B VPWR VGND sg13cmos5l_nor2b_1
X_18907_ _18907_/Q _18975_/CLK _18907_/D _18907_/RESET_B VPWR VGND sg13cmos5l_dfrbpq_1
XFILLER_95_541 VPWR VGND sg13cmos5l_fill_1
X_18838_ _18838_/Q clkload62/A _18838_/D _18838_/RESET_B VPWR VGND sg13cmos5l_dfrbpq_1
X_18769_ _18769_/Q clkload68/A _18769_/D _18769_/RESET_B VPWR VGND sg13cmos5l_dfrbpq_1
Xclkbuf_leaf_47_clk _18931_/CLK clkload4/A VPWR VGND sg13cmos5l_buf_8
XFILLER_82_268 VPWR VGND sg13cmos5l_fill_1
XFILLER_51_688 VPWR VGND sg13cmos5l_fill_2
XFILLER_23_379 VPWR VGND sg13cmos5l_fill_1
X_19571__640 _19571_/RESET_B VPWR VGND sg13cmos5l_tiehi
X_18842__1430 _18842_/RESET_B VPWR VGND sg13cmos5l_tiehi
XFILLER_58_221 VPWR VGND sg13cmos5l_fill_1
XFILLER_59_777 VPWR VGND sg13cmos5l_fill_1
XFILLER_86_596 VPWR VGND sg13cmos5l_fill_2
X_11800_ _11800_/Y _12194_/A _11800_/B VPWR VGND sg13cmos5l_xnor2_1
Xclkbuf_leaf_38_clk _18902_/CLK clkload3/A VPWR VGND sg13cmos5l_buf_8
XFILLER_39_490 VPWR VGND sg13cmos5l_fill_2
X_12780_ _18893_/D _13041_/A fanout50/X _12779_/Y VPWR VGND sg13cmos5l_a21oi_1
XFILLER_61_419 VPWR VGND sg13cmos5l_fill_2
X_19422__459 _19422_/D VPWR VGND sg13cmos5l_tielo
XFILLER_26_162 VPWR VGND sg13cmos5l_fill_2
X_11731_ _11731_/Y _11708_/D _11697_/B _11742_/B VPWR VGND sg13cmos5l_a21oi_1
XFILLER_42_655 VPWR VGND sg13cmos5l_fill_2
XFILLER_15_847 VPWR VGND sg13cmos5l_fill_1
X_11662_ _11662_/Y _12193_/A _18750_/Q VPWR VGND sg13cmos5l_nor2_1
XFILLER_41_154 VPWR VGND sg13cmos5l_decap_4
X_14450_ _14455_/A _14441_/Y _14445_/Y _14448_/Y _14239_/Y _14449_/Y VPWR VGND sg13cmos5l_a221oi_1
X_11593_ _11593_/Y _11585_/X _11593_/B VPWR VGND sg13cmos5l_nand2b_1
X_13401_ _13401_/X _13401_/A _13401_/B VPWR VGND sg13cmos5l_or2_1
X_14381_ _14381_/Y _14906_/A _19104_/Q _14378_/Y _14379_/Y _14380_/Y VPWR VGND sg13cmos5l_a221oi_1
X_10613_ _10614_/A _10646_/A _10616_/B _10612_/Y VPWR VGND sg13cmos5l_o21ai_1
X_13332_ _13332_/Y _10253_/Y _13326_/A _13331_/A _10259_/Y _13327_/Y VPWR VGND sg13cmos5l_a221oi_1
X_16120_ _16226_/A _16120_/A _16140_/B _16125_/C VPWR VGND sg13cmos5l_nand3_1
X_10544_ _10544_/Y _10544_/A _10898_/A VPWR VGND sg13cmos5l_nand2_1
XFILLER_41_73 VPWR VGND sg13cmos5l_fill_2
XFILLER_6_523 VPWR VGND sg13cmos5l_fill_1
X_13263_ _13264_/B _18967_/Q _13263_/B VPWR VGND sg13cmos5l_xor2_1
X_16051_ _16051_/Y _16344_/A _16049_/Y _16050_/Y VPWR VGND sg13cmos5l_o21ai_1
X_10475_ _10493_/A _19737_/Q _19735_/Q _19736_/Q VPWR VGND sg13cmos5l_or3_1
X_12214_ _12228_/B _12231_/C _12213_/Y _12210_/Y VPWR VGND sg13cmos5l_o21ai_1
X_13194_ _13200_/B _13167_/A _13413_/A _13199_/S VPWR VGND sg13cmos5l_mux2_1
X_15002_ _15011_/B _19205_/Q _15002_/B VPWR VGND sg13cmos5l_xor2_1
X_12145_ _12145_/Y _12145_/A _12145_/B VPWR VGND sg13cmos5l_nor2_1
X_19810_ _19810_/Q clkload27/A _19810_/D _19810_/RESET_B VPWR VGND sg13cmos5l_dfrbpq_1
X_12076_ _12090_/B _18789_/Q _18790_/Q _12110_/A _18788_/Q VPWR VGND sg13cmos5l_nor4_1
X_16953_ _17043_/C _19521_/Q _19482_/Q _19541_/Q VPWR VGND sg13cmos5l_nand3_1
XFILLER_77_541 VPWR VGND sg13cmos5l_fill_1
X_19741_ _19741_/Q clkload22/A _19741_/D _19741_/RESET_B VPWR VGND sg13cmos5l_dfrbpq_1
X_16884_ _19519_/D _09978_/Y fanout86/X _16883_/Y VPWR VGND sg13cmos5l_a21oi_1
X_19672_ _19672_/Q clkload11/A _19672_/D _19672_/RESET_B VPWR VGND sg13cmos5l_dfrbpq_1
X_11027_ _11030_/A _11058_/A _11027_/B VPWR VGND sg13cmos5l_nand2_1
X_15904_ _15909_/A _15904_/A _15904_/B VPWR VGND sg13cmos5l_xor2_1
X_18623_ _18623_/Q clkload58/A _18623_/D _18623_/RESET_B VPWR VGND sg13cmos5l_dfrbpq_1
X_15835_ _15860_/B _19331_/Q _15835_/B VPWR VGND sg13cmos5l_xor2_1
XFILLER_2_78 VPWR VGND sg13cmos5l_fill_1
Xclkbuf_leaf_29_clk clkload39/A clkload1/A VPWR VGND sg13cmos5l_buf_8
XFILLER_46_961 VPWR VGND sg13cmos5l_decap_8
X_18554_ _18554_/Y _10605_/B _10627_/Y _18553_/Y VPWR VGND sg13cmos5l_a21oi_1
X_12978_ _12978_/Y _12944_/Y _12986_/B _12977_/Y VPWR VGND sg13cmos5l_o21ai_1
X_18677__1616 _18677_/RESET_B VPWR VGND sg13cmos5l_tiehi
X_17505_ _17505_/Y _19604_/Q _19565_/Q VPWR VGND sg13cmos5l_xnor2_1
XFILLER_46_983 VPWR VGND sg13cmos5l_fill_1
X_15766_ _15768_/B _15779_/C _15764_/Y _15765_/Y VPWR VGND sg13cmos5l_o21ai_1
X_11929_ _11929_/Y _11929_/A VPWR VGND sg13cmos5l_inv_1
XFILLER_72_290 VPWR VGND sg13cmos5l_decap_8
XFILLER_61_942 VPWR VGND sg13cmos5l_fill_1
X_18485_ _18485_/Y _19722_/Q _19784_/Q VPWR VGND sg13cmos5l_nand2b_1
X_14717_ _14717_/Y _19160_/Q _14725_/B VPWR VGND sg13cmos5l_xnor2_1
X_15697_ _15697_/Y _15744_/B _15710_/B _15692_/X _15717_/A _15695_/Y VPWR VGND sg13cmos5l_a221oi_1
X_17436_ _17436_/Y _09973_/Y fanout87/X _17435_/Y VPWR VGND sg13cmos5l_a21oi_1
X_14648_ _19183_/D _14648_/A _14648_/B VPWR VGND sg13cmos5l_nor2_1
X_17367_ _19584_/D _17367_/A _17370_/B VPWR VGND sg13cmos5l_nor2_1
XFILLER_21_839 VPWR VGND sg13cmos5l_fill_2
XFILLER_70_2 VPWR VGND sg13cmos5l_fill_1
X_14579_ _14648_/B _14577_/B _14578_/X _14577_/Y VPWR VGND sg13cmos5l_o21ai_1
X_16318_ _19434_/D _16318_/A _16318_/B VPWR VGND sg13cmos5l_and2_1
X_19106_ _19106_/Q _19220_/CLK _19106_/D _19106_/RESET_B VPWR VGND sg13cmos5l_dfrbpq_1
X_17298_ _17304_/C _17298_/A _17298_/B VPWR VGND sg13cmos5l_nand2_1
X_19037_ _19037_/Q clkload31/A _19037_/D _19037_/RESET_B VPWR VGND sg13cmos5l_dfrbpq_1
X_16249_ _16250_/B _16249_/A _16255_/B VPWR VGND sg13cmos5l_nor2_1
X_18927__1339 _18927_/RESET_B VPWR VGND sg13cmos5l_tiehi
XFILLER_56_0 VPWR VGND sg13cmos5l_fill_2
Xhold2904 hold2904/X _18781_/Q VPWR VGND sg13cmos5l_dlygate4sd3_1
XFILLER_102_605 VPWR VGND sg13cmos5l_fill_1
X_18623__1673 _18623_/RESET_B VPWR VGND sg13cmos5l_tiehi
Xhold2915 _16979_/A _19552_/Q VPWR VGND sg13cmos5l_dlygate4sd3_1
Xhold2937 _13765_/A _19046_/Q VPWR VGND sg13cmos5l_dlygate4sd3_1
Xhold2926 _13973_/A _19099_/Q VPWR VGND sg13cmos5l_dlygate4sd3_1
Xhold2948 _14279_/A _19137_/Q VPWR VGND sg13cmos5l_dlygate4sd3_1
Xhold2959 _15284_/A _19241_/Q VPWR VGND sg13cmos5l_dlygate4sd3_1
XFILLER_83_555 VPWR VGND sg13cmos5l_fill_1
XFILLER_83_599 VPWR VGND sg13cmos5l_fill_1
XFILLER_52_920 VPWR VGND sg13cmos5l_decap_8
XFILLER_37_972 VPWR VGND sg13cmos5l_fill_2
XFILLER_64_791 VPWR VGND sg13cmos5l_fill_1
XFILLER_51_430 VPWR VGND sg13cmos5l_fill_2
X_18740__1538 _18740_/RESET_B VPWR VGND sg13cmos5l_tiehi
X_10260_ _13323_/A _10260_/A VPWR VGND sg13cmos5l_inv_1
XFILLER_3_515 VPWR VGND sg13cmos5l_fill_1
XFILLER_87_36 VPWR VGND sg13cmos5l_fill_2
XFILLER_78_316 VPWR VGND sg13cmos5l_fill_2
X_10191_ _18246_/B _10191_/A VPWR VGND sg13cmos5l_inv_1
XFILLER_87_850 VPWR VGND sg13cmos5l_fill_2
Xfanout340 _16227_/A hold3036/X VPWR VGND sg13cmos5l_buf_1
Xfanout373 _10750_/A _16603_/B VPWR VGND sg13cmos5l_buf_1
Xfanout351 _11437_/A hold3033/X VPWR VGND sg13cmos5l_buf_1
X_13950_ _13950_/Y _14052_/A _13950_/B VPWR VGND sg13cmos5l_nand2_1
Xfanout384 _14978_/A _14710_/A VPWR VGND sg13cmos5l_buf_1
Xfanout362 _16307_/A _16082_/A VPWR VGND sg13cmos5l_buf_1
Xfanout395 _12188_/A _11691_/A VPWR VGND sg13cmos5l_buf_1
X_12901_ _12954_/A _18931_/Q _12901_/B VPWR VGND sg13cmos5l_xnor2_1
XFILLER_4_1028 VPWR VGND sg13cmos5l_fill_1
XFILLER_59_1008 VPWR VGND sg13cmos5l_fill_1
X_13881_ _13886_/B _18991_/Q _18992_/Q _18989_/Q _18990_/Q VPWR VGND sg13cmos5l_nor4_1
X_15620_ _15646_/B _19352_/Q _15621_/B VPWR VGND sg13cmos5l_nor2b_1
X_12832_ _12832_/Y _12832_/A _12850_/B VPWR VGND sg13cmos5l_nor2_1
XFILLER_62_717 VPWR VGND sg13cmos5l_decap_8
X_12763_ _12765_/B _13050_/A _12763_/B VPWR VGND sg13cmos5l_nor2_1
XFILLER_43_953 VPWR VGND sg13cmos5l_fill_2
X_15551_ _15551_/Y _19288_/Q _15552_/B VPWR VGND sg13cmos5l_xnor2_1
X_11714_ _11727_/B _18701_/Q _11715_/B VPWR VGND sg13cmos5l_xnor2_1
X_18270_ _18271_/B _18284_/B _18268_/Y _18498_/B VPWR VGND sg13cmos5l_o21ai_1
X_15482_ _15482_/Y _19272_/Q _15482_/B _15482_/C VPWR VGND sg13cmos5l_nand3_1
X_14502_ _14602_/A _19174_/Q _14516_/B VPWR VGND sg13cmos5l_xnor2_1
X_12694_ _12694_/Y _12677_/A _12677_/B _12687_/X _12692_/Y _12693_/Y VPWR VGND sg13cmos5l_a221oi_1
X_17221_ _17330_/A _17221_/A _17221_/B VPWR VGND sg13cmos5l_xnor2_1
X_19176__1072 _19176_/RESET_B VPWR VGND sg13cmos5l_tiehi
X_14433_ _19152_/D _09994_/Y fanout73/X _14432_/Y VPWR VGND sg13cmos5l_a21oi_1
X_11645_ _11645_/Y _18688_/Q _11642_/Y _11644_/Y VPWR VGND sg13cmos5l_o21ai_1
X_17152_ _19566_/D _17152_/A _17152_/B VPWR VGND sg13cmos5l_and2_1
X_11576_ _11586_/A _11596_/B _11576_/B VPWR VGND sg13cmos5l_nand2b_1
X_14364_ _19129_/D _14364_/A _14364_/B VPWR VGND sg13cmos5l_and2_1
X_17083_ _19544_/D _17083_/A _17087_/A VPWR VGND sg13cmos5l_nor2_1
X_13315_ _13317_/B _13329_/C _13313_/Y _13314_/Y VPWR VGND sg13cmos5l_o21ai_1
X_16103_ _16103_/Y _16087_/Y _16096_/Y _16101_/Y VPWR VGND sg13cmos5l_o21ai_1
X_10527_ _10528_/B _19799_/Q _19800_/Q _19801_/Q VPWR VGND sg13cmos5l_o21ai_1
X_14295_ _14295_/Y _14282_/Y _14288_/Y _14374_/B _14193_/B _14294_/Y VPWR VGND sg13cmos5l_a221oi_1
X_13246_ _13247_/B _13265_/A _13246_/B VPWR VGND sg13cmos5l_nor2_1
X_10458_ _10465_/A _10464_/B _10464_/C _10464_/A VPWR VGND sg13cmos5l_a21oi_1
X_16034_ _16052_/C _19422_/Q _16038_/B _16033_/B VPWR VGND sg13cmos5l_o21ai_1
X_10389_ _10390_/A _19810_/D _19807_/D VPWR VGND sg13cmos5l_nor2_1
X_13177_ _13178_/A _13177_/A _13202_/A VPWR VGND sg13cmos5l_nor2_1
X_12128_ _12128_/X _12128_/A _12128_/B VPWR VGND sg13cmos5l_or2_1
X_17985_ _17985_/X _17958_/Y _10338_/Y _17993_/S VPWR VGND sg13cmos5l_mux2_1
X_12059_ _12062_/B _12110_/A _18788_/Q VPWR VGND sg13cmos5l_nor2_1
XFILLER_96_179 VPWR VGND sg13cmos5l_fill_2
X_16936_ _19528_/D _16939_/A _17030_/A VPWR VGND sg13cmos5l_and2_1
X_19724_ _19724_/Q _19790_/CLK _19724_/D _19724_/RESET_B VPWR VGND sg13cmos5l_dfrbpq_1
XFILLER_28_4 VPWR VGND sg13cmos5l_fill_2
X_16867_ _16868_/B _16881_/B _16864_/Y _17110_/B VPWR VGND sg13cmos5l_o21ai_1
X_19776__603 _19776_/RESET_B VPWR VGND sg13cmos5l_tiehi
X_19655_ _19655_/Q _19679_/CLK _19655_/D _19655_/RESET_B VPWR VGND sg13cmos5l_dfrbpq_1
X_16798_ _16798_/Y _16792_/Y _16811_/A _16797_/Y VPWR VGND sg13cmos5l_a21oi_1
X_19586_ _19586_/Q clkload38/A _19586_/D _19586_/RESET_B VPWR VGND sg13cmos5l_dfrbpq_1
X_18606_ _18606_/Q clkload34/A _18606_/D _18606_/RESET_B VPWR VGND sg13cmos5l_dfrbpq_1
X_15818_ _15818_/X _19332_/Q _19325_/Q VPWR VGND sg13cmos5l_or2_1
XFILLER_19_994 VPWR VGND sg13cmos5l_fill_1
XFILLER_80_558 VPWR VGND sg13cmos5l_decap_4
XFILLER_80_547 VPWR VGND sg13cmos5l_fill_1
XFILLER_80_536 VPWR VGND sg13cmos5l_fill_1
X_18537_ _18537_/Y _19773_/Q fanout84/X _18541_/A VPWR VGND sg13cmos5l_o21ai_1
X_15749_ _15749_/Y _16313_/A _19317_/Q VPWR VGND sg13cmos5l_nor2_1
XFILLER_34_975 VPWR VGND sg13cmos5l_decap_4
X_18468_ _18468_/Y _18468_/A _18468_/B VPWR VGND sg13cmos5l_nand2_1
X_17419_ _17419_/Y _17400_/B fanout25/X _17677_/A VPWR VGND sg13cmos5l_o21ai_1
XFILLER_33_474 VPWR VGND sg13cmos5l_fill_2
XFILLER_21_669 VPWR VGND sg13cmos5l_fill_2
X_18399_ _18399_/Y _18399_/A _18409_/B _18409_/C VPWR VGND sg13cmos5l_nor3_1
Xclkbuf_leaf_9_clk _19756_/CLK clkload0/A VPWR VGND sg13cmos5l_buf_8
XFILLER_106_229 VPWR VGND sg13cmos5l_fill_2
XFILLER_103_958 VPWR VGND sg13cmos5l_decap_4
Xhold2723 _16804_/A _16802_/X VPWR VGND sg13cmos5l_dlygate4sd3_1
Xhold2701 _10755_/A _18597_/Q VPWR VGND sg13cmos5l_dlygate4sd3_1
Xhold2712 _10397_/A _19810_/Q VPWR VGND sg13cmos5l_dlygate4sd3_1
Xhold2745 _10621_/A _19797_/Q VPWR VGND sg13cmos5l_dlygate4sd3_1
Xhold2756 hold2756/X _19462_/Q VPWR VGND sg13cmos5l_dlygate4sd3_1
Xhold2734 hold2734/X _16465_/A VPWR VGND sg13cmos5l_dlygate4sd3_1
Xhold2778 hold2778/X _12969_/Y VPWR VGND sg13cmos5l_dlygate4sd3_1
Xhold2767 _17507_/A _19630_/Q VPWR VGND sg13cmos5l_dlygate4sd3_1
Xhold2789 _11216_/A _18674_/Q VPWR VGND sg13cmos5l_dlygate4sd3_1
XFILLER_56_511 VPWR VGND sg13cmos5l_fill_2
XFILLER_56_544 VPWR VGND sg13cmos5l_decap_8
XFILLER_28_279 VPWR VGND sg13cmos5l_fill_2
XFILLER_71_558 VPWR VGND sg13cmos5l_fill_1
X_19131__1120 _19131_/RESET_B VPWR VGND sg13cmos5l_tiehi
XFILLER_25_975 VPWR VGND sg13cmos5l_decap_8
XFILLER_106_1017 VPWR VGND sg13cmos5l_decap_8
XFILLER_106_1028 VPWR VGND sg13cmos5l_fill_1
X_11430_ _11430_/Y _11266_/A _11474_/A VPWR VGND sg13cmos5l_nand2b_1
XFILLER_7_106 VPWR VGND sg13cmos5l_decap_4
X_19276__473 _19276_/D VPWR VGND sg13cmos5l_tielo
X_11361_ _18678_/D _11363_/A _11361_/B VPWR VGND sg13cmos5l_nor2_1
XFILLER_4_802 VPWR VGND sg13cmos5l_decap_4
X_13100_ _13136_/A _18909_/Q _13104_/C VPWR VGND sg13cmos5l_xor2_1
X_10312_ _11110_/A _10312_/A VPWR VGND sg13cmos5l_inv_1
XFILLER_106_741 VPWR VGND sg13cmos5l_decap_8
X_11292_ _11304_/A _11361_/B VPWR VGND sg13cmos5l_inv_1
XFILLER_3_323 VPWR VGND sg13cmos5l_fill_2
X_14080_ _19097_/D _14080_/A _14080_/B VPWR VGND sg13cmos5l_nor2_1
XFILLER_106_763 VPWR VGND sg13cmos5l_fill_2
X_13031_ _13031_/Y _18957_/Q _13050_/A _12764_/A _18956_/Q _13030_/Y VPWR VGND sg13cmos5l_a221oi_1
X_10243_ _14106_/A _14387_/A VPWR VGND sg13cmos5l_inv_1
X_10174_ _18225_/A _10174_/A VPWR VGND sg13cmos5l_inv_1
X_17770_ _19651_/D _17770_/A _17770_/B VPWR VGND sg13cmos5l_and2_1
X_16721_ _16721_/X _19505_/Q _16721_/B VPWR VGND sg13cmos5l_xor2_1
Xfanout181 _12875_/B _12879_/B VPWR VGND sg13cmos5l_buf_1
Xfanout192 _11503_/B _11483_/Y VPWR VGND sg13cmos5l_buf_1
X_14982_ _15000_/B _14982_/A _14982_/B VPWR VGND sg13cmos5l_xor2_1
Xfanout170 _14512_/B _14496_/Y VPWR VGND sg13cmos5l_buf_1
X_13933_ _13933_/Y _19094_/Q _14050_/B VPWR VGND sg13cmos5l_nor2_1
XFILLER_47_83 VPWR VGND sg13cmos5l_fill_1
X_16652_ _16659_/S _16650_/A _16650_/B _16651_/Y VPWR VGND sg13cmos5l_o21ai_1
X_19440_ _19440_/Q clkload5/A _19440_/D _19440_/RESET_B VPWR VGND sg13cmos5l_dfrbpq_1
X_13864_ _13864_/Y _14085_/B _13859_/S _13863_/Y VPWR VGND sg13cmos5l_a21oi_1
XFILLER_34_205 VPWR VGND sg13cmos5l_fill_2
X_12815_ _12818_/C _10066_/Y _12810_/B _10065_/Y VPWR VGND sg13cmos5l_a21oi_1
X_16583_ _16583_/Y _19018_/Q _16583_/B VPWR VGND sg13cmos5l_nand2_1
X_19371_ _19371_/Q clkload9/A _19371_/D _19371_/RESET_B VPWR VGND sg13cmos5l_dfrbpq_1
X_15603_ _15721_/C _15716_/A _15603_/B VPWR VGND sg13cmos5l_or2_1
X_13795_ _13796_/B _13762_/X _13803_/A _13813_/B VPWR VGND sg13cmos5l_o21ai_1
X_15534_ _15534_/Y _15550_/D _15535_/C VPWR VGND sg13cmos5l_nand2_1
X_18322_ _18322_/Y _18316_/X _18318_/Y _18138_/Y VPWR VGND sg13cmos5l_a21oi_1
X_12746_ _12747_/B _13291_/A _18856_/Q VPWR VGND sg13cmos5l_nand2_1
XFILLER_15_496 VPWR VGND sg13cmos5l_fill_2
X_12677_ _12677_/Y _12677_/A _12677_/B VPWR VGND sg13cmos5l_nor2_1
X_18253_ _18253_/Y _19748_/Q _18253_/B _18264_/C VPWR VGND sg13cmos5l_nor3_1
X_15465_ _19309_/D _15465_/A _15465_/B VPWR VGND sg13cmos5l_and2_1
XFILLER_31_967 VPWR VGND sg13cmos5l_decap_8
X_11628_ _18719_/D _11628_/A _11628_/B VPWR VGND sg13cmos5l_nor2_1
X_17204_ _17204_/Y _17204_/A _17199_/B VPWR VGND sg13cmos5l_nor2b_1
X_18184_ _18184_/Y _18184_/A VPWR VGND sg13cmos5l_inv_1
X_15396_ _15397_/A _15392_/A _15392_/B _15465_/B _15398_/A VPWR VGND sg13cmos5l_a22oi_1
X_14416_ _14649_/A _15234_/A _14903_/B VPWR VGND sg13cmos5l_nor2_1
XFILLER_30_477 VPWR VGND sg13cmos5l_decap_8
XFILLER_31_989 VPWR VGND sg13cmos5l_fill_2
X_18967__1296 _18967_/RESET_B VPWR VGND sg13cmos5l_tiehi
X_17135_ _19555_/D _10356_/Y _17136_/S _17134_/Y VPWR VGND sg13cmos5l_a21oi_1
X_14347_ _14350_/A _14333_/Y _14338_/X _14346_/Y VPWR VGND sg13cmos5l_o21ai_1
X_11559_ _11736_/A _11720_/A _11559_/B VPWR VGND sg13cmos5l_and2_1
XFILLER_7_673 VPWR VGND sg13cmos5l_fill_2
X_17066_ _17066_/Y _17041_/Y _17070_/S _16939_/A VPWR VGND sg13cmos5l_o21ai_1
X_14278_ _14282_/C _14278_/A _14291_/A VPWR VGND sg13cmos5l_nand2_1
X_13229_ _13229_/Y _13229_/A _13232_/B VPWR VGND sg13cmos5l_nand2_1
X_16017_ _19389_/D _16020_/A _16017_/B VPWR VGND sg13cmos5l_nor2_1
XFILLER_98_967 VPWR VGND sg13cmos5l_fill_2
Xhold2008 _13573_/B _18961_/Q VPWR VGND sg13cmos5l_dlygate4sd3_1
XFILLER_69_146 VPWR VGND sg13cmos5l_fill_1
Xhold2019 hold2019/X _19687_/Q VPWR VGND sg13cmos5l_dlygate4sd3_1
XFILLER_78_680 VPWR VGND sg13cmos5l_fill_1
X_17968_ _17973_/B _17968_/A _17968_/B VPWR VGND sg13cmos5l_nor2_1
X_16919_ _16919_/X _19483_/Q _16940_/B VPWR VGND sg13cmos5l_or2_1
X_18859__1411 _18859_/RESET_B VPWR VGND sg13cmos5l_tiehi
XFILLER_84_149 VPWR VGND sg13cmos5l_fill_1
X_19707_ _19707_/Q clkload20/A _19707_/D _19707_/RESET_B VPWR VGND sg13cmos5l_dfrbpq_1
X_17899_ _17899_/Y _17888_/X _17891_/X _17900_/A _17900_/B VPWR VGND sg13cmos5l_a22oi_1
X_19216__1029 _19216_/RESET_B VPWR VGND sg13cmos5l_tiehi
X_19638_ _19638_/Q clkload13/A _19638_/D _19638_/RESET_B VPWR VGND sg13cmos5l_dfrbpq_1
X_19569_ _19569_/Q _19814_/CLK _19569_/D _19569_/RESET_B VPWR VGND sg13cmos5l_dfrbpq_1
XFILLER_34_761 VPWR VGND sg13cmos5l_fill_1
XFILLER_33_260 VPWR VGND sg13cmos5l_fill_2
XFILLER_22_967 VPWR VGND sg13cmos5l_fill_1
X_18780__1495 _18780_/RESET_B VPWR VGND sg13cmos5l_tiehi
XFILLER_103_733 VPWR VGND sg13cmos5l_fill_2
XFILLER_1_849 VPWR VGND sg13cmos5l_fill_2
X_19149__1102 _19149_/RESET_B VPWR VGND sg13cmos5l_tiehi
XFILLER_102_232 VPWR VGND sg13cmos5l_fill_1
X_18672__1621 _18672_/RESET_B VPWR VGND sg13cmos5l_tiehi
Xhold2520 _10106_/A _19251_/Q VPWR VGND sg13cmos5l_dlygate4sd3_1
Xhold2531 _10111_/A _19254_/Q VPWR VGND sg13cmos5l_dlygate4sd3_1
Xhold2553 _12587_/A _18881_/Q VPWR VGND sg13cmos5l_dlygate4sd3_1
XFILLER_76_628 VPWR VGND sg13cmos5l_fill_2
Xhold2542 _10156_/A _19577_/Q VPWR VGND sg13cmos5l_dlygate4sd3_1
Xhold2564 _10068_/A _18957_/Q VPWR VGND sg13cmos5l_dlygate4sd3_1
Xhold1841 _12260_/B _18777_/Q VPWR VGND sg13cmos5l_dlygate4sd3_1
Xhold1830 _12528_/B _18819_/Q VPWR VGND sg13cmos5l_dlygate4sd3_1
Xhold2597 _10164_/A _19619_/Q VPWR VGND sg13cmos5l_dlygate4sd3_1
Xhold1852 _17738_/B _19607_/Q VPWR VGND sg13cmos5l_dlygate4sd3_1
Xhold2575 _14026_/A _19089_/Q VPWR VGND sg13cmos5l_dlygate4sd3_1
Xhold2586 _10254_/A _18978_/Q VPWR VGND sg13cmos5l_dlygate4sd3_1
XFILLER_29_555 VPWR VGND sg13cmos5l_fill_2
Xhold1863 _14143_/B _19070_/Q VPWR VGND sg13cmos5l_dlygate4sd3_1
Xhold1885 _13811_/A _18587_/Q VPWR VGND sg13cmos5l_dlygate4sd3_1
Xhold1874 _16891_/B _19482_/Q VPWR VGND sg13cmos5l_dlygate4sd3_1
X_10930_ _18615_/D _11089_/A _10930_/B VPWR VGND sg13cmos5l_nor2_1
Xhold1896 _14976_/B _19196_/Q VPWR VGND sg13cmos5l_dlygate4sd3_1
XFILLER_44_547 VPWR VGND sg13cmos5l_fill_2
X_12600_ _12600_/Y _12600_/A _12600_/B _12702_/B VPWR VGND sg13cmos5l_nor3_1
X_10861_ _10861_/Y _10841_/B _10865_/S _11084_/B VPWR VGND sg13cmos5l_o21ai_1
X_10792_ _18560_/B _10755_/Y hold2871/X _13728_/A VPWR VGND sg13cmos5l_a21oi_1
X_13580_ _19010_/D _13580_/A _13586_/A VPWR VGND sg13cmos5l_nor2_1
X_12531_ _12537_/B _18823_/Q _18824_/Q _18821_/Q _18822_/Q VPWR VGND sg13cmos5l_nor4_1
X_18922__1344 _18922_/RESET_B VPWR VGND sg13cmos5l_tiehi
X_12462_ _18842_/D _12462_/A _12462_/B VPWR VGND sg13cmos5l_nor2_1
X_15250_ _15250_/Y _09992_/Y fanout92/X _15249_/Y VPWR VGND sg13cmos5l_a21oi_1
XFILLER_32_1000 VPWR VGND sg13cmos5l_fill_2
X_11413_ _18686_/D _11629_/A _11413_/B VPWR VGND sg13cmos5l_nor2_1
X_14201_ _14201_/Y _14201_/A _14201_/B VPWR VGND sg13cmos5l_nor2_1
X_12393_ _12393_/Y _12427_/B _12427_/C _12427_/A VPWR VGND sg13cmos5l_a21oi_1
X_15181_ _19255_/D _15453_/A _15181_/B VPWR VGND sg13cmos5l_and2_1
X_11344_ _11344_/Y _11306_/B _11342_/S _11360_/A VPWR VGND sg13cmos5l_o21ai_1
XFILLER_4_621 VPWR VGND sg13cmos5l_fill_1
X_14132_ _19105_/D _14371_/B _14132_/B VPWR VGND sg13cmos5l_nor2_1
X_11275_ _11300_/B _11245_/A _11245_/B _11447_/A VPWR VGND sg13cmos5l_a21oi_1
X_18940_ _18940_/Q clkload46/A _18940_/D _18940_/RESET_B VPWR VGND sg13cmos5l_dfrbpq_1
X_14063_ _19082_/D _14076_/B _14063_/B VPWR VGND sg13cmos5l_nor2_1
X_13014_ _18917_/D _12997_/A hold2788/X _13027_/A VPWR VGND sg13cmos5l_a21oi_1
XFILLER_3_164 VPWR VGND sg13cmos5l_fill_2
X_10226_ _15210_/B _19234_/Q VPWR VGND sg13cmos5l_inv_1
X_18871_ _18871_/Q _18931_/CLK _18871_/D _18871_/RESET_B VPWR VGND sg13cmos5l_dfrbpq_1
XFILLER_79_466 VPWR VGND sg13cmos5l_fill_2
XFILLER_79_477 VPWR VGND sg13cmos5l_fill_2
X_10157_ _17671_/A _10157_/A VPWR VGND sg13cmos5l_inv_1
XFILLER_67_628 VPWR VGND sg13cmos5l_fill_1
XFILLER_66_127 VPWR VGND sg13cmos5l_decap_8
X_17822_ _17822_/Y _19662_/Q _17823_/B VPWR VGND sg13cmos5l_xnor2_1
XFILLER_58_93 VPWR VGND sg13cmos5l_fill_2
X_17753_ _17777_/A _19612_/Q _17757_/D VPWR VGND sg13cmos5l_xor2_1
X_14965_ _14965_/Y _15220_/A _14958_/S _14964_/Y VPWR VGND sg13cmos5l_a21oi_1
X_10088_ _14366_/A _10088_/A VPWR VGND sg13cmos5l_inv_1
X_16704_ _16708_/B _19509_/Q _16711_/B VPWR VGND sg13cmos5l_nor2b_1
X_13916_ _19074_/D _14080_/A _13916_/B VPWR VGND sg13cmos5l_nor2_1
X_17684_ _17684_/Y _19601_/Q _19663_/Q VPWR VGND sg13cmos5l_nand2b_1
X_16635_ _16640_/A _16641_/B _16641_/C _16641_/A VPWR VGND sg13cmos5l_a21oi_1
XFILLER_47_396 VPWR VGND sg13cmos5l_fill_2
X_14896_ _19208_/D _14913_/A _14896_/B VPWR VGND sg13cmos5l_nor2_1
X_19423_ _19423_/Q _19738_/CLK _19423_/D _19423_/RESET_B VPWR VGND sg13cmos5l_dfrbpq_1
X_13847_ _13847_/Y _13847_/A _13847_/B _13847_/C VPWR VGND sg13cmos5l_nor3_1
X_13778_ _13779_/C _13778_/A _13778_/B _13778_/C VPWR VGND sg13cmos5l_nand3_1
X_16566_ _16567_/B _17081_/A _19020_/Q _19019_/Q _17080_/A VPWR VGND sg13cmos5l_a22oi_1
X_19751__915 _19751_/RESET_B VPWR VGND sg13cmos5l_tiehi
X_19702__1691 _19702_/RESET_B VPWR VGND sg13cmos5l_tiehi
X_19354_ _19354_/Q _19462_/CLK _19354_/D _19354_/RESET_B VPWR VGND sg13cmos5l_dfrbpq_1
X_12729_ _18884_/D _12729_/A _12729_/B VPWR VGND sg13cmos5l_nor2_1
X_15517_ _19316_/D _15586_/A _15517_/B VPWR VGND sg13cmos5l_nor2_1
X_19285_ _19285_/Q clkload43/A _19285_/D _19285_/RESET_B VPWR VGND sg13cmos5l_dfrbpq_1
X_16497_ _16531_/A _19460_/Q _16500_/B _16496_/Y VPWR VGND sg13cmos5l_a21oi_1
X_18305_ _18305_/X _19700_/Q _19693_/Q _19694_/Q VPWR VGND sg13cmos5l_or3_1
X_18236_ _18236_/Y _18236_/A _19681_/Q VPWR VGND sg13cmos5l_nor2b_1
X_15448_ _19293_/D _15458_/B _15448_/B VPWR VGND sg13cmos5l_nor2_1
XFILLER_30_252 VPWR VGND sg13cmos5l_fill_1
XFILLER_31_797 VPWR VGND sg13cmos5l_fill_2
X_18167_ _18180_/B _18156_/X _18162_/Y _18166_/Y VPWR VGND sg13cmos5l_a21oi_1
X_15379_ _15570_/A _15737_/A _15394_/B VPWR VGND sg13cmos5l_nand2_1
X_17118_ _17119_/A _17122_/C _17116_/Y _17117_/Y VPWR VGND sg13cmos5l_a21o_1
X_18098_ _18129_/A _18098_/A _18098_/B VPWR VGND sg13cmos5l_xor2_1
X_17049_ _17049_/Y _17049_/A _17049_/B VPWR VGND sg13cmos5l_nor2_1
XFILLER_85_447 VPWR VGND sg13cmos5l_fill_2
XFILLER_57_149 VPWR VGND sg13cmos5l_fill_1
X_18798__1477 _18798_/RESET_B VPWR VGND sg13cmos5l_tiehi
XFILLER_66_672 VPWR VGND sg13cmos5l_fill_1
XFILLER_81_620 VPWR VGND sg13cmos5l_fill_2
XFILLER_54_29 VPWR VGND sg13cmos5l_fill_2
X_19227__478 _19227_/D VPWR VGND sg13cmos5l_tielo
XFILLER_0_1020 VPWR VGND sg13cmos5l_decap_8
XFILLER_81_675 VPWR VGND sg13cmos5l_fill_2
XFILLER_81_653 VPWR VGND sg13cmos5l_fill_2
XFILLER_41_506 VPWR VGND sg13cmos5l_fill_1
X_18703__1587 _18703_/RESET_B VPWR VGND sg13cmos5l_tiehi
XFILLER_89_742 VPWR VGND sg13cmos5l_fill_1
X_11060_ _11060_/Y _11076_/A _11075_/A _11059_/Y VPWR VGND sg13cmos5l_a21oi_1
Xhold3051 _12276_/A _18783_/Q VPWR VGND sg13cmos5l_dlygate4sd3_1
XFILLER_88_252 VPWR VGND sg13cmos5l_fill_2
X_10011_ _10011_/Y _10011_/A VPWR VGND sg13cmos5l_inv_1
XFILLER_0_123 VPWR VGND sg13cmos5l_fill_1
Xhold3040 _15904_/A _19392_/Q VPWR VGND sg13cmos5l_dlygate4sd3_1
Xhold3062 _11758_/A _18733_/Q VPWR VGND sg13cmos5l_dlygate4sd3_1
XFILLER_77_937 VPWR VGND sg13cmos5l_fill_2
Xhold2350 _11512_/A _18723_/Q VPWR VGND sg13cmos5l_dlygate4sd3_1
Xhold2372 hold2372/X _12787_/Y VPWR VGND sg13cmos5l_dlygate4sd3_1
Xhold2361 _10641_/A _19747_/Q VPWR VGND sg13cmos5l_dlygate4sd3_1
XFILLER_63_119 VPWR VGND sg13cmos5l_fill_2
XFILLER_63_108 VPWR VGND sg13cmos5l_fill_2
Xhold2394 hold2394/X _10871_/Y VPWR VGND sg13cmos5l_dlygate4sd3_1
X_14750_ _19201_/D _14913_/A _14750_/B VPWR VGND sg13cmos5l_nor2_1
Xhold2383 _19456_/D _16550_/X VPWR VGND sg13cmos5l_dlygate4sd3_1
X_13701_ _13701_/X _19038_/Q _16648_/A VPWR VGND sg13cmos5l_and2_1
XFILLER_91_439 VPWR VGND sg13cmos5l_fill_2
X_11962_ _11962_/Y hold1981/X fanout77/X _11691_/A VPWR VGND sg13cmos5l_o21ai_1
X_18636__1660 _18636_/RESET_B VPWR VGND sg13cmos5l_tiehi
XFILLER_17_536 VPWR VGND sg13cmos5l_fill_1
X_11893_ _18752_/D _11893_/A _11904_/A VPWR VGND sg13cmos5l_and2_1
X_10913_ _10913_/Y _10928_/B _10887_/Y VPWR VGND sg13cmos5l_nor2b_1
X_14681_ _14684_/B _14680_/C _14679_/Y _14680_/Y VPWR VGND sg13cmos5l_o21ai_1
X_13632_ _13633_/B _13613_/Y _16588_/A _13632_/S VPWR VGND sg13cmos5l_mux2_1
X_10844_ _10844_/Y _10844_/A _19770_/Q VPWR VGND sg13cmos5l_nor2_1
X_16420_ _16431_/B _19411_/Q _19412_/Q _19409_/Q _19410_/Q VPWR VGND sg13cmos5l_nor4_1
X_13563_ _13563_/Y _13543_/B fanout47/X _13569_/B1 VPWR VGND sg13cmos5l_o21ai_1
XFILLER_44_73 VPWR VGND sg13cmos5l_fill_1
X_16351_ _16352_/A _16350_/C _16349_/Y _16350_/Y VPWR VGND sg13cmos5l_a21o_1
X_10775_ _10775_/Y _10775_/A _10798_/B VPWR VGND sg13cmos5l_nor2_1
X_12514_ _12514_/Y _10273_/Y _12509_/S _12513_/Y VPWR VGND sg13cmos5l_a21oi_1
X_19070_ _19070_/Q clkload47/A _19070_/D _19070_/RESET_B VPWR VGND sg13cmos5l_dfrbpq_1
X_15302_ _15302_/Y _15279_/X _15281_/Y _15120_/Y VPWR VGND sg13cmos5l_a21oi_1
XFILLER_100_90 VPWR VGND sg13cmos5l_fill_2
X_13494_ _13519_/S _13503_/B _13503_/C VPWR VGND sg13cmos5l_nand2_1
X_16282_ _16282_/Y _16282_/A _16282_/B VPWR VGND sg13cmos5l_nand2_1
X_18021_ _18061_/A _19655_/Q _18021_/B VPWR VGND sg13cmos5l_xnor2_1
X_12445_ _18829_/D _12413_/B _12451_/A _12444_/Y VPWR VGND sg13cmos5l_a21oi_1
X_15233_ _15241_/S _15233_/A _15233_/B VPWR VGND sg13cmos5l_nor2_1
X_12376_ _12429_/B _12374_/A _12468_/B _12375_/Y _12372_/Y VPWR VGND sg13cmos5l_a22oi_1
X_15164_ _15164_/Y _15164_/A _15164_/B VPWR VGND sg13cmos5l_nor2_1
X_11327_ _11327_/Y _11334_/A _11334_/B VPWR VGND sg13cmos5l_nand2_1
XFILLER_4_440 VPWR VGND sg13cmos5l_fill_1
X_14115_ _14115_/Y _14641_/A _19128_/Q VPWR VGND sg13cmos5l_nor2_1
X_15095_ _15098_/B _15455_/A _15282_/A VPWR VGND sg13cmos5l_nand2_1
X_18923_ _18923_/Q clkload63/A _18923_/D _18923_/RESET_B VPWR VGND sg13cmos5l_dfrbpq_1
X_11258_ _11258_/Y _11437_/A _18676_/Q VPWR VGND sg13cmos5l_nand2_1
X_14046_ _14046_/Y _14054_/A _14054_/B VPWR VGND sg13cmos5l_nand2_1
X_18753__1525 _18753_/RESET_B VPWR VGND sg13cmos5l_tiehi
X_18854_ _18854_/Q clkload63/A _18854_/D _18854_/RESET_B VPWR VGND sg13cmos5l_dfrbpq_1
X_11189_ _18653_/D _11351_/B _11189_/B VPWR VGND sg13cmos5l_and2_1
X_19289__472 _19289_/D VPWR VGND sg13cmos5l_tielo
X_10209_ _16052_/B _10209_/A VPWR VGND sg13cmos5l_inv_1
X_17805_ _17897_/B _17789_/A _17803_/B _17804_/Y VPWR VGND sg13cmos5l_a21oi_1
X_18785_ _18785_/Q clkload62/A _18785_/D _18785_/RESET_B VPWR VGND sg13cmos5l_dfrbpq_1
XFILLER_48_661 VPWR VGND sg13cmos5l_fill_1
X_15997_ _15997_/Y _15973_/Y _16001_/S _15864_/A VPWR VGND sg13cmos5l_o21ai_1
X_17736_ _19647_/D _09970_/Y fanout67/X _17735_/Y VPWR VGND sg13cmos5l_a21oi_1
X_14948_ _14948_/Y _15458_/A _19254_/Q _14948_/C VPWR VGND sg13cmos5l_nor3_1
XFILLER_35_311 VPWR VGND sg13cmos5l_fill_1
X_17667_ _19624_/D _17667_/A _17671_/B VPWR VGND sg13cmos5l_nor2_1
X_14879_ _14879_/Y _14887_/A _14887_/B VPWR VGND sg13cmos5l_nand2_1
X_16618_ _16618_/Y hold1960/X fanout69/X _16624_/A VPWR VGND sg13cmos5l_o21ai_1
X_17598_ _17598_/Y _17585_/A _17585_/B _17585_/C _17585_/D VPWR VGND sg13cmos5l_a22oi_1
X_19406_ _19406_/Q clkload7/A _19406_/D _19406_/RESET_B VPWR VGND sg13cmos5l_dfrbpq_1
X_19337_ _19337_/Q clkload15/A _19337_/D _19337_/RESET_B VPWR VGND sg13cmos5l_dfrbpq_1
X_16549_ _19455_/D _16549_/A _16549_/B VPWR VGND sg13cmos5l_and2_1
XFILLER_31_561 VPWR VGND sg13cmos5l_fill_2
X_19268_ _19268_/Q _19308_/CLK _19268_/D _19268_/RESET_B VPWR VGND sg13cmos5l_dfrbpq_1
X_18219_ _19705_/D hold2852/X _18212_/S _18218_/Y VPWR VGND sg13cmos5l_a21oi_1
X_19199_ _19199_/Q clkload51/A _19199_/D _19199_/RESET_B VPWR VGND sg13cmos5l_dfrbpq_1
XFILLER_59_937 VPWR VGND sg13cmos5l_fill_2
XFILLER_105_57 VPWR VGND sg13cmos5l_fill_1
XFILLER_98_594 VPWR VGND sg13cmos5l_fill_1
XFILLER_85_222 VPWR VGND sg13cmos5l_fill_2
XFILLER_27_867 VPWR VGND sg13cmos5l_fill_2
XFILLER_27_878 VPWR VGND sg13cmos5l_fill_1
XFILLER_14_32 VPWR VGND sg13cmos5l_fill_2
XFILLER_14_76 VPWR VGND sg13cmos5l_fill_2
X_10560_ _10560_/Y _10560_/A _10906_/A VPWR VGND sg13cmos5l_nand2_1
X_10491_ _18380_/A _19744_/Q _10497_/A VPWR VGND sg13cmos5l_xnor2_1
XFILLER_6_716 VPWR VGND sg13cmos5l_fill_2
X_12230_ _12230_/Y _18772_/Q _12230_/B VPWR VGND sg13cmos5l_nor2_1
X_12161_ _12172_/A _12047_/Y _12170_/A _12161_/C VPWR VGND sg13cmos5l_nand3b_1
X_19211__1034 _19211_/RESET_B VPWR VGND sg13cmos5l_tiehi
X_12092_ _12092_/Y _12281_/B _12081_/Y _12097_/A _12097_/B VPWR VGND sg13cmos5l_a22oi_1
XFILLER_89_550 VPWR VGND sg13cmos5l_fill_1
X_11112_ _11113_/A _11111_/Y _11110_/Y _11123_/C VPWR VGND sg13cmos5l_mux2_1
XFILLER_1_421 VPWR VGND sg13cmos5l_fill_1
X_11043_ _11044_/A _11016_/B _11058_/A _11043_/C VPWR VGND sg13cmos5l_nand3b_1
X_15920_ _15921_/A _19394_/Q _15920_/B VPWR VGND sg13cmos5l_xnor2_1
X_19329__907 _19329_/RESET_B VPWR VGND sg13cmos5l_tiehi
XFILLER_103_393 VPWR VGND sg13cmos5l_fill_2
XFILLER_77_745 VPWR VGND sg13cmos5l_fill_2
XFILLER_39_73 VPWR VGND sg13cmos5l_decap_4
X_15851_ _15851_/Y _15851_/A _15851_/B VPWR VGND sg13cmos5l_nor2_1
Xhold2191 _10378_/A _19022_/Q VPWR VGND sg13cmos5l_dlygate4sd3_1
XFILLER_92_704 VPWR VGND sg13cmos5l_fill_1
Xhold2180 _16860_/B _19474_/Q VPWR VGND sg13cmos5l_dlygate4sd3_1
Xclkbuf_4_3_0_clk clkload0/A clkbuf_0_clk/X VPWR VGND sg13cmos5l_buf_8
X_14802_ _14802_/Y _14995_/A VPWR VGND sg13cmos5l_inv_1
XFILLER_91_203 VPWR VGND sg13cmos5l_fill_1
X_18570_ _18570_/Q clkload29/A _18570_/D _18570_/RESET_B VPWR VGND sg13cmos5l_dfrbpq_1
X_12994_ _12994_/Y _12997_/A _13013_/B VPWR VGND sg13cmos5l_nand2_1
X_15782_ _15782_/Y _15782_/A VPWR VGND sg13cmos5l_inv_1
XFILLER_36_119 VPWR VGND sg13cmos5l_fill_1
X_11945_ _11945_/Y _11945_/A _11945_/B VPWR VGND sg13cmos5l_nor2_1
X_17521_ _17528_/B _17644_/A _17643_/A VPWR VGND sg13cmos5l_nor2_1
X_14733_ _14757_/B _19163_/Q _14733_/B VPWR VGND sg13cmos5l_xor2_1
X_17452_ _17452_/X _17461_/D _17442_/C _17442_/A VPWR VGND sg13cmos5l_a21o_1
X_14664_ _14664_/Y _14664_/A _14679_/A VPWR VGND sg13cmos5l_nand2_1
X_13615_ _13615_/Y _16821_/A _19044_/Q VPWR VGND sg13cmos5l_nor2_1
X_11876_ _11876_/Y _11876_/A _11876_/B VPWR VGND sg13cmos5l_nor2_1
XFILLER_60_634 VPWR VGND sg13cmos5l_fill_1
XFILLER_17_399 VPWR VGND sg13cmos5l_fill_2
X_16403_ _16403_/X _16403_/A _16403_/B _16403_/C VPWR VGND sg13cmos5l_or3_1
XFILLER_60_667 VPWR VGND sg13cmos5l_fill_1
X_17383_ _17383_/Y _17934_/A _19557_/Q _17379_/Y _17382_/Y VPWR VGND sg13cmos5l_a22oi_1
X_10827_ _10838_/C _10823_/Y _10825_/Y _10826_/Y VPWR VGND sg13cmos5l_o21ai_1
X_14595_ _14595_/Y _14595_/A VPWR VGND sg13cmos5l_inv_1
X_10758_ _10804_/A _13813_/A _10758_/B VPWR VGND sg13cmos5l_xnor2_1
XFILLER_71_60 VPWR VGND sg13cmos5l_fill_2
X_13546_ _13546_/Y _13546_/A _13546_/B _13546_/C VPWR VGND sg13cmos5l_nand3_1
X_16334_ _16334_/Y _16334_/A VPWR VGND sg13cmos5l_inv_1
X_19122_ _19122_/Q _19136_/CLK _19122_/D _19122_/RESET_B VPWR VGND sg13cmos5l_dfrbpq_1
X_19053_ _19053_/Q clkload30/A _19053_/D _19053_/RESET_B VPWR VGND sg13cmos5l_dfrbpq_1
X_13477_ _13899_/A _14075_/A _13477_/B VPWR VGND sg13cmos5l_xnor2_1
X_16265_ _16265_/Y _16265_/A _16265_/B VPWR VGND sg13cmos5l_nor2_1
X_12428_ _12437_/A _12393_/Y _12436_/A _12428_/C VPWR VGND sg13cmos5l_nand3b_1
X_10689_ _10689_/Y _10385_/B _10680_/Y _10679_/Y VPWR VGND sg13cmos5l_o21ai_1
X_18004_ _19691_/D _18273_/B _18004_/B VPWR VGND sg13cmos5l_and2_1
X_15216_ _15216_/Y _15742_/A _19290_/Q _15225_/C VPWR VGND sg13cmos5l_nand3_1
X_16196_ _16249_/A _19435_/Q _16196_/B VPWR VGND sg13cmos5l_xnor2_1
Xheichips26_digital_project_419 uo_out[10] VPWR VGND sg13cmos5l_tielo
Xheichips26_digital_project_408 uio_out[8] VPWR VGND sg13cmos5l_tielo
X_12359_ _12359_/Y _12355_/A _12355_/B _12464_/B VPWR VGND sg13cmos5l_a21oi_1
X_15147_ _15148_/C _15147_/A _15147_/B _15147_/C VPWR VGND sg13cmos5l_nand3_1
X_15078_ _15263_/A _15458_/A _15078_/B VPWR VGND sg13cmos5l_xnor2_1
X_19780__1771 _19780_/RESET_B VPWR VGND sg13cmos5l_tiehi
X_18906_ _18906_/Q _18975_/CLK _18906_/D _18906_/RESET_B VPWR VGND sg13cmos5l_dfrbpq_1
X_14029_ _14029_/X _13915_/X _13996_/Y _14045_/S VPWR VGND sg13cmos5l_mux2_1
X_18837_ _18837_/Q clkload62/A _18837_/D _18837_/RESET_B VPWR VGND sg13cmos5l_dfrbpq_1
X_18768_ _18768_/Q clkload69/A _18768_/D _18768_/RESET_B VPWR VGND sg13cmos5l_dfrbpq_1
X_18717__1564 _18717_/RESET_B VPWR VGND sg13cmos5l_tiehi
X_17719_ _17720_/B _17692_/Y _10345_/Y _17719_/S VPWR VGND sg13cmos5l_mux2_1
XFILLER_36_653 VPWR VGND sg13cmos5l_fill_2
X_18699_ _18699_/Q clkload56/A _18699_/D _18699_/RESET_B VPWR VGND sg13cmos5l_dfrbpq_1
XFILLER_36_686 VPWR VGND sg13cmos5l_fill_2
X_19087__1167 _19087_/RESET_B VPWR VGND sg13cmos5l_tiehi
XFILLER_50_144 VPWR VGND sg13cmos5l_fill_1
XFILLER_101_842 VPWR VGND sg13cmos5l_fill_1
XFILLER_98_380 VPWR VGND sg13cmos5l_decap_8
XFILLER_100_330 VPWR VGND sg13cmos5l_fill_1
XFILLER_73_203 VPWR VGND sg13cmos5l_fill_2
XFILLER_18_119 VPWR VGND sg13cmos5l_fill_1
XFILLER_92_37 VPWR VGND sg13cmos5l_fill_2
X_11730_ _11824_/A _11554_/B _11736_/B VPWR VGND sg13cmos5l_nand2b_1
XFILLER_70_943 VPWR VGND sg13cmos5l_decap_8
X_11661_ _11661_/Y _18688_/Q _11661_/B _11661_/C VPWR VGND sg13cmos5l_nor3_1
XFILLER_41_166 VPWR VGND sg13cmos5l_decap_4
X_19229__1016 _19229_/RESET_B VPWR VGND sg13cmos5l_tiehi
X_11592_ _11592_/Y _11562_/Y _11597_/S _11591_/Y VPWR VGND sg13cmos5l_o21ai_1
X_13400_ _18989_/D _13583_/A _13400_/B VPWR VGND sg13cmos5l_and2_1
X_14380_ _14380_/Y _14380_/A _19103_/Q VPWR VGND sg13cmos5l_nor2b_1
X_10612_ _10612_/Y _18545_/A _10616_/B VPWR VGND sg13cmos5l_nand2_1
X_13331_ _13331_/Y _13331_/A VPWR VGND sg13cmos5l_inv_1
XFILLER_10_542 VPWR VGND sg13cmos5l_decap_4
XFILLER_10_553 VPWR VGND sg13cmos5l_fill_1
X_10543_ _10543_/Y _10575_/B _10538_/Y _10539_/Y _10534_/Y _10542_/Y VPWR VGND sg13cmos5l_a221oi_1
XFILLER_41_63 VPWR VGND sg13cmos5l_decap_4
X_16050_ _16050_/Y _10199_/A _16037_/Y _16046_/Y VPWR VGND sg13cmos5l_a21oi_1
X_13262_ _13262_/Y _13237_/Y _13256_/Y _13261_/Y VPWR VGND sg13cmos5l_o21ai_1
X_15001_ _15024_/B _19205_/Q _15002_/B VPWR VGND sg13cmos5l_xnor2_1
X_10474_ _10511_/A _10497_/A _10579_/A VPWR VGND sg13cmos5l_nand2b_1
X_12213_ _12213_/Y _18830_/Q _12729_/A VPWR VGND sg13cmos5l_nand2_1
X_18856__513 _18856_/D VPWR VGND sg13cmos5l_tielo
X_13193_ _13413_/A _13377_/A _13202_/B VPWR VGND sg13cmos5l_and2_1
X_12144_ _12145_/B _12021_/B _12162_/B _12143_/Y VPWR VGND sg13cmos5l_a21oi_1
X_18793__1482 _18793_/RESET_B VPWR VGND sg13cmos5l_tiehi
XFILLER_29_1027 VPWR VGND sg13cmos5l_fill_2
X_19740_ _19740_/Q clkload23/A _19740_/D _19740_/RESET_B VPWR VGND sg13cmos5l_dfrbpq_1
X_12075_ _12083_/A _12265_/B _12123_/B _12069_/Y _12073_/Y _12074_/Y VPWR VGND sg13cmos5l_a221oi_1
X_16952_ _17043_/B _16964_/A _17058_/B VPWR VGND sg13cmos5l_nand2_1
XFILLER_2_35 VPWR VGND sg13cmos5l_fill_1
X_16883_ _16883_/Y hold1969/X fanout86/X _16889_/A VPWR VGND sg13cmos5l_o21ai_1
X_19671_ _19671_/Q clkload26/A _19671_/D _19671_/RESET_B VPWR VGND sg13cmos5l_dfrbpq_1
X_11026_ _11027_/B _11026_/A _11026_/B VPWR VGND sg13cmos5l_xnor2_1
X_15903_ _15911_/B _19389_/Q _19390_/Q _19391_/Q _19392_/Q VPWR VGND sg13cmos5l_nor4_1
XFILLER_77_586 VPWR VGND sg13cmos5l_fill_1
X_18622_ _18622_/Q clkload58/A _18622_/D _18622_/RESET_B VPWR VGND sg13cmos5l_dfrbpq_1
X_15834_ _15834_/Y _15834_/A _15834_/B VPWR VGND sg13cmos5l_nor2_1
X_18553_ _18553_/Y _10605_/A _10633_/A _10646_/B VPWR VGND sg13cmos5l_o21ai_1
X_19042__1215 _19042_/RESET_B VPWR VGND sg13cmos5l_tiehi
XFILLER_92_578 VPWR VGND sg13cmos5l_fill_1
X_12977_ _12977_/Y _12977_/A _12986_/B VPWR VGND sg13cmos5l_nand2_1
X_17504_ _17504_/Y _19603_/Q _19564_/Q VPWR VGND sg13cmos5l_xnor2_1
XFILLER_46_995 VPWR VGND sg13cmos5l_decap_8
X_15765_ _15765_/Y _19375_/Q _16314_/A _15779_/C VPWR VGND sg13cmos5l_nand3_1
X_11928_ _11929_/A _11927_/Y _11926_/Y _11938_/C VPWR VGND sg13cmos5l_mux2_1
X_18484_ _18484_/Y _19723_/Q _18486_/A VPWR VGND sg13cmos5l_nand2b_1
X_14716_ _14716_/Y _14716_/A _14754_/A VPWR VGND sg13cmos5l_nand2_1
X_15696_ _15696_/X _15744_/B _15710_/B _15695_/Y VPWR VGND sg13cmos5l_a21o_1
X_11859_ _11860_/A _11760_/B _11874_/A _11859_/C VPWR VGND sg13cmos5l_nand3b_1
X_17435_ _17435_/Y _19605_/Q fanout87/X _17152_/A VPWR VGND sg13cmos5l_o21ai_1
X_14647_ _19182_/D _14648_/A _14647_/B VPWR VGND sg13cmos5l_nor2_1
XFILLER_32_133 VPWR VGND sg13cmos5l_fill_2
XFILLER_32_155 VPWR VGND sg13cmos5l_fill_1
X_17366_ _19583_/D _17366_/A _17370_/B VPWR VGND sg13cmos5l_nor2_1
X_14578_ _14578_/X _14716_/A _14578_/B VPWR VGND sg13cmos5l_and2_1
XFILLER_14_881 VPWR VGND sg13cmos5l_fill_1
XFILLER_32_188 VPWR VGND sg13cmos5l_fill_1
X_13529_ _13529_/Y _13529_/A _13548_/B VPWR VGND sg13cmos5l_nand2_1
X_16317_ _19433_/D _16318_/A _16317_/B VPWR VGND sg13cmos5l_and2_1
X_19105_ _19105_/Q _19220_/CLK _19105_/D _19105_/RESET_B VPWR VGND sg13cmos5l_dfrbpq_1
X_17297_ _17298_/B _17442_/A _17309_/B VPWR VGND sg13cmos5l_and2_1
X_19036_ _19036_/Q clkload31/A _19036_/D _19036_/RESET_B VPWR VGND sg13cmos5l_dfrbpq_1
XFILLER_63_2 VPWR VGND sg13cmos5l_fill_1
X_16248_ _16248_/X _16432_/A _16248_/B VPWR VGND sg13cmos5l_and2_1
X_16179_ _16196_/B _19431_/Q _19432_/Q _19433_/Q _19434_/Q VPWR VGND sg13cmos5l_nor4_1
X_18935__1331 _18935_/RESET_B VPWR VGND sg13cmos5l_tiehi
Xhold2905 _13455_/B _19012_/Q VPWR VGND sg13cmos5l_dlygate4sd3_1
Xhold2916 hold2916/X _16979_/X VPWR VGND sg13cmos5l_dlygate4sd3_1
Xhold2927 _14082_/B _14013_/B VPWR VGND sg13cmos5l_dlygate4sd3_1
Xhold2938 _10908_/A _19777_/Q VPWR VGND sg13cmos5l_dlygate4sd3_1
XFILLER_101_149 VPWR VGND sg13cmos5l_fill_1
XFILLER_56_715 VPWR VGND sg13cmos5l_fill_2
Xhold2949 _14372_/B _14281_/X VPWR VGND sg13cmos5l_dlygate4sd3_1
XFILLER_95_394 VPWR VGND sg13cmos5l_decap_4
XFILLER_37_962 VPWR VGND sg13cmos5l_fill_1
X_19380__463 _19380_/D VPWR VGND sg13cmos5l_tielo
XFILLER_83_589 VPWR VGND sg13cmos5l_decap_4
XFILLER_70_217 VPWR VGND sg13cmos5l_fill_2
XFILLER_36_461 VPWR VGND sg13cmos5l_fill_2
XFILLER_51_442 VPWR VGND sg13cmos5l_fill_2
XFILLER_23_155 VPWR VGND sg13cmos5l_fill_2
XFILLER_106_934 VPWR VGND sg13cmos5l_fill_2
XFILLER_106_923 VPWR VGND sg13cmos5l_decap_8
XFILLER_106_945 VPWR VGND sg13cmos5l_fill_2
X_10190_ _10638_/A _10190_/A VPWR VGND sg13cmos5l_inv_1
XFILLER_87_840 VPWR VGND sg13cmos5l_fill_2
Xfanout330 _10680_/A hold2548/X VPWR VGND sg13cmos5l_buf_1
Xfanout341 _15912_/C hold2878/X VPWR VGND sg13cmos5l_buf_1
Xfanout374 _17930_/A _17439_/A VPWR VGND sg13cmos5l_buf_1
Xfanout352 _10945_/C hold2865/X VPWR VGND sg13cmos5l_buf_1
Xfanout363 _16082_/A _16549_/A VPWR VGND sg13cmos5l_buf_1
Xfanout396 _11691_/A fanout402/X VPWR VGND sg13cmos5l_buf_1
X_12900_ _12900_/Y _12947_/A _12890_/X _12898_/X VPWR VGND sg13cmos5l_o21ai_1
XFILLER_74_523 VPWR VGND sg13cmos5l_fill_1
XFILLER_59_586 VPWR VGND sg13cmos5l_fill_1
X_13880_ _13891_/A _18991_/Q _18989_/Q _18990_/Q VPWR VGND sg13cmos5l_or3_1
Xfanout385 _14436_/A _14710_/A VPWR VGND sg13cmos5l_buf_1
XFILLER_100_182 VPWR VGND sg13cmos5l_fill_2
X_12831_ _18905_/D _13025_/A _12831_/B VPWR VGND sg13cmos5l_nor2_1
XFILLER_47_759 VPWR VGND sg13cmos5l_fill_2
XFILLER_61_206 VPWR VGND sg13cmos5l_fill_1
XFILLER_28_984 VPWR VGND sg13cmos5l_fill_1
XFILLER_36_41 VPWR VGND sg13cmos5l_fill_2
X_12762_ _12763_/B _12767_/C _12760_/Y _12761_/Y VPWR VGND sg13cmos5l_a21o_1
X_15550_ _15557_/B _19288_/Q _19287_/Q _19286_/Q _15550_/D VPWR VGND sg13cmos5l_nor4_1
X_12693_ _12693_/Y _12693_/A _12693_/B VPWR VGND sg13cmos5l_nor2_1
X_11713_ _11713_/X _11713_/A _11715_/B _11713_/C VPWR VGND sg13cmos5l_or3_1
X_15481_ _15481_/Y _15482_/B _15477_/X _15480_/Y VPWR VGND sg13cmos5l_a21oi_1
X_14501_ _14506_/A _19174_/Q _14516_/B VPWR VGND sg13cmos5l_and2_1
X_11644_ _11644_/Y _11644_/A _12195_/A _11661_/C VPWR VGND sg13cmos5l_nand3_1
X_17220_ _17225_/A _19584_/Q _17221_/B VPWR VGND sg13cmos5l_and2_1
X_14432_ _14432_/Y hold2003/X fanout73/X _14436_/A VPWR VGND sg13cmos5l_o21ai_1
X_17151_ _19565_/D _17439_/A _17151_/B VPWR VGND sg13cmos5l_and2_1
X_11575_ _11575_/X _11575_/A _11575_/B VPWR VGND sg13cmos5l_xor2_1
X_16102_ _16102_/Y _16088_/X _16097_/X _16141_/A _16107_/A _16100_/X VPWR VGND sg13cmos5l_a221oi_1
X_14363_ _19127_/D _14344_/A _14349_/X _14362_/Y VPWR VGND sg13cmos5l_a21oi_1
X_17082_ _19543_/D _17082_/A _17087_/A VPWR VGND sg13cmos5l_nor2_1
X_13314_ _13314_/Y _13476_/C _14077_/A _13329_/C VPWR VGND sg13cmos5l_nand3_1
X_10526_ _10567_/B _19786_/Q _10526_/B VPWR VGND sg13cmos5l_xnor2_1
X_14294_ _14294_/Y _14288_/A _14288_/B _14288_/C _14288_/D VPWR VGND sg13cmos5l_a22oi_1
X_13245_ _13246_/B _13245_/A _13263_/B VPWR VGND sg13cmos5l_nor2_1
X_10457_ _10464_/C _19795_/Q _10608_/B _10609_/A VPWR VGND sg13cmos5l_o21ai_1
XFILLER_6_387 VPWR VGND sg13cmos5l_fill_1
X_16033_ _16033_/Y _19356_/Q _16033_/B VPWR VGND sg13cmos5l_nand2_1
XFILLER_6_398 VPWR VGND sg13cmos5l_fill_1
X_10388_ _19807_/D _10683_/A _10680_/B VPWR VGND sg13cmos5l_nor2_1
X_13176_ _13393_/A _13580_/A _13176_/B VPWR VGND sg13cmos5l_xnor2_1
X_12127_ _12128_/B _12014_/A _12014_/B _12133_/S _12299_/A _12119_/Y VPWR VGND sg13cmos5l_a221oi_1
X_17984_ _17984_/Y _18470_/B _18273_/B VPWR VGND sg13cmos5l_nand2b_1
X_18583__1716 _18583_/RESET_B VPWR VGND sg13cmos5l_tiehi
X_12058_ _12145_/A _12170_/A _12058_/B VPWR VGND sg13cmos5l_nand2_1
X_16935_ _17030_/A _16938_/S _16934_/Y _16932_/Y VPWR VGND sg13cmos5l_o21ai_1
X_19723_ _19723_/Q _19790_/CLK _19723_/D _19723_/RESET_B VPWR VGND sg13cmos5l_dfrbpq_1
X_11009_ _11025_/A _18629_/Q _11022_/B VPWR VGND sg13cmos5l_or2_1
X_19654_ _19654_/Q clkload11/A _19654_/D _19654_/RESET_B VPWR VGND sg13cmos5l_dfrbpq_1
X_16866_ _16868_/A _16859_/Y _16863_/Y _16864_/Y _16881_/B _16865_/Y VPWR VGND sg13cmos5l_a221oi_1
X_18605_ _18605_/Q clkload21/A _18605_/D _18605_/RESET_B VPWR VGND sg13cmos5l_dfrbpq_1
X_16797_ _16797_/Y _16797_/A _16797_/B VPWR VGND sg13cmos5l_nor2_1
X_19585_ _19585_/Q clkload38/A _19585_/D _19585_/RESET_B VPWR VGND sg13cmos5l_dfrbpq_1
XFILLER_53_718 VPWR VGND sg13cmos5l_decap_4
X_15817_ _15847_/A _19325_/Q _19326_/Q VPWR VGND sg13cmos5l_xor2_1
X_18536_ _18536_/Y _09968_/Y fanout89/X _18535_/Y VPWR VGND sg13cmos5l_a21oi_1
XFILLER_52_228 VPWR VGND sg13cmos5l_fill_2
X_15748_ _19352_/D _15748_/A _15748_/B VPWR VGND sg13cmos5l_nor2_1
X_18467_ _18467_/Y _18453_/A _18457_/Y _18466_/Y VPWR VGND sg13cmos5l_a21oi_1
XFILLER_33_464 VPWR VGND sg13cmos5l_fill_2
X_17418_ _17673_/B _17930_/B _17439_/A VPWR VGND sg13cmos5l_nand2b_1
X_15679_ _15747_/B _15679_/A _15679_/B VPWR VGND sg13cmos5l_nor2_1
XFILLER_21_637 VPWR VGND sg13cmos5l_fill_1
XFILLER_33_486 VPWR VGND sg13cmos5l_fill_2
X_18833__1439 _18833_/RESET_B VPWR VGND sg13cmos5l_tiehi
X_19006__1254 _19006_/RESET_B VPWR VGND sg13cmos5l_tiehi
X_18398_ _18402_/S _18414_/B _18414_/C VPWR VGND sg13cmos5l_nand2_1
X_17349_ _17349_/Y _17343_/A _17343_/B _17348_/X VPWR VGND sg13cmos5l_o21ai_1
X_19713__1504 _19713_/RESET_B VPWR VGND sg13cmos5l_tiehi
X_19019_ _19019_/Q clkload33/A _19019_/D _19019_/RESET_B VPWR VGND sg13cmos5l_dfrbpq_1
XFILLER_0_508 VPWR VGND sg13cmos5l_decap_8
Xhold2702 hold2702/X _18759_/Q VPWR VGND sg13cmos5l_dlygate4sd3_1
Xhold2713 _10398_/B _10397_/X VPWR VGND sg13cmos5l_dlygate4sd3_1
Xhold2746 hold2746/X _18885_/Q VPWR VGND sg13cmos5l_dlygate4sd3_1
XFILLER_75_309 VPWR VGND sg13cmos5l_fill_1
Xhold2724 _14982_/A _19204_/Q VPWR VGND sg13cmos5l_dlygate4sd3_1
Xhold2735 _19465_/D _16559_/Y VPWR VGND sg13cmos5l_dlygate4sd3_1
XFILLER_69_895 VPWR VGND sg13cmos5l_decap_8
Xhold2768 _17664_/A _17650_/A VPWR VGND sg13cmos5l_dlygate4sd3_1
Xhold2779 _16492_/B _19408_/Q VPWR VGND sg13cmos5l_dlygate4sd3_1
Xhold2757 hold2757/X _16533_/B VPWR VGND sg13cmos5l_dlygate4sd3_1
XFILLER_44_707 VPWR VGND sg13cmos5l_fill_2
X_18766__1512 _18766_/RESET_B VPWR VGND sg13cmos5l_tiehi
XFILLER_43_217 VPWR VGND sg13cmos5l_fill_1
X_18807__518 _18807_/D VPWR VGND sg13cmos5l_tielo
XFILLER_51_250 VPWR VGND sg13cmos5l_fill_2
X_11360_ _18677_/D _11360_/A _11360_/B VPWR VGND sg13cmos5l_and2_1
XFILLER_22_76 VPWR VGND sg13cmos5l_fill_2
X_10311_ _10311_/Y _10311_/A VPWR VGND sg13cmos5l_inv_1
X_11291_ _11361_/B _11263_/X _11290_/Y _11295_/B VPWR VGND sg13cmos5l_mux2_1
X_13030_ _13030_/Y _13576_/A _18894_/Q _18893_/Q _13575_/A _13029_/Y VPWR VGND sg13cmos5l_a221oi_1
X_10242_ _14396_/A _10242_/A VPWR VGND sg13cmos5l_inv_1
XFILLER_106_797 VPWR VGND sg13cmos5l_decap_8
XFILLER_79_637 VPWR VGND sg13cmos5l_fill_1
X_10173_ _18224_/A _10173_/A VPWR VGND sg13cmos5l_inv_1
X_16720_ _16720_/X _19490_/Q _19505_/Q VPWR VGND sg13cmos5l_and2_1
Xfanout182 _12879_/B _12859_/Y VPWR VGND sg13cmos5l_buf_1
XFILLER_47_523 VPWR VGND sg13cmos5l_fill_1
Xfanout171 _14229_/B _14210_/Y VPWR VGND sg13cmos5l_buf_1
X_14981_ _15002_/B _14982_/A _14982_/B VPWR VGND sg13cmos5l_nor2b_1
Xfanout160 _15887_/B _15868_/Y VPWR VGND sg13cmos5l_buf_1
XFILLER_101_480 VPWR VGND sg13cmos5l_fill_2
XFILLER_87_692 VPWR VGND sg13cmos5l_fill_2
Xfanout193 _11234_/B _11215_/Y VPWR VGND sg13cmos5l_buf_1
X_19082__1172 _19082_/RESET_B VPWR VGND sg13cmos5l_tiehi
X_13932_ _13932_/Y _13930_/Y _13931_/Y _13929_/Y VPWR VGND sg13cmos5l_a21oi_1
X_16651_ _16651_/Y _16651_/A _16651_/B VPWR VGND sg13cmos5l_nand2_1
X_13863_ _13863_/Y _13846_/B _13859_/S _14071_/B VPWR VGND sg13cmos5l_o21ai_1
XFILLER_35_729 VPWR VGND sg13cmos5l_fill_1
X_13794_ _13796_/A _13794_/A _13803_/A VPWR VGND sg13cmos5l_nor2b_1
X_12814_ _12820_/B _18868_/Q _18867_/Q _18866_/Q _12814_/D VPWR VGND sg13cmos5l_nor4_1
X_16582_ _16582_/X _16582_/A _16582_/B VPWR VGND sg13cmos5l_and2_1
X_19370_ _19370_/Q clkload8/A _19370_/D _19370_/RESET_B VPWR VGND sg13cmos5l_dfrbpq_1
X_15602_ _15603_/B _19345_/Q _15721_/B VPWR VGND sg13cmos5l_nor2_1
X_12745_ _12745_/Y _12745_/A _12754_/B _12754_/C VPWR VGND sg13cmos5l_nand3_1
X_15533_ _15535_/C _19283_/Q _19284_/Q _19285_/Q VPWR VGND sg13cmos5l_o21ai_1
X_18321_ _18321_/Y _18321_/A _18341_/B VPWR VGND sg13cmos5l_nor2_1
XFILLER_72_1028 VPWR VGND sg13cmos5l_fill_1
XFILLER_63_94 VPWR VGND sg13cmos5l_fill_1
X_12676_ _12677_/B _12733_/B _12697_/B _12675_/Y VPWR VGND sg13cmos5l_a21oi_1
X_18252_ _18252_/X _19680_/Q _18252_/B VPWR VGND sg13cmos5l_and2_1
X_15464_ _19308_/D _15464_/A _15464_/B VPWR VGND sg13cmos5l_nor2_1
X_17203_ _17203_/Y _17203_/A _17203_/B VPWR VGND sg13cmos5l_nor2_1
X_11627_ _18718_/D _11629_/A _11627_/B VPWR VGND sg13cmos5l_nor2_1
X_15395_ _15465_/B _15357_/X _15394_/X _15395_/S VPWR VGND sg13cmos5l_mux2_1
X_14415_ _14424_/S _14415_/A _14415_/B VPWR VGND sg13cmos5l_nor2_1
X_18183_ _18184_/A _18228_/B _18044_/B _18195_/B VPWR VGND sg13cmos5l_mux2_1
X_11558_ _11558_/X _11462_/B _11550_/X _11557_/Y VPWR VGND sg13cmos5l_a21o_1
X_17134_ _17134_/Y _17113_/A _17136_/S _17375_/A VPWR VGND sg13cmos5l_o21ai_1
X_14346_ _14346_/Y _14340_/A _14344_/Y _14345_/Y VPWR VGND sg13cmos5l_a21oi_1
X_17065_ _17065_/Y _16948_/Y _16961_/Y _17056_/Y _17063_/Y _17064_/X VPWR VGND sg13cmos5l_a221oi_1
XFILLER_6_162 VPWR VGND sg13cmos5l_fill_2
X_10509_ _10564_/A _10506_/A _10506_/B _10507_/Y VPWR VGND sg13cmos5l_a21o_1
X_11489_ _11582_/B _11500_/A _11503_/B VPWR VGND sg13cmos5l_nand2_1
XFILLER_6_173 VPWR VGND sg13cmos5l_fill_1
X_16016_ _19388_/D _16016_/A _16016_/B VPWR VGND sg13cmos5l_nor2_1
X_14277_ _14307_/S _14277_/A _14277_/B VPWR VGND sg13cmos5l_nor2_1
X_13228_ _13228_/Y _13264_/A _13228_/B VPWR VGND sg13cmos5l_nor2_1
XFILLER_40_4 VPWR VGND sg13cmos5l_fill_1
X_19331__468 _19331_/D VPWR VGND sg13cmos5l_tielo
XFILLER_97_423 VPWR VGND sg13cmos5l_fill_2
X_13159_ _13159_/Y _13159_/A _13159_/B _13365_/A VPWR VGND sg13cmos5l_nand3_1
Xhold2009 _14387_/A _19102_/Q VPWR VGND sg13cmos5l_dlygate4sd3_1
XFILLER_100_929 VPWR VGND sg13cmos5l_decap_4
X_19706_ _19706_/Q _19756_/CLK _19706_/D _19706_/RESET_B VPWR VGND sg13cmos5l_dfrbpq_1
X_17967_ _17973_/A _17968_/A _17968_/B _17965_/A _18248_/A _17966_/Y VPWR VGND sg13cmos5l_a221oi_1
XFILLER_26_2 VPWR VGND sg13cmos5l_fill_1
X_16918_ _16938_/S _16932_/B _16918_/B VPWR VGND sg13cmos5l_and2_1
X_18869__512 _18869_/D VPWR VGND sg13cmos5l_tielo
X_17898_ _17900_/B _17861_/A _17940_/B _17898_/S VPWR VGND sg13cmos5l_mux2_1
XFILLER_38_556 VPWR VGND sg13cmos5l_fill_1
X_19224__1021 _19224_/RESET_B VPWR VGND sg13cmos5l_tiehi
X_16849_ _16849_/Y _19470_/Q _16849_/B VPWR VGND sg13cmos5l_nand2_1
X_19637_ _19637_/Q clkload27/A _19637_/D _19637_/RESET_B VPWR VGND sg13cmos5l_dfrbpq_1
XFILLER_92_161 VPWR VGND sg13cmos5l_fill_2
X_19568_ _19568_/Q clkload37/A _19568_/D _19568_/RESET_B VPWR VGND sg13cmos5l_dfrbpq_1
X_18519_ _18521_/A _19768_/Q _18516_/Y _18518_/Y _19769_/Q _18517_/Y VPWR VGND sg13cmos5l_a221oi_1
X_19499_ _19499_/Q clkload32/A _19499_/D _19499_/RESET_B VPWR VGND sg13cmos5l_dfrbpq_1
XFILLER_80_378 VPWR VGND sg13cmos5l_fill_2
XFILLER_88_1024 VPWR VGND sg13cmos5l_decap_4
XFILLER_0_327 VPWR VGND sg13cmos5l_decap_8
Xhold2510 hold2510/X _18570_/Q VPWR VGND sg13cmos5l_dlygate4sd3_1
Xhold2521 _10072_/A _18960_/Q VPWR VGND sg13cmos5l_dlygate4sd3_1
XFILLER_102_266 VPWR VGND sg13cmos5l_decap_4
Xhold2554 _12696_/C _12695_/Y VPWR VGND sg13cmos5l_dlygate4sd3_1
Xhold1820 _12378_/B _18778_/Q VPWR VGND sg13cmos5l_dlygate4sd3_1
XFILLER_75_106 VPWR VGND sg13cmos5l_fill_1
Xhold2543 _10535_/A _19787_/Q VPWR VGND sg13cmos5l_dlygate4sd3_1
Xhold2565 _14781_/A _19214_/Q VPWR VGND sg13cmos5l_dlygate4sd3_1
Xhold2532 _19304_/D _15460_/Y VPWR VGND sg13cmos5l_dlygate4sd3_1
Xhold1842 _12527_/B _18818_/Q VPWR VGND sg13cmos5l_dlygate4sd3_1
Xhold1831 _18293_/B _19691_/Q VPWR VGND sg13cmos5l_dlygate4sd3_1
Xhold1853 _18004_/B _19649_/Q VPWR VGND sg13cmos5l_dlygate4sd3_1
Xhold2576 _14027_/B _14026_/X VPWR VGND sg13cmos5l_dlygate4sd3_1
Xhold2587 _13344_/B _13343_/X VPWR VGND sg13cmos5l_dlygate4sd3_1
Xhold2598 _10259_/A _18980_/Q VPWR VGND sg13cmos5l_dlygate4sd3_1
XFILLER_29_545 VPWR VGND sg13cmos5l_decap_4
X_19499__718 _19499_/RESET_B VPWR VGND sg13cmos5l_tiehi
Xhold1864 _12529_/B _18820_/Q VPWR VGND sg13cmos5l_dlygate4sd3_1
Xhold1886 _15810_/B _19324_/Q VPWR VGND sg13cmos5l_dlygate4sd3_1
Xhold1875 _14760_/B _19156_/Q VPWR VGND sg13cmos5l_dlygate4sd3_1
Xhold1897 _13812_/A _18588_/Q VPWR VGND sg13cmos5l_dlygate4sd3_1
X_10860_ _10860_/Y _11350_/B _10860_/B VPWR VGND sg13cmos5l_nand2b_1
XFILLER_16_239 VPWR VGND sg13cmos5l_fill_1
X_10791_ _13728_/A _13649_/B _13653_/B VPWR VGND sg13cmos5l_nor2_1
XFILLER_24_272 VPWR VGND sg13cmos5l_fill_1
X_12530_ _12546_/B _18823_/Q _18821_/Q _18822_/Q VPWR VGND sg13cmos5l_or3_1
XFILLER_9_917 VPWR VGND sg13cmos5l_decap_8
X_12461_ _18841_/D _12461_/A _12462_/B VPWR VGND sg13cmos5l_nor2_1
XFILLER_12_467 VPWR VGND sg13cmos5l_decap_8
XFILLER_12_478 VPWR VGND sg13cmos5l_fill_1
XFILLER_33_75 VPWR VGND sg13cmos5l_fill_1
X_11412_ _11413_/B _11396_/Y _11661_/B _11412_/S VPWR VGND sg13cmos5l_mux2_1
X_15180_ _19253_/D _15167_/B hold2924/X _15191_/A VPWR VGND sg13cmos5l_a21oi_1
X_14200_ _14200_/Y _14200_/A _14200_/B _14200_/C VPWR VGND sg13cmos5l_nand3_1
X_12392_ _12427_/C _12391_/A _12391_/B _12402_/A VPWR VGND sg13cmos5l_o21ai_1
X_14131_ _14131_/X _14111_/Y _14402_/A _14131_/S VPWR VGND sg13cmos5l_mux2_1
X_11343_ _18662_/D _11355_/B _11343_/B VPWR VGND sg13cmos5l_nor2_1
XFILLER_3_110 VPWR VGND sg13cmos5l_decap_4
X_11274_ _11300_/A _11274_/A _11274_/B VPWR VGND sg13cmos5l_nor2_1
X_14062_ _14063_/B _14041_/B _14038_/A _14062_/S VPWR VGND sg13cmos5l_mux2_1
XFILLER_4_666 VPWR VGND sg13cmos5l_fill_2
XFILLER_4_655 VPWR VGND sg13cmos5l_decap_8
X_18870_ _18870_/Q clkload71/A _18870_/D _18870_/RESET_B VPWR VGND sg13cmos5l_dfrbpq_1
X_13013_ _13013_/Y _13013_/A _13013_/B _13013_/C VPWR VGND sg13cmos5l_nand3_1
X_10225_ _10225_/Y _10225_/A VPWR VGND sg13cmos5l_inv_1
X_17821_ _17875_/A _18226_/A _17821_/B VPWR VGND sg13cmos5l_xnor2_1
X_10156_ _17670_/A _10156_/A VPWR VGND sg13cmos5l_inv_1
XFILLER_75_640 VPWR VGND sg13cmos5l_fill_1
X_17752_ _17752_/X _17749_/Y _17751_/X _17747_/Y VPWR VGND sg13cmos5l_a21o_1
X_14964_ _14964_/Y _14945_/B _14958_/S _15185_/B VPWR VGND sg13cmos5l_o21ai_1
X_10087_ _14367_/A _10087_/A VPWR VGND sg13cmos5l_inv_1
X_16703_ _16711_/B _19505_/Q _19506_/Q _19507_/Q _19508_/Q VPWR VGND sg13cmos5l_nor4_1
XFILLER_75_673 VPWR VGND sg13cmos5l_fill_1
X_13915_ _13915_/X _13495_/Y _13912_/Y _13924_/S VPWR VGND sg13cmos5l_mux2_1
X_17683_ _17683_/Y _18224_/A _19599_/Q _19600_/Q _18225_/A _17682_/Y VPWR VGND sg13cmos5l_a221oi_1
X_16634_ _16641_/C _19031_/Q _19032_/Q hold3039/X VPWR VGND sg13cmos5l_o21ai_1
X_14895_ _14896_/B _14873_/B _14870_/Y _14895_/S VPWR VGND sg13cmos5l_mux2_1
X_19422_ _19422_/Q clkload5/A _19422_/D _19422_/RESET_B VPWR VGND sg13cmos5l_dfrbpq_1
XFILLER_35_537 VPWR VGND sg13cmos5l_fill_1
XFILLER_35_548 VPWR VGND sg13cmos5l_decap_8
X_13846_ _13847_/C _14085_/B _13846_/B VPWR VGND sg13cmos5l_nor2_1
X_13777_ _13777_/Y _13774_/Y _13776_/Y _13759_/Y VPWR VGND sg13cmos5l_o21ai_1
X_18873__1396 _18873_/RESET_B VPWR VGND sg13cmos5l_tiehi
X_16565_ _16565_/Y _16722_/A _13606_/A _10376_/Y _19490_/Q VPWR VGND sg13cmos5l_a22oi_1
X_10989_ _10992_/A _10989_/A _10989_/B _10989_/C VPWR VGND sg13cmos5l_nand3_1
X_19353_ _19353_/Q clkload17/A _19353_/D _19353_/RESET_B VPWR VGND sg13cmos5l_dfrbpq_1
X_12728_ _18883_/D _12728_/A _12728_/B VPWR VGND sg13cmos5l_nor2_1
X_19674__1785 _19674_/RESET_B VPWR VGND sg13cmos5l_tiehi
X_19284_ _19284_/Q clkload43/A _19284_/D _19284_/RESET_B VPWR VGND sg13cmos5l_dfrbpq_1
X_15516_ _15517_/B _15500_/Y _15779_/B _15516_/S VPWR VGND sg13cmos5l_mux2_1
X_16496_ _16496_/Y _16524_/B _16524_/C _16524_/A VPWR VGND sg13cmos5l_a21oi_1
X_18304_ _18304_/Y _18309_/B _18309_/C _18309_/A VPWR VGND sg13cmos5l_a21oi_1
X_12659_ _12733_/B _12664_/S _12843_/A _12658_/X VPWR VGND sg13cmos5l_a21oi_1
XFILLER_90_70 VPWR VGND sg13cmos5l_fill_2
X_18235_ _18235_/Y _19680_/Q _19742_/Q VPWR VGND sg13cmos5l_nand2b_1
X_15447_ _15448_/B _15424_/A _15407_/A _15447_/S VPWR VGND sg13cmos5l_mux2_1
X_15378_ _15378_/Y _15378_/A _15378_/B _15378_/C VPWR VGND sg13cmos5l_nor3_1
X_18166_ _18166_/Y _18166_/A VPWR VGND sg13cmos5l_inv_1
X_17117_ _17117_/Y _17670_/A _17122_/B _17122_/C VPWR VGND sg13cmos5l_nor3_1
XFILLER_7_482 VPWR VGND sg13cmos5l_fill_2
X_18097_ _18127_/B _19720_/Q _18098_/B VPWR VGND sg13cmos5l_nor2b_1
X_14329_ _14329_/X _14281_/X _14184_/B _14336_/B VPWR VGND sg13cmos5l_mux2_1
X_17048_ _17048_/Y _17036_/Y _17038_/X _17049_/A _17049_/B VPWR VGND sg13cmos5l_a22oi_1
X_19122__1129 _19122_/RESET_B VPWR VGND sg13cmos5l_tiehi
XFILLER_98_732 VPWR VGND sg13cmos5l_fill_1
XFILLER_97_253 VPWR VGND sg13cmos5l_fill_2
X_18999_ _18999_/Q clkload53/A _18999_/D _18999_/RESET_B VPWR VGND sg13cmos5l_dfrbpq_1
XFILLER_100_737 VPWR VGND sg13cmos5l_fill_2
X_19756__827 _19756_/RESET_B VPWR VGND sg13cmos5l_tiehi
XFILLER_81_665 VPWR VGND sg13cmos5l_fill_1
XFILLER_54_868 VPWR VGND sg13cmos5l_fill_2
XFILLER_26_548 VPWR VGND sg13cmos5l_fill_1
XFILLER_55_1012 VPWR VGND sg13cmos5l_decap_8
XFILLER_34_592 VPWR VGND sg13cmos5l_fill_2
X_19055__1202 _19055_/RESET_B VPWR VGND sg13cmos5l_tiehi
XFILLER_88_242 VPWR VGND sg13cmos5l_fill_1
X_10010_ _10010_/Y _10010_/A VPWR VGND sg13cmos5l_inv_1
Xhold3041 _13938_/B _18988_/Q VPWR VGND sg13cmos5l_dlygate4sd3_1
XFILLER_1_636 VPWR VGND sg13cmos5l_fill_1
XFILLER_88_264 VPWR VGND sg13cmos5l_fill_2
X_09999_ _09999_/Y _10794_/A VPWR VGND sg13cmos5l_inv_1
XFILLER_77_949 VPWR VGND sg13cmos5l_fill_1
Xhold3063 _11166_/A _18615_/Q VPWR VGND sg13cmos5l_dlygate4sd3_1
Xhold3052 hold3052/X _19391_/Q VPWR VGND sg13cmos5l_dlygate4sd3_1
Xhold2340 _19065_/D _13870_/Y VPWR VGND sg13cmos5l_dlygate4sd3_1
Xhold2351 _11521_/A _11522_/A VPWR VGND sg13cmos5l_dlygate4sd3_1
Xhold2362 _10366_/A _19516_/Q VPWR VGND sg13cmos5l_dlygate4sd3_1
Xhold2373 _14968_/B _19233_/Q VPWR VGND sg13cmos5l_dlygate4sd3_1
X_11961_ _18773_/D _10010_/Y fanout79/X _11960_/Y VPWR VGND sg13cmos5l_a21oi_1
Xhold2395 _18603_/D _10872_/Y VPWR VGND sg13cmos5l_dlygate4sd3_1
Xhold2384 _15182_/A _19206_/Q VPWR VGND sg13cmos5l_dlygate4sd3_1
XFILLER_28_64 VPWR VGND sg13cmos5l_fill_1
X_13700_ _13700_/Y _13700_/A _13700_/B _13700_/C VPWR VGND sg13cmos5l_nand3_1
XFILLER_85_993 VPWR VGND sg13cmos5l_decap_8
XFILLER_57_695 VPWR VGND sg13cmos5l_decap_8
X_10912_ _18611_/D _11089_/A _10912_/B VPWR VGND sg13cmos5l_nor2_1
X_11892_ _18751_/D _12188_/A _11892_/B VPWR VGND sg13cmos5l_and2_1
X_14680_ _14680_/Y _19210_/Q _15188_/A _14680_/C VPWR VGND sg13cmos5l_nand3_1
X_13631_ _19020_/D _16564_/B _13632_/S _13630_/Y VPWR VGND sg13cmos5l_a21oi_1
X_10843_ _10843_/Y _10311_/Y _10833_/A _10837_/A _11110_/A _10842_/Y VPWR VGND sg13cmos5l_a221oi_1
X_10774_ _10798_/B _13811_/A _10774_/B VPWR VGND sg13cmos5l_xnor2_1
XFILLER_71_186 VPWR VGND sg13cmos5l_fill_1
X_13562_ _18996_/D hold2632/X fanout47/X _13561_/Y VPWR VGND sg13cmos5l_a21oi_1
X_16350_ _16350_/Y _16400_/A _19454_/Q _16350_/C VPWR VGND sg13cmos5l_nor3_1
X_12513_ _12513_/Y _12482_/Y _12509_/S _12579_/A VPWR VGND sg13cmos5l_o21ai_1
XFILLER_8_202 VPWR VGND sg13cmos5l_fill_2
X_15301_ _19286_/D _15464_/A _15392_/A VPWR VGND sg13cmos5l_nor2_1
X_16281_ _16291_/A _16163_/Y _16289_/A _16281_/C VPWR VGND sg13cmos5l_nand3b_1
XFILLER_12_253 VPWR VGND sg13cmos5l_fill_2
X_13493_ _13512_/C _19017_/Q _13493_/B VPWR VGND sg13cmos5l_xor2_1
XFILLER_40_573 VPWR VGND sg13cmos5l_fill_1
XFILLER_12_264 VPWR VGND sg13cmos5l_fill_1
X_18020_ _18028_/B _19655_/Q _18021_/B VPWR VGND sg13cmos5l_nor2b_1
X_12444_ _12444_/Y hold2647/X _12451_/A _12468_/A VPWR VGND sg13cmos5l_o21ai_1
XFILLER_8_268 VPWR VGND sg13cmos5l_fill_1
X_15232_ _15233_/B _15247_/B _15230_/Y _15482_/B VPWR VGND sg13cmos5l_o21ai_1
X_12375_ _12375_/Y _12429_/A _12467_/B _12374_/Y VPWR VGND sg13cmos5l_a21oi_1
X_15163_ _15167_/B _15163_/A _15194_/B VPWR VGND sg13cmos5l_nor2_1
X_11326_ _11334_/B _11362_/B _11325_/B _11325_/Y VPWR VGND sg13cmos5l_o21ai_1
X_15094_ _15108_/A _15083_/Y _15090_/Y _15282_/A _15121_/B _15093_/Y VPWR VGND sg13cmos5l_a221oi_1
X_14114_ _14114_/Y _19066_/Q _14114_/B _14114_/C VPWR VGND sg13cmos5l_nor3_1
X_18922_ _18922_/Q clkload63/A _18922_/D _18922_/RESET_B VPWR VGND sg13cmos5l_dfrbpq_1
X_14045_ _14054_/B _14013_/A _14011_/Y _14045_/S VPWR VGND sg13cmos5l_mux2_1
XFILLER_69_93 VPWR VGND sg13cmos5l_decap_8
X_11257_ _11257_/X _18675_/Q _11257_/B VPWR VGND sg13cmos5l_xor2_1
XFILLER_79_253 VPWR VGND sg13cmos5l_fill_1
X_18853_ _18853_/Q clkload63/A _18853_/D _18853_/RESET_B VPWR VGND sg13cmos5l_dfrbpq_1
X_11188_ _11189_/B _11188_/A _11188_/B VPWR VGND sg13cmos5l_or2_1
X_10208_ _16038_/B _19360_/Q VPWR VGND sg13cmos5l_inv_1
X_18784_ _18784_/Q clkload61/A _18784_/D _18784_/RESET_B VPWR VGND sg13cmos5l_dfrbpq_1
X_17804_ _17804_/Y _17804_/A _17804_/B _17910_/B VPWR VGND sg13cmos5l_nor3_1
X_10139_ _16332_/A _19450_/Q VPWR VGND sg13cmos5l_inv_1
X_19730__1234 _19730_/RESET_B VPWR VGND sg13cmos5l_tiehi
X_17735_ _17735_/Y hold2027/X fanout67/X _17739_/A VPWR VGND sg13cmos5l_o21ai_1
X_15996_ _15996_/Y _15885_/A _15885_/B _15987_/Y _15994_/Y _15995_/X VPWR VGND sg13cmos5l_a221oi_1
X_19185__482 _19185_/D VPWR VGND sg13cmos5l_tielo
X_14947_ _14947_/Y _19192_/Q _14947_/B VPWR VGND sg13cmos5l_nor2_1
XFILLER_36_846 VPWR VGND sg13cmos5l_fill_2
X_17666_ _19623_/D _17930_/A _17666_/B VPWR VGND sg13cmos5l_and2_1
X_14878_ _14887_/B _14915_/B _14877_/B _14877_/Y VPWR VGND sg13cmos5l_o21ai_1
X_19777__562 _19777_/RESET_B VPWR VGND sg13cmos5l_tiehi
XFILLER_35_334 VPWR VGND sg13cmos5l_decap_8
X_16617_ _16617_/Y _09978_/Y fanout68/X _16616_/Y VPWR VGND sg13cmos5l_a21oi_1
X_17597_ _17597_/Y _17596_/A _17597_/B VPWR VGND sg13cmos5l_nand2b_1
X_13829_ _13829_/X _13829_/A _13833_/B VPWR VGND sg13cmos5l_and2_1
X_19405_ _19405_/Q _19462_/CLK _19405_/D _19405_/RESET_B VPWR VGND sg13cmos5l_dfrbpq_1
X_19558__656 _19558_/RESET_B VPWR VGND sg13cmos5l_tiehi
X_19336_ _19336_/Q clkload15/A _19336_/D _19336_/RESET_B VPWR VGND sg13cmos5l_dfrbpq_1
X_16548_ _16548_/Y hold2757/X fanout32/X _16547_/Y VPWR VGND sg13cmos5l_a21oi_1
X_19267_ _19267_/Q _19304_/CLK _19267_/D _19267_/RESET_B VPWR VGND sg13cmos5l_dfrbpq_1
X_16479_ _16526_/B _16474_/Y _16529_/B _16478_/Y _16472_/Y VPWR VGND sg13cmos5l_a22oi_1
X_18218_ _18218_/Y _18206_/A _18212_/S _18231_/A VPWR VGND sg13cmos5l_o21ai_1
X_19198_ _19198_/Q _19302_/CLK _19198_/D _19198_/RESET_B VPWR VGND sg13cmos5l_dfrbpq_1
X_18149_ _18149_/Y _18180_/A _18137_/X _18148_/X _18055_/B VPWR VGND sg13cmos5l_a22oi_1
X_19489__728 _19489_/RESET_B VPWR VGND sg13cmos5l_tiehi
X_19606__602 _19606_/RESET_B VPWR VGND sg13cmos5l_tiehi
XFILLER_100_512 VPWR VGND sg13cmos5l_fill_2
XFILLER_85_256 VPWR VGND sg13cmos5l_fill_1
XFILLER_38_172 VPWR VGND sg13cmos5l_decap_4
XFILLER_38_150 VPWR VGND sg13cmos5l_decap_8
XFILLER_82_952 VPWR VGND sg13cmos5l_fill_1
XFILLER_42_805 VPWR VGND sg13cmos5l_fill_1
X_18596__1703 _18596_/RESET_B VPWR VGND sg13cmos5l_tiehi
XFILLER_14_507 VPWR VGND sg13cmos5l_decap_4
X_18960__503 _18960_/D VPWR VGND sg13cmos5l_tielo
X_10490_ _10572_/B _18384_/A VPWR VGND sg13cmos5l_inv_1
XFILLER_30_32 VPWR VGND sg13cmos5l_fill_1
X_12160_ _12160_/Y _12160_/A _12160_/B _12160_/C VPWR VGND sg13cmos5l_nand3_1
X_18846__1426 _18846_/RESET_B VPWR VGND sg13cmos5l_tiehi
X_19019__1241 _19019_/RESET_B VPWR VGND sg13cmos5l_tiehi
X_11111_ _11111_/Y _11620_/A _18666_/Q VPWR VGND sg13cmos5l_nor2_1
X_12091_ _12097_/B _12137_/A VPWR VGND sg13cmos5l_inv_1
X_11042_ _11043_/C _11042_/A _11042_/B _11042_/C VPWR VGND sg13cmos5l_nand3_1
X_19708__1601 _19708_/RESET_B VPWR VGND sg13cmos5l_tiehi
XFILLER_7_1005 VPWR VGND sg13cmos5l_fill_2
XFILLER_1_477 VPWR VGND sg13cmos5l_fill_1
X_15850_ _19368_/D _15944_/A _15944_/B _16020_/A VPWR VGND sg13cmos5l_a21oi_1
Xhold2181 _19474_/D _16613_/Y VPWR VGND sg13cmos5l_dlygate4sd3_1
Xhold2170 hold2170/X _12519_/Y VPWR VGND sg13cmos5l_dlygate4sd3_1
X_14801_ _14995_/A _19207_/Q _19208_/Q VPWR VGND sg13cmos5l_xnor2_1
X_12993_ _13013_/B _12993_/A _12993_/B VPWR VGND sg13cmos5l_nor2_1
XFILLER_45_621 VPWR VGND sg13cmos5l_decap_4
X_15781_ _15782_/A _15779_/C _15780_/Y _15779_/Y VPWR VGND sg13cmos5l_a21o_1
Xhold2192 _10199_/A _19398_/Q VPWR VGND sg13cmos5l_dlygate4sd3_1
X_11944_ _11945_/B _11958_/B _11942_/Y _12210_/B VPWR VGND sg13cmos5l_o21ai_1
XFILLER_73_963 VPWR VGND sg13cmos5l_decap_8
X_17520_ _17643_/A _19629_/Q _17522_/B VPWR VGND sg13cmos5l_nor2_1
X_14732_ _14735_/A _14716_/Y _14728_/Y _14731_/Y VPWR VGND sg13cmos5l_a21o_1
XFILLER_18_857 VPWR VGND sg13cmos5l_fill_1
X_11875_ _11875_/Y _11878_/B VPWR VGND sg13cmos5l_inv_1
XFILLER_73_974 VPWR VGND sg13cmos5l_fill_2
X_17451_ _17451_/Y _17461_/D _17442_/C _17442_/A VPWR VGND sg13cmos5l_a21oi_1
XFILLER_45_676 VPWR VGND sg13cmos5l_fill_2
X_14663_ _14663_/Y _19150_/Q _14660_/Y _14662_/Y VPWR VGND sg13cmos5l_o21ai_1
X_13614_ _13614_/Y _19020_/Q _13602_/Y _13613_/Y _19021_/Q _13610_/Y VPWR VGND sg13cmos5l_a221oi_1
X_10826_ _10826_/Y _18624_/Q _10854_/A _19769_/Q _11356_/A VPWR VGND sg13cmos5l_a22oi_1
X_16402_ _16403_/C _16402_/A _16463_/A VPWR VGND sg13cmos5l_nor2_1
X_17382_ _17382_/Y _17380_/Y _17382_/B VPWR VGND sg13cmos5l_nand2b_1
XFILLER_13_540 VPWR VGND sg13cmos5l_fill_1
X_14594_ _14595_/A _14610_/B _14594_/B VPWR VGND sg13cmos5l_nand2_1
X_19121_ _19121_/Q clkload50/A _19121_/D _19121_/RESET_B VPWR VGND sg13cmos5l_dfrbpq_1
X_10757_ _13653_/A _13813_/A _10758_/B VPWR VGND sg13cmos5l_xor2_1
X_13545_ _13545_/Y _13531_/A _13531_/B _13542_/A _13542_/B _13544_/Y VPWR VGND sg13cmos5l_a221oi_1
XFILLER_9_511 VPWR VGND sg13cmos5l_fill_2
X_16333_ _16334_/A _16329_/Y _16350_/C _16332_/Y VPWR VGND sg13cmos5l_a21o_1
X_19052_ _19052_/Q clkload29/A _19052_/D _19052_/RESET_B VPWR VGND sg13cmos5l_dfrbpq_1
X_10688_ _10688_/Y _10688_/A _10688_/B VPWR VGND sg13cmos5l_nand2_1
X_13476_ _13482_/B _18999_/Q _19000_/Q _13476_/C _18998_/Q VPWR VGND sg13cmos5l_nor4_1
X_16264_ _16265_/B _16139_/B _16282_/B _16263_/Y VPWR VGND sg13cmos5l_a21oi_1
X_12427_ _12428_/C _12427_/A _12427_/B _12427_/C VPWR VGND sg13cmos5l_nand3_1
X_18003_ _19690_/D _18273_/B _18003_/B VPWR VGND sg13cmos5l_and2_1
X_19162__1086 _19162_/RESET_B VPWR VGND sg13cmos5l_tiehi
X_15215_ _15215_/Y _19228_/Q _15215_/B VPWR VGND sg13cmos5l_nand2_1
X_16195_ _16204_/B _19435_/Q _16196_/B VPWR VGND sg13cmos5l_nor2b_1
Xheichips26_digital_project_409 uio_out[9] VPWR VGND sg13cmos5l_tielo
X_12358_ _12358_/Y _12465_/B VPWR VGND sg13cmos5l_inv_1
XFILLER_4_260 VPWR VGND sg13cmos5l_fill_1
X_15146_ _15146_/X _15138_/A _15140_/Y _15145_/Y VPWR VGND sg13cmos5l_a21o_1
X_12289_ _12289_/Y hold2907/X _12294_/B VPWR VGND sg13cmos5l_nand2b_1
XFILLER_99_359 VPWR VGND sg13cmos5l_fill_1
X_11309_ _11309_/X _11332_/A _11309_/B VPWR VGND sg13cmos5l_and2_1
XFILLER_5_794 VPWR VGND sg13cmos5l_fill_2
XFILLER_4_271 VPWR VGND sg13cmos5l_decap_4
X_15077_ _15077_/Y _19252_/Q _15078_/B VPWR VGND sg13cmos5l_xnor2_1
X_18905_ _18905_/Q _18975_/CLK _18905_/D _18905_/RESET_B VPWR VGND sg13cmos5l_dfrbpq_1
X_14028_ _14028_/Y _14028_/A VPWR VGND sg13cmos5l_inv_1
X_18836_ _18836_/Q clkload62/A _18836_/D _18836_/RESET_B VPWR VGND sg13cmos5l_dfrbpq_1
X_19795__1761 _19795_/RESET_B VPWR VGND sg13cmos5l_tiehi
X_18767_ _18767_/Q clkload69/A _18767_/D _18767_/RESET_B VPWR VGND sg13cmos5l_dfrbpq_1
X_15979_ _15979_/Y _15967_/Y _15970_/Y _15980_/A _15980_/B VPWR VGND sg13cmos5l_a22oi_1
X_18698_ _18698_/Q clkload57/A _18698_/D _18698_/RESET_B VPWR VGND sg13cmos5l_dfrbpq_1
X_17718_ _17718_/Y _18220_/B _17739_/A VPWR VGND sg13cmos5l_nand2b_1
XFILLER_36_632 VPWR VGND sg13cmos5l_fill_2
X_17649_ _17650_/C _17649_/A _17664_/B VPWR VGND sg13cmos5l_or2_1
XFILLER_50_112 VPWR VGND sg13cmos5l_fill_1
X_19319_ _19319_/Q clkload23/A _19319_/D _19319_/RESET_B VPWR VGND sg13cmos5l_dfrbpq_1
X_18627__1669 _18627_/RESET_B VPWR VGND sg13cmos5l_tiehi
XFILLER_99_893 VPWR VGND sg13cmos5l_decap_8
XFILLER_59_735 VPWR VGND sg13cmos5l_decap_4
XFILLER_39_492 VPWR VGND sg13cmos5l_fill_1
XFILLER_82_771 VPWR VGND sg13cmos5l_fill_1
XFILLER_15_805 VPWR VGND sg13cmos5l_fill_2
X_11660_ _11660_/Y _10292_/Y _11645_/Y _11659_/Y VPWR VGND sg13cmos5l_o21ai_1
XFILLER_25_87 VPWR VGND sg13cmos5l_fill_2
X_11591_ _11591_/Y _11591_/A _11597_/S VPWR VGND sg13cmos5l_nand2_1
X_10611_ _10611_/Y _10611_/A VPWR VGND sg13cmos5l_inv_1
X_13330_ _13331_/A _13329_/C _13328_/Y _13329_/Y VPWR VGND sg13cmos5l_o21ai_1
X_19335__901 _19335_/RESET_B VPWR VGND sg13cmos5l_tiehi
XFILLER_10_521 VPWR VGND sg13cmos5l_decap_4
X_10542_ _10542_/Y _10544_/A _10898_/A VPWR VGND sg13cmos5l_nor2_1
X_13261_ _13261_/Y _13267_/A _13267_/B VPWR VGND sg13cmos5l_nand2_1
XFILLER_41_75 VPWR VGND sg13cmos5l_fill_1
X_12212_ _12231_/C _12219_/B _12212_/B VPWR VGND sg13cmos5l_and2_1
X_10473_ _10589_/A _18246_/B _10473_/B VPWR VGND sg13cmos5l_xnor2_1
XFILLER_6_558 VPWR VGND sg13cmos5l_decap_8
X_15000_ _15000_/Y _15000_/A _15000_/B VPWR VGND sg13cmos5l_nor2_1
X_13192_ _13192_/Y _13125_/B _13293_/B _13196_/B _13196_/A VPWR VGND sg13cmos5l_a22oi_1
X_12143_ _12143_/Y _12199_/B _12162_/B VPWR VGND sg13cmos5l_nor2_1
X_12074_ _12074_/Y _12086_/D _12069_/B _12267_/A VPWR VGND sg13cmos5l_a21oi_1
X_19548__666 _19548_/RESET_B VPWR VGND sg13cmos5l_tiehi
X_16951_ _17043_/A _19542_/Q _17058_/B VPWR VGND sg13cmos5l_xnor2_1
XFILLER_77_510 VPWR VGND sg13cmos5l_fill_2
X_11025_ _11026_/B _11025_/A _11049_/B VPWR VGND sg13cmos5l_and2_1
X_15902_ _15902_/X _15904_/B _15902_/B _16090_/A VPWR VGND sg13cmos5l_and3_1
X_16882_ _16882_/Y _16864_/Y hold2123/X _16870_/Y VPWR VGND sg13cmos5l_a21oi_1
X_19670_ _19670_/Q clkload11/A _19670_/D _19670_/RESET_B VPWR VGND sg13cmos5l_dfrbpq_1
X_18621_ _18621_/Q clkload45/A _18621_/D _18621_/RESET_B VPWR VGND sg13cmos5l_dfrbpq_1
X_15833_ _15833_/X _15834_/A _15834_/B _15831_/Y VPWR VGND sg13cmos5l_a21o_1
XFILLER_80_708 VPWR VGND sg13cmos5l_fill_1
X_15764_ _15764_/Y _15764_/A _15764_/B VPWR VGND sg13cmos5l_nand2_1
X_18552_ _19785_/D _10606_/B _10633_/A _18551_/Y VPWR VGND sg13cmos5l_a21oi_1
X_12976_ _12976_/Y _12993_/A _12976_/B VPWR VGND sg13cmos5l_nor2_1
XFILLER_61_922 VPWR VGND sg13cmos5l_fill_1
X_17503_ _17503_/Y _19605_/Q _19566_/Q VPWR VGND sg13cmos5l_nand2_1
X_14715_ _14715_/X _19161_/Q _14715_/B VPWR VGND sg13cmos5l_xor2_1
X_11927_ _11927_/Y _12457_/A _18792_/Q VPWR VGND sg13cmos5l_nor2_1
X_15695_ _15695_/Y _15695_/A _15698_/B _15698_/C VPWR VGND sg13cmos5l_nor3_1
X_18483_ _19762_/D _18483_/A _18483_/B VPWR VGND sg13cmos5l_nor2_1
X_11858_ _11859_/C _11858_/A _11858_/B _11858_/C VPWR VGND sg13cmos5l_nand3_1
X_17434_ _17434_/Y _09974_/Y fanout88/X _17433_/Y VPWR VGND sg13cmos5l_a21oi_1
X_14646_ _19181_/D _14648_/A _14646_/B VPWR VGND sg13cmos5l_nor2_1
X_11789_ _11791_/B _18747_/Q _11789_/B VPWR VGND sg13cmos5l_xor2_1
X_10809_ _18583_/D _18591_/D _10809_/B VPWR VGND sg13cmos5l_and2_1
X_17365_ _19582_/D _17365_/A _17365_/B VPWR VGND sg13cmos5l_and2_1
X_19555__659 _19555_/RESET_B VPWR VGND sg13cmos5l_tiehi
X_14577_ _14577_/Y _14577_/A _14577_/B VPWR VGND sg13cmos5l_nand2_1
XFILLER_14_871 VPWR VGND sg13cmos5l_fill_1
X_13528_ _13548_/B _13526_/A _13526_/B _13527_/Y VPWR VGND sg13cmos5l_a21oi_1
X_19752__874 _19752_/RESET_B VPWR VGND sg13cmos5l_tiehi
X_16316_ _19432_/D _16320_/A _16316_/B VPWR VGND sg13cmos5l_nor2_1
X_19104_ _19104_/Q _19220_/CLK _19104_/D _19104_/RESET_B VPWR VGND sg13cmos5l_dfrbpq_1
X_19035_ _19035_/Q clkload31/A _19035_/D _19035_/RESET_B VPWR VGND sg13cmos5l_dfrbpq_1
X_17296_ _17296_/Y _17296_/A _17296_/B _17296_/C _17296_/D VPWR VGND sg13cmos5l_nand4_1
X_13459_ _13470_/B _13476_/C _18998_/Q VPWR VGND sg13cmos5l_nor2_1
X_16247_ _16247_/X _16247_/A _16247_/B VPWR VGND sg13cmos5l_or2_1
XFILLER_9_396 VPWR VGND sg13cmos5l_fill_1
X_16178_ _16202_/D _19431_/Q _19432_/Q _19433_/Q VPWR VGND sg13cmos5l_or3_1
X_15129_ _15142_/B _15118_/Y _15124_/Y _15128_/Y VPWR VGND sg13cmos5l_a21oi_1
Xhold2906 _13761_/A _19047_/Q VPWR VGND sg13cmos5l_dlygate4sd3_1
Xhold2939 _13232_/A _18965_/Q VPWR VGND sg13cmos5l_dlygate4sd3_1
Xhold2928 _17221_/A _19584_/Q VPWR VGND sg13cmos5l_dlygate4sd3_1
Xhold2917 _11444_/A _18658_/Q VPWR VGND sg13cmos5l_dlygate4sd3_1
X_18911__508 _18911_/D VPWR VGND sg13cmos5l_tielo
XFILLER_68_554 VPWR VGND sg13cmos5l_fill_1
XFILLER_96_885 VPWR VGND sg13cmos5l_fill_1
X_18819_ _18819_/Q clkload57/A _18819_/D _18819_/RESET_B VPWR VGND sg13cmos5l_dfrbpq_1
X_19799_ _19799_/Q _19805_/CLK _19799_/D _19799_/RESET_B VPWR VGND sg13cmos5l_dfrbpq_1
XFILLER_102_26 VPWR VGND sg13cmos5l_fill_2
XFILLER_37_974 VPWR VGND sg13cmos5l_fill_1
XFILLER_52_944 VPWR VGND sg13cmos5l_fill_1
XFILLER_52_999 VPWR VGND sg13cmos5l_fill_2
X_18886__1383 _18886_/RESET_B VPWR VGND sg13cmos5l_tiehi
Xclkbuf_4_2_0_clk clkbuf_4_2_0_clk/X clkbuf_0_clk/X VPWR VGND sg13cmos5l_buf_8
X_19687__1772 _19687_/RESET_B VPWR VGND sg13cmos5l_tiehi
XFILLER_3_528 VPWR VGND sg13cmos5l_fill_2
Xfanout320 _11091_/A _11085_/B VPWR VGND sg13cmos5l_buf_1
Xfanout331 _10526_/B _19785_/Q VPWR VGND sg13cmos5l_buf_1
Xfanout353 _13808_/A _13649_/A VPWR VGND sg13cmos5l_buf_1
Xfanout375 _18540_/A _17439_/A VPWR VGND sg13cmos5l_buf_1
Xfanout364 _17739_/A _18005_/A VPWR VGND sg13cmos5l_buf_1
Xfanout342 _15351_/C hold2829/X VPWR VGND sg13cmos5l_buf_1
Xfanout397 _12528_/A fanout402/X VPWR VGND sg13cmos5l_buf_1
Xfanout386 _14636_/A _14710_/A VPWR VGND sg13cmos5l_buf_1
X_19135__1116 _19135_/RESET_B VPWR VGND sg13cmos5l_tiehi
X_12830_ _12831_/B _12931_/A _12931_/B VPWR VGND sg13cmos5l_nand2_1
XFILLER_36_53 VPWR VGND sg13cmos5l_fill_2
X_12761_ _12761_/Y _13288_/A _18918_/Q _12767_/C VPWR VGND sg13cmos5l_nor3_1
X_12692_ _12692_/Y _12680_/X _12683_/X _12693_/A _12693_/B VPWR VGND sg13cmos5l_a22oi_1
X_11712_ _11712_/Y _11713_/A _11710_/X _11711_/Y VPWR VGND sg13cmos5l_a21oi_1
X_14500_ _14609_/B _14500_/A _14516_/B VPWR VGND sg13cmos5l_nand2_1
X_15480_ _15480_/Y _19338_/Q _16010_/A _15498_/C VPWR VGND sg13cmos5l_nor3_1
X_11643_ _11661_/C _18750_/Q _11646_/B _11642_/B VPWR VGND sg13cmos5l_o21ai_1
X_14431_ _19151_/D _09995_/Y fanout73/X _14430_/Y VPWR VGND sg13cmos5l_a21oi_1
X_17150_ _19564_/D _17150_/A _17150_/B VPWR VGND sg13cmos5l_and2_1
X_11574_ _11575_/B _18710_/Q _11503_/B _11480_/Y VPWR VGND sg13cmos5l_a21oi_1
XFILLER_7_834 VPWR VGND sg13cmos5l_fill_1
X_16101_ _16101_/Y _16100_/A _16136_/A _16141_/A _16107_/A VPWR VGND sg13cmos5l_a22oi_1
XFILLER_10_340 VPWR VGND sg13cmos5l_fill_1
X_14362_ _14362_/Y _14340_/Y _14349_/X _14374_/A VPWR VGND sg13cmos5l_o21ai_1
X_17081_ _19542_/D _17081_/A _17087_/A VPWR VGND sg13cmos5l_nor2_1
X_13313_ _13313_/Y _13313_/A _13328_/A VPWR VGND sg13cmos5l_nand2_1
X_10525_ _10552_/A _10525_/A _10525_/B VPWR VGND sg13cmos5l_xnor2_1
X_14293_ _14374_/B _14293_/A _14293_/B VPWR VGND sg13cmos5l_and2_1
X_13244_ _13244_/X _13125_/B _13259_/B _13242_/Y VPWR VGND sg13cmos5l_a21o_1
X_10456_ _10609_/A _19794_/Q _10608_/B _10603_/A VPWR VGND sg13cmos5l_a21o_1
X_16032_ _16033_/B _16023_/Y _16030_/Y _16031_/Y VPWR VGND sg13cmos5l_o21ai_1
X_13175_ _13175_/Y _13151_/Y _13168_/Y _13174_/Y VPWR VGND sg13cmos5l_o21ai_1
X_12126_ _12128_/A _12020_/A _12020_/B _12133_/S _12122_/Y _12124_/Y VPWR VGND sg13cmos5l_a221oi_1
X_10387_ _10680_/B _10680_/A _10402_/A VPWR VGND sg13cmos5l_nand2_1
XFILLER_42_8 VPWR VGND sg13cmos5l_decap_4
X_17983_ _17983_/Y _18272_/A _18470_/B VPWR VGND sg13cmos5l_nor2_1
X_16934_ _16934_/Y _16934_/A VPWR VGND sg13cmos5l_inv_1
X_12057_ _12058_/B _12057_/A _12057_/B VPWR VGND sg13cmos5l_xor2_1
X_19722_ _19722_/Q clkload21/A _19722_/D _19722_/RESET_B VPWR VGND sg13cmos5l_dfrbpq_1
XFILLER_77_384 VPWR VGND sg13cmos5l_fill_1
X_16865_ _16865_/Y _17121_/B _16865_/B VPWR VGND sg13cmos5l_nor2_1
X_11008_ _11049_/A _18630_/Q _11022_/B VPWR VGND sg13cmos5l_xnor2_1
XFILLER_38_727 VPWR VGND sg13cmos5l_fill_1
X_19653_ _19653_/Q _19679_/CLK _19653_/D _19653_/RESET_B VPWR VGND sg13cmos5l_dfrbpq_1
XFILLER_92_332 VPWR VGND sg13cmos5l_fill_2
X_18604_ _18604_/Q clkload55/A _18604_/D _18604_/RESET_B VPWR VGND sg13cmos5l_dfrbpq_1
X_15816_ _15816_/Y _15828_/D _15821_/C _15821_/A VPWR VGND sg13cmos5l_a21oi_1
X_16796_ _16796_/Y _16792_/Y _16811_/A _16795_/Y VPWR VGND sg13cmos5l_o21ai_1
X_19584_ _19584_/Q clkload38/A _19584_/D _19584_/RESET_B VPWR VGND sg13cmos5l_dfrbpq_1
XFILLER_18_462 VPWR VGND sg13cmos5l_fill_1
XFILLER_19_985 VPWR VGND sg13cmos5l_decap_8
X_12959_ _12959_/Y _12946_/Y _12952_/X _12958_/Y VPWR VGND sg13cmos5l_o21ai_1
X_18535_ _18535_/Y _19772_/Q fanout89/X _18540_/A VPWR VGND sg13cmos5l_o21ai_1
XFILLER_46_793 VPWR VGND sg13cmos5l_fill_1
XFILLER_45_270 VPWR VGND sg13cmos5l_fill_1
X_15747_ _19351_/D _15747_/A _15747_/B VPWR VGND sg13cmos5l_and2_1
X_18466_ _18466_/Y _18453_/B _18462_/S _18272_/Y VPWR VGND sg13cmos5l_o21ai_1
X_15678_ _15679_/B _15678_/A _15678_/B VPWR VGND sg13cmos5l_nor2_1
X_17417_ _17672_/B _17417_/A _17930_/B VPWR VGND sg13cmos5l_nor2_1
XFILLER_61_796 VPWR VGND sg13cmos5l_fill_1
XFILLER_60_273 VPWR VGND sg13cmos5l_fill_1
X_14629_ _19166_/D _14643_/B _14629_/B VPWR VGND sg13cmos5l_nor2_1
XFILLER_33_476 VPWR VGND sg13cmos5l_fill_1
X_18841__1431 _18841_/RESET_B VPWR VGND sg13cmos5l_tiehi
X_18397_ _18409_/C _18397_/A _18397_/B VPWR VGND sg13cmos5l_xor2_1
X_17348_ _17348_/X _17348_/A _17348_/B VPWR VGND sg13cmos5l_or2_1
X_19277__965 _19277_/RESET_B VPWR VGND sg13cmos5l_tiehi
X_17279_ _17279_/Y _17316_/A _17272_/A _17316_/B _17309_/B VPWR VGND sg13cmos5l_a22oi_1
XFILLER_9_171 VPWR VGND sg13cmos5l_fill_2
X_19018_ _19018_/Q clkload33/A _19018_/D _19018_/RESET_B VPWR VGND sg13cmos5l_dfrbpq_1
Xhold2703 _17006_/A _19533_/Q VPWR VGND sg13cmos5l_dlygate4sd3_1
Xhold2714 _16223_/A _19431_/Q VPWR VGND sg13cmos5l_dlygate4sd3_1
Xhold2747 _12730_/B _12645_/X VPWR VGND sg13cmos5l_dlygate4sd3_1
Xhold2736 _11575_/A _18711_/Q VPWR VGND sg13cmos5l_dlygate4sd3_1
Xhold2725 hold2725/X _15000_/B VPWR VGND sg13cmos5l_dlygate4sd3_1
XFILLER_69_874 VPWR VGND sg13cmos5l_fill_1
Xhold2769 hold2769/X _17664_/Y VPWR VGND sg13cmos5l_dlygate4sd3_1
Xhold2758 _19453_/D _16548_/Y VPWR VGND sg13cmos5l_dlygate4sd3_1
X_19325__911 _19325_/RESET_B VPWR VGND sg13cmos5l_tiehi
X_19401__832 _19401_/RESET_B VPWR VGND sg13cmos5l_tiehi
XFILLER_25_988 VPWR VGND sg13cmos5l_decap_8
X_19538__676 _19538_/RESET_B VPWR VGND sg13cmos5l_tiehi
XFILLER_51_295 VPWR VGND sg13cmos5l_fill_2
X_11290_ _11290_/Y _11452_/A _11290_/B VPWR VGND sg13cmos5l_nand2_1
X_10310_ _11621_/A _11108_/A VPWR VGND sg13cmos5l_inv_1
XFILLER_4_826 VPWR VGND sg13cmos5l_decap_4
X_19332__904 _19332_/RESET_B VPWR VGND sg13cmos5l_tiehi
XFILLER_3_325 VPWR VGND sg13cmos5l_fill_1
X_10241_ _10241_/Y _14392_/A VPWR VGND sg13cmos5l_inv_1
XFILLER_106_776 VPWR VGND sg13cmos5l_decap_8
X_18676__1617 _18676_/RESET_B VPWR VGND sg13cmos5l_tiehi
XFILLER_0_4 VPWR VGND sg13cmos5l_fill_1
XFILLER_106_787 VPWR VGND sg13cmos5l_fill_1
X_10172_ _11352_/A _10945_/C VPWR VGND sg13cmos5l_inv_1
X_14980_ _14982_/B _19203_/Q _19202_/Q _14995_/B VPWR VGND sg13cmos5l_nor3_1
X_19545__669 _19545_/RESET_B VPWR VGND sg13cmos5l_tiehi
Xfanout183 _12602_/B _12583_/Y VPWR VGND sg13cmos5l_buf_1
Xfanout150 _17221_/B _17214_/Y VPWR VGND sg13cmos5l_buf_1
X_13931_ _13931_/Y _19068_/Q _18987_/Q VPWR VGND sg13cmos5l_xnor2_1
Xfanout161 _15721_/B _15608_/B VPWR VGND sg13cmos5l_buf_1
Xfanout172 _14226_/B _14210_/Y VPWR VGND sg13cmos5l_buf_1
Xfanout194 _11231_/B _11215_/Y VPWR VGND sg13cmos5l_buf_1
X_16650_ _16650_/X _16650_/A _16650_/B VPWR VGND sg13cmos5l_or2_1
XFILLER_47_579 VPWR VGND sg13cmos5l_fill_1
XFILLER_47_74 VPWR VGND sg13cmos5l_decap_8
X_13862_ _13862_/Y _10249_/Y _13859_/S _13861_/Y VPWR VGND sg13cmos5l_a21oi_1
XFILLER_34_207 VPWR VGND sg13cmos5l_fill_1
X_13793_ _19038_/D _13801_/A _13793_/B VPWR VGND sg13cmos5l_nor2_1
X_12813_ _12813_/Y _12808_/Y _12809_/Y _12812_/Y VPWR VGND sg13cmos5l_o21ai_1
X_16581_ _16581_/X _16582_/A _16582_/B VPWR VGND sg13cmos5l_or2_1
XFILLER_62_538 VPWR VGND sg13cmos5l_fill_2
X_15601_ _15716_/A _19344_/Q _15608_/B _15600_/Y VPWR VGND sg13cmos5l_a21oi_1
XFILLER_34_229 VPWR VGND sg13cmos5l_decap_8
X_12744_ _12754_/C _18917_/Q _10277_/Y _12743_/Y VPWR VGND sg13cmos5l_o21ai_1
X_15532_ _15532_/X _15544_/A _15578_/A VPWR VGND sg13cmos5l_or2_1
X_18320_ _18320_/X _18316_/X _18318_/Y _18319_/Y VPWR VGND sg13cmos5l_a21o_1
X_18622__1674 _18622_/RESET_B VPWR VGND sg13cmos5l_tiehi
X_18251_ _18251_/Y _18251_/A VPWR VGND sg13cmos5l_inv_1
XFILLER_15_476 VPWR VGND sg13cmos5l_decap_8
X_12675_ _12675_/Y _12675_/A _12697_/B VPWR VGND sg13cmos5l_nor2_1
X_17202_ _19570_/D _17370_/B _17202_/B VPWR VGND sg13cmos5l_nor2_1
X_15463_ _19307_/D _15464_/A _15463_/B VPWR VGND sg13cmos5l_nor2_1
X_11626_ _18717_/D _11629_/A _11626_/B VPWR VGND sg13cmos5l_nor2_1
X_18182_ _18182_/Y _18181_/A _18181_/B _18178_/A VPWR VGND sg13cmos5l_o21ai_1
XFILLER_8_35 VPWR VGND sg13cmos5l_fill_1
X_15394_ _15394_/X _15553_/A _15394_/B VPWR VGND sg13cmos5l_and2_1
X_14414_ _14415_/B _19149_/Q _14412_/Y _14679_/A VPWR VGND sg13cmos5l_o21ai_1
X_11557_ _11557_/Y _11453_/X _11464_/X _11556_/A _11556_/B _11463_/Y VPWR VGND sg13cmos5l_a221oi_1
X_17133_ _19554_/D _17137_/A _17133_/B VPWR VGND sg13cmos5l_nor2_1
XFILLER_8_79 VPWR VGND sg13cmos5l_decap_4
XFILLER_7_642 VPWR VGND sg13cmos5l_fill_1
X_14345_ _14345_/Y _14345_/A _14345_/B VPWR VGND sg13cmos5l_nor2_1
X_17064_ _17064_/X _17064_/A _17064_/B VPWR VGND sg13cmos5l_and2_1
XFILLER_6_141 VPWR VGND sg13cmos5l_fill_2
X_10508_ _10580_/A _10506_/A _10506_/B _10507_/Y VPWR VGND sg13cmos5l_a21oi_1
X_11488_ _11582_/A _18712_/Q _11503_/B VPWR VGND sg13cmos5l_xnor2_1
XFILLER_7_686 VPWR VGND sg13cmos5l_fill_1
X_16015_ _19387_/D _16015_/A _16020_/A VPWR VGND sg13cmos5l_nor2_1
X_14276_ _14291_/B _14303_/A _14310_/B VPWR VGND sg13cmos5l_or2_1
X_10439_ _10442_/B _18667_/Q _18709_/Q _18751_/Q _18793_/Q VPWR VGND sg13cmos5l_nor4_1
X_13227_ _13228_/B _18967_/Q _13232_/B VPWR VGND sg13cmos5l_nor2_1
X_13158_ _13365_/A _18955_/Q _18956_/Q VPWR VGND sg13cmos5l_xnor2_1
X_12109_ _12109_/Y _12109_/A _12109_/B _12109_/C _12109_/D VPWR VGND sg13cmos5l_nand4_1
X_13089_ _13090_/B _18905_/Q _18906_/Q _18907_/Q VPWR VGND sg13cmos5l_o21ai_1
X_17966_ _17966_/Y _19680_/Q _17958_/Y _17965_/Y _19681_/Q VPWR VGND sg13cmos5l_a22oi_1
X_16917_ _16918_/B _16917_/A VPWR VGND sg13cmos5l_inv_1
XFILLER_85_619 VPWR VGND sg13cmos5l_fill_1
X_19705_ _19705_/Q clkload14/A _19705_/D _19705_/RESET_B VPWR VGND sg13cmos5l_dfrbpq_1
X_17897_ _17897_/Y _17897_/A _17897_/B _17897_/C VPWR VGND sg13cmos5l_nand3_1
X_16848_ _16848_/X _16848_/A _16848_/B VPWR VGND sg13cmos5l_and2_1
X_19636_ _19636_/Q clkload26/A _19636_/D _19636_/RESET_B VPWR VGND sg13cmos5l_dfrbpq_1
X_16779_ _16781_/C _16779_/A _16779_/B _16779_/C VPWR VGND sg13cmos5l_nand3_1
XFILLER_92_184 VPWR VGND sg13cmos5l_fill_2
X_19567_ _19567_/Q clkload37/A _19567_/D _19567_/RESET_B VPWR VGND sg13cmos5l_dfrbpq_1
X_18518_ _18518_/Y _19789_/Q _18499_/B _18284_/B _18498_/B VPWR VGND sg13cmos5l_a22oi_1
X_18765__522 _18765_/D VPWR VGND sg13cmos5l_tielo
X_19498_ _19498_/Q clkload32/A _19498_/D _19498_/RESET_B VPWR VGND sg13cmos5l_dfrbpq_1
XFILLER_22_925 VPWR VGND sg13cmos5l_fill_2
XFILLER_22_958 VPWR VGND sg13cmos5l_decap_8
X_18449_ _18456_/A _18449_/A _18483_/B VPWR VGND sg13cmos5l_nor2b_1
X_18805__1470 _18805_/RESET_B VPWR VGND sg13cmos5l_tiehi
XFILLER_103_768 VPWR VGND sg13cmos5l_fill_2
Xhold2500 _10275_/A _18850_/Q VPWR VGND sg13cmos5l_dlygate4sd3_1
Xhold2522 _17217_/A _19586_/Q VPWR VGND sg13cmos5l_dlygate4sd3_1
Xhold2511 _10263_/A _18934_/Q VPWR VGND sg13cmos5l_dlygate4sd3_1
Xhold2555 hold2555/X _12706_/A VPWR VGND sg13cmos5l_dlygate4sd3_1
Xhold2533 _10306_/A _18640_/Q VPWR VGND sg13cmos5l_dlygate4sd3_1
XFILLER_69_660 VPWR VGND sg13cmos5l_decap_8
X_19175__1073 _19175_/RESET_B VPWR VGND sg13cmos5l_tiehi
Xhold2544 _10250_/A _19060_/Q VPWR VGND sg13cmos5l_dlygate4sd3_1
XFILLER_102_289 VPWR VGND sg13cmos5l_fill_2
Xhold2588 _12602_/A _18878_/Q VPWR VGND sg13cmos5l_dlygate4sd3_1
Xhold1832 _11151_/B _18608_/Q VPWR VGND sg13cmos5l_dlygate4sd3_1
Xhold1843 _18540_/B _19733_/Q VPWR VGND sg13cmos5l_dlygate4sd3_1
Xhold2577 hold2577/X _14028_/A VPWR VGND sg13cmos5l_dlygate4sd3_1
Xhold2566 hold2566/X _14782_/Y VPWR VGND sg13cmos5l_dlygate4sd3_1
Xhold1821 _16082_/B _19365_/Q VPWR VGND sg13cmos5l_dlygate4sd3_1
Xhold1854 _14437_/B _19113_/Q VPWR VGND sg13cmos5l_dlygate4sd3_1
XFILLER_83_151 VPWR VGND sg13cmos5l_fill_2
Xhold2599 _10311_/A _18600_/Q VPWR VGND sg13cmos5l_dlygate4sd3_1
Xhold1865 _17739_/B _19608_/Q VPWR VGND sg13cmos5l_dlygate4sd3_1
Xhold1887 _15808_/B _19322_/Q VPWR VGND sg13cmos5l_dlygate4sd3_1
Xhold1876 _15256_/B _19239_/Q VPWR VGND sg13cmos5l_dlygate4sd3_1
Xhold1898 _17152_/B _19524_/Q VPWR VGND sg13cmos5l_dlygate4sd3_1
X_10790_ _10810_/B hold2590/X _10784_/Y _13700_/A _10784_/B VPWR VGND sg13cmos5l_a22oi_1
XFILLER_24_240 VPWR VGND sg13cmos5l_fill_2
X_12460_ _18840_/D _12460_/A _12460_/B VPWR VGND sg13cmos5l_nor2_1
XFILLER_8_406 VPWR VGND sg13cmos5l_fill_2
XFILLER_8_417 VPWR VGND sg13cmos5l_decap_4
X_12391_ _12403_/A _12391_/A _12391_/B VPWR VGND sg13cmos5l_nor2_1
X_11411_ _11411_/Y _11655_/A _11412_/S _11410_/Y VPWR VGND sg13cmos5l_a21oi_1
XFILLER_40_799 VPWR VGND sg13cmos5l_fill_2
X_11342_ _11343_/B _11321_/B _11317_/A _11342_/S VPWR VGND sg13cmos5l_mux2_1
X_14130_ _14130_/Y _10241_/Y _14131_/S _14129_/Y VPWR VGND sg13cmos5l_a21oi_1
XFILLER_106_540 VPWR VGND sg13cmos5l_fill_2
X_11273_ _11274_/B _11273_/A _11273_/B VPWR VGND sg13cmos5l_xor2_1
X_14061_ _14061_/Y hold2577/X _14057_/Y _14060_/Y VPWR VGND sg13cmos5l_a21oi_1
XFILLER_4_645 VPWR VGND sg13cmos5l_fill_2
X_13012_ _18916_/D _13027_/A _13012_/B _13012_/C VPWR VGND sg13cmos5l_nor3_1
XFILLER_4_689 VPWR VGND sg13cmos5l_fill_1
X_10224_ _10224_/Y _15210_/A VPWR VGND sg13cmos5l_inv_1
XFILLER_95_906 VPWR VGND sg13cmos5l_fill_2
X_10155_ _17371_/A _10155_/A VPWR VGND sg13cmos5l_inv_1
XFILLER_58_40 VPWR VGND sg13cmos5l_decap_8
X_17820_ _18032_/A _19663_/Q _17821_/B VPWR VGND sg13cmos5l_xnor2_1
XFILLER_94_438 VPWR VGND sg13cmos5l_fill_2
X_17751_ _17751_/X _17751_/A _17751_/B VPWR VGND sg13cmos5l_or2_1
XFILLER_48_822 VPWR VGND sg13cmos5l_fill_2
Xclkbuf_leaf_86_clk clkload18/A clkbuf_4_2_0_clk/X VPWR VGND sg13cmos5l_buf_8
X_19267__975 _19267_/RESET_B VPWR VGND sg13cmos5l_tiehi
X_14963_ _14963_/Y _15196_/B _14955_/Y _14962_/Y VPWR VGND sg13cmos5l_a21oi_1
X_10086_ _14369_/A _13849_/A VPWR VGND sg13cmos5l_inv_1
X_16702_ _16742_/A _19505_/Q _19506_/Q _19507_/Q VPWR VGND sg13cmos5l_or3_1
X_13914_ _13916_/B _13495_/Y _13924_/S _13913_/Y VPWR VGND sg13cmos5l_o21ai_1
X_17682_ _17682_/Y _19661_/Q _17702_/A _17402_/A _19660_/Q _17681_/Y VPWR VGND sg13cmos5l_a221oi_1
X_14894_ _19207_/D hold2685/X _14895_/S _14893_/Y VPWR VGND sg13cmos5l_a21oi_1
XFILLER_35_505 VPWR VGND sg13cmos5l_decap_8
X_16633_ _16633_/Y _19034_/Q _16641_/B VPWR VGND sg13cmos5l_xnor2_1
XFILLER_74_61 VPWR VGND sg13cmos5l_fill_1
X_19421_ _19421_/Q clkload5/A _19421_/D _19421_/RESET_B VPWR VGND sg13cmos5l_dfrbpq_1
X_13845_ _13847_/B _14108_/A _13845_/B VPWR VGND sg13cmos5l_nor2_1
XFILLER_35_516 VPWR VGND sg13cmos5l_fill_2
X_19352_ _19352_/Q clkload17/A _19352_/D _19352_/RESET_B VPWR VGND sg13cmos5l_dfrbpq_1
X_13776_ _13776_/Y _13770_/Y _13772_/Y _13775_/Y VPWR VGND sg13cmos5l_o21ai_1
X_16564_ _16564_/Y _19492_/Q _16564_/B VPWR VGND sg13cmos5l_nand2_1
XFILLER_90_699 VPWR VGND sg13cmos5l_fill_2
X_10988_ _10988_/Y _11028_/A _11089_/B VPWR VGND sg13cmos5l_nor2_1
X_18303_ _18309_/C _19693_/Q _19694_/Q hold3044/X VPWR VGND sg13cmos5l_o21ai_1
X_12727_ _18882_/D _12727_/A _12728_/B VPWR VGND sg13cmos5l_nor2_1
X_19283_ _19283_/Q clkload43/A _19283_/D _19283_/RESET_B VPWR VGND sg13cmos5l_dfrbpq_1
X_15515_ _19315_/D _15586_/A _15515_/B VPWR VGND sg13cmos5l_nor2_1
X_16495_ _16524_/C _16494_/A _16494_/B _16516_/A VPWR VGND sg13cmos5l_o21ai_1
X_12658_ _12658_/X _12658_/A _12658_/B _12658_/C VPWR VGND sg13cmos5l_and3_1
X_18234_ _18234_/Y _19681_/Q _18236_/A VPWR VGND sg13cmos5l_nand2b_1
X_15446_ _19292_/D _15420_/A _15447_/S _15445_/Y VPWR VGND sg13cmos5l_a21oi_1
X_11609_ _11610_/B _11585_/X _11593_/B _11614_/B VPWR VGND sg13cmos5l_mux2_1
X_18165_ _18166_/A _18195_/A _18232_/B _18164_/Y _18066_/Y VPWR VGND sg13cmos5l_a22oi_1
X_12589_ _12688_/A _18880_/Q _12602_/B VPWR VGND sg13cmos5l_xnor2_1
X_17116_ _17116_/Y _17116_/A _19518_/Q VPWR VGND sg13cmos5l_nor2_1
Xclkbuf_leaf_10_clk clkload20/A clkload0/A VPWR VGND sg13cmos5l_buf_8
X_15377_ _15377_/Y _15283_/X _15284_/X _15376_/A _15376_/B _15285_/Y VPWR VGND sg13cmos5l_a221oi_1
XFILLER_8_962 VPWR VGND sg13cmos5l_decap_4
X_19274__968 _19274_/RESET_B VPWR VGND sg13cmos5l_tiehi
X_14328_ _14328_/Y _14328_/A _14328_/B VPWR VGND sg13cmos5l_nor2_1
X_18096_ _18098_/B _19719_/Q _18108_/B VPWR VGND sg13cmos5l_nor2b_1
X_17047_ _17049_/B _16931_/B _17088_/B _17047_/S VPWR VGND sg13cmos5l_mux2_1
X_14259_ _14261_/B _14297_/B _14243_/X _14303_/B _14304_/A VPWR VGND sg13cmos5l_a22oi_1
XFILLER_98_722 VPWR VGND sg13cmos5l_fill_1
X_19130__1121 _19130_/RESET_B VPWR VGND sg13cmos5l_tiehi
XFILLER_98_777 VPWR VGND sg13cmos5l_fill_1
X_18998_ _18998_/Q clkload53/A _18998_/D _18998_/RESET_B VPWR VGND sg13cmos5l_dfrbpq_1
X_19528__686 _19528_/RESET_B VPWR VGND sg13cmos5l_tiehi
X_17949_ _17949_/Y _18474_/A _19641_/Q _19642_/Q _18475_/A _17948_/Y VPWR VGND sg13cmos5l_a221oi_1
Xclkbuf_leaf_77_clk _19805_/CLK clkbuf_4_9_0_clk/X VPWR VGND sg13cmos5l_buf_8
XFILLER_54_814 VPWR VGND sg13cmos5l_fill_2
XFILLER_81_622 VPWR VGND sg13cmos5l_fill_1
X_19619_ _19619_/Q clkload25/A _19619_/D _19619_/RESET_B VPWR VGND sg13cmos5l_dfrbpq_1
XFILLER_26_538 VPWR VGND sg13cmos5l_fill_1
XFILLER_0_80 VPWR VGND sg13cmos5l_fill_2
X_19322__914 _19322_/RESET_B VPWR VGND sg13cmos5l_tiehi
XFILLER_34_560 VPWR VGND sg13cmos5l_fill_1
X_19535__679 _19535_/RESET_B VPWR VGND sg13cmos5l_tiehi
XFILLER_5_409 VPWR VGND sg13cmos5l_fill_2
Xhold3031 _10147_/A _16722_/A VPWR VGND sg13cmos5l_dlygate4sd3_1
XFILLER_62_1006 VPWR VGND sg13cmos5l_fill_1
Xhold3042 _14800_/A _19223_/Q VPWR VGND sg13cmos5l_dlygate4sd3_1
Xhold3020 _18306_/B _19694_/Q VPWR VGND sg13cmos5l_dlygate4sd3_1
XFILLER_76_405 VPWR VGND sg13cmos5l_fill_2
Xhold3064 _17111_/A _19575_/Q VPWR VGND sg13cmos5l_dlygate4sd3_1
XFILLER_62_1028 VPWR VGND sg13cmos5l_fill_1
X_09998_ _09998_/Y _09998_/A VPWR VGND sg13cmos5l_inv_1
XFILLER_0_158 VPWR VGND sg13cmos5l_fill_1
Xhold2330 _10134_/A _19418_/Q VPWR VGND sg13cmos5l_dlygate4sd3_1
Xhold3053 _15320_/C _19299_/Q VPWR VGND sg13cmos5l_dlygate4sd3_1
Xhold2363 _14071_/A _18996_/Q VPWR VGND sg13cmos5l_dlygate4sd3_1
Xhold2341 _10325_/A _19725_/Q VPWR VGND sg13cmos5l_dlygate4sd3_1
Xhold2352 _10177_/A _19663_/Q VPWR VGND sg13cmos5l_dlygate4sd3_1
Xhold2385 _11414_/B _18687_/Q VPWR VGND sg13cmos5l_dlygate4sd3_1
XFILLER_85_972 VPWR VGND sg13cmos5l_decap_8
X_11960_ _11960_/Y hold1980/X fanout79/X _12188_/A VPWR VGND sg13cmos5l_o21ai_1
Xhold2396 _10384_/B _18567_/Q VPWR VGND sg13cmos5l_dlygate4sd3_1
XFILLER_57_663 VPWR VGND sg13cmos5l_fill_2
Xclkbuf_leaf_68_clk _19227_/CLK clkbuf_4_10_0_clk/X VPWR VGND sg13cmos5l_buf_8
Xhold2374 hold2374/X _14968_/Y VPWR VGND sg13cmos5l_dlygate4sd3_1
X_18966__1297 _18966_/RESET_B VPWR VGND sg13cmos5l_tiehi
X_10911_ _10911_/X _10908_/Y _10559_/Y _10929_/S VPWR VGND sg13cmos5l_mux2_1
X_11891_ _18749_/D _11891_/A _11891_/B VPWR VGND sg13cmos5l_nor2_1
XFILLER_71_132 VPWR VGND sg13cmos5l_fill_2
XFILLER_44_357 VPWR VGND sg13cmos5l_fill_1
X_19442__784 _19442_/RESET_B VPWR VGND sg13cmos5l_tiehi
X_13630_ _13630_/Y _13602_/A _13632_/S _13817_/A VPWR VGND sg13cmos5l_o21ai_1
X_10842_ _10842_/Y _18599_/Q _10837_/Y _10841_/Y VPWR VGND sg13cmos5l_a21oi_1
X_10773_ _10775_/A _10773_/A _10773_/B VPWR VGND sg13cmos5l_xor2_1
X_13561_ _13561_/Y _13537_/X fanout47/X _13569_/B1 VPWR VGND sg13cmos5l_o21ai_1
XFILLER_12_221 VPWR VGND sg13cmos5l_fill_1
X_12512_ _18851_/D _10274_/Y _12509_/S _12511_/Y VPWR VGND sg13cmos5l_a21oi_1
X_15300_ _15392_/A _15283_/X _15299_/Y _15298_/Y VPWR VGND sg13cmos5l_a21oi_1
X_16280_ _16280_/Y _16280_/A _16280_/B _16280_/C VPWR VGND sg13cmos5l_nand3_1
X_13492_ _13503_/C _19017_/Q _13493_/B VPWR VGND sg13cmos5l_xnor2_1
X_15231_ _15233_/A _10221_/A _15228_/Y _15230_/Y _19275_/Q _15229_/Y VPWR VGND sg13cmos5l_a221oi_1
X_12443_ _18828_/D _12452_/A _12443_/B VPWR VGND sg13cmos5l_nor2_1
XFILLER_100_92 VPWR VGND sg13cmos5l_fill_1
X_12374_ _12374_/Y _12374_/A _12468_/B VPWR VGND sg13cmos5l_nor2_1
X_15162_ _15179_/A _15162_/A _15162_/B VPWR VGND sg13cmos5l_nor2_1
X_11325_ _11325_/Y _11325_/A _11325_/B VPWR VGND sg13cmos5l_nand2_1
XFILLER_5_954 VPWR VGND sg13cmos5l_decap_8
X_15093_ _15093_/Y _15093_/A _15093_/B VPWR VGND sg13cmos5l_nor2_1
X_14113_ _14113_/Y _10241_/Y _14097_/Y _14112_/Y VPWR VGND sg13cmos5l_o21ai_1
X_18921_ _18921_/Q clkload68/A _18921_/D _18921_/RESET_B VPWR VGND sg13cmos5l_dfrbpq_1
XFILLER_69_50 VPWR VGND sg13cmos5l_fill_1
X_11256_ _11256_/X _18660_/Q _18675_/Q VPWR VGND sg13cmos5l_and2_1
X_14044_ _14054_/A _13942_/Y _14052_/A _14044_/C VPWR VGND sg13cmos5l_nand3b_1
XFILLER_106_370 VPWR VGND sg13cmos5l_decap_8
X_18899__1370 _18899_/RESET_B VPWR VGND sg13cmos5l_tiehi
X_18852_ _18852_/Q clkload63/A _18852_/D _18852_/RESET_B VPWR VGND sg13cmos5l_dfrbpq_1
X_11187_ _11188_/B _11204_/B _11204_/C _11186_/Y VPWR VGND sg13cmos5l_a21oi_1
X_10207_ _16042_/A _10207_/A VPWR VGND sg13cmos5l_inv_1
X_18783_ _18783_/Q clkload61/A _18783_/D _18783_/RESET_B VPWR VGND sg13cmos5l_dfrbpq_1
X_17803_ _17910_/B _19671_/Q _17803_/B VPWR VGND sg13cmos5l_and2_1
XFILLER_48_630 VPWR VGND sg13cmos5l_fill_1
XFILLER_0_681 VPWR VGND sg13cmos5l_fill_2
X_15995_ _15995_/X _15995_/A _15995_/B VPWR VGND sg13cmos5l_and2_1
X_10138_ _16400_/A _19452_/Q VPWR VGND sg13cmos5l_inv_1
X_10069_ _13575_/A _10069_/A VPWR VGND sg13cmos5l_inv_1
X_17734_ _19646_/D _09971_/Y fanout70/X _17733_/Y VPWR VGND sg13cmos5l_a21oi_1
XFILLER_48_652 VPWR VGND sg13cmos5l_decap_8
XFILLER_48_641 VPWR VGND sg13cmos5l_fill_2
Xclkbuf_leaf_59_clk clkload47/A clkbuf_4_9_0_clk/X VPWR VGND sg13cmos5l_buf_8
X_14946_ _14946_/Y _14946_/A _14946_/B _14946_/C VPWR VGND sg13cmos5l_nor3_1
XFILLER_78_1024 VPWR VGND sg13cmos5l_decap_4
X_17665_ _19621_/D _17649_/A hold2769/X _17679_/A VPWR VGND sg13cmos5l_a21oi_1
XFILLER_47_184 VPWR VGND sg13cmos5l_fill_1
X_14877_ _14877_/Y _14877_/A _14877_/B VPWR VGND sg13cmos5l_nand2_1
XFILLER_36_869 VPWR VGND sg13cmos5l_fill_2
X_16616_ _16616_/Y _19025_/Q fanout68/X _16889_/A VPWR VGND sg13cmos5l_o21ai_1
X_17596_ _17676_/B _17596_/A _17597_/B VPWR VGND sg13cmos5l_nor2b_1
X_13828_ _13833_/B _19085_/Q _10258_/Y _13827_/Y VPWR VGND sg13cmos5l_o21ai_1
X_19404_ _19404_/Q _19738_/CLK _19404_/D _19404_/RESET_B VPWR VGND sg13cmos5l_dfrbpq_1
X_13759_ _13759_/Y _13759_/A VPWR VGND sg13cmos5l_inv_1
X_19335_ _19335_/Q clkload16/A _19335_/D _19335_/RESET_B VPWR VGND sg13cmos5l_dfrbpq_1
X_19148__1103 _19148_/RESET_B VPWR VGND sg13cmos5l_tiehi
X_16547_ _16547_/Y _16533_/A fanout32/X _16553_/B VPWR VGND sg13cmos5l_o21ai_1
X_19266_ _19266_/Q _19304_/CLK _19266_/D _19266_/RESET_B VPWR VGND sg13cmos5l_dfrbpq_1
X_18671__1622 _18671_/RESET_B VPWR VGND sg13cmos5l_tiehi
X_18217_ _18217_/Y hold2887/X _18207_/Y _18216_/Y VPWR VGND sg13cmos5l_a21oi_1
X_16478_ _16478_/Y _16562_/B _16476_/Y _16477_/Y VPWR VGND sg13cmos5l_a21oi_1
X_15429_ _15436_/B _15398_/A _15428_/B _15428_/Y VPWR VGND sg13cmos5l_o21ai_1
X_19197_ _19197_/Q _19302_/CLK _19197_/D _19197_/RESET_B VPWR VGND sg13cmos5l_dfrbpq_1
XFILLER_8_770 VPWR VGND sg13cmos5l_fill_2
X_18148_ _18148_/X _18154_/B1 _18146_/Y _18145_/Y VPWR VGND sg13cmos5l_a21o_1
X_18079_ _18092_/A _19710_/Q _18091_/B _18078_/Y VPWR VGND sg13cmos5l_a21o_1
XFILLER_98_530 VPWR VGND sg13cmos5l_decap_8
XFILLER_98_563 VPWR VGND sg13cmos5l_fill_1
XFILLER_59_939 VPWR VGND sg13cmos5l_fill_1
XFILLER_100_535 VPWR VGND sg13cmos5l_decap_8
XFILLER_100_524 VPWR VGND sg13cmos5l_fill_1
X_18921__1345 _18921_/RESET_B VPWR VGND sg13cmos5l_tiehi
X_19742__1050 _19742_/RESET_B VPWR VGND sg13cmos5l_tiehi
XFILLER_39_641 VPWR VGND sg13cmos5l_fill_1
XFILLER_82_931 VPWR VGND sg13cmos5l_fill_1
XFILLER_82_964 VPWR VGND sg13cmos5l_decap_8
XFILLER_82_986 VPWR VGND sg13cmos5l_fill_1
XFILLER_54_688 VPWR VGND sg13cmos5l_decap_4
XFILLER_5_228 VPWR VGND sg13cmos5l_decap_4
XFILLER_5_217 VPWR VGND sg13cmos5l_decap_8
X_19257__985 _19257_/RESET_B VPWR VGND sg13cmos5l_tiehi
X_19711__1547 _19711_/RESET_B VPWR VGND sg13cmos5l_tiehi
X_11110_ _11110_/Y _11110_/A _18604_/Q VPWR VGND sg13cmos5l_nor2_1
XFILLER_30_66 VPWR VGND sg13cmos5l_fill_2
XFILLER_30_77 VPWR VGND sg13cmos5l_fill_2
X_12090_ _12137_/A _12461_/A _12090_/B VPWR VGND sg13cmos5l_xnor2_1
XFILLER_103_351 VPWR VGND sg13cmos5l_fill_1
X_11041_ _11041_/Y _11002_/X _11040_/Y _11038_/Y VPWR VGND sg13cmos5l_o21ai_1
XFILLER_7_1017 VPWR VGND sg13cmos5l_fill_2
XFILLER_2_968 VPWR VGND sg13cmos5l_fill_2
XFILLER_103_395 VPWR VGND sg13cmos5l_fill_1
XFILLER_7_1028 VPWR VGND sg13cmos5l_fill_1
Xhold2171 _18855_/D _12520_/Y VPWR VGND sg13cmos5l_dlygate4sd3_1
XFILLER_76_257 VPWR VGND sg13cmos5l_fill_2
Xhold2160 _18977_/D _13342_/Y VPWR VGND sg13cmos5l_dlygate4sd3_1
X_14800_ _14833_/A _14800_/A _14800_/B VPWR VGND sg13cmos5l_xor2_1
Xhold2182 _16038_/A _19355_/Q VPWR VGND sg13cmos5l_dlygate4sd3_1
X_12992_ _12993_/B _12992_/A _12992_/B VPWR VGND sg13cmos5l_xnor2_1
X_15780_ _15780_/Y _16312_/A _19380_/Q VPWR VGND sg13cmos5l_nor2_1
Xhold2193 _19398_/D _16068_/Y VPWR VGND sg13cmos5l_dlygate4sd3_1
XFILLER_29_140 VPWR VGND sg13cmos5l_fill_1
X_11943_ _11945_/A _11936_/Y _11940_/Y _11942_/Y _11958_/B _11941_/Y VPWR VGND sg13cmos5l_a221oi_1
X_14731_ _14731_/Y _14731_/A _14757_/A VPWR VGND sg13cmos5l_nor2_1
X_19264__978 _19264_/RESET_B VPWR VGND sg13cmos5l_tiehi
XFILLER_29_195 VPWR VGND sg13cmos5l_fill_1
X_11874_ _11878_/B _11874_/A _11874_/B VPWR VGND sg13cmos5l_and2_1
XFILLER_73_986 VPWR VGND sg13cmos5l_decap_4
X_17450_ _17450_/Y _17490_/A _17450_/B VPWR VGND sg13cmos5l_nand2b_1
X_14662_ _14662_/Y _19208_/Q _15188_/A _14680_/C VPWR VGND sg13cmos5l_nand3_1
X_13613_ _13613_/Y _13613_/A VPWR VGND sg13cmos5l_inv_1
X_17381_ _17382_/B _17933_/A _19556_/Q _19555_/Q _17932_/A VPWR VGND sg13cmos5l_a22oi_1
X_10825_ _10825_/Y _11355_/A _19768_/Q _10824_/Y VPWR VGND sg13cmos5l_o21ai_1
XFILLER_45_699 VPWR VGND sg13cmos5l_decap_4
X_16401_ _16403_/B _16401_/A _16467_/A VPWR VGND sg13cmos5l_nor2_1
XFILLER_32_338 VPWR VGND sg13cmos5l_decap_4
X_16332_ _16332_/Y _16332_/A _19454_/Q _16350_/C VPWR VGND sg13cmos5l_nor3_1
X_19120_ _19120_/Q clkload50/A _19120_/D _19120_/RESET_B VPWR VGND sg13cmos5l_dfrbpq_1
X_14593_ _14594_/B _14593_/A _14593_/B VPWR VGND sg13cmos5l_xor2_1
Xheichips26_digital_project uio_out[3] VPWR VGND sg13cmos5l_tielo
X_10756_ _10784_/A _18597_/Q _10756_/B VPWR VGND sg13cmos5l_xor2_1
X_13544_ _13544_/Y _13544_/A _13544_/B _13544_/C VPWR VGND sg13cmos5l_nor3_1
X_19051_ _19051_/Q clkload29/A _19051_/D _19051_/RESET_B VPWR VGND sg13cmos5l_dfrbpq_1
X_10687_ _10688_/B _18567_/Q _18566_/Q _19811_/Q VPWR VGND sg13cmos5l_o21ai_1
X_13475_ _13475_/X _19015_/Q _13475_/B VPWR VGND sg13cmos5l_xor2_1
X_16263_ _16263_/Y _16318_/B _16282_/B VPWR VGND sg13cmos5l_nor2_1
X_12426_ _12426_/Y _12424_/Y _12425_/Y _12408_/Y VPWR VGND sg13cmos5l_a21oi_1
X_18797__1478 _18797_/RESET_B VPWR VGND sg13cmos5l_tiehi
X_18002_ _18002_/Y _09970_/Y fanout85/X _18001_/Y VPWR VGND sg13cmos5l_a21oi_1
X_16194_ _16432_/A _16554_/A _16194_/B VPWR VGND sg13cmos5l_xnor2_1
X_15214_ _15214_/X _15486_/A _15238_/A VPWR VGND sg13cmos5l_and2_1
X_15145_ _15145_/Y _15147_/B _15054_/Y _15189_/B _15131_/X _15142_/Y VPWR VGND sg13cmos5l_a221oi_1
X_12357_ _12465_/B _12320_/X _12356_/Y _12368_/B VPWR VGND sg13cmos5l_mux2_1
X_12288_ _12288_/Y _12299_/B _12295_/C VPWR VGND sg13cmos5l_nand2_1
X_11308_ _11309_/B _18669_/Q _11308_/B VPWR VGND sg13cmos5l_xor2_1
X_15076_ _15089_/B _19251_/Q _19252_/Q _19249_/Q _19250_/Q VPWR VGND sg13cmos5l_nor4_1
X_18904_ _18904_/Q clkload67/A _18904_/D _18904_/RESET_B VPWR VGND sg13cmos5l_dfrbpq_1
X_11239_ _11262_/B _18662_/Q _11437_/A VPWR VGND sg13cmos5l_nor2_1
X_14027_ _14028_/A _14052_/A _14027_/B VPWR VGND sg13cmos5l_nand2_1
X_18835_ _18835_/Q _18902_/CLK _18835_/D _18835_/RESET_B VPWR VGND sg13cmos5l_dfrbpq_1
X_18702__1588 _18702_/RESET_B VPWR VGND sg13cmos5l_tiehi
X_18766_ _18766_/Q clkload62/A _18766_/D _18766_/RESET_B VPWR VGND sg13cmos5l_dfrbpq_1
X_19525__689 _19525_/RESET_B VPWR VGND sg13cmos5l_tiehi
X_18689__1604 _18689_/RESET_B VPWR VGND sg13cmos5l_tiehi
X_15978_ _15980_/B _15855_/B _16019_/B _15984_/B VPWR VGND sg13cmos5l_mux2_1
X_18697_ _18697_/Q clkload57/A _18697_/D _18697_/RESET_B VPWR VGND sg13cmos5l_dfrbpq_1
X_17717_ _17717_/Y _18272_/A _18220_/B VPWR VGND sg13cmos5l_nor2_1
X_14929_ _14948_/C _14932_/C _14929_/B VPWR VGND sg13cmos5l_and2_1
X_17648_ _17664_/C _17636_/Y _17641_/X _17647_/Y VPWR VGND sg13cmos5l_o21ai_1
XFILLER_36_688 VPWR VGND sg13cmos5l_fill_1
X_19495__722 _19495_/RESET_B VPWR VGND sg13cmos5l_tiehi
XFILLER_91_0 VPWR VGND sg13cmos5l_fill_1
X_17579_ _17579_/X _17607_/B _17613_/B VPWR VGND sg13cmos5l_or2_1
X_19318_ _19318_/Q clkload7/A _19318_/D _19318_/RESET_B VPWR VGND sg13cmos5l_dfrbpq_1
X_19249_ _19249_/Q _19304_/CLK _19249_/D _19249_/RESET_B VPWR VGND sg13cmos5l_dfrbpq_1
X_18939__1327 _18939_/RESET_B VPWR VGND sg13cmos5l_tiehi
X_18635__1661 _18635_/RESET_B VPWR VGND sg13cmos5l_tiehi
XFILLER_101_899 VPWR VGND sg13cmos5l_decap_8
XFILLER_101_888 VPWR VGND sg13cmos5l_fill_2
XFILLER_100_387 VPWR VGND sg13cmos5l_fill_2
XFILLER_73_205 VPWR VGND sg13cmos5l_fill_1
X_11590_ _11611_/A _11596_/B _11590_/B VPWR VGND sg13cmos5l_nor2_1
X_10610_ _10611_/A _10610_/A _10610_/B VPWR VGND sg13cmos5l_or2_1
XFILLER_23_894 VPWR VGND sg13cmos5l_fill_1
X_18752__1526 _18752_/RESET_B VPWR VGND sg13cmos5l_tiehi
X_10541_ _10898_/A _18514_/B _10541_/B VPWR VGND sg13cmos5l_xnor2_1
X_13260_ _13267_/B _13296_/B _13259_/B _13259_/Y VPWR VGND sg13cmos5l_o21ai_1
XFILLER_6_504 VPWR VGND sg13cmos5l_fill_1
X_12211_ _12212_/B _12729_/A _18772_/Q VPWR VGND sg13cmos5l_nand2_1
X_10472_ _10579_/A _19748_/Q _10473_/B VPWR VGND sg13cmos5l_xnor2_1
X_13191_ _13294_/B _13199_/S _13407_/A _13189_/Y VPWR VGND sg13cmos5l_a21oi_1
X_12142_ _12162_/B _12140_/A _12167_/A _12141_/Y _12135_/Y VPWR VGND sg13cmos5l_a22oi_1
X_12073_ _12073_/Y _12457_/A _12112_/A _12072_/Y _12070_/X VPWR VGND sg13cmos5l_a22oi_1
XFILLER_96_308 VPWR VGND sg13cmos5l_fill_1
X_16950_ _17051_/B _16966_/A _16966_/B VPWR VGND sg13cmos5l_nand2_1
X_19726__1322 _19726_/RESET_B VPWR VGND sg13cmos5l_tiehi
XFILLER_89_371 VPWR VGND sg13cmos5l_fill_2
X_11024_ _11058_/A _11007_/A _11022_/B _11023_/Y VPWR VGND sg13cmos5l_a21oi_1
X_15901_ _15901_/Y _15898_/Y _15899_/Y _15900_/Y _15912_/C VPWR VGND sg13cmos5l_a22oi_1
XFILLER_106_80 VPWR VGND sg13cmos5l_fill_2
X_16881_ _16881_/Y _17110_/B _16881_/B VPWR VGND sg13cmos5l_nand2_1
X_18620_ _18620_/Q clkload45/A _18620_/D _18620_/RESET_B VPWR VGND sg13cmos5l_dfrbpq_1
XFILLER_46_920 VPWR VGND sg13cmos5l_decap_4
X_15832_ _15832_/Y _15834_/A _15834_/B _15831_/Y VPWR VGND sg13cmos5l_a21oi_1
X_12975_ _12976_/B _12869_/B _12975_/B VPWR VGND sg13cmos5l_nand2b_1
XFILLER_45_430 VPWR VGND sg13cmos5l_fill_2
X_18551_ _18551_/Y _10606_/A _10633_/A _10646_/B VPWR VGND sg13cmos5l_o21ai_1
X_15763_ _15763_/Y _15763_/A VPWR VGND sg13cmos5l_inv_1
X_11926_ _11926_/Y _11926_/A _18730_/Q VPWR VGND sg13cmos5l_nor2_1
X_19479__739 _19479_/RESET_B VPWR VGND sg13cmos5l_tiehi
X_17502_ _19614_/D _17671_/B _17502_/B VPWR VGND sg13cmos5l_nor2_1
X_14714_ _14754_/A _19161_/Q _14715_/B VPWR VGND sg13cmos5l_xnor2_1
X_18482_ _19761_/D _18482_/A _18482_/B VPWR VGND sg13cmos5l_and2_1
XFILLER_72_282 VPWR VGND sg13cmos5l_fill_2
X_17433_ _17433_/Y _19604_/Q fanout88/X _17439_/A VPWR VGND sg13cmos5l_o21ai_1
X_15694_ _15694_/Y _15694_/A VPWR VGND sg13cmos5l_inv_1
X_19188__1060 _19188_/RESET_B VPWR VGND sg13cmos5l_tiehi
X_11857_ _11857_/Y _11770_/X _11856_/A _11854_/Y VPWR VGND sg13cmos5l_o21ai_1
X_14645_ _19180_/D _14649_/A _14645_/B VPWR VGND sg13cmos5l_and2_1
XFILLER_32_146 VPWR VGND sg13cmos5l_decap_8
X_11788_ _11826_/A _18747_/Q _11789_/B VPWR VGND sg13cmos5l_xnor2_1
X_10808_ _10809_/B _10810_/B _10808_/B VPWR VGND sg13cmos5l_nand2_1
X_17364_ _19581_/D _18540_/A _17364_/B VPWR VGND sg13cmos5l_and2_1
X_14576_ _14576_/Y _14566_/X _14571_/Y _14647_/B _14589_/A _14575_/Y VPWR VGND sg13cmos5l_a221oi_1
X_10739_ _10739_/X _10739_/A _10739_/B VPWR VGND sg13cmos5l_or2_1
X_17295_ _17295_/Y _17296_/C _17296_/D VPWR VGND sg13cmos5l_nand2_1
X_13527_ _13527_/Y _13527_/A _13586_/B VPWR VGND sg13cmos5l_nor2_1
X_16315_ _19431_/D _16226_/C _16226_/D _16320_/A VPWR VGND sg13cmos5l_a21oi_1
XFILLER_13_382 VPWR VGND sg13cmos5l_fill_2
X_19103_ _19103_/Q _19220_/CLK _19103_/D _19103_/RESET_B VPWR VGND sg13cmos5l_dfrbpq_1
X_19034_ _19034_/Q clkload31/A _19034_/D _19034_/RESET_B VPWR VGND sg13cmos5l_dfrbpq_1
X_16246_ _16247_/B _16138_/A _16138_/B _16252_/S _16244_/Y _16243_/Y VPWR VGND sg13cmos5l_a221oi_1
X_13458_ _13507_/A _13467_/B _13465_/B VPWR VGND sg13cmos5l_and2_1
X_12409_ _12410_/B _18836_/Q _12381_/Y _12378_/Y VPWR VGND sg13cmos5l_a21oi_1
X_13389_ _13389_/Y _13202_/A _13382_/Y _13419_/B _13202_/B VPWR VGND sg13cmos5l_a22oi_1
X_16177_ _16433_/A _16194_/B _16177_/B VPWR VGND sg13cmos5l_nand2b_1
XFILLER_5_592 VPWR VGND sg13cmos5l_fill_2
X_15128_ _15128_/Y _15026_/B _15193_/B _15127_/Y VPWR VGND sg13cmos5l_o21ai_1
XFILLER_99_168 VPWR VGND sg13cmos5l_fill_2
X_15059_ _15074_/B _19263_/Q _19264_/Q _19265_/Q VPWR VGND sg13cmos5l_or3_1
Xhold2907 hold2907/X _18779_/Q VPWR VGND sg13cmos5l_dlygate4sd3_1
Xhold2918 _11479_/B _11478_/Y VPWR VGND sg13cmos5l_dlygate4sd3_1
Xhold2929 _17331_/C _17330_/Y VPWR VGND sg13cmos5l_dlygate4sd3_1
XFILLER_68_511 VPWR VGND sg13cmos5l_fill_1
X_18818_ _18818_/Q _18902_/CLK _18818_/D _18818_/RESET_B VPWR VGND sg13cmos5l_dfrbpq_1
X_19798_ _19798_/Q clkload22/A _19798_/D _19798_/RESET_B VPWR VGND sg13cmos5l_dfrbpq_1
X_18749_ _18749_/Q _18750_/CLK _18749_/D _18749_/RESET_B VPWR VGND sg13cmos5l_dfrbpq_1
X_18688__529 _18688_/D VPWR VGND sg13cmos5l_tielo
X_19247__995 _19247_/RESET_B VPWR VGND sg13cmos5l_tiehi
XFILLER_70_219 VPWR VGND sg13cmos5l_fill_1
X_19210__1035 _19210_/RESET_B VPWR VGND sg13cmos5l_tiehi
XFILLER_106_903 VPWR VGND sg13cmos5l_decap_8
XFILLER_106_969 VPWR VGND sg13cmos5l_fill_2
XFILLER_106_947 VPWR VGND sg13cmos5l_fill_1
X_19254__988 _19254_/RESET_B VPWR VGND sg13cmos5l_tiehi
X_19764__779 _19764_/RESET_B VPWR VGND sg13cmos5l_tiehi
Xfanout310 _11625_/B _11628_/A VPWR VGND sg13cmos5l_buf_1
Xfanout321 _11085_/B _10860_/Y VPWR VGND sg13cmos5l_buf_1
Xfanout332 _18486_/A hold2477/X VPWR VGND sg13cmos5l_buf_1
Xfanout354 _10683_/A _17417_/A VPWR VGND sg13cmos5l_buf_1
Xfanout365 _18273_/B _18470_/A VPWR VGND sg13cmos5l_buf_1
Xfanout343 _14721_/A _14380_/A VPWR VGND sg13cmos5l_buf_1
Xfanout398 _13284_/A fanout402/X VPWR VGND sg13cmos5l_buf_1
Xfanout376 _17439_/A _16603_/B VPWR VGND sg13cmos5l_buf_1
Xfanout387 _14710_/A _14364_/A VPWR VGND sg13cmos5l_buf_1
XFILLER_98_1027 VPWR VGND sg13cmos5l_fill_2
XFILLER_74_558 VPWR VGND sg13cmos5l_fill_2
XFILLER_74_547 VPWR VGND sg13cmos5l_decap_8
X_12760_ _12760_/Y _12760_/A _18856_/Q VPWR VGND sg13cmos5l_nor2_1
XFILLER_55_794 VPWR VGND sg13cmos5l_fill_1
XFILLER_43_923 VPWR VGND sg13cmos5l_fill_2
XFILLER_27_485 VPWR VGND sg13cmos5l_fill_2
XFILLER_28_997 VPWR VGND sg13cmos5l_fill_1
XFILLER_36_87 VPWR VGND sg13cmos5l_decap_8
X_12691_ _12693_/B _12568_/B _12732_/B _12697_/B VPWR VGND sg13cmos5l_mux2_1
X_11711_ _11711_/Y _11711_/A _11742_/A VPWR VGND sg13cmos5l_nor2_1
X_11642_ _11642_/Y _11642_/A _11642_/B VPWR VGND sg13cmos5l_nand2_1
X_14430_ _14430_/Y hold1964/X fanout72/X _14436_/A VPWR VGND sg13cmos5l_o21ai_1
XFILLER_11_842 VPWR VGND sg13cmos5l_fill_1
X_14361_ _19126_/D hold2793/X _14349_/X _14360_/Y VPWR VGND sg13cmos5l_a21oi_1
X_11573_ _11573_/Y _11601_/A _11601_/B VPWR VGND sg13cmos5l_nor2_1
X_19554__660 _19554_/RESET_B VPWR VGND sg13cmos5l_tiehi
X_13312_ _13312_/Y _13312_/A VPWR VGND sg13cmos5l_inv_1
XFILLER_6_301 VPWR VGND sg13cmos5l_fill_1
X_16100_ _16100_/X _16100_/A _16136_/A VPWR VGND sg13cmos5l_and2_1
X_17080_ _19541_/D _17080_/A _17087_/A VPWR VGND sg13cmos5l_nor2_1
X_14292_ _14293_/B _14277_/A _14277_/B _14290_/X VPWR VGND sg13cmos5l_o21ai_1
X_10524_ _10525_/B _19804_/Q _10547_/B VPWR VGND sg13cmos5l_nor2b_1
X_13243_ _13243_/Y _13125_/B _13259_/B _13242_/Y VPWR VGND sg13cmos5l_a21oi_1
X_18716__1565 _18716_/RESET_B VPWR VGND sg13cmos5l_tiehi
X_10455_ _10603_/A _10602_/A _10602_/B _10602_/C VPWR VGND sg13cmos5l_a21oi_1
X_16031_ _16031_/Y _19422_/Q _16038_/B _19359_/Q _16555_/A VPWR VGND sg13cmos5l_a22oi_1
X_13174_ _13174_/Y _13177_/A _13202_/A VPWR VGND sg13cmos5l_nand2_1
X_12125_ _12199_/B _12133_/S _12122_/Y _12124_/Y VPWR VGND sg13cmos5l_a21o_1
X_10386_ _10432_/A _10402_/A VPWR VGND sg13cmos5l_inv_1
X_19485__732 _19485_/RESET_B VPWR VGND sg13cmos5l_tiehi
X_17982_ _17993_/S _17982_/A _17982_/B VPWR VGND sg13cmos5l_nor2_1
X_16933_ _16934_/A _16933_/A _16940_/B VPWR VGND sg13cmos5l_nor2_1
X_12056_ _12057_/B _12056_/A _12160_/B VPWR VGND sg13cmos5l_nand2_1
X_19086__1168 _19086_/RESET_B VPWR VGND sg13cmos5l_tiehi
X_19721_ _19721_/Q clkload10/A _19721_/D _19721_/RESET_B VPWR VGND sg13cmos5l_dfrbpq_1
X_16864_ _16864_/Y _10154_/A _17371_/A _16860_/A _19475_/Q VPWR VGND sg13cmos5l_a22oi_1
X_19561__653 _19561_/RESET_B VPWR VGND sg13cmos5l_tiehi
X_11007_ _11061_/A _11007_/A _11022_/B VPWR VGND sg13cmos5l_nor2_1
X_19652_ _19652_/Q clkload11/A _19652_/D _19652_/RESET_B VPWR VGND sg13cmos5l_dfrbpq_1
X_18603_ _18603_/Q clkload55/A _18603_/D _18603_/RESET_B VPWR VGND sg13cmos5l_dfrbpq_1
X_15815_ _15821_/C _19325_/Q _19326_/Q _19327_/Q VPWR VGND sg13cmos5l_o21ai_1
X_16795_ _16795_/Y _16787_/Y _16795_/B VPWR VGND sg13cmos5l_nand2b_1
X_19583_ _19583_/Q clkload38/A _19583_/D _19583_/RESET_B VPWR VGND sg13cmos5l_dfrbpq_1
X_12958_ _12958_/Y _12848_/B _13026_/B _12957_/X _12853_/B VPWR VGND sg13cmos5l_a22oi_1
X_18534_ _19771_/D _09969_/Y fanout84/X _18533_/Y VPWR VGND sg13cmos5l_a21oi_1
X_15746_ _19350_/D _15748_/A _15746_/B VPWR VGND sg13cmos5l_nor2_1
XFILLER_34_945 VPWR VGND sg13cmos5l_decap_4
X_11909_ _11909_/Y _12458_/A _18726_/Q VPWR VGND sg13cmos5l_nor2_1
X_12889_ _12901_/B _18927_/Q _18928_/Q _18929_/Q _18930_/Q VPWR VGND sg13cmos5l_nor4_1
XFILLER_73_591 VPWR VGND sg13cmos5l_fill_1
X_18465_ _19745_/D _18423_/A _18462_/S _18464_/Y VPWR VGND sg13cmos5l_a21oi_1
X_15677_ _15679_/A _15629_/B _15656_/B _15650_/Y VPWR VGND sg13cmos5l_a21oi_1
X_19492__725 _19492_/RESET_B VPWR VGND sg13cmos5l_tiehi
XFILLER_61_786 VPWR VGND sg13cmos5l_fill_1
X_17416_ _17416_/Y _17416_/A _17416_/B VPWR VGND sg13cmos5l_nor2_1
X_14628_ _14629_/B _14607_/B _14604_/A _14628_/S VPWR VGND sg13cmos5l_mux2_1
X_18396_ _18414_/C _19763_/Q _18397_/B VPWR VGND sg13cmos5l_xnor2_1
X_17347_ _17348_/B _17347_/A _17347_/B VPWR VGND sg13cmos5l_nand2_1
X_18979__1284 _18979_/RESET_B VPWR VGND sg13cmos5l_tiehi
X_14559_ _14573_/S _14552_/Y _14556_/Y _14557_/Y VPWR VGND sg13cmos5l_a21o_1
X_17278_ _17278_/Y _17278_/A _17467_/A VPWR VGND sg13cmos5l_nor2_1
X_19017_ _19017_/Q clkload53/A _19017_/D _19017_/RESET_B VPWR VGND sg13cmos5l_dfrbpq_1
X_16229_ _16229_/Y _16229_/A _16244_/B VPWR VGND sg13cmos5l_nor2_1
Xhold2704 _10180_/A _18624_/Q VPWR VGND sg13cmos5l_dlygate4sd3_1
X_19228__1017 _19228_/RESET_B VPWR VGND sg13cmos5l_tiehi
Xhold2737 _11576_/B _11575_/X VPWR VGND sg13cmos5l_dlygate4sd3_1
Xhold2715 hold2715/X _18633_/Q VPWR VGND sg13cmos5l_dlygate4sd3_1
Xhold2726 _15029_/B _15130_/A VPWR VGND sg13cmos5l_dlygate4sd3_1
Xhold2748 _12382_/A _18842_/Q VPWR VGND sg13cmos5l_dlygate4sd3_1
Xhold2759 hold2759/X _19221_/Q VPWR VGND sg13cmos5l_dlygate4sd3_1
XFILLER_83_333 VPWR VGND sg13cmos5l_fill_2
XFILLER_71_506 VPWR VGND sg13cmos5l_fill_1
XFILLER_44_709 VPWR VGND sg13cmos5l_fill_1
XFILLER_83_388 VPWR VGND sg13cmos5l_fill_2
X_18792__1483 _18792_/RESET_B VPWR VGND sg13cmos5l_tiehi
XFILLER_52_786 VPWR VGND sg13cmos5l_fill_1
XFILLER_11_138 VPWR VGND sg13cmos5l_fill_1
X_10240_ _14402_/A _10240_/A VPWR VGND sg13cmos5l_inv_1
X_19041__1216 _19041_/RESET_B VPWR VGND sg13cmos5l_tiehi
XFILLER_105_254 VPWR VGND sg13cmos5l_decap_4
X_10171_ _11353_/A _10171_/A VPWR VGND sg13cmos5l_inv_1
Xfanout140 _12018_/B _12028_/B VPWR VGND sg13cmos5l_buf_1
XFILLER_94_609 VPWR VGND sg13cmos5l_fill_1
XFILLER_101_460 VPWR VGND sg13cmos5l_fill_1
Xfanout151 _16966_/B _17058_/B VPWR VGND sg13cmos5l_buf_1
X_13930_ _13930_/Y _19067_/Q _18986_/Q VPWR VGND sg13cmos5l_xnor2_1
Xfanout173 _13951_/B _13932_/Y VPWR VGND sg13cmos5l_buf_1
Xfanout162 _15608_/B _15590_/Y VPWR VGND sg13cmos5l_buf_1
Xfanout184 _12599_/B _12583_/Y VPWR VGND sg13cmos5l_buf_1
XFILLER_87_683 VPWR VGND sg13cmos5l_fill_1
Xfanout195 _11022_/B _11006_/Y VPWR VGND sg13cmos5l_buf_1
XFILLER_86_193 VPWR VGND sg13cmos5l_fill_1
X_15600_ _15600_/Y _15708_/B _15708_/C _15708_/A VPWR VGND sg13cmos5l_a21oi_1
X_13861_ _13861_/Y _13839_/A _13859_/S _14071_/B VPWR VGND sg13cmos5l_o21ai_1
X_13792_ _13793_/B _13767_/B _13730_/X _13803_/A VPWR VGND sg13cmos5l_mux2_1
X_12812_ _12812_/Y _12621_/X _12844_/A _12850_/A _12627_/Y VPWR VGND sg13cmos5l_a22oi_1
X_16580_ _16582_/B _16593_/C _16578_/Y _16579_/Y VPWR VGND sg13cmos5l_o21ai_1
X_12743_ _12743_/Y _18918_/Q _12754_/B _12742_/Y VPWR VGND sg13cmos5l_a21oi_1
X_18934__1332 _18934_/RESET_B VPWR VGND sg13cmos5l_tiehi
XFILLER_43_742 VPWR VGND sg13cmos5l_fill_1
X_15531_ _15578_/A _19286_/Q _15550_/D VPWR VGND sg13cmos5l_xor2_1
XFILLER_15_444 VPWR VGND sg13cmos5l_fill_2
XFILLER_70_550 VPWR VGND sg13cmos5l_fill_1
X_18250_ _18251_/A _18249_/Y _18248_/Y _18264_/C VPWR VGND sg13cmos5l_mux2_1
X_15462_ _19306_/D _15464_/A _15462_/B VPWR VGND sg13cmos5l_nor2_1
X_12674_ _12697_/B _12674_/A _12674_/B VPWR VGND sg13cmos5l_nand2_1
X_17201_ _17201_/Y _17202_/B VPWR VGND sg13cmos5l_inv_1
X_14413_ _14415_/A _19148_/Q _14410_/Y _14412_/Y _19149_/Q _14411_/Y VPWR VGND sg13cmos5l_a221oi_1
XFILLER_31_959 VPWR VGND sg13cmos5l_fill_1
X_11625_ _18716_/D _11625_/A _11625_/B VPWR VGND sg13cmos5l_nor2_1
X_18181_ _18181_/Y _18181_/A _18181_/B VPWR VGND sg13cmos5l_nor2_1
X_15393_ _15393_/Y _15296_/Y _15463_/B _15387_/Y _15382_/X _15392_/Y VPWR VGND sg13cmos5l_a221oi_1
XFILLER_30_458 VPWR VGND sg13cmos5l_fill_1
X_11556_ _11628_/B _11556_/A _11556_/B VPWR VGND sg13cmos5l_and2_1
X_17132_ _17132_/X _17105_/Y _10357_/Y _17136_/S VPWR VGND sg13cmos5l_mux2_1
X_14344_ _14344_/Y _14344_/A VPWR VGND sg13cmos5l_inv_1
X_17063_ _17063_/Y _17063_/A _17063_/B VPWR VGND sg13cmos5l_nor2_1
XFILLER_6_120 VPWR VGND sg13cmos5l_fill_2
X_14275_ _14277_/B _14468_/A _14310_/B VPWR VGND sg13cmos5l_nor2_1
X_10507_ _10507_/Y _10579_/A _10590_/B VPWR VGND sg13cmos5l_nor2_1
X_13226_ _13264_/A _18966_/Q _13232_/B _13258_/A VPWR VGND sg13cmos5l_a21oi_1
X_11487_ _11595_/B _18713_/Q _11588_/B VPWR VGND sg13cmos5l_nand2_1
X_16014_ _19386_/D _16014_/A _16016_/B VPWR VGND sg13cmos5l_nor2_1
X_10438_ _10442_/A _18590_/Q _18625_/Q VPWR VGND sg13cmos5l_nor2_1
X_10369_ _16582_/A _10369_/A VPWR VGND sg13cmos5l_inv_1
X_13157_ _13157_/Y _13159_/A _13159_/B VPWR VGND sg13cmos5l_nand2_1
X_12108_ _12108_/Y _12109_/C _12109_/D VPWR VGND sg13cmos5l_nand2_1
X_13088_ _13098_/B _18907_/Q _18905_/Q _18906_/Q VPWR VGND sg13cmos5l_or3_1
XFILLER_69_138 VPWR VGND sg13cmos5l_fill_2
X_17965_ _17965_/Y _17965_/A VPWR VGND sg13cmos5l_inv_1
XFILLER_3_893 VPWR VGND sg13cmos5l_fill_2
X_12039_ _12160_/B _12039_/A _12051_/B VPWR VGND sg13cmos5l_nand2_1
X_16916_ _16917_/A _16916_/A _16940_/B VPWR VGND sg13cmos5l_nor2_1
X_19704_ _19704_/Q clkload14/A _19704_/D _19704_/RESET_B VPWR VGND sg13cmos5l_dfrbpq_1
X_17896_ _17900_/A _17897_/A _17912_/A _17897_/C VPWR VGND sg13cmos5l_and3_1
X_19706__1644 _19706_/RESET_B VPWR VGND sg13cmos5l_tiehi
X_16847_ _16847_/X _16848_/A _16848_/B VPWR VGND sg13cmos5l_or2_1
X_19635_ _19635_/Q clkload26/A _19635_/D _19635_/RESET_B VPWR VGND sg13cmos5l_dfrbpq_1
XFILLER_53_506 VPWR VGND sg13cmos5l_fill_2
Xclkbuf_4_1_0_clk clkbuf_4_1_0_clk/X clkbuf_0_clk/X VPWR VGND sg13cmos5l_buf_8
X_16778_ _16778_/X _16769_/Y _16773_/X _16777_/Y VPWR VGND sg13cmos5l_a21o_1
X_19566_ _19566_/Q clkload28/A _19566_/D _19566_/RESET_B VPWR VGND sg13cmos5l_dfrbpq_1
XFILLER_65_377 VPWR VGND sg13cmos5l_fill_1
X_18517_ _18517_/Y _10844_/A _18511_/A _18516_/A _10849_/B _18512_/Y VPWR VGND sg13cmos5l_a221oi_1
XFILLER_46_580 VPWR VGND sg13cmos5l_fill_1
X_19244__998 _19244_/RESET_B VPWR VGND sg13cmos5l_tiehi
X_15729_ _15729_/Y _15690_/B _15727_/S _15747_/A VPWR VGND sg13cmos5l_o21ai_1
X_19497_ _19497_/Q clkload34/A _19497_/D _19497_/RESET_B VPWR VGND sg13cmos5l_dfrbpq_1
XFILLER_61_550 VPWR VGND sg13cmos5l_fill_1
X_18448_ _18448_/Y _18423_/Y _18442_/Y _18447_/Y VPWR VGND sg13cmos5l_o21ai_1
X_18379_ _18379_/Y _18399_/A _18377_/Y _18378_/Y _10497_/A VPWR VGND sg13cmos5l_a22oi_1
XFILLER_103_714 VPWR VGND sg13cmos5l_fill_2
XFILLER_88_458 VPWR VGND sg13cmos5l_fill_1
Xhold2512 _10294_/A _18724_/Q VPWR VGND sg13cmos5l_dlygate4sd3_1
Xhold2501 _12510_/B _12509_/X VPWR VGND sg13cmos5l_dlygate4sd3_1
XFILLER_97_981 VPWR VGND sg13cmos5l_fill_2
Xhold2534 _11134_/B _11133_/X VPWR VGND sg13cmos5l_dlygate4sd3_1
Xhold2523 _17347_/B _17346_/X VPWR VGND sg13cmos5l_dlygate4sd3_1
Xhold2556 _10131_/A _19380_/Q VPWR VGND sg13cmos5l_dlygate4sd3_1
Xhold2545 _13860_/B _13859_/X VPWR VGND sg13cmos5l_dlygate4sd3_1
X_19544__670 _19544_/RESET_B VPWR VGND sg13cmos5l_tiehi
Xhold2589 _10767_/B _18592_/Q VPWR VGND sg13cmos5l_dlygate4sd3_1
Xhold1844 _18541_/B _19734_/Q VPWR VGND sg13cmos5l_dlygate4sd3_1
Xhold2578 _19081_/D _14061_/Y VPWR VGND sg13cmos5l_dlygate4sd3_1
Xhold2567 _10118_/A _19296_/Q VPWR VGND sg13cmos5l_dlygate4sd3_1
XFILLER_29_525 VPWR VGND sg13cmos5l_decap_4
Xhold1822 _14144_/B _19071_/Q VPWR VGND sg13cmos5l_dlygate4sd3_1
Xhold1833 _14218_/B _19072_/Q VPWR VGND sg13cmos5l_dlygate4sd3_1
Xhold1866 _13212_/B _18904_/Q VPWR VGND sg13cmos5l_dlygate4sd3_1
Xhold1855 _11422_/B _18650_/Q VPWR VGND sg13cmos5l_dlygate4sd3_1
Xhold1877 _11014_/B _19776_/Q VPWR VGND sg13cmos5l_dlygate4sd3_1
XFILLER_72_826 VPWR VGND sg13cmos5l_fill_2
Xhold1888 _15255_/B _19238_/Q VPWR VGND sg13cmos5l_dlygate4sd3_1
Xhold1899 _15526_/B _19280_/Q VPWR VGND sg13cmos5l_dlygate4sd3_1
XFILLER_17_89 VPWR VGND sg13cmos5l_fill_2
XFILLER_25_720 VPWR VGND sg13cmos5l_fill_1
X_12390_ _12391_/B _12417_/B _12417_/C _12417_/A VPWR VGND sg13cmos5l_a21oi_1
X_18582__1717 _18582_/RESET_B VPWR VGND sg13cmos5l_tiehi
X_11410_ _11410_/Y _11391_/B _11412_/S _11630_/A VPWR VGND sg13cmos5l_o21ai_1
X_19551__663 _19551_/RESET_B VPWR VGND sg13cmos5l_tiehi
X_11341_ _18661_/D _11351_/B _11341_/B VPWR VGND sg13cmos5l_and2_1
X_11272_ _11272_/Y _11274_/A _11271_/Y _11251_/Y VPWR VGND sg13cmos5l_o21ai_1
X_14060_ _14060_/Y _14029_/X _14062_/S _13925_/A VPWR VGND sg13cmos5l_o21ai_1
XFILLER_106_574 VPWR VGND sg13cmos5l_fill_1
XFILLER_106_563 VPWR VGND sg13cmos5l_fill_2
X_13011_ _13012_/C _13011_/A _12988_/A VPWR VGND sg13cmos5l_nor2b_1
XFILLER_3_178 VPWR VGND sg13cmos5l_fill_1
XFILLER_3_145 VPWR VGND sg13cmos5l_decap_8
X_10223_ _15196_/B _15205_/A VPWR VGND sg13cmos5l_inv_1
X_10154_ _17370_/A _10154_/A VPWR VGND sg13cmos5l_inv_1
X_19482__735 _19482_/RESET_B VPWR VGND sg13cmos5l_tiehi
X_19005__1255 _19005_/RESET_B VPWR VGND sg13cmos5l_tiehi
X_17750_ _17751_/B _19616_/Q _19609_/Q _19610_/Q VPWR VGND sg13cmos5l_nor3_1
XFILLER_0_896 VPWR VGND sg13cmos5l_decap_8
X_14962_ _14962_/Y _14941_/B _14958_/S _15185_/B VPWR VGND sg13cmos5l_o21ai_1
X_10085_ _14368_/A _10085_/A VPWR VGND sg13cmos5l_inv_1
X_16701_ _16941_/A _16729_/A _16916_/A VPWR VGND sg13cmos5l_and2_1
X_13913_ _13913_/Y _13912_/A _13923_/B _13924_/S VPWR VGND sg13cmos5l_o21ai_1
X_17681_ _17681_/Y _18223_/A _19598_/Q _19597_/Q _18222_/A _17680_/Y VPWR VGND sg13cmos5l_a221oi_1
X_14893_ _14893_/Y _14861_/X _14895_/S _14916_/A VPWR VGND sg13cmos5l_o21ai_1
X_16632_ _16632_/Y _16632_/A _16632_/B VPWR VGND sg13cmos5l_nand2_1
X_13844_ _13845_/B _13849_/C _13842_/Y _13843_/Y VPWR VGND sg13cmos5l_o21ai_1
X_19420_ _19420_/Q clkload5/A _19420_/D _19420_/RESET_B VPWR VGND sg13cmos5l_dfrbpq_1
XFILLER_62_358 VPWR VGND sg13cmos5l_fill_2
X_19351_ _19351_/Q clkload17/A _19351_/D _19351_/RESET_B VPWR VGND sg13cmos5l_dfrbpq_1
X_16563_ _16563_/Y _17084_/A _19023_/Q VPWR VGND sg13cmos5l_nor2_1
X_13775_ _13775_/Y _13775_/A _13800_/A VPWR VGND sg13cmos5l_nand2_1
X_10987_ _10987_/Y _10976_/Y _10983_/Y _10986_/Y VPWR VGND sg13cmos5l_o21ai_1
XFILLER_16_775 VPWR VGND sg13cmos5l_fill_1
X_18302_ _18302_/Y _18302_/A _18302_/B VPWR VGND sg13cmos5l_nor2_1
X_12726_ _18881_/D _12726_/A _12728_/B VPWR VGND sg13cmos5l_nor2_1
X_15514_ _15515_/B _15495_/Y _15774_/A _15516_/S VPWR VGND sg13cmos5l_mux2_1
X_19282_ _19282_/Q clkload44/A _19282_/D _19282_/RESET_B VPWR VGND sg13cmos5l_dfrbpq_1
X_16494_ _16517_/A _16494_/A _16494_/B VPWR VGND sg13cmos5l_nor2_1
X_12657_ _12843_/A _12657_/A _12825_/A VPWR VGND sg13cmos5l_nor2_1
X_15445_ _15445_/Y _15422_/Y _15447_/S _15465_/A VPWR VGND sg13cmos5l_o21ai_1
X_18233_ _19720_/D _18233_/A _18233_/B VPWR VGND sg13cmos5l_nor2_1
X_11608_ _18703_/D _11625_/B _11608_/B VPWR VGND sg13cmos5l_nor2_1
X_15376_ _15461_/B _15376_/A _15376_/B VPWR VGND sg13cmos5l_nand2_1
XFILLER_12_992 VPWR VGND sg13cmos5l_fill_2
X_18164_ _18164_/Y _18129_/A _18135_/B _18157_/B _18315_/A VPWR VGND sg13cmos5l_a22oi_1
X_12588_ _12593_/A _18880_/Q _12602_/B VPWR VGND sg13cmos5l_and2_1
X_17115_ _17115_/Y _17379_/B _17109_/A _17113_/A _10356_/Y _17114_/Y VPWR VGND sg13cmos5l_a221oi_1
XFILLER_7_440 VPWR VGND sg13cmos5l_fill_2
X_14327_ _14328_/B _14373_/B _14189_/B _14336_/B VPWR VGND sg13cmos5l_mux2_1
X_11539_ _11540_/C _18703_/Q _11539_/B VPWR VGND sg13cmos5l_nor2_1
X_18095_ _18108_/B _19715_/Q _19716_/Q _19717_/Q _19718_/Q VPWR VGND sg13cmos5l_nor4_1
X_17046_ _17046_/Y _17049_/A VPWR VGND sg13cmos5l_inv_1
X_14258_ _14258_/Y _14304_/A VPWR VGND sg13cmos5l_inv_1
X_18765__1513 _18765_/RESET_B VPWR VGND sg13cmos5l_tiehi
X_13209_ _13253_/S _13210_/B _13210_/C VPWR VGND sg13cmos5l_nand2_1
X_14189_ _19116_/D _14377_/A _14189_/B VPWR VGND sg13cmos5l_nor2_1
XFILLER_79_970 VPWR VGND sg13cmos5l_decap_4
X_18997_ _18997_/Q clkload66/A _18997_/D _18997_/RESET_B VPWR VGND sg13cmos5l_dfrbpq_1
XFILLER_100_739 VPWR VGND sg13cmos5l_fill_1
X_17948_ _17948_/Y _19702_/Q _17706_/A _17945_/Y _17946_/Y _17947_/Y VPWR VGND sg13cmos5l_a221oi_1
XFILLER_94_951 VPWR VGND sg13cmos5l_decap_4
XFILLER_65_130 VPWR VGND sg13cmos5l_fill_2
X_17879_ _17879_/X _17879_/A _17943_/B VPWR VGND sg13cmos5l_and2_1
X_19618_ _19618_/Q clkload25/A _19618_/D _19618_/RESET_B VPWR VGND sg13cmos5l_dfrbpq_1
XFILLER_38_377 VPWR VGND sg13cmos5l_fill_1
XFILLER_65_196 VPWR VGND sg13cmos5l_fill_1
X_19549_ _19549_/Q clkload40/A _19549_/D _19549_/RESET_B VPWR VGND sg13cmos5l_dfrbpq_1
X_18711__1570 _18711_/RESET_B VPWR VGND sg13cmos5l_tiehi
X_19081__1173 _19081_/RESET_B VPWR VGND sg13cmos5l_tiehi
XFILLER_102_8 VPWR VGND sg13cmos5l_fill_1
Xhold3010 _11993_/A _18743_/Q VPWR VGND sg13cmos5l_dlygate4sd3_1
Xhold3032 hold3032/X _19055_/Q VPWR VGND sg13cmos5l_dlygate4sd3_1
Xhold3021 _15006_/A _19199_/Q VPWR VGND sg13cmos5l_dlygate4sd3_1
Xhold3043 _12324_/B _18844_/Q VPWR VGND sg13cmos5l_dlygate4sd3_1
XFILLER_103_566 VPWR VGND sg13cmos5l_decap_4
Xhold3054 _12612_/B _18886_/Q VPWR VGND sg13cmos5l_dlygate4sd3_1
Xhold2320 _11378_/A _18641_/Q VPWR VGND sg13cmos5l_dlygate4sd3_1
X_09997_ _09997_/Y _09997_/A VPWR VGND sg13cmos5l_inv_1
Xhold2331 _19458_/D _16552_/Y VPWR VGND sg13cmos5l_dlygate4sd3_1
Xhold2364 _11958_/B _18771_/Q VPWR VGND sg13cmos5l_dlygate4sd3_1
Xhold2342 _19725_/D _18281_/Y VPWR VGND sg13cmos5l_dlygate4sd3_1
Xhold2353 _10221_/A _19274_/Q VPWR VGND sg13cmos5l_dlygate4sd3_1
Xhold2386 hold2386/X _11414_/Y VPWR VGND sg13cmos5l_dlygate4sd3_1
Xhold2397 _18567_/D _10686_/Y VPWR VGND sg13cmos5l_dlygate4sd3_1
XFILLER_45_804 VPWR VGND sg13cmos5l_fill_1
Xhold2375 _19233_/D _14969_/Y VPWR VGND sg13cmos5l_dlygate4sd3_1
XFILLER_28_33 VPWR VGND sg13cmos5l_fill_2
X_10910_ _10912_/B _10559_/Y _10929_/S _10909_/Y VPWR VGND sg13cmos5l_a21oi_1
X_11890_ _11891_/B _11878_/A _11875_/Y _11890_/S VPWR VGND sg13cmos5l_mux2_1
XFILLER_44_325 VPWR VGND sg13cmos5l_fill_2
X_10841_ _10841_/Y _10841_/A _10841_/B VPWR VGND sg13cmos5l_nor2_1
X_10772_ _10772_/Y _10759_/X _10801_/B _10769_/Y VPWR VGND sg13cmos5l_a21oi_1
X_13560_ _13571_/S _13448_/A _13448_/B _13551_/Y _13558_/Y _13559_/Y VPWR VGND sg13cmos5l_a221oi_1
XFILLER_25_572 VPWR VGND sg13cmos5l_fill_2
X_12511_ _12511_/Y _12486_/A _12509_/S _12579_/A VPWR VGND sg13cmos5l_o21ai_1
X_13491_ _13503_/B _13479_/X _13486_/Y _13489_/Y VPWR VGND sg13cmos5l_a21o_1
X_12442_ _12443_/B _12415_/Y _12416_/A _12451_/A VPWR VGND sg13cmos5l_mux2_1
XFILLER_100_60 VPWR VGND sg13cmos5l_fill_2
XFILLER_8_204 VPWR VGND sg13cmos5l_fill_1
X_15230_ _15230_/Y _19295_/Q _15742_/A _15210_/B _19233_/Q VPWR VGND sg13cmos5l_a22oi_1
X_12373_ _12468_/B _12337_/Y _12345_/X _12347_/Y VPWR VGND sg13cmos5l_o21ai_1
X_18858__1413 _18858_/RESET_B VPWR VGND sg13cmos5l_tiehi
XFILLER_60_75 VPWR VGND sg13cmos5l_fill_2
XFILLER_5_911 VPWR VGND sg13cmos5l_fill_1
X_19223__1022 _19223_/RESET_B VPWR VGND sg13cmos5l_tiehi
X_15161_ _15162_/B _15161_/A _15161_/B VPWR VGND sg13cmos5l_xnor2_1
XFILLER_99_509 VPWR VGND sg13cmos5l_decap_4
X_11324_ _11334_/A _11227_/Y _11332_/A _11324_/C VPWR VGND sg13cmos5l_nand3b_1
XFILLER_5_15 VPWR VGND sg13cmos5l_fill_1
X_15092_ _15121_/B _19269_/Q _15092_/B VPWR VGND sg13cmos5l_xor2_1
X_14112_ _14112_/Y _19105_/Q _14111_/Y _14107_/Y VPWR VGND sg13cmos5l_a21oi_1
XFILLER_106_360 VPWR VGND sg13cmos5l_fill_1
X_18920_ _18920_/Q clkload63/A _18920_/D _18920_/RESET_B VPWR VGND sg13cmos5l_dfrbpq_1
X_11255_ _11286_/A _11268_/D _11255_/B VPWR VGND sg13cmos5l_nand2_1
X_14043_ _14043_/Y _14043_/A _14043_/B _14043_/C VPWR VGND sg13cmos5l_nand3_1
XFILLER_5_59 VPWR VGND sg13cmos5l_fill_2
X_10206_ _15768_/A _16038_/A VPWR VGND sg13cmos5l_inv_1
X_18851_ _18851_/Q clkload63/A _18851_/D _18851_/RESET_B VPWR VGND sg13cmos5l_dfrbpq_1
X_11186_ _11186_/Y _18611_/Q _11199_/B VPWR VGND sg13cmos5l_nand2b_1
X_18782_ _18782_/Q clkload61/A _18782_/D _18782_/RESET_B VPWR VGND sg13cmos5l_dfrbpq_1
X_17802_ _17804_/B _17911_/A _17910_/A VPWR VGND sg13cmos5l_nor2_1
XFILLER_0_660 VPWR VGND sg13cmos5l_fill_2
X_15994_ _15994_/Y _15994_/A _15994_/B VPWR VGND sg13cmos5l_nor2_1
X_10137_ _16345_/A _19451_/Q VPWR VGND sg13cmos5l_inv_1
XFILLER_76_940 VPWR VGND sg13cmos5l_fill_1
X_10068_ _13577_/A _10068_/A VPWR VGND sg13cmos5l_inv_1
X_17733_ _17733_/Y hold2005/X fanout70/X _17439_/A VPWR VGND sg13cmos5l_o21ai_1
X_14945_ _14946_/C _15220_/A _14945_/B VPWR VGND sg13cmos5l_nor2_1
XFILLER_76_973 VPWR VGND sg13cmos5l_fill_1
XFILLER_63_656 VPWR VGND sg13cmos5l_fill_2
XFILLER_62_111 VPWR VGND sg13cmos5l_decap_4
X_17664_ _17664_/Y _17664_/A _17664_/B _17664_/C VPWR VGND sg13cmos5l_nand3_1
X_14876_ _14887_/A _14774_/Y _14876_/B _14876_/C VPWR VGND sg13cmos5l_nand3b_1
X_19403_ _19403_/Q clkload7/A _19403_/D _19403_/RESET_B VPWR VGND sg13cmos5l_dfrbpq_1
XFILLER_36_859 VPWR VGND sg13cmos5l_fill_1
X_16615_ _16615_/Y _16598_/Y hold2303/X _16609_/A VPWR VGND sg13cmos5l_a21oi_1
X_17595_ _17597_/B _17593_/A _17580_/B _17594_/Y VPWR VGND sg13cmos5l_o21ai_1
XFILLER_63_678 VPWR VGND sg13cmos5l_fill_1
X_13827_ _13827_/Y _19086_/Q _13848_/A _13826_/Y VPWR VGND sg13cmos5l_a21oi_1
X_13758_ _13759_/A _13775_/A _13800_/A VPWR VGND sg13cmos5l_nor2_1
X_19334_ _19334_/Q clkload15/A _19334_/D _19334_/RESET_B VPWR VGND sg13cmos5l_dfrbpq_1
X_16546_ _16546_/Y _16525_/Y fanout32/X _16545_/Y VPWR VGND sg13cmos5l_a21oi_1
X_12709_ _12720_/S _12600_/A _12600_/B _12700_/Y _12707_/Y _12708_/Y VPWR VGND sg13cmos5l_a221oi_1
X_19265_ _19265_/Q _19304_/CLK _19265_/D _19265_/RESET_B VPWR VGND sg13cmos5l_dfrbpq_1
X_13689_ _13689_/Y _13681_/Y _13683_/Y _16648_/A VPWR VGND sg13cmos5l_o21ai_1
X_18216_ _18216_/Y _18204_/B _18207_/Y _18231_/A VPWR VGND sg13cmos5l_o21ai_1
X_16477_ _16477_/Y _16561_/B _16477_/B VPWR VGND sg13cmos5l_nor2_1
XFILLER_102_1001 VPWR VGND sg13cmos5l_fill_1
X_15428_ _15428_/Y _15465_/B _15428_/B VPWR VGND sg13cmos5l_nand2_1
X_19196_ _19196_/Q _19805_/CLK _19196_/D _19196_/RESET_B VPWR VGND sg13cmos5l_dfrbpq_1
X_19534__680 _19534_/RESET_B VPWR VGND sg13cmos5l_tiehi
X_15359_ _15553_/A _15740_/A _15359_/B VPWR VGND sg13cmos5l_xnor2_1
X_18147_ _18230_/B _18154_/B1 _18146_/Y _18145_/Y VPWR VGND sg13cmos5l_a21oi_1
X_18078_ _18078_/Y _18186_/B _18186_/C _18186_/A VPWR VGND sg13cmos5l_a21oi_1
XFILLER_7_292 VPWR VGND sg13cmos5l_fill_2
X_17029_ _17047_/S _17040_/B _17040_/C VPWR VGND sg13cmos5l_or2_1
X_19799__1757 _19799_/RESET_B VPWR VGND sg13cmos5l_tiehi
X_18729__1552 _18729_/RESET_B VPWR VGND sg13cmos5l_tiehi
XFILLER_67_940 VPWR VGND sg13cmos5l_decap_4
XFILLER_38_130 VPWR VGND sg13cmos5l_fill_2
X_19541__673 _19541_/RESET_B VPWR VGND sg13cmos5l_tiehi
XFILLER_66_483 VPWR VGND sg13cmos5l_fill_1
X_19099__1155 _19099_/RESET_B VPWR VGND sg13cmos5l_tiehi
XFILLER_22_531 VPWR VGND sg13cmos5l_fill_1
XFILLER_34_380 VPWR VGND sg13cmos5l_fill_1
XFILLER_89_520 VPWR VGND sg13cmos5l_fill_1
X_19701__1693 _19701_/RESET_B VPWR VGND sg13cmos5l_tiehi
XFILLER_103_330 VPWR VGND sg13cmos5l_fill_2
X_18872__1397 _18872_/RESET_B VPWR VGND sg13cmos5l_tiehi
X_11040_ _11040_/Y _11040_/A _11042_/B VPWR VGND sg13cmos5l_nor2b_1
X_19673__1786 _19673_/RESET_B VPWR VGND sg13cmos5l_tiehi
XFILLER_77_726 VPWR VGND sg13cmos5l_fill_2
Xhold2150 _10279_/A _18811_/Q VPWR VGND sg13cmos5l_dlygate4sd3_1
Xhold2172 _17960_/A _19702_/Q VPWR VGND sg13cmos5l_dlygate4sd3_1
Xhold2161 _14637_/A _19122_/Q VPWR VGND sg13cmos5l_dlygate4sd3_1
X_12991_ _12992_/B _12991_/A _12991_/B VPWR VGND sg13cmos5l_or2_1
XFILLER_58_973 VPWR VGND sg13cmos5l_decap_8
Xhold2194 _10350_/A _19597_/Q VPWR VGND sg13cmos5l_dlygate4sd3_1
Xhold2183 _19355_/D _15793_/Y VPWR VGND sg13cmos5l_dlygate4sd3_1
X_11942_ _11942_/Y _10041_/A _12462_/A _11922_/B _18729_/Q VPWR VGND sg13cmos5l_a22oi_1
X_14730_ _14757_/A _19162_/Q _14730_/B VPWR VGND sg13cmos5l_xnor2_1
XFILLER_17_336 VPWR VGND sg13cmos5l_fill_2
X_11873_ _11874_/B _11873_/A _11873_/B VPWR VGND sg13cmos5l_xor2_1
XFILLER_73_998 VPWR VGND sg13cmos5l_fill_2
X_14661_ _14680_/C _19212_/Q _14679_/A _14660_/B VPWR VGND sg13cmos5l_o21ai_1
X_13612_ _13613_/A _10731_/Y _13611_/Y _13616_/S VPWR VGND sg13cmos5l_mux2_1
XFILLER_72_486 VPWR VGND sg13cmos5l_fill_2
X_17380_ _17380_/Y _17751_/A _10356_/Y _10357_/Y _19616_/Q VPWR VGND sg13cmos5l_a22oi_1
X_10824_ _10824_/Y _19769_/Q _18623_/Q VPWR VGND sg13cmos5l_nand2b_1
X_16400_ _16467_/A _16400_/A _16400_/B VPWR VGND sg13cmos5l_xnor2_1
X_14592_ _14593_/B _19172_/Q _14516_/B _14493_/Y VPWR VGND sg13cmos5l_a21oi_1
X_13543_ _13544_/C _13543_/A _13543_/B VPWR VGND sg13cmos5l_nor2_1
X_16331_ _16350_/C _16339_/B _16331_/B VPWR VGND sg13cmos5l_and2_1
X_10755_ _10755_/Y _10755_/A _10756_/B VPWR VGND sg13cmos5l_xnor2_1
XFILLER_9_513 VPWR VGND sg13cmos5l_fill_1
XFILLER_13_564 VPWR VGND sg13cmos5l_fill_2
XFILLER_13_575 VPWR VGND sg13cmos5l_fill_1
X_19050_ _19050_/Q clkload30/A _19050_/D _19050_/RESET_B VPWR VGND sg13cmos5l_dfrbpq_1
X_10686_ _10686_/Y _10688_/A _10684_/Y _10685_/Y VPWR VGND sg13cmos5l_a21oi_1
X_13474_ _13518_/A _13474_/A _13475_/B VPWR VGND sg13cmos5l_xnor2_1
X_16262_ _16282_/B _16260_/A _16260_/B _16261_/Y VPWR VGND sg13cmos5l_a21oi_1
XFILLER_13_597 VPWR VGND sg13cmos5l_fill_1
X_12425_ _12425_/Y _12408_/A _12408_/B _12420_/Y _12422_/Y VPWR VGND sg13cmos5l_a22oi_1
X_18001_ _18001_/Y _19689_/Q fanout85/X _17739_/A VPWR VGND sg13cmos5l_o21ai_1
X_16193_ _16207_/B _19419_/Q _19420_/Q _19417_/Q _19418_/Q VPWR VGND sg13cmos5l_nor4_1
X_15213_ _15213_/X _15486_/A _15238_/A VPWR VGND sg13cmos5l_or2_1
X_12356_ _12356_/Y _12546_/A _12554_/A VPWR VGND sg13cmos5l_nand2_1
X_15144_ _15144_/Y _15144_/A VPWR VGND sg13cmos5l_inv_1
X_11307_ _11308_/B _18668_/Q _11234_/B _11212_/Y VPWR VGND sg13cmos5l_a21oi_1
X_12287_ _12295_/C _12287_/A _12294_/B VPWR VGND sg13cmos5l_nand2_1
X_18792__519 _18792_/D VPWR VGND sg13cmos5l_tielo
X_15075_ _15075_/Y _15114_/A _15115_/A _15069_/X VPWR VGND sg13cmos5l_o21ai_1
X_18903_ _18903_/Q _19003_/CLK _18903_/D _18903_/RESET_B VPWR VGND sg13cmos5l_dfrbpq_1
X_11238_ _11306_/A _11332_/A _11238_/B VPWR VGND sg13cmos5l_nand2_1
X_14026_ _14026_/X _14026_/A _14026_/B VPWR VGND sg13cmos5l_xor2_1
X_18834_ _18834_/Q clkload69/A _18834_/D _18834_/RESET_B VPWR VGND sg13cmos5l_dfrbpq_1
X_11169_ _11169_/Y _11169_/A _11170_/B VPWR VGND sg13cmos5l_nor2b_1
X_18765_ _18765_/Q clkload39/A _18765_/D _18765_/RESET_B VPWR VGND sg13cmos5l_dfrbpq_1
X_19054__1203 _19054_/RESET_B VPWR VGND sg13cmos5l_tiehi
X_15977_ _15980_/A _15977_/A VPWR VGND sg13cmos5l_inv_1
XFILLER_36_601 VPWR VGND sg13cmos5l_fill_1
X_18696_ _18696_/Q clkload56/A _18696_/D _18696_/RESET_B VPWR VGND sg13cmos5l_dfrbpq_1
XFILLER_75_280 VPWR VGND sg13cmos5l_decap_4
X_17716_ _17716_/Y _17716_/A _17716_/B VPWR VGND sg13cmos5l_nor2_1
X_14928_ _14929_/B _15460_/A _19192_/Q VPWR VGND sg13cmos5l_nand2_1
XFILLER_64_965 VPWR VGND sg13cmos5l_fill_2
X_17647_ _17647_/Y _17649_/A _17664_/B _17646_/Y VPWR VGND sg13cmos5l_a21oi_1
X_14859_ _14859_/X _14876_/B _14860_/B VPWR VGND sg13cmos5l_and2_1
X_17578_ _17580_/B _17607_/B _17613_/B VPWR VGND sg13cmos5l_nor2_1
X_19317_ _19317_/Q clkload19/A _19317_/D _19317_/RESET_B VPWR VGND sg13cmos5l_dfrbpq_1
X_16529_ _16533_/A _16562_/B _16529_/B VPWR VGND sg13cmos5l_nand2_1
XFILLER_31_350 VPWR VGND sg13cmos5l_fill_2
XFILLER_84_0 VPWR VGND sg13cmos5l_fill_2
X_19248_ _19248_/Q _19304_/CLK _19248_/D _19248_/RESET_B VPWR VGND sg13cmos5l_dfrbpq_1
X_19179_ _19179_/Q clkload50/A _19179_/D _19179_/RESET_B VPWR VGND sg13cmos5l_dfrbpq_1
X_19000__1260 _19000_/RESET_B VPWR VGND sg13cmos5l_tiehi
XFILLER_104_116 VPWR VGND sg13cmos5l_fill_2
XFILLER_98_394 VPWR VGND sg13cmos5l_fill_2
XFILLER_70_913 VPWR VGND sg13cmos5l_decap_4
XFILLER_10_501 VPWR VGND sg13cmos5l_decap_4
X_10540_ _10544_/A _10540_/A _10540_/B VPWR VGND sg13cmos5l_xnor2_1
X_10471_ _10473_/B _19747_/Q _10481_/B VPWR VGND sg13cmos5l_nor2b_1
X_12210_ _12210_/Y _18768_/Q _12210_/B _12219_/B VPWR VGND sg13cmos5l_nand3_1
X_13190_ _13196_/B _13157_/Y _13407_/A _13199_/S VPWR VGND sg13cmos5l_mux2_1
X_12141_ _12141_/Y _12162_/A _12200_/B _12140_/Y VPWR VGND sg13cmos5l_a21oi_1
X_19270__972 _19270_/RESET_B VPWR VGND sg13cmos5l_tiehi
X_19763__427 _19763_/D VPWR VGND sg13cmos5l_tielo
X_12072_ _12072_/Y _12110_/A _18802_/Q VPWR VGND sg13cmos5l_nand2_1
XFILLER_89_350 VPWR VGND sg13cmos5l_fill_1
XFILLER_89_361 VPWR VGND sg13cmos5l_fill_2
X_11023_ _11023_/Y _11061_/A _11061_/B _11056_/B VPWR VGND sg13cmos5l_nor3_1
X_15900_ _15900_/Y _19390_/Q _19389_/Q _19374_/Q VPWR VGND sg13cmos5l_nand3b_1
X_16880_ _19516_/D _17121_/B fanout29/X _16879_/Y VPWR VGND sg13cmos5l_a21oi_1
XFILLER_46_910 VPWR VGND sg13cmos5l_decap_4
X_15831_ _15831_/Y _15831_/A _15860_/A VPWR VGND sg13cmos5l_nor2_1
X_12974_ _12975_/B _12974_/A _12974_/B _12974_/C VPWR VGND sg13cmos5l_nand3_1
XFILLER_46_932 VPWR VGND sg13cmos5l_decap_8
X_15762_ _15763_/A _19318_/Q _15759_/Y _15761_/Y VPWR VGND sg13cmos5l_o21ai_1
X_18550_ _19784_/D _18550_/A _18549_/Y VPWR VGND sg13cmos5l_nor2b_1
X_11925_ _11925_/Y _11925_/A VPWR VGND sg13cmos5l_inv_1
X_19524__690 _19524_/RESET_B VPWR VGND sg13cmos5l_tiehi
XFILLER_73_740 VPWR VGND sg13cmos5l_fill_1
X_17501_ _17642_/A _17272_/A _17473_/A _17499_/Y VPWR VGND sg13cmos5l_a21o_1
XFILLER_46_976 VPWR VGND sg13cmos5l_fill_1
X_14713_ _14730_/B _19161_/Q _14715_/B VPWR VGND sg13cmos5l_nor2b_1
X_18481_ _19760_/D _18481_/A _18481_/B VPWR VGND sg13cmos5l_nor2_1
X_17432_ _19603_/D _09975_/Y fanout87/X _17431_/Y VPWR VGND sg13cmos5l_a21oi_1
X_15693_ _15694_/A _15717_/A _15693_/B VPWR VGND sg13cmos5l_nand2_1
XFILLER_17_188 VPWR VGND sg13cmos5l_fill_2
X_11856_ _11856_/Y _11856_/A VPWR VGND sg13cmos5l_inv_1
X_14644_ _19179_/D _14648_/A _14644_/B VPWR VGND sg13cmos5l_nor2_1
XFILLER_17_199 VPWR VGND sg13cmos5l_fill_2
X_11787_ _11795_/B _18747_/Q _18745_/Q _18746_/Q VPWR VGND sg13cmos5l_nor3_1
X_10807_ _10808_/B _10807_/A _10807_/B _10807_/C _10807_/D VPWR VGND sg13cmos5l_nor4_1
X_17363_ _19579_/D hold2524/X fanout27/X _17362_/Y VPWR VGND sg13cmos5l_a21oi_1
X_14575_ _14575_/Y _14575_/A _14575_/B VPWR VGND sg13cmos5l_nor2_1
X_10738_ _10738_/Y _10739_/A _10739_/B VPWR VGND sg13cmos5l_nor2_1
X_17294_ _17296_/D _17284_/A _17284_/B _17293_/Y VPWR VGND sg13cmos5l_o21ai_1
X_13526_ _13526_/Y _13526_/A _13526_/B VPWR VGND sg13cmos5l_nand2_1
X_19518__450 _19518_/D VPWR VGND sg13cmos5l_tielo
X_16314_ _19430_/D _16314_/A _16314_/B VPWR VGND sg13cmos5l_nor2_1
XFILLER_9_343 VPWR VGND sg13cmos5l_fill_2
X_19102_ _19102_/Q _19220_/CLK _19102_/D _19102_/RESET_B VPWR VGND sg13cmos5l_dfrbpq_1
X_19033_ _19033_/Q clkload31/A _19033_/D _19033_/RESET_B VPWR VGND sg13cmos5l_dfrbpq_1
X_13457_ _13465_/B _19011_/Q _19012_/Q _19013_/Q VPWR VGND sg13cmos5l_o21ai_1
X_16245_ _16318_/B _16252_/S _16244_/Y _16243_/Y VPWR VGND sg13cmos5l_a21o_1
X_12408_ _12408_/Y _12408_/A _12408_/B VPWR VGND sg13cmos5l_nor2_1
X_10669_ _10669_/Y _10673_/C _10669_/B VPWR VGND sg13cmos5l_nor2_1
XFILLER_9_387 VPWR VGND sg13cmos5l_fill_2
X_13388_ _13401_/B _18953_/Q _13388_/B VPWR VGND sg13cmos5l_xor2_1
X_16176_ _16177_/B _19417_/Q _19418_/Q _19419_/Q VPWR VGND sg13cmos5l_o21ai_1
X_12339_ _12535_/A _12728_/A _12341_/C VPWR VGND sg13cmos5l_xnor2_1
X_19531__683 _19531_/RESET_B VPWR VGND sg13cmos5l_tiehi
XFILLER_5_571 VPWR VGND sg13cmos5l_fill_2
XFILLER_5_560 VPWR VGND sg13cmos5l_decap_8
X_15127_ _15127_/Y _15194_/B _15163_/A VPWR VGND sg13cmos5l_nand2b_1
X_18595__1704 _18595_/RESET_B VPWR VGND sg13cmos5l_tiehi
X_15058_ _15134_/A _15057_/Y _15155_/B VPWR VGND sg13cmos5l_nand2b_1
Xhold2919 _17462_/A _19572_/Q VPWR VGND sg13cmos5l_dlygate4sd3_1
X_14009_ _14200_/A _14164_/A _14176_/A VPWR VGND sg13cmos5l_nand2_1
Xhold2908 _15692_/A _19341_/Q VPWR VGND sg13cmos5l_dlygate4sd3_1
X_18817_ _18817_/Q clkload68/A _18817_/D _18817_/RESET_B VPWR VGND sg13cmos5l_dfrbpq_1
X_19797_ _19797_/Q clkload22/A _19797_/D _19797_/RESET_B VPWR VGND sg13cmos5l_dfrbpq_1
X_18748_ _18748_/Q _18750_/CLK _18748_/D _18748_/RESET_B VPWR VGND sg13cmos5l_dfrbpq_1
XFILLER_83_537 VPWR VGND sg13cmos5l_decap_4
XFILLER_102_17 VPWR VGND sg13cmos5l_fill_1
XFILLER_37_954 VPWR VGND sg13cmos5l_decap_4
X_19018__1242 _19018_/RESET_B VPWR VGND sg13cmos5l_tiehi
X_18679_ _18679_/Q _19003_/CLK _18679_/D _18679_/RESET_B VPWR VGND sg13cmos5l_dfrbpq_1
X_18845__1427 _18845_/RESET_B VPWR VGND sg13cmos5l_tiehi
Xfanout300 _12462_/B _12240_/Y VPWR VGND sg13cmos5l_buf_1
Xfanout311 _11479_/A _11628_/A VPWR VGND sg13cmos5l_buf_1
Xfanout322 _11084_/B _10859_/Y VPWR VGND sg13cmos5l_buf_1
Xfanout355 _10748_/A _17417_/A VPWR VGND sg13cmos5l_buf_1
Xfanout366 _18470_/A _18005_/A VPWR VGND sg13cmos5l_buf_1
Xfanout333 _10497_/A _19743_/Q VPWR VGND sg13cmos5l_buf_1
Xfanout344 _14380_/A _19165_/Q VPWR VGND sg13cmos5l_buf_1
Xfanout399 _12527_/A _12529_/A VPWR VGND sg13cmos5l_buf_1
Xfanout377 _17152_/A _16603_/B VPWR VGND sg13cmos5l_buf_1
XFILLER_86_342 VPWR VGND sg13cmos5l_fill_2
Xfanout388 _14364_/A fanout403/X VPWR VGND sg13cmos5l_buf_1
XFILLER_100_163 VPWR VGND sg13cmos5l_fill_2
X_19161__1087 _19161_/RESET_B VPWR VGND sg13cmos5l_tiehi
XFILLER_36_55 VPWR VGND sg13cmos5l_fill_1
X_11710_ _11710_/X _11715_/B _11713_/C VPWR VGND sg13cmos5l_or2_1
XFILLER_54_250 VPWR VGND sg13cmos5l_fill_1
X_12690_ _12693_/A _12690_/A VPWR VGND sg13cmos5l_inv_1
X_11641_ _11642_/B _11632_/Y _11639_/Y _11640_/Y VPWR VGND sg13cmos5l_o21ai_1
X_11572_ _11572_/Y _11601_/B VPWR VGND sg13cmos5l_inv_1
X_14360_ _14360_/Y _14345_/B _14349_/X _14374_/A VPWR VGND sg13cmos5l_o21ai_1
X_13311_ _13312_/A _18940_/Q _13308_/Y _13310_/Y VPWR VGND sg13cmos5l_o21ai_1
XFILLER_7_825 VPWR VGND sg13cmos5l_fill_1
X_10523_ _10547_/B _19803_/Q _10540_/B VPWR VGND sg13cmos5l_nor2b_1
X_19794__1762 _19794_/RESET_B VPWR VGND sg13cmos5l_tiehi
XFILLER_6_335 VPWR VGND sg13cmos5l_decap_4
X_14291_ _14293_/A _14291_/A _14291_/B _14478_/A VPWR VGND sg13cmos5l_nand3_1
X_13242_ _13242_/Y _13210_/B _13210_/C _13293_/B VPWR VGND sg13cmos5l_a21oi_1
X_10454_ _10602_/C _19794_/Q _10608_/B VPWR VGND sg13cmos5l_xnor2_1
XFILLER_7_869 VPWR VGND sg13cmos5l_decap_4
X_16030_ _16030_/Y _16554_/A _19358_/Q _16028_/Y _16029_/Y VPWR VGND sg13cmos5l_a22oi_1
X_10385_ _10402_/A _10385_/A _10385_/B VPWR VGND sg13cmos5l_nor2_1
X_13173_ _13202_/A _13579_/A _13173_/B VPWR VGND sg13cmos5l_xnor2_1
X_12124_ _12124_/Y _12111_/A _12103_/Y _12123_/Y VPWR VGND sg13cmos5l_a21oi_1
XFILLER_2_530 VPWR VGND sg13cmos5l_fill_2
X_17981_ _17982_/B _19685_/Q _17979_/Y _18243_/B VPWR VGND sg13cmos5l_o21ai_1
XFILLER_2_574 VPWR VGND sg13cmos5l_fill_2
X_19720_ _19720_/Q clkload10/A _19720_/D _19720_/RESET_B VPWR VGND sg13cmos5l_dfrbpq_1
X_16932_ _16932_/Y _16932_/A _16932_/B VPWR VGND sg13cmos5l_nand2_1
X_12055_ _12055_/Y _12153_/B _12170_/A _12055_/C VPWR VGND sg13cmos5l_nand3_1
X_19094__1160 _19094_/RESET_B VPWR VGND sg13cmos5l_tiehi
XFILLER_93_824 VPWR VGND sg13cmos5l_fill_1
XFILLER_77_342 VPWR VGND sg13cmos5l_fill_1
X_16863_ _16863_/Y _17116_/A _16857_/A _16865_/B _17121_/B VPWR VGND sg13cmos5l_a22oi_1
X_11006_ _11006_/Y _11004_/Y _11005_/Y _11003_/Y VPWR VGND sg13cmos5l_a21oi_1
XFILLER_42_1027 VPWR VGND sg13cmos5l_fill_2
X_19651_ _19651_/Q clkload11/A _19651_/D _19651_/RESET_B VPWR VGND sg13cmos5l_dfrbpq_1
XFILLER_92_334 VPWR VGND sg13cmos5l_fill_1
X_19582_ _19582_/Q clkload38/A _19582_/D _19582_/RESET_B VPWR VGND sg13cmos5l_dfrbpq_1
X_18602_ _18602_/Q clkload55/A _18602_/D _18602_/RESET_B VPWR VGND sg13cmos5l_dfrbpq_1
X_15814_ _15814_/Y _19328_/Q _15828_/D VPWR VGND sg13cmos5l_xnor2_1
XFILLER_19_943 VPWR VGND sg13cmos5l_fill_1
X_16794_ _16811_/A _16757_/A _16793_/B _16793_/Y VPWR VGND sg13cmos5l_a21oi_1
X_18533_ _18533_/Y hold1979/X fanout84/X _18541_/A VPWR VGND sg13cmos5l_o21ai_1
XFILLER_18_453 VPWR VGND sg13cmos5l_fill_1
XFILLER_19_976 VPWR VGND sg13cmos5l_fill_2
X_12957_ _12957_/X _12954_/Y _12953_/Y _12957_/S VPWR VGND sg13cmos5l_mux2_1
X_15745_ _19349_/D _15748_/A _15745_/B VPWR VGND sg13cmos5l_nor2_1
XFILLER_34_913 VPWR VGND sg13cmos5l_fill_1
X_11908_ _11908_/Y _12458_/A _18726_/Q _18725_/Q _12457_/A VPWR VGND sg13cmos5l_a22oi_1
X_12888_ _12908_/D _18927_/Q _18928_/Q _18929_/Q VPWR VGND sg13cmos5l_or3_1
X_18464_ _18464_/Y _18423_/B _18462_/S _18482_/A VPWR VGND sg13cmos5l_o21ai_1
X_15676_ _15678_/B _15676_/A _15676_/B VPWR VGND sg13cmos5l_nor2_1
XFILLER_34_979 VPWR VGND sg13cmos5l_fill_1
X_11839_ _11839_/Y _11744_/B _11904_/B _11838_/Y VPWR VGND sg13cmos5l_o21ai_1
X_17415_ _17416_/B _19601_/Q _17413_/Y _17693_/B VPWR VGND sg13cmos5l_o21ai_1
X_14627_ _19165_/D _14643_/B _14627_/B VPWR VGND sg13cmos5l_nor2_1
X_18395_ _18414_/B _18388_/X _18392_/Y _18393_/Y VPWR VGND sg13cmos5l_a21o_1
X_17346_ _17346_/X _17346_/A _17346_/B VPWR VGND sg13cmos5l_xor2_1
X_14558_ _14577_/B _14552_/Y _14556_/Y _14557_/Y VPWR VGND sg13cmos5l_a21oi_1
X_17277_ _17283_/B _19580_/Q _17277_/B VPWR VGND sg13cmos5l_xnor2_1
X_13509_ _13509_/Y _13500_/A _13500_/B _13500_/C _13500_/D VPWR VGND sg13cmos5l_a22oi_1
X_14489_ _14489_/Y _14489_/A _14489_/B VPWR VGND sg13cmos5l_nor2_1
X_19016_ _19016_/Q clkload53/A _19016_/D _19016_/RESET_B VPWR VGND sg13cmos5l_dfrbpq_1
X_16228_ _16233_/C _16238_/A _16228_/B VPWR VGND sg13cmos5l_nand2_1
X_16159_ _16273_/C _16159_/A _16159_/B _16159_/C VPWR VGND sg13cmos5l_nand3_1
Xhold2705 hold2705/X _18843_/Q VPWR VGND sg13cmos5l_dlygate4sd3_1
XFILLER_102_428 VPWR VGND sg13cmos5l_fill_2
Xhold2738 _11751_/A _18758_/Q VPWR VGND sg13cmos5l_dlygate4sd3_1
Xhold2716 _10056_/A _18876_/Q VPWR VGND sg13cmos5l_dlygate4sd3_1
Xhold2727 hold2727/X _19799_/Q VPWR VGND sg13cmos5l_dlygate4sd3_1
Xhold2749 _12453_/A _12441_/A VPWR VGND sg13cmos5l_dlygate4sd3_1
XFILLER_95_183 VPWR VGND sg13cmos5l_fill_2
XFILLER_95_172 VPWR VGND sg13cmos5l_fill_1
XFILLER_56_537 VPWR VGND sg13cmos5l_decap_8
XFILLER_58_1001 VPWR VGND sg13cmos5l_fill_1
XFILLER_24_434 VPWR VGND sg13cmos5l_fill_2
XFILLER_25_946 VPWR VGND sg13cmos5l_fill_2
X_19260__982 _19260_/RESET_B VPWR VGND sg13cmos5l_tiehi
X_18809__1466 _18809_/RESET_B VPWR VGND sg13cmos5l_tiehi
XFILLER_20_640 VPWR VGND sg13cmos5l_fill_1
XFILLER_4_806 VPWR VGND sg13cmos5l_fill_1
XFILLER_106_734 VPWR VGND sg13cmos5l_decap_8
XFILLER_106_756 VPWR VGND sg13cmos5l_fill_2
XFILLER_105_244 VPWR VGND sg13cmos5l_fill_1
X_19179__1069 _19179_/RESET_B VPWR VGND sg13cmos5l_tiehi
X_10170_ _17937_/A _10170_/A VPWR VGND sg13cmos5l_inv_1
XFILLER_105_288 VPWR VGND sg13cmos5l_decap_4
X_19805__541 _19805_/D VPWR VGND sg13cmos5l_tielo
Xfanout130 _14737_/A _14578_/B VPWR VGND sg13cmos5l_buf_1
XFILLER_102_962 VPWR VGND sg13cmos5l_decap_8
Xfanout152 _17058_/B _16947_/Y VPWR VGND sg13cmos5l_buf_1
Xfanout174 _14050_/B _13932_/Y VPWR VGND sg13cmos5l_buf_1
Xfanout141 _18450_/B _18349_/Y VPWR VGND sg13cmos5l_buf_1
Xfanout163 _15433_/B _15331_/B VPWR VGND sg13cmos5l_buf_1
Xfanout185 _12414_/B _12381_/Y VPWR VGND sg13cmos5l_buf_1
Xfanout196 _11013_/B _11006_/Y VPWR VGND sg13cmos5l_buf_1
X_13860_ _19060_/D _14076_/B _13860_/B VPWR VGND sg13cmos5l_nor2_1
X_13791_ _13791_/Y _13791_/A _13805_/C _13791_/C VPWR VGND sg13cmos5l_nand3_1
X_12811_ _12811_/Y _12850_/A VPWR VGND sg13cmos5l_inv_1
X_12742_ _12742_/Y _18917_/Q _10277_/Y _12766_/B _18916_/Q _12741_/Y VPWR VGND sg13cmos5l_a221oi_1
X_15530_ _15546_/B _19285_/Q _19286_/Q _19283_/Q _19284_/Q VPWR VGND sg13cmos5l_nor4_1
XFILLER_16_946 VPWR VGND sg13cmos5l_fill_2
X_12673_ _12685_/C _12674_/B VPWR VGND sg13cmos5l_inv_1
X_15461_ _19305_/D _15464_/A _15461_/B VPWR VGND sg13cmos5l_nor2_1
X_17200_ _17202_/B _17015_/Y _17199_/Y _17200_/S VPWR VGND sg13cmos5l_mux2_1
X_11624_ _18715_/D _11624_/A _11628_/A VPWR VGND sg13cmos5l_nor2_1
X_14412_ _14412_/Y _14909_/A _14910_/A _14392_/B _14135_/B VPWR VGND sg13cmos5l_a22oi_1
X_15392_ _15392_/Y _15392_/A _15392_/B VPWR VGND sg13cmos5l_nor2_1
X_18180_ _18181_/B _18180_/A _18180_/B _18180_/C VPWR VGND sg13cmos5l_nor3_1
X_11555_ _11556_/B _11555_/A _11560_/B VPWR VGND sg13cmos5l_nand2_1
X_17131_ _17131_/Y _17666_/B _17930_/A VPWR VGND sg13cmos5l_nand2b_1
X_14343_ _14344_/A _14343_/A _14343_/B VPWR VGND sg13cmos5l_nand2_1
X_17062_ _17063_/B _17062_/A _17062_/B VPWR VGND sg13cmos5l_nor2_1
X_11486_ _11595_/A _18714_/Q _11588_/B VPWR VGND sg13cmos5l_xnor2_1
XFILLER_6_132 VPWR VGND sg13cmos5l_fill_1
X_14274_ _14291_/A _14260_/Y _14269_/Y _14272_/Y VPWR VGND sg13cmos5l_o21ai_1
X_10506_ _10506_/Y _10506_/A _10506_/B VPWR VGND sg13cmos5l_nand2_1
X_13225_ _13258_/A _13257_/B _13257_/C _13257_/A VPWR VGND sg13cmos5l_a21oi_1
X_16013_ _19385_/D _16013_/A _16016_/B VPWR VGND sg13cmos5l_nor2_1
X_10437_ _10443_/C _10437_/A _10437_/B _10437_/C VPWR VGND sg13cmos5l_nand3_1
XFILLER_98_938 VPWR VGND sg13cmos5l_decap_4
X_10368_ _16831_/B _10368_/A VPWR VGND sg13cmos5l_inv_1
X_13156_ _13159_/B _18969_/Q _18970_/Q hold2974/X VPWR VGND sg13cmos5l_o21ai_1
X_12107_ _12109_/D _12104_/A _12104_/B _12106_/Y VPWR VGND sg13cmos5l_o21ai_1
X_10299_ _10299_/Y _10299_/A VPWR VGND sg13cmos5l_inv_1
X_13087_ _18946_/D _13573_/A _13212_/B VPWR VGND sg13cmos5l_and2_1
X_17964_ _17965_/A _17975_/C _17963_/Y _17962_/Y VPWR VGND sg13cmos5l_o21ai_1
XFILLER_2_393 VPWR VGND sg13cmos5l_decap_4
X_16915_ _16915_/Y _16732_/Y _16932_/B VPWR VGND sg13cmos5l_nand2b_1
X_12038_ _12056_/A _12039_/A _12051_/B VPWR VGND sg13cmos5l_or2_1
X_19703_ _19703_/Q clkload14/A _19703_/D _19703_/RESET_B VPWR VGND sg13cmos5l_dfrbpq_1
X_19634_ _19634_/Q clkload26/A _19634_/D _19634_/RESET_B VPWR VGND sg13cmos5l_dfrbpq_1
X_17895_ _17897_/C _17895_/A _17895_/B _17895_/C VPWR VGND sg13cmos5l_nand3_1
X_16846_ _16848_/B _16861_/C _16844_/Y _16845_/Y VPWR VGND sg13cmos5l_o21ai_1
X_18885__1384 _18885_/RESET_B VPWR VGND sg13cmos5l_tiehi
X_16777_ _16777_/Y _16792_/B _16693_/X _16824_/B _16788_/S _16775_/Y VPWR VGND sg13cmos5l_a221oi_1
X_19565_ _19565_/Q clkload24/A _19565_/D _19565_/RESET_B VPWR VGND sg13cmos5l_dfrbpq_1
X_13989_ _13991_/A _13978_/Y _13985_/Y _13988_/Y VPWR VGND sg13cmos5l_o21ai_1
X_19496_ _19496_/Q clkload33/A _19496_/D _19496_/RESET_B VPWR VGND sg13cmos5l_dfrbpq_1
X_18516_ _18516_/Y _18516_/A VPWR VGND sg13cmos5l_inv_1
X_19686__1773 _19686_/RESET_B VPWR VGND sg13cmos5l_tiehi
X_15728_ _19334_/D _15742_/B _15728_/B VPWR VGND sg13cmos5l_nor2_1
X_18447_ _18447_/Y _18453_/A _18453_/B VPWR VGND sg13cmos5l_nand2_1
X_15659_ _15659_/Y _15698_/A _15743_/B _15744_/B _15695_/A VPWR VGND sg13cmos5l_a22oi_1
X_18378_ _18378_/Y _19758_/Q _19757_/Q _19742_/Q VPWR VGND sg13cmos5l_nand3b_1
X_17329_ _17335_/A _17334_/A _17334_/B _17328_/X _17235_/Y VPWR VGND sg13cmos5l_a22oi_1
X_19134__1117 _19134_/RESET_B VPWR VGND sg13cmos5l_tiehi
XFILLER_103_726 VPWR VGND sg13cmos5l_decap_8
Xhold2513 _09984_/A _19440_/Q VPWR VGND sg13cmos5l_dlygate4sd3_1
Xhold2502 _10225_/A _19228_/Q VPWR VGND sg13cmos5l_dlygate4sd3_1
Xhold2546 _10282_/A _18808_/Q VPWR VGND sg13cmos5l_dlygate4sd3_1
XFILLER_69_651 VPWR VGND sg13cmos5l_decap_4
Xhold2524 hold2524/X _17348_/B VPWR VGND sg13cmos5l_dlygate4sd3_1
Xhold2535 _10316_/A _18666_/Q VPWR VGND sg13cmos5l_dlygate4sd3_1
Xhold2568 _12623_/A _18889_/Q VPWR VGND sg13cmos5l_dlygate4sd3_1
Xhold2557 _10149_/A _19496_/Q VPWR VGND sg13cmos5l_dlygate4sd3_1
Xhold1845 _16890_/B _19481_/Q VPWR VGND sg13cmos5l_dlygate4sd3_1
Xhold1823 _13645_/B _18581_/Q VPWR VGND sg13cmos5l_dlygate4sd3_1
Xhold1834 _11152_/B _18609_/Q VPWR VGND sg13cmos5l_dlygate4sd3_1
Xhold2579 _10165_/A _19620_/Q VPWR VGND sg13cmos5l_dlygate4sd3_1
Xhold1856 _13357_/B _18944_/Q VPWR VGND sg13cmos5l_dlygate4sd3_1
Xhold1878 _10016_/A _18605_/Q VPWR VGND sg13cmos5l_dlygate4sd3_1
Xhold1867 _14708_/B _19154_/Q VPWR VGND sg13cmos5l_dlygate4sd3_1
XFILLER_83_153 VPWR VGND sg13cmos5l_fill_1
Xhold1889 _17151_/B _19523_/Q VPWR VGND sg13cmos5l_dlygate4sd3_1
XFILLER_40_702 VPWR VGND sg13cmos5l_fill_2
XFILLER_71_1020 VPWR VGND sg13cmos5l_decap_8
XFILLER_8_408 VPWR VGND sg13cmos5l_fill_1
X_11340_ _11341_/B _11311_/Y _11309_/X _11342_/S VPWR VGND sg13cmos5l_mux2_1
X_13010_ _13012_/B _13010_/A _13011_/A VPWR VGND sg13cmos5l_nor2b_1
X_11271_ _11271_/Y _11447_/A VPWR VGND sg13cmos5l_inv_1
XFILLER_106_553 VPWR VGND sg13cmos5l_fill_1
X_18597__538 _18597_/D VPWR VGND sg13cmos5l_tielo
X_10222_ _15220_/A _10222_/A VPWR VGND sg13cmos5l_inv_1
XFILLER_106_586 VPWR VGND sg13cmos5l_decap_8
X_10153_ _17366_/A _16982_/B VPWR VGND sg13cmos5l_inv_1
X_10084_ _16823_/A _13603_/B VPWR VGND sg13cmos5l_inv_1
X_18840__1432 _18840_/RESET_B VPWR VGND sg13cmos5l_tiehi
X_16700_ _16746_/A _16916_/A VPWR VGND sg13cmos5l_inv_1
XFILLER_58_86 VPWR VGND sg13cmos5l_decap_8
X_14961_ _19229_/D _10224_/Y _14958_/S _14960_/Y VPWR VGND sg13cmos5l_a21oi_1
XFILLER_74_120 VPWR VGND sg13cmos5l_fill_1
X_13912_ _13912_/Y _13912_/A _13923_/B VPWR VGND sg13cmos5l_nor2_1
X_17680_ _17680_/Y _17831_/A _17696_/A _17400_/A _19658_/Q VPWR VGND sg13cmos5l_a22oi_1
X_14892_ _19206_/D hold2566/X _14895_/S _14891_/Y VPWR VGND sg13cmos5l_a21oi_1
X_16631_ _16631_/X _19035_/Q _16631_/B VPWR VGND sg13cmos5l_xor2_1
X_13843_ _13843_/Y _19083_/Q _14371_/A _13849_/C VPWR VGND sg13cmos5l_nand3_1
X_19350_ _19350_/Q clkload17/A _19350_/D _19350_/RESET_B VPWR VGND sg13cmos5l_dfrbpq_1
X_16562_ _19468_/D _16562_/A _16562_/B VPWR VGND sg13cmos5l_nor2_1
X_13774_ _13774_/Y _13764_/Y _13767_/Y _13770_/Y _13772_/Y _13773_/Y VPWR VGND sg13cmos5l_a221oi_1
X_10986_ _10986_/Y _10921_/Y _11088_/B _11089_/B _11028_/A VPWR VGND sg13cmos5l_a22oi_1
XFILLER_15_231 VPWR VGND sg13cmos5l_fill_1
X_15513_ _15513_/Y _15750_/B _15516_/S _15512_/Y VPWR VGND sg13cmos5l_a21oi_1
X_18301_ _18302_/B _18301_/A _18309_/B VPWR VGND sg13cmos5l_xnor2_1
X_12725_ _18880_/D _12725_/A _12728_/B VPWR VGND sg13cmos5l_nor2_1
X_16493_ _16494_/B _16512_/B _16492_/Y _16512_/A VPWR VGND sg13cmos5l_a21oi_1
X_19281_ _19281_/Q clkload48/A _19281_/D _19281_/RESET_B VPWR VGND sg13cmos5l_dfrbpq_1
X_12656_ _12656_/X _12568_/B _12653_/Y _12655_/Y VPWR VGND sg13cmos5l_a21o_1
X_15444_ _19291_/D _15458_/B _15444_/B VPWR VGND sg13cmos5l_nor2_1
X_18232_ _19719_/D _18233_/A _18232_/B VPWR VGND sg13cmos5l_nor2_1
XFILLER_30_245 VPWR VGND sg13cmos5l_fill_2
X_12587_ _12695_/B _12587_/A _12599_/B VPWR VGND sg13cmos5l_nand2_1
X_11607_ _11608_/B _11578_/X _11586_/A _11614_/B VPWR VGND sg13cmos5l_mux2_1
X_15375_ _15376_/B _15378_/A _15378_/C _15374_/Y VPWR VGND sg13cmos5l_o21ai_1
X_18163_ _18163_/Y _18315_/A _18319_/A VPWR VGND sg13cmos5l_nand2_1
X_17114_ _17114_/Y _19554_/Q _17105_/Y _17113_/Y _19555_/Q VPWR VGND sg13cmos5l_a22oi_1
X_14326_ _14328_/A _14343_/A _14326_/B VPWR VGND sg13cmos5l_and2_1
X_11538_ _11540_/B _11533_/B _18718_/Q _11536_/Y VPWR VGND sg13cmos5l_a21oi_1
XFILLER_8_997 VPWR VGND sg13cmos5l_fill_2
X_18094_ _18120_/B _19715_/Q _19716_/Q _19717_/Q VPWR VGND sg13cmos5l_or3_1
X_17045_ _17049_/A _17045_/A _17043_/Y VPWR VGND sg13cmos5l_nor2b_1
X_11469_ _11469_/X _11469_/A _11469_/B VPWR VGND sg13cmos5l_and2_1
X_14257_ _14304_/A _19141_/Q _14257_/B VPWR VGND sg13cmos5l_xnor2_1
X_13208_ _13259_/B _13210_/B _13210_/C VPWR VGND sg13cmos5l_and2_1
X_14188_ _14189_/B _14288_/A _14288_/B VPWR VGND sg13cmos5l_nand2_1
X_13139_ _13207_/A _13108_/A _13114_/A _13106_/Y _13122_/B VPWR VGND sg13cmos5l_a22oi_1
X_18996_ _18996_/Q clkload66/A _18996_/D _18996_/RESET_B VPWR VGND sg13cmos5l_dfrbpq_1
X_19250__992 _19250_/RESET_B VPWR VGND sg13cmos5l_tiehi
XFILLER_94_930 VPWR VGND sg13cmos5l_fill_1
X_17947_ _17947_/Y _18474_/A _19641_/Q VPWR VGND sg13cmos5l_nor2_1
X_19724__1365 _19724_/RESET_B VPWR VGND sg13cmos5l_tiehi
X_17878_ _17878_/Y _17904_/A _17942_/B _17877_/Y VPWR VGND sg13cmos5l_a21oi_1
X_16829_ _19510_/D _16829_/A _16829_/B VPWR VGND sg13cmos5l_and2_1
XFILLER_66_698 VPWR VGND sg13cmos5l_fill_1
XFILLER_65_164 VPWR VGND sg13cmos5l_decap_4
X_19617_ _19617_/Q clkload25/A _19617_/D _19617_/RESET_B VPWR VGND sg13cmos5l_dfrbpq_1
XFILLER_26_518 VPWR VGND sg13cmos5l_fill_1
X_19548_ _19548_/Q clkload40/A _19548_/D _19548_/RESET_B VPWR VGND sg13cmos5l_dfrbpq_1
XFILLER_0_1013 VPWR VGND sg13cmos5l_decap_8
X_19479_ _19479_/Q clkload28/A _19479_/D _19479_/RESET_B VPWR VGND sg13cmos5l_dfrbpq_1
X_18675__1618 _18675_/RESET_B VPWR VGND sg13cmos5l_tiehi
XFILLER_55_1026 VPWR VGND sg13cmos5l_fill_2
XFILLER_22_713 VPWR VGND sg13cmos5l_fill_1
Xhold3011 _16721_/B _19506_/Q VPWR VGND sg13cmos5l_dlygate4sd3_1
Xhold3000 hold3000/X _11257_/X VPWR VGND sg13cmos5l_dlygate4sd3_1
Xhold3033 hold3033/X _18661_/Q VPWR VGND sg13cmos5l_dlygate4sd3_1
Xhold3022 _14805_/B _19222_/Q VPWR VGND sg13cmos5l_dlygate4sd3_1
XFILLER_103_545 VPWR VGND sg13cmos5l_decap_4
Xhold2321 _13807_/B _18590_/Q VPWR VGND sg13cmos5l_dlygate4sd3_1
X_18621__1675 _18621_/RESET_B VPWR VGND sg13cmos5l_tiehi
X_09996_ _09996_/Y _13938_/A VPWR VGND sg13cmos5l_inv_1
Xhold3055 hold3055/X _18635_/Q VPWR VGND sg13cmos5l_dlygate4sd3_1
Xhold2310 _15518_/B _19317_/Q VPWR VGND sg13cmos5l_dlygate4sd3_1
Xhold3044 hold3044/X _19695_/Q VPWR VGND sg13cmos5l_dlygate4sd3_1
Xhold2332 _17142_/B _19559_/Q VPWR VGND sg13cmos5l_dlygate4sd3_1
Xhold2343 _10171_/A _18620_/Q VPWR VGND sg13cmos5l_dlygate4sd3_1
Xhold2354 _19274_/D _15246_/Y VPWR VGND sg13cmos5l_dlygate4sd3_1
Xhold2376 _13636_/B _19023_/Q VPWR VGND sg13cmos5l_dlygate4sd3_1
Xhold2398 _10146_/A _19492_/Q VPWR VGND sg13cmos5l_dlygate4sd3_1
Xhold2365 hold2365/X _11958_/Y VPWR VGND sg13cmos5l_dlygate4sd3_1
Xhold2387 _18687_/D _11415_/Y VPWR VGND sg13cmos5l_dlygate4sd3_1
XFILLER_28_45 VPWR VGND sg13cmos5l_fill_2
XFILLER_57_665 VPWR VGND sg13cmos5l_fill_1
XFILLER_29_367 VPWR VGND sg13cmos5l_fill_2
X_10840_ _10841_/B _10850_/C _10839_/Y _10838_/Y VPWR VGND sg13cmos5l_o21ai_1
X_10771_ _10771_/Y _13808_/A _10766_/Y _10770_/Y VPWR VGND sg13cmos5l_o21ai_1
XFILLER_53_871 VPWR VGND sg13cmos5l_fill_2
X_12510_ _18850_/D _12728_/B _12510_/B VPWR VGND sg13cmos5l_nor2_1
X_13490_ _13512_/B _13479_/X _13486_/Y _13489_/Y VPWR VGND sg13cmos5l_a21oi_1
XFILLER_13_746 VPWR VGND sg13cmos5l_fill_2
X_12441_ _12451_/A _12441_/A _12453_/C _12441_/C VPWR VGND sg13cmos5l_nand3_1
XFILLER_60_21 VPWR VGND sg13cmos5l_decap_4
XFILLER_8_249 VPWR VGND sg13cmos5l_fill_1
X_12372_ _12372_/Y _12360_/Y _12366_/Y _12371_/Y VPWR VGND sg13cmos5l_o21ai_1
X_15160_ _15161_/B _15160_/A _15160_/B VPWR VGND sg13cmos5l_or2_1
X_11323_ _11323_/Y _11323_/A _11323_/B _11323_/C VPWR VGND sg13cmos5l_nand3_1
X_15091_ _15119_/B _15460_/A _15091_/B VPWR VGND sg13cmos5l_xnor2_1
X_14111_ _14111_/Y _14111_/A VPWR VGND sg13cmos5l_inv_1
Xclkbuf_4_0_0_clk clkbuf_4_0_0_clk/X clkbuf_0_clk/X VPWR VGND sg13cmos5l_buf_8
X_11254_ _11255_/B _18675_/Q _18676_/Q _18677_/Q VPWR VGND sg13cmos5l_o21ai_1
X_14042_ _14042_/Y _14024_/A _14024_/B _14035_/X _14040_/Y _14041_/Y VPWR VGND sg13cmos5l_a221oi_1
XFILLER_4_477 VPWR VGND sg13cmos5l_fill_2
XFILLER_106_394 VPWR VGND sg13cmos5l_decap_8
X_18850_ _18850_/Q clkload68/A _18850_/D _18850_/RESET_B VPWR VGND sg13cmos5l_dfrbpq_1
X_10205_ _10205_/Y _10205_/A VPWR VGND sg13cmos5l_inv_1
XFILLER_79_234 VPWR VGND sg13cmos5l_fill_2
XFILLER_68_919 VPWR VGND sg13cmos5l_fill_1
X_11185_ _11188_/A _11185_/A _11198_/B VPWR VGND sg13cmos5l_nor2_1
X_17801_ _17910_/A _19671_/Q _17803_/B VPWR VGND sg13cmos5l_nor2_1
X_18781_ _18781_/Q clkload61/A _18781_/D _18781_/RESET_B VPWR VGND sg13cmos5l_dfrbpq_1
X_10136_ _16556_/A _10136_/A VPWR VGND sg13cmos5l_inv_1
XFILLER_0_683 VPWR VGND sg13cmos5l_fill_1
X_15993_ _15994_/B _15993_/A _15993_/B VPWR VGND sg13cmos5l_nor2_1
X_10067_ _13578_/A _10067_/A VPWR VGND sg13cmos5l_inv_1
X_17732_ _19645_/D _09972_/Y fanout66/X _17731_/Y VPWR VGND sg13cmos5l_a21oi_1
XFILLER_48_643 VPWR VGND sg13cmos5l_fill_1
X_14944_ _14945_/B _14948_/C _14942_/Y _14943_/Y VPWR VGND sg13cmos5l_a21o_1
X_17663_ _19620_/D _17679_/A _17663_/B _17663_/C VPWR VGND sg13cmos5l_nor3_1
XFILLER_35_304 VPWR VGND sg13cmos5l_fill_2
X_18804__1471 _18804_/RESET_B VPWR VGND sg13cmos5l_tiehi
XFILLER_90_432 VPWR VGND sg13cmos5l_fill_1
X_16614_ _16614_/Y _16860_/A _16614_/B VPWR VGND sg13cmos5l_nand2_1
XFILLER_63_635 VPWR VGND sg13cmos5l_fill_1
X_14875_ _14876_/C _14875_/A _14875_/B _14875_/C VPWR VGND sg13cmos5l_nand3_1
X_19402_ _19402_/Q clkload6/A _19402_/D _19402_/RESET_B VPWR VGND sg13cmos5l_dfrbpq_1
X_17594_ _17594_/Y _17562_/D _17542_/B _17588_/B VPWR VGND sg13cmos5l_a21oi_1
X_13826_ _13826_/Y _19085_/Q _10258_/Y _10259_/Y _19084_/Q _13825_/Y VPWR VGND sg13cmos5l_a221oi_1
X_13757_ _13800_/A _13817_/B _10800_/Y _13780_/B VPWR VGND sg13cmos5l_mux2_1
XFILLER_90_487 VPWR VGND sg13cmos5l_fill_2
XFILLER_62_178 VPWR VGND sg13cmos5l_fill_2
X_10969_ _10969_/X _10989_/B _10989_/C VPWR VGND sg13cmos5l_and2_1
X_19333_ _19333_/Q clkload16/A _19333_/D _19333_/RESET_B VPWR VGND sg13cmos5l_dfrbpq_1
X_16545_ _16545_/Y _16527_/Y fanout32/X _16553_/B VPWR VGND sg13cmos5l_o21ai_1
X_12708_ _12708_/Y _12708_/A _12708_/B VPWR VGND sg13cmos5l_nor2_1
X_19264_ _19264_/Q _19304_/CLK _19264_/D _19264_/RESET_B VPWR VGND sg13cmos5l_dfrbpq_1
X_16476_ _16476_/Y _16529_/B VPWR VGND sg13cmos5l_inv_1
X_13688_ _13688_/Y _13688_/A _16651_/A VPWR VGND sg13cmos5l_nor2_1
XFILLER_86_4 VPWR VGND sg13cmos5l_fill_1
X_18215_ _19703_/D _18174_/A _18212_/S _18214_/Y VPWR VGND sg13cmos5l_a21oi_1
X_19174__1074 _19174_/RESET_B VPWR VGND sg13cmos5l_tiehi
X_15427_ _15436_/A _15324_/Y _15427_/B _15427_/C VPWR VGND sg13cmos5l_nand3b_1
X_12639_ _12825_/A _13022_/A _12639_/B VPWR VGND sg13cmos5l_xnor2_1
X_19195_ _19195_/Q clkload42/A _19195_/D _19195_/RESET_B VPWR VGND sg13cmos5l_dfrbpq_1
X_15358_ _15364_/B _19293_/Q _19294_/Q _19292_/Q _19291_/Q VPWR VGND sg13cmos5l_nor4_1
X_18146_ _18146_/Y _18120_/B _18117_/B _18159_/B VPWR VGND sg13cmos5l_a21oi_1
X_18077_ _18186_/C _19689_/Q _18077_/B _18176_/A VPWR VGND sg13cmos5l_nand3_1
X_15289_ _15289_/Y _15279_/X _15281_/Y _15098_/B VPWR VGND sg13cmos5l_a21oi_1
X_14309_ _14314_/A _14295_/Y _14302_/X _14308_/Y VPWR VGND sg13cmos5l_o21ai_1
X_17028_ _17053_/B _17040_/B _17040_/C VPWR VGND sg13cmos5l_nor2_1
XFILLER_105_39 VPWR VGND sg13cmos5l_fill_1
X_18979_ _18979_/Q _19092_/CLK _18979_/D _18979_/RESET_B VPWR VGND sg13cmos5l_dfrbpq_1
XFILLER_39_610 VPWR VGND sg13cmos5l_fill_2
XFILLER_53_101 VPWR VGND sg13cmos5l_fill_1
XFILLER_50_885 VPWR VGND sg13cmos5l_fill_1
X_18639__1657 _18639_/RESET_B VPWR VGND sg13cmos5l_tiehi
XFILLER_22_598 VPWR VGND sg13cmos5l_fill_1
XFILLER_30_79 VPWR VGND sg13cmos5l_fill_1
X_09979_ _09979_/Y _16159_/A VPWR VGND sg13cmos5l_inv_1
Xhold2151 _18811_/D _12248_/Y VPWR VGND sg13cmos5l_dlygate4sd3_1
Xhold2173 _16816_/B _19045_/Q VPWR VGND sg13cmos5l_dlygate4sd3_1
Xhold2162 _12745_/A _18852_/Q VPWR VGND sg13cmos5l_dlygate4sd3_1
XFILLER_39_77 VPWR VGND sg13cmos5l_fill_2
Xhold2140 _19459_/D _16553_/X VPWR VGND sg13cmos5l_dlygate4sd3_1
X_12990_ _12997_/A _13028_/B _12990_/B VPWR VGND sg13cmos5l_nor2_1
X_19622__440 _19622_/D VPWR VGND sg13cmos5l_tielo
Xhold2195 _19597_/D _17422_/Y VPWR VGND sg13cmos5l_dlygate4sd3_1
Xhold2184 _10126_/A _19377_/Q VPWR VGND sg13cmos5l_dlygate4sd3_1
X_11941_ _11941_/Y _12230_/B _11941_/B VPWR VGND sg13cmos5l_nor2_1
X_11872_ _11873_/B _11872_/A _11872_/B VPWR VGND sg13cmos5l_or2_1
XFILLER_60_605 VPWR VGND sg13cmos5l_fill_1
X_14660_ _14660_/Y _19146_/Q _14660_/B VPWR VGND sg13cmos5l_nand2_1
X_13611_ _13611_/Y _16820_/A _19044_/Q VPWR VGND sg13cmos5l_nor2_1
X_10823_ _10823_/Y _11354_/A _19767_/Q _19768_/Q _11355_/A _10822_/Y VPWR VGND sg13cmos5l_a221oi_1
X_14591_ _14591_/Y _14591_/A _14591_/B VPWR VGND sg13cmos5l_nor2_1
X_13542_ _13544_/B _13542_/A _13542_/B VPWR VGND sg13cmos5l_nor2_1
X_16330_ _16331_/B _16409_/A _19402_/Q VPWR VGND sg13cmos5l_nand2_1
X_10754_ _10756_/B _10779_/A _10779_/B VPWR VGND sg13cmos5l_nor2b_1
XFILLER_71_53 VPWR VGND sg13cmos5l_fill_2
X_10685_ _10685_/Y _10384_/B _10681_/Y _16889_/A VPWR VGND sg13cmos5l_o21ai_1
X_18000_ _19688_/D _09971_/Y fanout89/X _17999_/Y VPWR VGND sg13cmos5l_a21oi_1
X_13473_ _13485_/B _13473_/A _13475_/B VPWR VGND sg13cmos5l_nor2b_1
X_16261_ _16261_/Y _16261_/A _16320_/B VPWR VGND sg13cmos5l_nor2_1
X_12424_ _12424_/Y _12413_/Y _12416_/Y _12423_/Y VPWR VGND sg13cmos5l_o21ai_1
X_16192_ _16192_/Y _16185_/Y _16189_/Y _16190_/Y VPWR VGND sg13cmos5l_a21oi_1
X_15212_ _15238_/A _15225_/C _15210_/Y _15211_/Y VPWR VGND sg13cmos5l_o21ai_1
X_12355_ _12355_/Y _12355_/A _12355_/B _12464_/B VPWR VGND sg13cmos5l_nand3_1
X_15143_ _15144_/A _15189_/B _15156_/B _15142_/Y VPWR VGND sg13cmos5l_a21o_1
X_11306_ _11306_/Y _11306_/A _11306_/B VPWR VGND sg13cmos5l_nor2_1
XFILLER_5_775 VPWR VGND sg13cmos5l_fill_1
X_12286_ _12306_/B _12277_/Y _12282_/Y _12285_/Y VPWR VGND sg13cmos5l_o21ai_1
X_15074_ _15115_/A _19266_/Q _15074_/B VPWR VGND sg13cmos5l_xor2_1
X_18902_ _18902_/Q _18902_/CLK _18902_/D _18902_/RESET_B VPWR VGND sg13cmos5l_dfrbpq_1
X_11237_ _11238_/B _11237_/A _11237_/B VPWR VGND sg13cmos5l_xor2_1
X_14025_ _14026_/B _19088_/Q _13951_/B _13929_/Y VPWR VGND sg13cmos5l_a21oi_1
X_18833_ _18833_/Q clkload69/A _18833_/D _18833_/RESET_B VPWR VGND sg13cmos5l_dfrbpq_1
XFILLER_96_50 VPWR VGND sg13cmos5l_fill_1
X_11168_ _11170_/B _10984_/A _11156_/X _11203_/A _11174_/A VPWR VGND sg13cmos5l_a22oi_1
X_18764_ _18764_/Q clkload39/A _18764_/D _18764_/RESET_B VPWR VGND sg13cmos5l_dfrbpq_1
X_10119_ _16013_/A _10119_/A VPWR VGND sg13cmos5l_inv_1
X_11099_ _11099_/Y _11624_/A _18603_/Q _11098_/Y VPWR VGND sg13cmos5l_o21ai_1
XFILLER_49_974 VPWR VGND sg13cmos5l_fill_2
X_17715_ _17716_/B _17729_/B _17713_/Y _17962_/B VPWR VGND sg13cmos5l_o21ai_1
X_15976_ _15977_/A _15878_/B _15991_/A _15976_/C VPWR VGND sg13cmos5l_nand3b_1
XFILLER_91_730 VPWR VGND sg13cmos5l_fill_1
X_18695_ _18695_/Q clkload56/A _18695_/D _18695_/RESET_B VPWR VGND sg13cmos5l_dfrbpq_1
X_14927_ _14927_/X _19186_/Q _14932_/C VPWR VGND sg13cmos5l_and2_1
X_17646_ _17646_/Y _17646_/A _17661_/A VPWR VGND sg13cmos5l_nor2_1
XFILLER_63_465 VPWR VGND sg13cmos5l_fill_1
X_14858_ _14860_/B _14858_/A VPWR VGND sg13cmos5l_inv_1
XFILLER_35_156 VPWR VGND sg13cmos5l_fill_2
X_13809_ _19048_/D _13809_/A _13813_/B VPWR VGND sg13cmos5l_and2_1
X_17577_ _17581_/B _17932_/A _17766_/A VPWR VGND sg13cmos5l_and2_1
XFILLER_35_189 VPWR VGND sg13cmos5l_fill_2
X_14789_ _14813_/B _19225_/Q _14790_/B VPWR VGND sg13cmos5l_nor2b_1
X_19316_ _19316_/Q clkload19/A _19316_/D _19316_/RESET_B VPWR VGND sg13cmos5l_dfrbpq_1
X_16528_ _16528_/Y _16518_/Y _16520_/Y _16525_/Y _16527_/Y VPWR VGND sg13cmos5l_a22oi_1
XFILLER_32_830 VPWR VGND sg13cmos5l_fill_2
X_19247_ _19247_/Q _19308_/CLK _19247_/D _19247_/RESET_B VPWR VGND sg13cmos5l_dfrbpq_1
X_16459_ _16459_/Y _16465_/C _16465_/D VPWR VGND sg13cmos5l_nand2_1
XFILLER_77_0 VPWR VGND sg13cmos5l_fill_1
X_19178_ _19178_/Q clkload50/A _19178_/D _19178_/RESET_B VPWR VGND sg13cmos5l_dfrbpq_1
X_18129_ _18129_/Y _18129_/A _18129_/B VPWR VGND sg13cmos5l_nor2_1
XFILLER_105_607 VPWR VGND sg13cmos5l_fill_1
X_18965__1298 _18965_/RESET_B VPWR VGND sg13cmos5l_tiehi
XFILLER_98_351 VPWR VGND sg13cmos5l_fill_2
XFILLER_58_248 VPWR VGND sg13cmos5l_fill_2
XFILLER_100_389 VPWR VGND sg13cmos5l_fill_1
XFILLER_55_944 VPWR VGND sg13cmos5l_fill_2
XFILLER_70_936 VPWR VGND sg13cmos5l_decap_8
XFILLER_54_487 VPWR VGND sg13cmos5l_fill_2
XFILLER_42_638 VPWR VGND sg13cmos5l_fill_1
XFILLER_42_649 VPWR VGND sg13cmos5l_fill_2
X_18898__1371 _18898_/RESET_B VPWR VGND sg13cmos5l_tiehi
XFILLER_10_535 VPWR VGND sg13cmos5l_decap_8
X_10470_ _10481_/B _19745_/Q _19746_/Q _19744_/Q _10497_/A VPWR VGND sg13cmos5l_nor4_1
XFILLER_10_546 VPWR VGND sg13cmos5l_fill_1
XFILLER_41_67 VPWR VGND sg13cmos5l_fill_2
XFILLER_6_539 VPWR VGND sg13cmos5l_fill_2
XFILLER_6_528 VPWR VGND sg13cmos5l_fill_2
XFILLER_10_579 VPWR VGND sg13cmos5l_fill_1
X_12140_ _12140_/Y _12140_/A _12167_/A VPWR VGND sg13cmos5l_nor2_1
X_12071_ _12112_/A _18801_/Q _18802_/Q VPWR VGND sg13cmos5l_xor2_1
XFILLER_1_211 VPWR VGND sg13cmos5l_fill_1
XFILLER_89_373 VPWR VGND sg13cmos5l_fill_1
X_11022_ _11056_/B _18631_/Q _11022_/B VPWR VGND sg13cmos5l_and2_1
XFILLER_2_789 VPWR VGND sg13cmos5l_fill_1
X_19147__1104 _19147_/RESET_B VPWR VGND sg13cmos5l_tiehi
X_15830_ _15834_/B _19330_/Q _15830_/B VPWR VGND sg13cmos5l_xor2_1
XFILLER_106_82 VPWR VGND sg13cmos5l_fill_1
XFILLER_66_53 VPWR VGND sg13cmos5l_fill_1
X_18670__1623 _18670_/RESET_B VPWR VGND sg13cmos5l_tiehi
XFILLER_92_538 VPWR VGND sg13cmos5l_decap_8
X_12973_ _12973_/Y _12972_/X _12999_/B VPWR VGND sg13cmos5l_nand2b_1
X_15761_ _15761_/Y _19376_/Q _16314_/A _15779_/C VPWR VGND sg13cmos5l_nand3_1
X_11924_ _11925_/A _11938_/C _11923_/Y _11922_/Y VPWR VGND sg13cmos5l_o21ai_1
X_17500_ _17502_/B _17272_/A _17473_/A hold2920/X VPWR VGND sg13cmos5l_a21oi_1
X_14712_ _14715_/B _19159_/Q _19160_/Q _19157_/Q _19158_/Q VPWR VGND sg13cmos5l_nor4_1
X_15692_ _15692_/X _15692_/A _15692_/B VPWR VGND sg13cmos5l_xor2_1
X_18480_ _19759_/D _18480_/A _18480_/B VPWR VGND sg13cmos5l_nor2_1
X_17431_ _17431_/Y hold1959/X fanout87/X _17150_/A VPWR VGND sg13cmos5l_o21ai_1
XFILLER_46_988 VPWR VGND sg13cmos5l_decap_8
X_14643_ _19178_/D _14643_/A _14643_/B VPWR VGND sg13cmos5l_nor2_1
X_11855_ _11856_/A _11726_/B _11900_/B _11867_/B VPWR VGND sg13cmos5l_mux2_1
X_11786_ _11827_/A _11786_/A _11820_/A VPWR VGND sg13cmos5l_xor2_1
X_10806_ _10807_/D _18559_/B _18558_/B _18557_/B VPWR VGND sg13cmos5l_nand3_1
X_17362_ _17362_/Y _17348_/A fanout27/X _17365_/B VPWR VGND sg13cmos5l_o21ai_1
X_19101_ _19101_/Q clkload54/A _19101_/D _19101_/RESET_B VPWR VGND sg13cmos5l_dfrbpq_1
X_14574_ _14647_/B _14580_/B VPWR VGND sg13cmos5l_inv_1
X_10737_ _10737_/Y hold2094/X _10716_/B _18560_/A VPWR VGND sg13cmos5l_a21oi_1
X_17293_ _17293_/Y _17293_/A _17316_/B VPWR VGND sg13cmos5l_nor2_1
X_13525_ _13526_/B _13548_/A _13585_/B _13586_/B _13527_/A VPWR VGND sg13cmos5l_a22oi_1
X_16313_ _19429_/D _16313_/A _16314_/B VPWR VGND sg13cmos5l_nor2_1
X_19032_ _19032_/Q clkload31/A _19032_/D _19032_/RESET_B VPWR VGND sg13cmos5l_dfrbpq_1
X_18920__1346 _18920_/RESET_B VPWR VGND sg13cmos5l_tiehi
X_13456_ _13467_/B _19011_/Q _19012_/Q _19013_/Q VPWR VGND sg13cmos5l_or3_1
X_16244_ _16244_/Y _16244_/A _16244_/B VPWR VGND sg13cmos5l_nor2_1
X_12407_ _12407_/Y _12408_/B VPWR VGND sg13cmos5l_inv_1
X_10668_ _10669_/B _10018_/A _10392_/B _10658_/A VPWR VGND sg13cmos5l_a21oi_1
X_13387_ _13387_/Y _13387_/A _13387_/B VPWR VGND sg13cmos5l_nor2_1
X_10599_ _10599_/Y _10610_/A _10599_/B VPWR VGND sg13cmos5l_nor2_1
X_16175_ _16194_/B _19419_/Q _19417_/Q _19418_/Q VPWR VGND sg13cmos5l_nor3_1
X_12338_ _12338_/Y _18833_/Q _12341_/C VPWR VGND sg13cmos5l_xnor2_1
X_15126_ _15194_/B _15085_/Y _15121_/B _15125_/Y VPWR VGND sg13cmos5l_o21ai_1
X_12269_ _12294_/A _18779_/Q _18780_/Q VPWR VGND sg13cmos5l_xnor2_1
XFILLER_49_4 VPWR VGND sg13cmos5l_fill_1
XFILLER_5_594 VPWR VGND sg13cmos5l_fill_1
X_15057_ _15057_/Y _15057_/A _15057_/B VPWR VGND sg13cmos5l_xnor2_1
X_14008_ _14008_/Y _13919_/B _14000_/Y _14007_/Y VPWR VGND sg13cmos5l_o21ai_1
Xhold2909 _15693_/B _15692_/X VPWR VGND sg13cmos5l_dlygate4sd3_1
XFILLER_95_354 VPWR VGND sg13cmos5l_fill_2
X_18816_ _18816_/Q clkload57/A _18816_/D _18816_/RESET_B VPWR VGND sg13cmos5l_dfrbpq_1
X_19603__608 _19603_/RESET_B VPWR VGND sg13cmos5l_tiehi
XFILLER_68_568 VPWR VGND sg13cmos5l_fill_2
XFILLER_56_708 VPWR VGND sg13cmos5l_decap_8
X_19796_ _19796_/Q clkload22/A _19796_/D _19796_/RESET_B VPWR VGND sg13cmos5l_dfrbpq_1
XFILLER_95_398 VPWR VGND sg13cmos5l_fill_2
XFILLER_95_387 VPWR VGND sg13cmos5l_decap_8
X_18747_ _18747_/Q _18750_/CLK _18747_/D _18747_/RESET_B VPWR VGND sg13cmos5l_dfrbpq_1
XFILLER_49_793 VPWR VGND sg13cmos5l_fill_1
XFILLER_37_944 VPWR VGND sg13cmos5l_fill_1
X_15959_ _15969_/C _15959_/A _16022_/B VPWR VGND sg13cmos5l_or2_1
X_18678_ _18678_/Q _19003_/CLK _18678_/D _18678_/RESET_B VPWR VGND sg13cmos5l_dfrbpq_1
XFILLER_91_582 VPWR VGND sg13cmos5l_fill_2
XFILLER_91_571 VPWR VGND sg13cmos5l_fill_1
X_17629_ _17630_/B _17629_/A _17628_/Y VPWR VGND sg13cmos5l_nor2b_1
X_19707__1603 _19707_/RESET_B VPWR VGND sg13cmos5l_tiehi
Xfanout301 _12200_/A _12201_/A VPWR VGND sg13cmos5l_buf_1
Xfanout312 _11628_/A _11629_/A VPWR VGND sg13cmos5l_buf_1
Xfanout323 _11090_/A _10859_/Y VPWR VGND sg13cmos5l_buf_1
Xfanout356 _17417_/A _18272_/A VPWR VGND sg13cmos5l_buf_1
Xfanout345 _13476_/C _18997_/Q VPWR VGND sg13cmos5l_buf_1
Xfanout334 _18236_/A hold2443/X VPWR VGND sg13cmos5l_buf_1
Xfanout378 _16603_/B input1/X VPWR VGND sg13cmos5l_buf_1
Xfanout389 _11152_/A _11423_/A VPWR VGND sg13cmos5l_buf_1
Xfanout367 _18005_/A _16549_/A VPWR VGND sg13cmos5l_buf_1
X_18796__1479 _18796_/RESET_B VPWR VGND sg13cmos5l_tiehi
XFILLER_67_590 VPWR VGND sg13cmos5l_fill_1
X_19478__741 _19478_/RESET_B VPWR VGND sg13cmos5l_tiehi
XFILLER_82_593 VPWR VGND sg13cmos5l_decap_4
X_11640_ _11640_/Y _18750_/Q _11646_/B _18687_/Q _12194_/A VPWR VGND sg13cmos5l_a22oi_1
X_18701__1589 _18701_/RESET_B VPWR VGND sg13cmos5l_tiehi
X_11571_ _11601_/B _11478_/Y _11570_/Y _11631_/B VPWR VGND sg13cmos5l_o21ai_1
XFILLER_70_799 VPWR VGND sg13cmos5l_fill_1
XFILLER_11_833 VPWR VGND sg13cmos5l_fill_1
XFILLER_35_1024 VPWR VGND sg13cmos5l_decap_4
X_13310_ _13310_/Y _18998_/Q _14077_/A _13329_/C VPWR VGND sg13cmos5l_nand3_1
X_10522_ _10540_/B _19799_/Q _19800_/Q _19801_/Q _19802_/Q VPWR VGND sg13cmos5l_nor4_1
XFILLER_7_848 VPWR VGND sg13cmos5l_fill_1
XFILLER_11_899 VPWR VGND sg13cmos5l_fill_2
X_14290_ _14290_/X _14262_/D _14248_/B _14310_/B VPWR VGND sg13cmos5l_a21o_1
X_18688__1605 _18688_/RESET_B VPWR VGND sg13cmos5l_tiehi
X_13241_ _13241_/Y _13241_/A VPWR VGND sg13cmos5l_inv_1
X_10453_ _10602_/B _19773_/Q _19734_/Q _19793_/Q VPWR VGND sg13cmos5l_nand3_1
X_10384_ _10385_/B _10384_/A _10384_/B _10384_/C VPWR VGND sg13cmos5l_or3_1
X_13172_ _13387_/A _18959_/Q _13173_/B VPWR VGND sg13cmos5l_xnor2_1
X_12123_ _12123_/Y _12096_/X _12123_/B VPWR VGND sg13cmos5l_nand2b_1
X_17980_ _17982_/A _19684_/Q _17977_/Y _17979_/Y _19685_/Q _17978_/Y VPWR VGND sg13cmos5l_a221oi_1
XFILLER_2_520 VPWR VGND sg13cmos5l_fill_2
X_12054_ _12055_/C _12054_/A _12054_/B VPWR VGND sg13cmos5l_or2_1
X_16931_ _19527_/D _17071_/A _16931_/B VPWR VGND sg13cmos5l_nor2_1
XFILLER_78_800 VPWR VGND sg13cmos5l_fill_1
XFILLER_104_481 VPWR VGND sg13cmos5l_fill_1
XFILLER_77_321 VPWR VGND sg13cmos5l_fill_1
X_16862_ _16865_/B _16861_/C _16860_/Y _16861_/Y VPWR VGND sg13cmos5l_o21ai_1
XFILLER_65_505 VPWR VGND sg13cmos5l_fill_1
X_11005_ _11005_/Y _18606_/Q _19775_/Q VPWR VGND sg13cmos5l_xnor2_1
X_19650_ _19650_/Q clkload13/A _19650_/D _19650_/RESET_B VPWR VGND sg13cmos5l_dfrbpq_1
X_16793_ _16793_/Y _16828_/B _16793_/B VPWR VGND sg13cmos5l_nor2_1
X_18601_ _18601_/Q clkload55/A _18601_/D _18601_/RESET_B VPWR VGND sg13cmos5l_dfrbpq_1
X_19581_ _19581_/Q clkload34/A _19581_/D _19581_/RESET_B VPWR VGND sg13cmos5l_dfrbpq_1
XFILLER_37_207 VPWR VGND sg13cmos5l_fill_1
X_15813_ _15856_/A _19328_/Q _15828_/D VPWR VGND sg13cmos5l_xor2_1
XFILLER_58_590 VPWR VGND sg13cmos5l_fill_2
X_18938__1328 _18938_/RESET_B VPWR VGND sg13cmos5l_tiehi
X_18532_ _18532_/Y hold2199/X _18518_/Y _18531_/A VPWR VGND sg13cmos5l_a21oi_1
X_15744_ _19348_/D _15748_/A _15744_/B VPWR VGND sg13cmos5l_nor2_1
XFILLER_93_84 VPWR VGND sg13cmos5l_fill_1
XFILLER_93_62 VPWR VGND sg13cmos5l_fill_1
X_12956_ _13027_/B _12957_/S _12953_/Y _12955_/Y VPWR VGND sg13cmos5l_a21oi_1
X_18634__1662 _18634_/RESET_B VPWR VGND sg13cmos5l_tiehi
X_11907_ _11907_/Y _12456_/A _18724_/Q _11906_/Y VPWR VGND sg13cmos5l_o21ai_1
X_12887_ _12947_/A _12905_/B _12887_/B VPWR VGND sg13cmos5l_nand2b_1
X_18463_ _19744_/D _18481_/A _18463_/B VPWR VGND sg13cmos5l_nor2_1
X_15675_ _15675_/Y _15688_/A _15746_/B VPWR VGND sg13cmos5l_nor2_1
X_11838_ _11838_/Y _11841_/A _11905_/B VPWR VGND sg13cmos5l_nand2_1
XFILLER_61_766 VPWR VGND sg13cmos5l_fill_2
X_17414_ _17416_/A _10353_/A _17411_/Y _17413_/Y _19601_/Q _17412_/Y VPWR VGND sg13cmos5l_a221oi_1
X_14626_ _14627_/B _14597_/X _14595_/A _14628_/S VPWR VGND sg13cmos5l_mux2_1
X_18394_ _18409_/B _18388_/X _18392_/Y _18393_/Y VPWR VGND sg13cmos5l_a21oi_1
X_17345_ _17346_/B _17345_/A _17345_/B VPWR VGND sg13cmos5l_or2_1
X_14557_ _14557_/Y _19185_/Q _14557_/B VPWR VGND sg13cmos5l_xnor2_1
Xclkbuf_leaf_40_clk clkload60/A clkload3/A VPWR VGND sg13cmos5l_buf_8
X_11769_ _11771_/C _11769_/A _11769_/B VPWR VGND sg13cmos5l_or2_1
X_13508_ _13583_/B _13519_/S _13506_/X _13507_/Y VPWR VGND sg13cmos5l_a21o_1
X_17276_ _17310_/B _19595_/Q _17276_/B VPWR VGND sg13cmos5l_xor2_1
X_19015_ _19015_/Q clkload65/A _19015_/D _19015_/RESET_B VPWR VGND sg13cmos5l_dfrbpq_1
X_14488_ _19161_/D _14637_/B _14611_/A VPWR VGND sg13cmos5l_and2_1
X_19318__921 _19318_/RESET_B VPWR VGND sg13cmos5l_tiehi
X_13439_ _13539_/C _13439_/A _13439_/B _13533_/A VPWR VGND sg13cmos5l_nand3_1
X_16227_ _16228_/B _16227_/A _16256_/B VPWR VGND sg13cmos5l_nor2_1
X_16158_ _16273_/B _16170_/A _16170_/B VPWR VGND sg13cmos5l_nand2_1
X_15109_ _15109_/Y _15109_/A _15121_/B VPWR VGND sg13cmos5l_nor2_1
X_16089_ _16090_/C _19367_/Q _19368_/Q _19369_/Q VPWR VGND sg13cmos5l_o21ai_1
XFILLER_69_844 VPWR VGND sg13cmos5l_fill_2
Xhold2706 _17588_/A _19631_/Q VPWR VGND sg13cmos5l_dlygate4sd3_1
Xhold2717 _10088_/A _19081_/Q VPWR VGND sg13cmos5l_dlygate4sd3_1
Xhold2728 _16152_/A _19430_/Q VPWR VGND sg13cmos5l_dlygate4sd3_1
X_19763__781 _19763_/RESET_B VPWR VGND sg13cmos5l_tiehi
Xhold2739 _18747_/D _11887_/Y VPWR VGND sg13cmos5l_dlygate4sd3_1
X_18751__1527 _18751_/RESET_B VPWR VGND sg13cmos5l_tiehi
XFILLER_69_888 VPWR VGND sg13cmos5l_decap_8
X_19269__474 _19269_/D VPWR VGND sg13cmos5l_tielo
XFILLER_3_82 VPWR VGND sg13cmos5l_fill_1
X_19779_ _19779_/Q clkload48/A _19779_/D _19779_/RESET_B VPWR VGND sg13cmos5l_dfrbpq_1
Xclkbuf_leaf_31_clk clkload40/A clkload1/A VPWR VGND sg13cmos5l_buf_8
X_19187__1061 _19187_/RESET_B VPWR VGND sg13cmos5l_tiehi
Xfanout120 _17199_/B _17174_/X VPWR VGND sg13cmos5l_buf_1
Xfanout131 _14578_/B _14553_/Y VPWR VGND sg13cmos5l_buf_1
Xfanout153 _16785_/B _16693_/B VPWR VGND sg13cmos5l_buf_1
Xfanout142 _18369_/B _18349_/Y VPWR VGND sg13cmos5l_buf_1
Xfanout164 _15331_/B _15311_/Y VPWR VGND sg13cmos5l_buf_1
Xfanout186 _12398_/B _12381_/Y VPWR VGND sg13cmos5l_buf_1
Xfanout175 _13765_/B _13734_/Y VPWR VGND sg13cmos5l_buf_1
Xfanout197 _10621_/B _10447_/Y VPWR VGND sg13cmos5l_buf_1
X_12810_ _12850_/A _18867_/Q _12810_/B VPWR VGND sg13cmos5l_xnor2_1
XFILLER_75_869 VPWR VGND sg13cmos5l_fill_1
XFILLER_74_335 VPWR VGND sg13cmos5l_fill_1
X_13790_ _13791_/C _13790_/A _13805_/B VPWR VGND sg13cmos5l_or2_1
X_12741_ _12741_/Y _13288_/A _18853_/Q _18854_/Q _13289_/A _12740_/Y VPWR VGND sg13cmos5l_a221oi_1
X_12672_ _12674_/B _12672_/A _12735_/B VPWR VGND sg13cmos5l_or2_1
X_19521__694 _19521_/RESET_B VPWR VGND sg13cmos5l_tiehi
XFILLER_70_563 VPWR VGND sg13cmos5l_decap_4
X_15460_ _15460_/Y _15460_/A _15466_/A VPWR VGND sg13cmos5l_nor2_1
XFILLER_15_446 VPWR VGND sg13cmos5l_fill_1
XFILLER_16_969 VPWR VGND sg13cmos5l_fill_1
X_11623_ _18714_/D _11623_/A _11625_/B VPWR VGND sg13cmos5l_nor2_1
XFILLER_42_276 VPWR VGND sg13cmos5l_fill_2
X_14411_ _14411_/Y _14673_/A _14405_/A _14410_/A _10239_/Y _14406_/Y VPWR VGND sg13cmos5l_a221oi_1
Xclkbuf_leaf_22_clk clkload29/A clkbuf_4_5_0_clk/X VPWR VGND sg13cmos5l_buf_8
X_17130_ _17365_/B _17417_/A _17666_/B VPWR VGND sg13cmos5l_nor2_1
X_15391_ _15392_/B _15395_/S _15388_/Y _15389_/X VPWR VGND sg13cmos5l_a21oi_1
X_11554_ _11556_/A _11560_/B _11554_/B VPWR VGND sg13cmos5l_or2_1
XFILLER_7_601 VPWR VGND sg13cmos5l_fill_2
X_14342_ _14343_/B _14342_/A _14342_/B VPWR VGND sg13cmos5l_xor2_1
X_17061_ _17063_/A _17064_/A _17064_/B VPWR VGND sg13cmos5l_nor2_1
X_11485_ _11485_/Y _18716_/Q _11588_/B VPWR VGND sg13cmos5l_nand2_1
XFILLER_6_111 VPWR VGND sg13cmos5l_fill_1
X_14273_ _14277_/A _14261_/Y _14268_/Y _14310_/B _14468_/A _14271_/Y VPWR VGND sg13cmos5l_a221oi_1
X_10505_ _10506_/B _10590_/A _10481_/X _10590_/B _10579_/A VPWR VGND sg13cmos5l_a22oi_1
X_13224_ _13257_/C _18965_/Q _13232_/B _13233_/A VPWR VGND sg13cmos5l_o21ai_1
XFILLER_6_155 VPWR VGND sg13cmos5l_decap_8
X_16012_ _19384_/D _16012_/A _16016_/B VPWR VGND sg13cmos5l_nor2_1
X_10436_ _10437_/C _19171_/Q _19213_/Q _19255_/Q _19297_/Q VPWR VGND sg13cmos5l_nor4_1
XFILLER_88_73 VPWR VGND sg13cmos5l_fill_1
X_10367_ _16854_/A _10367_/A VPWR VGND sg13cmos5l_inv_1
XFILLER_69_107 VPWR VGND sg13cmos5l_decap_4
X_13155_ _13155_/Y _13167_/A _13363_/B VPWR VGND sg13cmos5l_nand2_1
X_12106_ _12106_/Y _12106_/A _12136_/B VPWR VGND sg13cmos5l_nor2_1
X_10298_ _11387_/A _11642_/A VPWR VGND sg13cmos5l_inv_1
X_13086_ _18945_/D _13573_/A _13086_/B VPWR VGND sg13cmos5l_and2_1
X_17963_ _17963_/Y _19701_/Q _18477_/A VPWR VGND sg13cmos5l_nand2_1
X_16914_ _16932_/B _16907_/Y _16911_/Y _16913_/Y VPWR VGND sg13cmos5l_o21ai_1
X_12037_ _12160_/A _18798_/Q _12054_/B VPWR VGND sg13cmos5l_xnor2_1
X_19702_ _19702_/Q _19756_/CLK _19702_/D _19702_/RESET_B VPWR VGND sg13cmos5l_dfrbpq_1
Xclkbuf_leaf_89_clk clkload8/A clkbuf_4_0_0_clk/X VPWR VGND sg13cmos5l_buf_8
XFILLER_93_600 VPWR VGND sg13cmos5l_fill_2
XFILLER_78_674 VPWR VGND sg13cmos5l_fill_2
X_19633_ _19633_/Q clkload26/A _19633_/D _19633_/RESET_B VPWR VGND sg13cmos5l_dfrbpq_1
X_17894_ _17894_/X _17807_/Y _17893_/X _17892_/Y VPWR VGND sg13cmos5l_a21o_1
XFILLER_38_505 VPWR VGND sg13cmos5l_fill_2
X_16845_ _16845_/Y _16982_/B _17371_/A _16861_/C VPWR VGND sg13cmos5l_nand3_1
X_16776_ _16776_/X _16824_/B _16788_/S _16775_/Y VPWR VGND sg13cmos5l_a21o_1
X_19564_ _19564_/Q clkload28/A _19564_/D _19564_/RESET_B VPWR VGND sg13cmos5l_dfrbpq_1
X_13988_ _13988_/Y _13980_/X _13982_/Y _14177_/A VPWR VGND sg13cmos5l_a21oi_1
XFILLER_34_700 VPWR VGND sg13cmos5l_fill_2
X_19495_ _19495_/Q clkload32/A _19495_/D _19495_/RESET_B VPWR VGND sg13cmos5l_dfrbpq_1
X_12939_ _12940_/B _12939_/A _13114_/A VPWR VGND sg13cmos5l_nand2_1
X_18515_ _18516_/A _18514_/C _18513_/Y _18514_/Y VPWR VGND sg13cmos5l_a21o_1
X_15727_ _15728_/B _15706_/B _15703_/A _15727_/S VPWR VGND sg13cmos5l_mux2_1
XFILLER_33_221 VPWR VGND sg13cmos5l_fill_1
X_15658_ _15744_/B _15678_/A _15656_/Y _15657_/Y VPWR VGND sg13cmos5l_a21o_1
X_19239__1003 _19239_/RESET_B VPWR VGND sg13cmos5l_tiehi
X_18446_ _18453_/B _18418_/A _18445_/B _18445_/Y VPWR VGND sg13cmos5l_o21ai_1
X_14609_ _14609_/Y _14609_/A _14609_/B _14609_/C VPWR VGND sg13cmos5l_nand3_1
XFILLER_21_416 VPWR VGND sg13cmos5l_fill_2
Xclkbuf_leaf_13_clk clkload35/A clkbuf_4_6_0_clk/X VPWR VGND sg13cmos5l_buf_8
X_15589_ _15589_/Y _19320_/Q _19281_/Q VPWR VGND sg13cmos5l_xnor2_1
X_18377_ _18377_/Y _19742_/Q _19757_/Q VPWR VGND sg13cmos5l_nand2_1
X_17328_ _17328_/X _17295_/Y _17185_/Y _17341_/B VPWR VGND sg13cmos5l_mux2_1
X_18769__1509 _18769_/RESET_B VPWR VGND sg13cmos5l_tiehi
XFILLER_88_1028 VPWR VGND sg13cmos5l_fill_1
XFILLER_88_1017 VPWR VGND sg13cmos5l_decap_8
X_17259_ _17259_/Y _17259_/A _17450_/B VPWR VGND sg13cmos5l_nor2_1
Xhold2503 _14959_/B _14958_/X VPWR VGND sg13cmos5l_dlygate4sd3_1
XFILLER_102_259 VPWR VGND sg13cmos5l_decap_8
Xhold2536 _10376_/A _19018_/Q VPWR VGND sg13cmos5l_dlygate4sd3_1
Xhold2525 _10155_/A _19538_/Q VPWR VGND sg13cmos5l_dlygate4sd3_1
Xhold2547 _10073_/A _18999_/Q VPWR VGND sg13cmos5l_dlygate4sd3_1
Xhold2514 _16365_/B _16364_/X VPWR VGND sg13cmos5l_dlygate4sd3_1
Xhold1813 _13649_/A _18584_/Q VPWR VGND sg13cmos5l_dlygate4sd3_1
Xhold1824 _16624_/B _19030_/Q VPWR VGND sg13cmos5l_dlygate4sd3_1
XFILLER_84_622 VPWR VGND sg13cmos5l_fill_2
Xhold1835 _16889_/B _19480_/Q VPWR VGND sg13cmos5l_dlygate4sd3_1
Xhold2569 _13239_/A _18963_/Q VPWR VGND sg13cmos5l_dlygate4sd3_1
Xhold2558 _10186_/A _19706_/Q VPWR VGND sg13cmos5l_dlygate4sd3_1
Xhold1846 _12797_/B _18862_/Q VPWR VGND sg13cmos5l_dlygate4sd3_1
Xhold1857 _13085_/B _18902_/Q VPWR VGND sg13cmos5l_dlygate4sd3_1
Xhold1868 _16159_/B _19366_/Q VPWR VGND sg13cmos5l_dlygate4sd3_1
XFILLER_29_549 VPWR VGND sg13cmos5l_fill_2
XFILLER_72_839 VPWR VGND sg13cmos5l_fill_1
Xhold1879 _18647_/D _11146_/Y VPWR VGND sg13cmos5l_dlygate4sd3_1
XFILLER_17_36 VPWR VGND sg13cmos5l_fill_1
X_18715__1566 _18715_/RESET_B VPWR VGND sg13cmos5l_tiehi
X_19399__834 _19399_/RESET_B VPWR VGND sg13cmos5l_tiehi
XFILLER_24_265 VPWR VGND sg13cmos5l_fill_2
X_19085__1169 _19085_/RESET_B VPWR VGND sg13cmos5l_tiehi
X_11270_ _11447_/A _18665_/Q _11270_/B VPWR VGND sg13cmos5l_xnor2_1
XFILLER_3_114 VPWR VGND sg13cmos5l_fill_1
XFILLER_106_565 VPWR VGND sg13cmos5l_fill_1
XFILLER_3_158 VPWR VGND sg13cmos5l_fill_1
X_10221_ _15497_/B _10221_/A VPWR VGND sg13cmos5l_inv_1
X_10152_ _17367_/A _16842_/A VPWR VGND sg13cmos5l_inv_1
X_10083_ _16822_/A _10083_/A VPWR VGND sg13cmos5l_inv_1
XFILLER_48_803 VPWR VGND sg13cmos5l_fill_1
X_14960_ _14960_/Y _14938_/A _14958_/S _15185_/B VPWR VGND sg13cmos5l_o21ai_1
X_13911_ _19073_/D _14071_/B _13911_/B VPWR VGND sg13cmos5l_and2_1
X_18978__1285 _18978_/RESET_B VPWR VGND sg13cmos5l_tiehi
XFILLER_75_633 VPWR VGND sg13cmos5l_fill_2
X_19308__931 _19308_/RESET_B VPWR VGND sg13cmos5l_tiehi
X_14891_ _14891_/Y _14865_/Y _14895_/S _14916_/A VPWR VGND sg13cmos5l_o21ai_1
X_16630_ _16632_/B _19035_/Q _16631_/B VPWR VGND sg13cmos5l_xnor2_1
XFILLER_90_614 VPWR VGND sg13cmos5l_fill_1
X_13842_ _13842_/Y _13842_/A _13848_/A VPWR VGND sg13cmos5l_nand2_1
X_13773_ _13773_/Y _13794_/A _13762_/X VPWR VGND sg13cmos5l_nor2b_1
XFILLER_56_880 VPWR VGND sg13cmos5l_fill_1
X_16561_ _19467_/D _16561_/A _16561_/B VPWR VGND sg13cmos5l_and2_1
X_12724_ _18879_/D _12724_/A _12728_/B VPWR VGND sg13cmos5l_nor2_1
X_10985_ _11089_/B _10954_/A _11198_/A _10991_/A VPWR VGND sg13cmos5l_mux2_1
X_15512_ _15512_/Y _15485_/A _15516_/S _15736_/B VPWR VGND sg13cmos5l_o21ai_1
X_19280_ _19280_/Q clkload48/A _19280_/D _19280_/RESET_B VPWR VGND sg13cmos5l_dfrbpq_1
X_18300_ _18300_/Y _18300_/A _18341_/A VPWR VGND sg13cmos5l_nand2_1
X_16492_ _16492_/Y _19447_/Q _16492_/B _16504_/A VPWR VGND sg13cmos5l_nand3_1
X_18231_ _19718_/D _18231_/A _18231_/B VPWR VGND sg13cmos5l_and2_1
X_12655_ _12655_/Y _12555_/X _12561_/Y _12649_/A _12649_/B _12560_/Y VPWR VGND sg13cmos5l_a221oi_1
XFILLER_70_393 VPWR VGND sg13cmos5l_fill_2
X_19227__1018 _19227_/RESET_B VPWR VGND sg13cmos5l_tiehi
X_15443_ _15444_/B _15413_/X _15411_/A _15447_/S VPWR VGND sg13cmos5l_mux2_1
XFILLER_30_235 VPWR VGND sg13cmos5l_fill_2
X_12586_ _12604_/A _18881_/Q _12602_/B VPWR VGND sg13cmos5l_or2_1
X_11606_ _18702_/D _11606_/A _11606_/B VPWR VGND sg13cmos5l_and2_1
X_15374_ _15374_/Y _15736_/A _15394_/B VPWR VGND sg13cmos5l_nand2_1
XFILLER_11_460 VPWR VGND sg13cmos5l_decap_8
X_18162_ _18162_/Y _18060_/B _18231_/B _18161_/Y VPWR VGND sg13cmos5l_a21oi_1
X_11537_ _11539_/B _11537_/A _18718_/Q VPWR VGND sg13cmos5l_xnor2_1
X_17113_ _17113_/Y _17113_/A VPWR VGND sg13cmos5l_inv_1
X_18093_ _18174_/A _18092_/Y _18202_/A VPWR VGND sg13cmos5l_nand2b_1
XFILLER_7_442 VPWR VGND sg13cmos5l_fill_1
X_14325_ _14326_/B _14325_/A _14325_/B VPWR VGND sg13cmos5l_xor2_1
X_17044_ _17045_/A _16954_/Y _17060_/A VPWR VGND sg13cmos5l_nand2b_1
XFILLER_7_475 VPWR VGND sg13cmos5l_decap_8
X_19315__924 _19315_/RESET_B VPWR VGND sg13cmos5l_tiehi
X_11468_ _11468_/Y _11446_/X _11450_/Y _11290_/Y VPWR VGND sg13cmos5l_a21oi_1
X_14256_ _14264_/B _19141_/Q _14257_/B VPWR VGND sg13cmos5l_nor2b_1
X_11399_ _11401_/A _18686_/Q _11396_/Y _11398_/Y _18687_/Q _11397_/Y VPWR VGND sg13cmos5l_a221oi_1
X_10419_ _10739_/A _10419_/A _10419_/B _10419_/C _10419_/D VPWR VGND sg13cmos5l_nand4_1
X_13207_ _13210_/C _13207_/A _13297_/B VPWR VGND sg13cmos5l_nand2_1
X_14187_ _14288_/B _14178_/A _14178_/B _14185_/Y VPWR VGND sg13cmos5l_o21ai_1
X_18791__1484 _18791_/RESET_B VPWR VGND sg13cmos5l_tiehi
X_13138_ _18951_/D _13290_/B _13259_/A VPWR VGND sg13cmos5l_and2_1
X_18995_ _18995_/Q clkload54/A _18995_/D _18995_/RESET_B VPWR VGND sg13cmos5l_dfrbpq_1
XFILLER_31_4 VPWR VGND sg13cmos5l_decap_4
X_13069_ _13069_/Y _13044_/A _13067_/S _13290_/B VPWR VGND sg13cmos5l_o21ai_1
X_17946_ _17946_/Y _18473_/A _19640_/Q _19639_/Q _18472_/A VPWR VGND sg13cmos5l_a22oi_1
Xclkbuf_leaf_2_clk _19462_/CLK clkbuf_4_0_0_clk/X VPWR VGND sg13cmos5l_buf_8
XFILLER_78_493 VPWR VGND sg13cmos5l_fill_1
X_17877_ _17877_/Y _17879_/A _17943_/B VPWR VGND sg13cmos5l_nor2_1
X_16828_ _19509_/D _16829_/A _16828_/B VPWR VGND sg13cmos5l_and2_1
X_19616_ _19616_/Q clkload24/A _19616_/D _19616_/RESET_B VPWR VGND sg13cmos5l_dfrbpq_1
XFILLER_38_357 VPWR VGND sg13cmos5l_fill_1
X_19547_ _19547_/Q clkload40/A _19547_/D _19547_/RESET_B VPWR VGND sg13cmos5l_dfrbpq_1
X_16759_ _16759_/Y _16759_/A _16759_/B VPWR VGND sg13cmos5l_nor2_1
X_19040__1217 _19040_/RESET_B VPWR VGND sg13cmos5l_tiehi
X_18683__1610 _18683_/RESET_B VPWR VGND sg13cmos5l_tiehi
X_19478_ _19478_/Q clkload28/A _19478_/D _19478_/RESET_B VPWR VGND sg13cmos5l_dfrbpq_1
X_18429_ _18429_/Y _18479_/B _18445_/B _18428_/Y VPWR VGND sg13cmos5l_a21oi_1
Xhold3012 _16990_/A _19550_/Q VPWR VGND sg13cmos5l_dlygate4sd3_1
XFILLER_88_213 VPWR VGND sg13cmos5l_fill_2
X_18933__1333 _18933_/RESET_B VPWR VGND sg13cmos5l_tiehi
Xhold3023 _13909_/A _18989_/Q VPWR VGND sg13cmos5l_dlygate4sd3_1
Xhold3001 _14464_/A _19121_/Q VPWR VGND sg13cmos5l_dlygate4sd3_1
Xhold3045 _16653_/A _19031_/Q VPWR VGND sg13cmos5l_dlygate4sd3_1
Xhold2300 hold2300/X _12251_/Y VPWR VGND sg13cmos5l_dlygate4sd3_1
Xhold3056 hold3056/X _19624_/Q VPWR VGND sg13cmos5l_dlygate4sd3_1
Xhold2322 _10342_/A _19641_/Q VPWR VGND sg13cmos5l_dlygate4sd3_1
Xhold3034 hold3034/X _19097_/Q VPWR VGND sg13cmos5l_dlygate4sd3_1
XFILLER_0_128 VPWR VGND sg13cmos5l_fill_2
Xhold2311 hold2311/X _15518_/Y VPWR VGND sg13cmos5l_dlygate4sd3_1
X_09995_ _09995_/Y _09995_/A VPWR VGND sg13cmos5l_inv_1
Xhold2333 hold2333/X _17142_/Y VPWR VGND sg13cmos5l_dlygate4sd3_1
Xhold2355 _10098_/A _19166_/Q VPWR VGND sg13cmos5l_dlygate4sd3_1
Xhold2344 _10181_/A _19703_/Q VPWR VGND sg13cmos5l_dlygate4sd3_1
Xhold2377 hold2377/X _13636_/Y VPWR VGND sg13cmos5l_dlygate4sd3_1
Xhold2366 _18771_/D _11959_/Y VPWR VGND sg13cmos5l_dlygate4sd3_1
XFILLER_69_493 VPWR VGND sg13cmos5l_fill_2
Xhold2388 _13574_/A _18954_/Q VPWR VGND sg13cmos5l_dlygate4sd3_1
XFILLER_29_335 VPWR VGND sg13cmos5l_fill_1
XFILLER_85_986 VPWR VGND sg13cmos5l_decap_8
Xhold2399 _10354_/A _19557_/Q VPWR VGND sg13cmos5l_dlygate4sd3_1
X_19360__465 _19360_/D VPWR VGND sg13cmos5l_tielo
X_10770_ _10770_/Y _10804_/B _10769_/B _10768_/Y VPWR VGND sg13cmos5l_a21oi_1
XFILLER_52_382 VPWR VGND sg13cmos5l_fill_2
XFILLER_44_78 VPWR VGND sg13cmos5l_fill_2
XFILLER_100_62 VPWR VGND sg13cmos5l_fill_1
X_12440_ _12441_/C _12440_/A _12453_/B VPWR VGND sg13cmos5l_or2_1
X_12371_ _12371_/Y _12305_/B _12466_/B _12369_/Y _12310_/B VPWR VGND sg13cmos5l_a22oi_1
X_14110_ _14111_/A _14114_/C _14109_/Y _14108_/Y VPWR VGND sg13cmos5l_a21o_1
X_11322_ _11322_/Y _11306_/A _11306_/B _11314_/Y _11320_/Y _11321_/Y VPWR VGND sg13cmos5l_a221oi_1
X_15090_ _15090_/Y _15077_/Y _15081_/Y _15093_/A _15093_/B VPWR VGND sg13cmos5l_a22oi_1
XFILLER_4_423 VPWR VGND sg13cmos5l_decap_4
X_11253_ _11253_/Y _11434_/A VPWR VGND sg13cmos5l_inv_1
X_14041_ _14041_/Y _14041_/A _14041_/B VPWR VGND sg13cmos5l_nor2_1
XFILLER_69_64 VPWR VGND sg13cmos5l_fill_2
X_10204_ _16047_/A _10204_/A VPWR VGND sg13cmos5l_inv_1
X_11184_ _11205_/A _11204_/B _11204_/C VPWR VGND sg13cmos5l_and2_1
X_17800_ _17911_/A _19670_/Q _17803_/B _17799_/Y VPWR VGND sg13cmos5l_a21oi_1
X_18780_ _18780_/Q clkload61/A _18780_/D _18780_/RESET_B VPWR VGND sg13cmos5l_dfrbpq_1
X_10135_ _16555_/A _10135_/A VPWR VGND sg13cmos5l_inv_1
X_15992_ _15994_/A _15995_/A _15995_/B VPWR VGND sg13cmos5l_nor2_1
X_10066_ _10066_/Y _18867_/Q VPWR VGND sg13cmos5l_inv_1
X_17731_ _17731_/Y hold1959/X fanout66/X _17739_/A VPWR VGND sg13cmos5l_o21ai_1
X_14943_ _14943_/Y _15457_/A _19254_/Q _14948_/C VPWR VGND sg13cmos5l_nor3_1
XFILLER_76_997 VPWR VGND sg13cmos5l_fill_2
X_17662_ _17663_/C _17662_/A _17646_/A VPWR VGND sg13cmos5l_nor2b_1
X_14874_ _14874_/Y _14855_/A _14855_/B _14867_/X _14872_/Y _14873_/Y VPWR VGND sg13cmos5l_a221oi_1
X_16613_ _16613_/Y _10372_/Y fanout31/X _16612_/Y VPWR VGND sg13cmos5l_a21oi_1
X_13825_ _13825_/Y _14368_/A _18979_/Q _18980_/Q _14369_/A _13824_/Y VPWR VGND sg13cmos5l_a221oi_1
X_19401_ _19401_/Q clkload6/A _19401_/D _19401_/RESET_B VPWR VGND sg13cmos5l_dfrbpq_1
XFILLER_35_327 VPWR VGND sg13cmos5l_decap_8
X_17593_ _17596_/A _17593_/A _17593_/B VPWR VGND sg13cmos5l_nor2_1
XFILLER_63_658 VPWR VGND sg13cmos5l_fill_1
X_13756_ _13775_/A _13786_/A _13756_/B VPWR VGND sg13cmos5l_nand2_1
X_10968_ _10989_/C _18639_/Q _10968_/B VPWR VGND sg13cmos5l_xnor2_1
X_19332_ _19332_/Q clkload16/A _19332_/D _19332_/RESET_B VPWR VGND sg13cmos5l_dfrbpq_1
X_16544_ _19451_/D _16518_/Y fanout33/X _16543_/Y VPWR VGND sg13cmos5l_a21oi_1
X_13687_ _16651_/A _16823_/A _13687_/B VPWR VGND sg13cmos5l_xnor2_1
X_12707_ _12707_/Y _12708_/A _12708_/B _12706_/Y VPWR VGND sg13cmos5l_a21oi_1
X_19263_ _19263_/Q _19304_/CLK _19263_/D _19263_/RESET_B VPWR VGND sg13cmos5l_dfrbpq_1
X_16475_ _16529_/B _16437_/X _16457_/D _16257_/B VPWR VGND sg13cmos5l_a21oi_1
X_12638_ _12824_/A _18876_/Q _12639_/B VPWR VGND sg13cmos5l_xnor2_1
X_10899_ _10903_/B _19782_/Q _10901_/B VPWR VGND sg13cmos5l_nor2b_1
X_18214_ _18214_/Y _18174_/B _18212_/S _18231_/A VPWR VGND sg13cmos5l_o21ai_1
X_15426_ _15426_/Y _15426_/A _15426_/B _15426_/C VPWR VGND sg13cmos5l_nand3_1
X_19194_ _19194_/Q _19302_/CLK _19194_/D _19194_/RESET_B VPWR VGND sg13cmos5l_dfrbpq_1
XFILLER_79_4 VPWR VGND sg13cmos5l_fill_1
X_12569_ _12569_/Y _12551_/X _12553_/Y _12363_/Y VPWR VGND sg13cmos5l_a21oi_1
X_15357_ _15357_/X _19309_/Q _15357_/B VPWR VGND sg13cmos5l_xor2_1
X_18145_ _18145_/Y _18125_/Y _18130_/Y _18144_/Y VPWR VGND sg13cmos5l_a21oi_1
X_18076_ _18186_/B _18088_/A _18091_/B VPWR VGND sg13cmos5l_nand2_1
X_15288_ _15288_/Y _15288_/A _15303_/B VPWR VGND sg13cmos5l_nor2_1
X_14308_ _14308_/Y _14198_/B _14375_/B _14307_/X _14204_/B VPWR VGND sg13cmos5l_a22oi_1
X_17027_ _17040_/C _17027_/A _17091_/B VPWR VGND sg13cmos5l_nor2_1
X_14239_ _14239_/Y _19125_/Q _14240_/B VPWR VGND sg13cmos5l_xnor2_1
X_19389__844 _19389_/RESET_B VPWR VGND sg13cmos5l_tiehi
X_18978_ _18978_/Q _19092_/CLK _18978_/D _18978_/RESET_B VPWR VGND sg13cmos5l_dfrbpq_1
X_18581__1718 _18581_/RESET_B VPWR VGND sg13cmos5l_tiehi
X_17929_ _19663_/D _17937_/B _17929_/B VPWR VGND sg13cmos5l_nor2_1
XFILLER_38_132 VPWR VGND sg13cmos5l_fill_1
XFILLER_22_1026 VPWR VGND sg13cmos5l_fill_2
XFILLER_27_828 VPWR VGND sg13cmos5l_fill_1
XFILLER_81_488 VPWR VGND sg13cmos5l_fill_2
X_19396__837 _19396_/RESET_B VPWR VGND sg13cmos5l_tiehi
X_19004__1256 _19004_/RESET_B VPWR VGND sg13cmos5l_tiehi
XFILLER_103_332 VPWR VGND sg13cmos5l_fill_1
XFILLER_104_888 VPWR VGND sg13cmos5l_decap_4
XFILLER_103_365 VPWR VGND sg13cmos5l_decap_4
X_09978_ _09978_/Y _09978_/A VPWR VGND sg13cmos5l_inv_1
Xhold2130 hold2130/X _13349_/Y VPWR VGND sg13cmos5l_dlygate4sd3_1
Xhold2163 _18852_/D _12514_/Y VPWR VGND sg13cmos5l_dlygate4sd3_1
Xhold2141 _10278_/A _18854_/Q VPWR VGND sg13cmos5l_dlygate4sd3_1
Xhold2152 _18284_/B _19727_/Q VPWR VGND sg13cmos5l_dlygate4sd3_1
X_11940_ _11940_/Y _12224_/A _11934_/X _11941_/B _12230_/B VPWR VGND sg13cmos5l_a22oi_1
Xhold2196 _10280_/A _18810_/Q VPWR VGND sg13cmos5l_dlygate4sd3_1
Xhold2185 _10384_/C _18566_/Q VPWR VGND sg13cmos5l_dlygate4sd3_1
Xhold2174 _10189_/A _19746_/Q VPWR VGND sg13cmos5l_dlygate4sd3_1
XFILLER_45_625 VPWR VGND sg13cmos5l_fill_1
XFILLER_17_316 VPWR VGND sg13cmos5l_fill_2
X_11871_ _11878_/A _11841_/A _11852_/B _11837_/Y VPWR VGND sg13cmos5l_a21oi_1
X_19305__934 _19305_/RESET_B VPWR VGND sg13cmos5l_tiehi
X_18764__1514 _18764_/RESET_B VPWR VGND sg13cmos5l_tiehi
X_13610_ _13610_/Y _16564_/B _13602_/A _13605_/X _13609_/Y VPWR VGND sg13cmos5l_a22oi_1
XFILLER_55_99 VPWR VGND sg13cmos5l_fill_2
X_10822_ _10822_/Y _18620_/Q _10320_/Y _10821_/Y VPWR VGND sg13cmos5l_a21oi_1
XFILLER_13_500 VPWR VGND sg13cmos5l_decap_8
X_14590_ _14591_/B _14647_/B _14605_/S _14589_/Y VPWR VGND sg13cmos5l_a21oi_1
X_19657__548 _19657_/RESET_B VPWR VGND sg13cmos5l_tiehi
X_10753_ _10779_/B _18595_/Q _10773_/B VPWR VGND sg13cmos5l_nor2b_1
X_13541_ _13542_/B _13583_/B _13411_/Y _13548_/B VPWR VGND sg13cmos5l_mux2_1
X_16260_ _16260_/Y _16260_/A _16260_/B VPWR VGND sg13cmos5l_nand2_1
XFILLER_9_504 VPWR VGND sg13cmos5l_decap_8
X_10684_ _10684_/Y _10384_/C _19811_/Q _10017_/Y VPWR VGND sg13cmos5l_a21oi_1
X_13472_ _13479_/B _13512_/A _13472_/B VPWR VGND sg13cmos5l_nor2_1
X_15211_ _15211_/Y _15351_/C _15742_/A _15225_/C VPWR VGND sg13cmos5l_nand3_1
X_12423_ _12423_/Y _12413_/A _12413_/B _12419_/Y _12422_/A VPWR VGND sg13cmos5l_a22oi_1
X_19518__699 _19518_/RESET_B VPWR VGND sg13cmos5l_tiehi
X_16191_ _16191_/X _16185_/Y _16189_/Y _16190_/Y VPWR VGND sg13cmos5l_a21o_1
X_12354_ _12464_/B _12324_/X _12353_/Y _12368_/B VPWR VGND sg13cmos5l_mux2_1
X_15142_ _15142_/Y _15142_/A _15142_/B _15142_/C VPWR VGND sg13cmos5l_nor3_1
X_11305_ _11306_/B _11202_/B _11325_/B _11304_/Y VPWR VGND sg13cmos5l_a21oi_1
X_15073_ _15080_/B _19263_/Q _19264_/Q _19265_/Q _19266_/Q VPWR VGND sg13cmos5l_nor4_1
X_12285_ _12285_/Y _12137_/A _12279_/Y _12307_/B _12137_/B VPWR VGND sg13cmos5l_a22oi_1
X_18901_ _18901_/Q clkload68/A _18901_/D _18901_/RESET_B VPWR VGND sg13cmos5l_dfrbpq_1
X_14024_ _14024_/Y _14024_/A _14024_/B VPWR VGND sg13cmos5l_nor2_1
X_19312__927 _19312_/RESET_B VPWR VGND sg13cmos5l_tiehi
X_11236_ _11237_/B _11236_/A _11323_/B VPWR VGND sg13cmos5l_nand2_1
XFILLER_20_80 VPWR VGND sg13cmos5l_fill_1
X_18832_ _18832_/Q clkload69/A _18832_/D _18832_/RESET_B VPWR VGND sg13cmos5l_dfrbpq_1
X_18710__1571 _18710_/RESET_B VPWR VGND sg13cmos5l_tiehi
X_11167_ _11203_/A _11167_/A _11167_/B VPWR VGND sg13cmos5l_xnor2_1
X_18763_ _18763_/Q clkload39/A _18763_/D _18763_/RESET_B VPWR VGND sg13cmos5l_dfrbpq_1
X_10118_ _15742_/A _10118_/A VPWR VGND sg13cmos5l_inv_1
X_11098_ _11098_/Y _11122_/B _18664_/Q VPWR VGND sg13cmos5l_nand2_1
X_17714_ _17716_/A _19642_/Q _17711_/Y _17713_/Y _17729_/B _17712_/Y VPWR VGND sg13cmos5l_a221oi_1
X_15975_ _15976_/C _15975_/A _15975_/B _15975_/C VPWR VGND sg13cmos5l_nand3_1
X_10049_ _12729_/A _12220_/A VPWR VGND sg13cmos5l_inv_1
X_18694_ _18694_/Q clkload38/A _18694_/D _18694_/RESET_B VPWR VGND sg13cmos5l_dfrbpq_1
XFILLER_63_411 VPWR VGND sg13cmos5l_fill_2
X_14926_ _14932_/C _14926_/A _14926_/B VPWR VGND sg13cmos5l_nand2_1
XFILLER_64_967 VPWR VGND sg13cmos5l_fill_1
X_17645_ _17664_/B _17645_/A _17645_/B VPWR VGND sg13cmos5l_nor2_1
X_19080__1174 _19080_/RESET_B VPWR VGND sg13cmos5l_tiehi
X_14857_ _14858_/A _14857_/A _14857_/B VPWR VGND sg13cmos5l_xnor2_1
XFILLER_91_1002 VPWR VGND sg13cmos5l_decap_4
X_13808_ _19047_/D _13808_/A _13813_/B VPWR VGND sg13cmos5l_and2_1
XFILLER_64_989 VPWR VGND sg13cmos5l_fill_2
X_17576_ _17587_/A _17560_/Y _17570_/Y _17574_/Y VPWR VGND sg13cmos5l_o21ai_1
X_14788_ _14790_/B _19221_/Q _19222_/Q _19223_/Q _19224_/Q VPWR VGND sg13cmos5l_nor4_1
XFILLER_90_296 VPWR VGND sg13cmos5l_fill_2
X_13739_ _13744_/A _19048_/Q _13751_/B VPWR VGND sg13cmos5l_and2_1
X_19315_ _19315_/Q clkload7/A _19315_/D _19315_/RESET_B VPWR VGND sg13cmos5l_dfrbpq_1
X_16527_ _16527_/Y _16477_/B _16526_/B _16526_/Y VPWR VGND sg13cmos5l_a21oi_1
X_19246_ _19246_/Q _19304_/CLK _19246_/D _19246_/RESET_B VPWR VGND sg13cmos5l_dfrbpq_1
X_16458_ _16458_/X _16465_/C _16465_/D VPWR VGND sg13cmos5l_and2_1
X_19177_ _19177_/Q clkload50/A _19177_/D _19177_/RESET_B VPWR VGND sg13cmos5l_dfrbpq_1
X_15409_ _15410_/B _15409_/A _15409_/B VPWR VGND sg13cmos5l_xor2_1
X_16389_ _16389_/Y _19448_/Q _19463_/Q VPWR VGND sg13cmos5l_nand2_1
X_18128_ _18319_/A _18477_/A _18128_/B VPWR VGND sg13cmos5l_xnor2_1
XFILLER_8_592 VPWR VGND sg13cmos5l_decap_8
X_18973__1290 _18973_/RESET_B VPWR VGND sg13cmos5l_tiehi
XFILLER_104_118 VPWR VGND sg13cmos5l_fill_1
XFILLER_6_71 VPWR VGND sg13cmos5l_decap_4
X_18059_ _18060_/B _18059_/A _18059_/B VPWR VGND sg13cmos5l_and2_1
XFILLER_59_739 VPWR VGND sg13cmos5l_fill_2
XFILLER_59_706 VPWR VGND sg13cmos5l_fill_1
XFILLER_98_396 VPWR VGND sg13cmos5l_fill_1
XFILLER_86_558 VPWR VGND sg13cmos5l_fill_2
X_19222__1023 _19222_/RESET_B VPWR VGND sg13cmos5l_tiehi
X_18849__514 _18849_/D VPWR VGND sg13cmos5l_tielo
XFILLER_70_904 VPWR VGND sg13cmos5l_decap_4
XFILLER_81_274 VPWR VGND sg13cmos5l_fill_1
XFILLER_42_628 VPWR VGND sg13cmos5l_decap_4
XFILLER_41_105 VPWR VGND sg13cmos5l_fill_2
XFILLER_41_46 VPWR VGND sg13cmos5l_fill_2
XFILLER_10_558 VPWR VGND sg13cmos5l_decap_4
XFILLER_1_201 VPWR VGND sg13cmos5l_fill_2
X_12070_ _12070_/X _18786_/Q _18801_/Q VPWR VGND sg13cmos5l_and2_1
X_11021_ _11061_/B _11057_/A _11056_/A VPWR VGND sg13cmos5l_nor2_1
XFILLER_66_21 VPWR VGND sg13cmos5l_decap_4
X_12972_ _12972_/X _13023_/B _12831_/B _12986_/B VPWR VGND sg13cmos5l_mux2_1
X_15760_ _15779_/C _19380_/Q _15764_/B _15769_/B VPWR VGND sg13cmos5l_o21ai_1
X_11923_ _11923_/Y _18788_/Q _12462_/A VPWR VGND sg13cmos5l_nand2_1
XFILLER_66_98 VPWR VGND sg13cmos5l_decap_4
X_14711_ _14725_/B _19159_/Q _19157_/Q _19158_/Q VPWR VGND sg13cmos5l_or3_1
X_15691_ _15692_/B _19340_/Q _15590_/Y _15587_/Y VPWR VGND sg13cmos5l_a21oi_1
X_11854_ _11854_/Y _11853_/A _11853_/B _11850_/A VPWR VGND sg13cmos5l_o21ai_1
XFILLER_72_252 VPWR VGND sg13cmos5l_fill_1
X_17430_ _17430_/Y _17413_/Y hold2348/X _17671_/B VPWR VGND sg13cmos5l_a21oi_1
X_14642_ _19177_/D _14642_/A _14643_/B VPWR VGND sg13cmos5l_nor2_1
X_10805_ _18557_/B _10765_/Y _10784_/Y _13716_/A _10784_/B VPWR VGND sg13cmos5l_a22oi_1
XFILLER_82_75 VPWR VGND sg13cmos5l_fill_1
X_19379__854 _19379_/RESET_B VPWR VGND sg13cmos5l_tiehi
XFILLER_32_116 VPWR VGND sg13cmos5l_fill_2
XFILLER_32_127 VPWR VGND sg13cmos5l_fill_2
X_11785_ _11793_/B _18759_/Q _18760_/Q _18761_/Q _18762_/Q VPWR VGND sg13cmos5l_nor4_1
X_17361_ _19578_/D hold2528/X fanout27/X _17360_/Y VPWR VGND sg13cmos5l_a21oi_1
X_19100_ _19100_/Q clkload54/A _19100_/D _19100_/RESET_B VPWR VGND sg13cmos5l_dfrbpq_1
XFILLER_41_661 VPWR VGND sg13cmos5l_fill_1
XFILLER_41_650 VPWR VGND sg13cmos5l_decap_8
X_14573_ _14580_/B _14545_/A _14572_/Y _14573_/S VPWR VGND sg13cmos5l_mux2_1
X_19798__1758 _19798_/RESET_B VPWR VGND sg13cmos5l_tiehi
X_10736_ _10736_/Y _10713_/Y _10719_/Y _10735_/Y VPWR VGND sg13cmos5l_a21oi_1
X_17292_ _17296_/C _17298_/A _17292_/B VPWR VGND sg13cmos5l_nand2_1
X_13524_ _13524_/Y _13586_/B VPWR VGND sg13cmos5l_inv_1
X_16312_ _19428_/D _16312_/A _16312_/B VPWR VGND sg13cmos5l_nor2_1
X_19031_ _19031_/Q clkload31/A _19031_/D _19031_/RESET_B VPWR VGND sg13cmos5l_dfrbpq_1
X_18728__1553 _18728_/RESET_B VPWR VGND sg13cmos5l_tiehi
X_10667_ _10667_/Y _10658_/A _10392_/X _10663_/A VPWR VGND sg13cmos5l_o21ai_1
X_13455_ _13497_/A _19011_/Q _13455_/B VPWR VGND sg13cmos5l_xnor2_1
X_16243_ _16243_/Y _16243_/A _16243_/B VPWR VGND sg13cmos5l_nor2_1
XFILLER_9_345 VPWR VGND sg13cmos5l_fill_1
X_19741__1052 _19741_/RESET_B VPWR VGND sg13cmos5l_tiehi
X_12406_ _12408_/B _12305_/B _12429_/B _12405_/Y VPWR VGND sg13cmos5l_a21oi_1
X_19373__464 _19373_/D VPWR VGND sg13cmos5l_tielo
X_16174_ _16265_/A _16289_/A _16174_/B VPWR VGND sg13cmos5l_nand2_1
X_13386_ _13386_/X _13387_/A _13387_/B _13384_/Y VPWR VGND sg13cmos5l_a21o_1
X_10598_ _10599_/B _10598_/A _10608_/B VPWR VGND sg13cmos5l_nor2_1
X_15125_ _15125_/Y _15278_/A _15282_/A VPWR VGND sg13cmos5l_nand2_1
X_12337_ _12337_/Y _18848_/Q _12337_/B VPWR VGND sg13cmos5l_xnor2_1
XFILLER_56_6 VPWR VGND sg13cmos5l_fill_1
X_12268_ _12268_/X _12278_/D _12267_/C _12267_/A VPWR VGND sg13cmos5l_a21o_1
X_19098__1156 _19098_/RESET_B VPWR VGND sg13cmos5l_tiehi
X_15056_ _15057_/B _15056_/A _15154_/B VPWR VGND sg13cmos5l_nand2_1
X_11219_ _11323_/B _11219_/A _11234_/B VPWR VGND sg13cmos5l_nand2_1
X_14007_ _14007_/Y _13922_/B _14007_/B VPWR VGND sg13cmos5l_nand2b_1
X_19386__847 _19386_/RESET_B VPWR VGND sg13cmos5l_tiehi
X_12199_ _18804_/D _12199_/A _12199_/B VPWR VGND sg13cmos5l_and2_1
X_18815_ _18815_/Q _18902_/CLK _18815_/D _18815_/RESET_B VPWR VGND sg13cmos5l_dfrbpq_1
XFILLER_68_525 VPWR VGND sg13cmos5l_fill_2
X_19795_ _19795_/Q clkload22/A _19795_/D _19795_/RESET_B VPWR VGND sg13cmos5l_dfrbpq_1
X_18746_ _18746_/Q _18750_/CLK _18746_/D _18746_/RESET_B VPWR VGND sg13cmos5l_dfrbpq_1
XFILLER_83_517 VPWR VGND sg13cmos5l_fill_2
X_15958_ _15969_/B _15949_/Y _15954_/Y _15957_/Y VPWR VGND sg13cmos5l_a21o_1
X_18677_ _18677_/Q _19087_/CLK _18677_/D _18677_/RESET_B VPWR VGND sg13cmos5l_dfrbpq_1
XFILLER_37_967 VPWR VGND sg13cmos5l_fill_1
X_14909_ _19219_/D _14909_/A _14909_/B VPWR VGND sg13cmos5l_and2_1
X_17628_ _17628_/Y _17628_/A _17628_/B _17628_/C VPWR VGND sg13cmos5l_nand3_1
X_19710__1549 _19710_/RESET_B VPWR VGND sg13cmos5l_tiehi
XFILLER_37_989 VPWR VGND sg13cmos5l_fill_2
X_15889_ _15889_/Y _15975_/B _15991_/A _15889_/C VPWR VGND sg13cmos5l_nand3_1
X_17559_ _17559_/Y _17534_/X _17755_/A _17759_/A _17607_/A VPWR VGND sg13cmos5l_a22oi_1
X_18871__1398 _18871_/RESET_B VPWR VGND sg13cmos5l_tiehi
X_19672__1787 _19672_/RESET_B VPWR VGND sg13cmos5l_tiehi
X_19229_ _19229_/Q clkload44/A _19229_/D _19229_/RESET_B VPWR VGND sg13cmos5l_dfrbpq_1
XFILLER_105_405 VPWR VGND sg13cmos5l_fill_1
XFILLER_101_600 VPWR VGND sg13cmos5l_fill_2
Xfanout302 _12201_/A _11947_/Y VPWR VGND sg13cmos5l_buf_1
Xfanout313 _11629_/A _11631_/A VPWR VGND sg13cmos5l_buf_1
Xfanout324 _18558_/A _18560_/A VPWR VGND sg13cmos5l_buf_1
Xfanout346 _12932_/A _12751_/A VPWR VGND sg13cmos5l_buf_1
Xfanout335 _17831_/A hold2989/X VPWR VGND sg13cmos5l_buf_1
Xfanout357 _18272_/A _10859_/A VPWR VGND sg13cmos5l_buf_1
XFILLER_87_889 VPWR VGND sg13cmos5l_fill_2
Xfanout368 _16549_/A input1/X VPWR VGND sg13cmos5l_buf_1
Xfanout379 _15528_/A _15735_/A VPWR VGND sg13cmos5l_buf_1
XFILLER_74_528 VPWR VGND sg13cmos5l_fill_1
X_19302__937 _19302_/RESET_B VPWR VGND sg13cmos5l_tiehi
X_11570_ _11570_/Y _11564_/Y _11567_/Y _11569_/Y VPWR VGND sg13cmos5l_a21oi_1
X_10521_ _10538_/B _19799_/Q _19800_/Q _19801_/Q VPWR VGND sg13cmos5l_or3_1
X_13240_ _13241_/A _13265_/A _13240_/B VPWR VGND sg13cmos5l_nand2b_1
X_19053__1204 _19053_/RESET_B VPWR VGND sg13cmos5l_tiehi
X_10452_ _10602_/A _10598_/A _10608_/B VPWR VGND sg13cmos5l_nand2_1
X_10383_ _10692_/A _10384_/A _18567_/Q _18566_/Q VPWR VGND sg13cmos5l_nor3_1
X_13171_ _13176_/B _13579_/A _13173_/B VPWR VGND sg13cmos5l_nand2_1
X_12122_ _12122_/Y _12265_/B _12287_/A VPWR VGND sg13cmos5l_nor2_1
XFILLER_2_532 VPWR VGND sg13cmos5l_fill_1
X_12053_ _12170_/A _12148_/A _12148_/B VPWR VGND sg13cmos5l_nor2_1
X_16930_ _16930_/Y _17013_/A _17013_/B VPWR VGND sg13cmos5l_nand2_1
XFILLER_81_1012 VPWR VGND sg13cmos5l_fill_2
X_11004_ _11004_/Y _18605_/Q _19774_/Q VPWR VGND sg13cmos5l_xnor2_1
XFILLER_2_576 VPWR VGND sg13cmos5l_fill_1
X_16861_ _16861_/Y _16861_/A _17371_/A _16861_/C VPWR VGND sg13cmos5l_nand3_1
X_16792_ _16792_/Y _16686_/Y _16792_/B _16792_/C VPWR VGND sg13cmos5l_nand3b_1
X_18600_ _18600_/Q clkload55/A _18600_/D _18600_/RESET_B VPWR VGND sg13cmos5l_dfrbpq_1
X_19580_ _19580_/Q clkload35/A _19580_/D _19580_/RESET_B VPWR VGND sg13cmos5l_dfrbpq_1
X_15812_ _15824_/B _19327_/Q _19328_/Q _19325_/Q _19326_/Q VPWR VGND sg13cmos5l_nor4_1
X_12955_ _12955_/Y _12957_/S _12954_/Y VPWR VGND sg13cmos5l_nor2b_1
X_18531_ _19768_/D _18531_/A _18531_/B VPWR VGND sg13cmos5l_nor2_1
X_15743_ _19347_/D _15748_/A _15743_/B VPWR VGND sg13cmos5l_nor2_1
X_11906_ _11906_/Y _18725_/Q _12110_/A VPWR VGND sg13cmos5l_nand2b_1
XFILLER_92_369 VPWR VGND sg13cmos5l_fill_2
XFILLER_73_550 VPWR VGND sg13cmos5l_fill_2
XFILLER_19_978 VPWR VGND sg13cmos5l_fill_1
X_12886_ _12887_/B _12932_/A _18914_/Q _18915_/Q VPWR VGND sg13cmos5l_o21ai_1
XFILLER_45_296 VPWR VGND sg13cmos5l_fill_2
X_18462_ _18463_/B _18441_/B _18438_/A _18462_/S VPWR VGND sg13cmos5l_mux2_1
X_15674_ _15674_/Y _15659_/Y _15667_/X _15673_/Y VPWR VGND sg13cmos5l_o21ai_1
X_11837_ _11837_/Y _11905_/B VPWR VGND sg13cmos5l_inv_1
X_17413_ _17413_/Y _19621_/Q _17937_/A _17392_/B _17142_/B VPWR VGND sg13cmos5l_a22oi_1
X_14625_ _19164_/D hold2682/X _14628_/S _14624_/Y VPWR VGND sg13cmos5l_a21oi_1
X_18393_ _18393_/Y _10481_/X _18390_/Y _10579_/A VPWR VGND sg13cmos5l_o21ai_1
XFILLER_33_447 VPWR VGND sg13cmos5l_fill_1
X_11768_ _11874_/A _11751_/A _11769_/B _11767_/Y VPWR VGND sg13cmos5l_a21oi_1
X_17344_ _17348_/A _17344_/A _17377_/B VPWR VGND sg13cmos5l_nand2_1
X_14556_ _14556_/Y _14556_/A _14556_/B VPWR VGND sg13cmos5l_nand2_1
X_10719_ _10719_/Y _10696_/Y _10716_/B _10715_/Y _10718_/Y VPWR VGND sg13cmos5l_a22oi_1
X_13507_ _13507_/Y _13507_/A _13512_/B _13512_/C VPWR VGND sg13cmos5l_nor3_1
X_11699_ _11701_/A _18702_/Q _18695_/Q VPWR VGND sg13cmos5l_nor2_1
X_17275_ _17275_/X _17278_/A _17467_/A _17273_/Y VPWR VGND sg13cmos5l_a21o_1
X_19014_ _19014_/Q clkload65/A _19014_/D _19014_/RESET_B VPWR VGND sg13cmos5l_dfrbpq_1
X_14487_ _14611_/A _14303_/X _14486_/Y _14487_/S VPWR VGND sg13cmos5l_mux2_1
X_13438_ _13539_/B _13450_/A _13450_/B VPWR VGND sg13cmos5l_nand2_1
X_16226_ _16226_/Y _16226_/A _16226_/B _16226_/C _16226_/D VPWR VGND sg13cmos5l_nand4_1
X_13369_ _13373_/B _13575_/A _13366_/X _13367_/X _13401_/A VPWR VGND sg13cmos5l_a22oi_1
X_16157_ _16273_/A _19426_/Q _16170_/B VPWR VGND sg13cmos5l_xnor2_1
X_15108_ _15111_/A _15108_/A _15108_/B _15108_/C VPWR VGND sg13cmos5l_or3_1
X_16088_ _16088_/X _16100_/A _16136_/A VPWR VGND sg13cmos5l_or2_1
XFILLER_102_408 VPWR VGND sg13cmos5l_decap_8
X_15039_ _15147_/A _19258_/Q _15039_/B VPWR VGND sg13cmos5l_xnor2_1
Xhold2718 _17324_/A _19583_/Q VPWR VGND sg13cmos5l_dlygate4sd3_1
Xhold2707 hold2707/X _17588_/Y VPWR VGND sg13cmos5l_dlygate4sd3_1
Xhold2729 _16269_/A _16268_/Y VPWR VGND sg13cmos5l_dlygate4sd3_1
XFILLER_95_152 VPWR VGND sg13cmos5l_fill_1
X_19778_ _19778_/Q clkload48/A _19778_/D _19778_/RESET_B VPWR VGND sg13cmos5l_dfrbpq_1
X_18729_ _18729_/Q clkload60/A _18729_/D _18729_/RESET_B VPWR VGND sg13cmos5l_dfrbpq_1
XFILLER_64_550 VPWR VGND sg13cmos5l_fill_2
XFILLER_24_436 VPWR VGND sg13cmos5l_fill_1
XFILLER_25_948 VPWR VGND sg13cmos5l_fill_1
XFILLER_40_907 VPWR VGND sg13cmos5l_fill_1
XFILLER_51_266 VPWR VGND sg13cmos5l_fill_2
X_19725__1324 _19725_/RESET_B VPWR VGND sg13cmos5l_tiehi
X_19438__792 _19438_/RESET_B VPWR VGND sg13cmos5l_tiehi
XFILLER_4_819 VPWR VGND sg13cmos5l_decap_8
XFILLER_106_758 VPWR VGND sg13cmos5l_fill_1
XFILLER_105_235 VPWR VGND sg13cmos5l_fill_2
XFILLER_106_769 VPWR VGND sg13cmos5l_decap_8
Xfanout110 _13649_/B _13653_/A VPWR VGND sg13cmos5l_buf_1
Xfanout121 _17179_/A _16972_/Y VPWR VGND sg13cmos5l_buf_1
X_19369__864 _19369_/RESET_B VPWR VGND sg13cmos5l_tiehi
Xfanout154 _16693_/B _16675_/Y VPWR VGND sg13cmos5l_buf_1
XFILLER_87_664 VPWR VGND sg13cmos5l_fill_2
XFILLER_86_130 VPWR VGND sg13cmos5l_fill_2
Xfanout143 _18200_/B _18091_/B VPWR VGND sg13cmos5l_buf_1
Xfanout165 _15053_/B _15033_/Y VPWR VGND sg13cmos5l_buf_1
Xfanout132 _14489_/B _14464_/X VPWR VGND sg13cmos5l_buf_1
Xfanout187 _12054_/B _12034_/Y VPWR VGND sg13cmos5l_buf_1
Xfanout176 _13751_/B _13734_/Y VPWR VGND sg13cmos5l_buf_1
XFILLER_75_837 VPWR VGND sg13cmos5l_fill_1
XFILLER_59_377 VPWR VGND sg13cmos5l_fill_1
Xfanout198 _10608_/B _10447_/Y VPWR VGND sg13cmos5l_buf_1
XFILLER_47_539 VPWR VGND sg13cmos5l_decap_4
XFILLER_47_67 VPWR VGND sg13cmos5l_fill_2
X_12740_ _12740_/Y _18915_/Q _12760_/A _12737_/Y _12738_/Y _12739_/Y VPWR VGND sg13cmos5l_a221oi_1
XFILLER_16_948 VPWR VGND sg13cmos5l_fill_1
X_18594__1705 _18594_/RESET_B VPWR VGND sg13cmos5l_tiehi
X_12671_ _12674_/A _12662_/Y _12665_/Y _12669_/Y VPWR VGND sg13cmos5l_a21o_1
X_11622_ _18713_/D _11622_/A _11625_/B VPWR VGND sg13cmos5l_nor2_1
X_15390_ _15464_/B _15395_/S _15388_/Y _15389_/X VPWR VGND sg13cmos5l_a21o_1
X_14410_ _14410_/Y _14410_/A VPWR VGND sg13cmos5l_inv_1
XFILLER_24_970 VPWR VGND sg13cmos5l_fill_1
XFILLER_30_428 VPWR VGND sg13cmos5l_fill_1
X_18940__505 _18940_/D VPWR VGND sg13cmos5l_tielo
X_19376__857 _19376_/RESET_B VPWR VGND sg13cmos5l_tiehi
X_14341_ _14342_/B _14341_/A _14341_/B VPWR VGND sg13cmos5l_or2_1
X_11553_ _11554_/B _11720_/A _11553_/B VPWR VGND sg13cmos5l_nand2_1
X_17060_ _17064_/B _17060_/A _17060_/B VPWR VGND sg13cmos5l_nand2_1
X_11484_ _11484_/Y _18716_/Q _11588_/B VPWR VGND sg13cmos5l_nor2_1
XFILLER_10_163 VPWR VGND sg13cmos5l_fill_1
X_14272_ _14272_/Y _14310_/A _14266_/A _14310_/B _14303_/A VPWR VGND sg13cmos5l_a22oi_1
X_10504_ _10590_/B _19741_/Q _10504_/B VPWR VGND sg13cmos5l_xor2_1
X_13223_ _13233_/A _18964_/Q _13263_/B _13251_/A VPWR VGND sg13cmos5l_a21o_1
X_16011_ _19383_/D _16011_/A _16016_/B VPWR VGND sg13cmos5l_nor2_1
X_10435_ _10437_/B _19339_/Q _19381_/Q _19423_/Q _19497_/Q VPWR VGND sg13cmos5l_nor4_1
XFILLER_88_30 VPWR VGND sg13cmos5l_fill_2
X_13154_ _13377_/A _13577_/A _13154_/B VPWR VGND sg13cmos5l_xnor2_1
XFILLER_6_178 VPWR VGND sg13cmos5l_decap_4
X_18844__1428 _18844_/RESET_B VPWR VGND sg13cmos5l_tiehi
X_12105_ _12109_/C _12111_/A _12291_/A VPWR VGND sg13cmos5l_nand2_1
X_10366_ _17121_/B _10366_/A VPWR VGND sg13cmos5l_inv_1
X_19017__1243 _19017_/RESET_B VPWR VGND sg13cmos5l_tiehi
X_10297_ _11655_/A _10297_/A VPWR VGND sg13cmos5l_inv_1
X_13085_ _18944_/D _13573_/A _13085_/B VPWR VGND sg13cmos5l_and2_1
X_17962_ _17962_/Y _17962_/A _17962_/B _17962_/C VPWR VGND sg13cmos5l_nand3_1
X_16913_ _16913_/Y _16729_/A _16940_/A _16940_/B _16916_/A VPWR VGND sg13cmos5l_a22oi_1
X_12036_ _12148_/A _12036_/A _12054_/B VPWR VGND sg13cmos5l_and2_1
X_17893_ _17893_/X _17770_/B _17852_/Y _17898_/S VPWR VGND sg13cmos5l_mux2_1
X_19701_ _19701_/Q _19756_/CLK _19701_/D _19701_/RESET_B VPWR VGND sg13cmos5l_dfrbpq_1
X_16844_ _16844_/Y _19471_/Q _16860_/A VPWR VGND sg13cmos5l_nand2_1
X_19632_ _19632_/Q clkload26/A _19632_/D _19632_/RESET_B VPWR VGND sg13cmos5l_dfrbpq_1
X_16775_ _16775_/Y _16770_/A _16829_/B _16756_/Y _16759_/Y _16655_/B VPWR VGND sg13cmos5l_a221oi_1
XFILLER_81_807 VPWR VGND sg13cmos5l_fill_2
X_19563_ _19563_/Q clkload37/A _19563_/D _19563_/RESET_B VPWR VGND sg13cmos5l_dfrbpq_1
X_13987_ _14177_/A _14371_/A _13987_/B VPWR VGND sg13cmos5l_xnor2_1
X_19494_ _19494_/Q clkload32/A _19494_/D _19494_/RESET_B VPWR VGND sg13cmos5l_dfrbpq_1
X_12938_ _12938_/Y _12938_/A _12938_/B _12938_/C _12938_/D VPWR VGND sg13cmos5l_nand4_1
XFILLER_46_594 VPWR VGND sg13cmos5l_fill_2
X_18514_ _18514_/Y _19790_/Q _18514_/B _18514_/C VPWR VGND sg13cmos5l_nor3_1
X_15726_ _19333_/D _15748_/A _15726_/B VPWR VGND sg13cmos5l_nor2_1
X_15657_ _15657_/Y _15676_/A _15656_/B _15648_/Y _15644_/Y _15846_/A VPWR VGND sg13cmos5l_a221oi_1
XFILLER_33_244 VPWR VGND sg13cmos5l_fill_1
X_18445_ _18445_/Y _18482_/B _18445_/B VPWR VGND sg13cmos5l_nand2_1
X_12869_ _12883_/A _12869_/A _12869_/B VPWR VGND sg13cmos5l_nor2_1
X_14608_ _14608_/Y _14591_/A _14591_/B _14601_/X _14606_/Y _14607_/Y VPWR VGND sg13cmos5l_a221oi_1
X_15588_ _15588_/Y _19319_/Q _19280_/Q VPWR VGND sg13cmos5l_xnor2_1
X_18376_ _18399_/A _19757_/Q _19758_/Q VPWR VGND sg13cmos5l_xnor2_1
XFILLER_105_1023 VPWR VGND sg13cmos5l_decap_4
X_17327_ _17334_/B _17289_/Y _17191_/Y _17341_/B VPWR VGND sg13cmos5l_mux2_1
X_14539_ _14540_/C _14721_/A _19180_/Q VPWR VGND sg13cmos5l_nand2_1
X_17258_ _17258_/X _17259_/A _17450_/B _17250_/Y VPWR VGND sg13cmos5l_a21o_1
X_16209_ _16209_/X _16213_/A _16256_/A _16201_/Y VPWR VGND sg13cmos5l_a21o_1
X_17189_ _17290_/B _17203_/B _17178_/X _17187_/Y VPWR VGND sg13cmos5l_o21ai_1
X_19160__1088 _19160_/RESET_B VPWR VGND sg13cmos5l_tiehi
Xhold2504 _17954_/A _19638_/Q VPWR VGND sg13cmos5l_dlygate4sd3_1
X_19468__752 _19468_/RESET_B VPWR VGND sg13cmos5l_tiehi
Xhold2537 _10051_/A _18874_/Q VPWR VGND sg13cmos5l_dlygate4sd3_1
Xhold2526 _10062_/A _18912_/Q VPWR VGND sg13cmos5l_dlygate4sd3_1
Xhold2515 _19440_/D _16365_/Y VPWR VGND sg13cmos5l_dlygate4sd3_1
XFILLER_25_1024 VPWR VGND sg13cmos5l_decap_4
Xhold1836 _13015_/B _18877_/Q VPWR VGND sg13cmos5l_dlygate4sd3_1
Xhold2548 hold2548/X _19811_/Q VPWR VGND sg13cmos5l_dlygate4sd3_1
XFILLER_68_152 VPWR VGND sg13cmos5l_fill_2
Xhold1814 _10879_/B _19774_/Q VPWR VGND sg13cmos5l_dlygate4sd3_1
Xhold2559 _16504_/A _19457_/Q VPWR VGND sg13cmos5l_dlygate4sd3_1
Xhold1825 _14709_/B _19155_/Q VPWR VGND sg13cmos5l_dlygate4sd3_1
Xhold1858 _16623_/B _19029_/Q VPWR VGND sg13cmos5l_dlygate4sd3_1
Xhold1847 _17150_/B _19522_/Q VPWR VGND sg13cmos5l_dlygate4sd3_1
Xhold1869 _13439_/B _18946_/Q VPWR VGND sg13cmos5l_dlygate4sd3_1
XFILLER_29_539 VPWR VGND sg13cmos5l_fill_2
XFILLER_65_870 VPWR VGND sg13cmos5l_fill_2
X_19793__1763 _19793_/RESET_B VPWR VGND sg13cmos5l_tiehi
XFILLER_37_550 VPWR VGND sg13cmos5l_fill_1
XFILLER_25_789 VPWR VGND sg13cmos5l_fill_1
X_19475__745 _19475_/RESET_B VPWR VGND sg13cmos5l_tiehi
X_19093__1161 _19093_/RESET_B VPWR VGND sg13cmos5l_tiehi
XFILLER_106_500 VPWR VGND sg13cmos5l_decap_8
XFILLER_106_533 VPWR VGND sg13cmos5l_decap_8
XFILLER_4_627 VPWR VGND sg13cmos5l_fill_2
X_10220_ _15482_/B _19276_/Q VPWR VGND sg13cmos5l_inv_1
X_10151_ _17369_/A _16861_/A VPWR VGND sg13cmos5l_inv_1
X_10082_ _16819_/A _13600_/A VPWR VGND sg13cmos5l_inv_1
XFILLER_58_33 VPWR VGND sg13cmos5l_decap_8
XFILLER_58_77 VPWR VGND sg13cmos5l_fill_1
X_13910_ _13911_/B _13501_/X _13909_/Y _13924_/S VPWR VGND sg13cmos5l_mux2_1
X_14890_ _14901_/S _14779_/A _14779_/B _14880_/Y _14888_/Y _14889_/Y VPWR VGND sg13cmos5l_a221oi_1
X_13841_ _13847_/A _14085_/B _13846_/B _13839_/A _10249_/Y _13840_/Y VPWR VGND sg13cmos5l_a221oi_1
X_13772_ _13772_/Y _13716_/A _13780_/B _13771_/Y VPWR VGND sg13cmos5l_a21oi_1
X_10984_ _11198_/A _10984_/A _10990_/B VPWR VGND sg13cmos5l_nand2_1
X_16560_ _19466_/D _16561_/A _16560_/B VPWR VGND sg13cmos5l_and2_1
X_12723_ _18878_/D _12723_/A _12728_/B VPWR VGND sg13cmos5l_nor2_1
X_15511_ _15511_/Y _10212_/Y _15516_/S _15510_/Y VPWR VGND sg13cmos5l_a21oi_1
X_16491_ _16512_/B _16508_/A _16508_/B VPWR VGND sg13cmos5l_nand2_1
X_18230_ _19717_/D _18233_/A _18230_/B VPWR VGND sg13cmos5l_nor2_1
X_12654_ _12732_/B _12664_/S _12838_/A _12652_/X VPWR VGND sg13cmos5l_a21o_1
X_15442_ _19290_/D _15332_/Y _15447_/S _15441_/Y VPWR VGND sg13cmos5l_a21oi_1
XFILLER_30_214 VPWR VGND sg13cmos5l_fill_2
XFILLER_31_759 VPWR VGND sg13cmos5l_fill_2
X_12585_ _12695_/A _18882_/Q _12602_/B VPWR VGND sg13cmos5l_xnor2_1
XFILLER_90_86 VPWR VGND sg13cmos5l_fill_2
X_11605_ _11606_/B _11581_/B _11614_/B _11625_/B VPWR VGND sg13cmos5l_a21oi_1
X_15373_ _15376_/A _15373_/A _15389_/A _15389_/C VPWR VGND sg13cmos5l_nand3_1
X_19235__1010 _19235_/RESET_B VPWR VGND sg13cmos5l_tiehi
XFILLER_30_247 VPWR VGND sg13cmos5l_fill_1
X_18161_ _18161_/Y _18195_/A _18232_/B VPWR VGND sg13cmos5l_nor2_1
X_11536_ _11536_/Y _18702_/Q _18717_/Q VPWR VGND sg13cmos5l_nand2_1
X_17112_ _17113_/A _17122_/C _17111_/Y _17110_/Y VPWR VGND sg13cmos5l_o21ai_1
X_19689__1768 _19689_/RESET_B VPWR VGND sg13cmos5l_tiehi
X_18092_ _18092_/Y _18092_/A _18092_/B VPWR VGND sg13cmos5l_xnor2_1
XFILLER_8_944 VPWR VGND sg13cmos5l_decap_4
XFILLER_8_966 VPWR VGND sg13cmos5l_fill_2
X_14324_ _14325_/B _19130_/Q _14229_/B _14207_/Y VPWR VGND sg13cmos5l_a21oi_1
X_17043_ _17043_/Y _17043_/A _17043_/B _17043_/C VPWR VGND sg13cmos5l_nand3_1
X_14255_ _14303_/B _14641_/A _14255_/B VPWR VGND sg13cmos5l_xnor2_1
X_11467_ _18697_/D _11479_/A _11467_/B VPWR VGND sg13cmos5l_nor2_1
X_13206_ _13210_/B _13197_/Y _13201_/Y _13205_/Y VPWR VGND sg13cmos5l_o21ai_1
X_11398_ _11398_/Y _10025_/A _11899_/A _11378_/B _18645_/Q VPWR VGND sg13cmos5l_a22oi_1
X_10418_ _10419_/D _10418_/A _10652_/B VPWR VGND sg13cmos5l_nor2_1
X_14186_ _14288_/A _14186_/A _14200_/B _14200_/C VPWR VGND sg13cmos5l_nand3_1
X_13137_ _13259_/A _12953_/Y _13136_/C _13136_/Y VPWR VGND sg13cmos5l_a21o_1
X_18994_ _18994_/Q clkload65/A _18994_/D _18994_/RESET_B VPWR VGND sg13cmos5l_dfrbpq_1
X_10349_ _17402_/A _10349_/A VPWR VGND sg13cmos5l_inv_1
X_13068_ _18934_/D _13289_/B _13068_/B VPWR VGND sg13cmos5l_nor2_1
X_17945_ _17945_/Y _18471_/A _19638_/Q _17944_/Y VPWR VGND sg13cmos5l_o21ai_1
XFILLER_3_693 VPWR VGND sg13cmos5l_decap_4
X_12019_ _12020_/B _11999_/A _11999_/B _12018_/Y VPWR VGND sg13cmos5l_o21ai_1
XFILLER_78_450 VPWR VGND sg13cmos5l_fill_1
X_18808__1467 _18808_/RESET_B VPWR VGND sg13cmos5l_tiehi
XFILLER_38_336 VPWR VGND sg13cmos5l_fill_2
X_17876_ _17943_/B _17815_/Y _17870_/B _17875_/X VPWR VGND sg13cmos5l_a21o_1
X_16827_ _19508_/D _16827_/A _16827_/B VPWR VGND sg13cmos5l_nor2_1
XFILLER_93_442 VPWR VGND sg13cmos5l_fill_2
XFILLER_66_678 VPWR VGND sg13cmos5l_decap_4
X_19615_ _19615_/Q clkload26/A _19615_/D _19615_/RESET_B VPWR VGND sg13cmos5l_dfrbpq_1
X_16758_ _16759_/B _16770_/A _16829_/B VPWR VGND sg13cmos5l_nor2_1
X_19546_ _19546_/Q _19546_/CLK _19546_/D _19546_/RESET_B VPWR VGND sg13cmos5l_dfrbpq_1
XFILLER_47_870 VPWR VGND sg13cmos5l_fill_2
XFILLER_0_40 VPWR VGND sg13cmos5l_fill_1
XFILLER_19_583 VPWR VGND sg13cmos5l_fill_2
X_15709_ _15719_/A _15600_/Y _15717_/A _15709_/C VPWR VGND sg13cmos5l_nand3b_1
X_16689_ _16800_/B _16763_/A _16762_/A VPWR VGND sg13cmos5l_nor2_1
X_19477_ _19477_/Q _19814_/CLK _19477_/D _19477_/RESET_B VPWR VGND sg13cmos5l_dfrbpq_1
XFILLER_55_1028 VPWR VGND sg13cmos5l_fill_1
XFILLER_21_225 VPWR VGND sg13cmos5l_fill_1
XFILLER_22_759 VPWR VGND sg13cmos5l_fill_1
X_18428_ _18428_/Y _18428_/A _18431_/B _18431_/C VPWR VGND sg13cmos5l_nor3_1
X_18359_ _18443_/C _19753_/Q _18369_/B _18370_/A VPWR VGND sg13cmos5l_o21ai_1
XFILLER_21_247 VPWR VGND sg13cmos5l_fill_2
X_19435__795 _19435_/RESET_B VPWR VGND sg13cmos5l_tiehi
Xhold3002 _16713_/A _19508_/Q VPWR VGND sg13cmos5l_dlygate4sd3_1
Xhold3013 _10483_/A _19739_/Q VPWR VGND sg13cmos5l_dlygate4sd3_1
X_09994_ _09994_/Y _09994_/A VPWR VGND sg13cmos5l_inv_1
XFILLER_103_536 VPWR VGND sg13cmos5l_decap_4
Xhold3057 _13607_/A _19044_/Q VPWR VGND sg13cmos5l_dlygate4sd3_1
Xhold2301 _18813_/D _12252_/Y VPWR VGND sg13cmos5l_dlygate4sd3_1
Xhold3035 _17268_/A _19594_/Q VPWR VGND sg13cmos5l_dlygate4sd3_1
Xhold3046 hold3046/X _19159_/Q VPWR VGND sg13cmos5l_dlygate4sd3_1
Xhold2312 _19317_/D _15519_/Y VPWR VGND sg13cmos5l_dlygate4sd3_1
Xhold2323 _19641_/D _17726_/Y VPWR VGND sg13cmos5l_dlygate4sd3_1
Xhold2345 _14700_/B _19191_/Q VPWR VGND sg13cmos5l_dlygate4sd3_1
Xhold2334 _10227_/A _19232_/Q VPWR VGND sg13cmos5l_dlygate4sd3_1
Xhold2367 _10303_/A _18643_/Q VPWR VGND sg13cmos5l_dlygate4sd3_1
Xhold2378 _13077_/B _18939_/Q VPWR VGND sg13cmos5l_dlygate4sd3_1
Xhold2356 _10216_/A _19273_/Q VPWR VGND sg13cmos5l_dlygate4sd3_1
Xhold2389 _15736_/A _19290_/Q VPWR VGND sg13cmos5l_dlygate4sd3_1
X_19366__867 _19366_/RESET_B VPWR VGND sg13cmos5l_tiehi
XFILLER_72_659 VPWR VGND sg13cmos5l_fill_1
XFILLER_53_873 VPWR VGND sg13cmos5l_fill_1
XFILLER_13_704 VPWR VGND sg13cmos5l_fill_1
XFILLER_25_553 VPWR VGND sg13cmos5l_fill_1
X_12370_ _12467_/B _12368_/B _12574_/A _12368_/Y VPWR VGND sg13cmos5l_a21o_1
X_11321_ _11321_/Y _11321_/A _11321_/B VPWR VGND sg13cmos5l_nor2_1
X_19705__1646 _19705_/RESET_B VPWR VGND sg13cmos5l_tiehi
X_18884__1385 _18884_/RESET_B VPWR VGND sg13cmos5l_tiehi
X_11252_ _11434_/A _18662_/Q _11437_/A VPWR VGND sg13cmos5l_xnor2_1
X_19685__1774 _19685_/RESET_B VPWR VGND sg13cmos5l_tiehi
X_14040_ _14040_/Y _14028_/Y _14030_/X _14041_/A _14041_/B VPWR VGND sg13cmos5l_a22oi_1
X_11183_ _11204_/C _11183_/A _11199_/B VPWR VGND sg13cmos5l_nand2_1
XFILLER_4_479 VPWR VGND sg13cmos5l_fill_1
X_10203_ _16349_/B _10203_/A VPWR VGND sg13cmos5l_inv_1
X_10134_ _16552_/A _10134_/A VPWR VGND sg13cmos5l_inv_1
XFILLER_0_652 VPWR VGND sg13cmos5l_decap_4
XFILLER_0_674 VPWR VGND sg13cmos5l_fill_2
X_15991_ _15995_/B _15991_/A _15991_/B VPWR VGND sg13cmos5l_nand2_1
X_10065_ _10065_/Y _18868_/Q VPWR VGND sg13cmos5l_inv_1
XFILLER_76_954 VPWR VGND sg13cmos5l_decap_4
X_17730_ _17730_/Y _17713_/Y hold2269/X _17933_/B VPWR VGND sg13cmos5l_a21oi_1
X_14942_ _14942_/Y _14942_/A _19192_/Q VPWR VGND sg13cmos5l_nor2_1
Xhold2890 _11803_/A _18764_/Q VPWR VGND sg13cmos5l_dlygate4sd3_1
XFILLER_76_987 VPWR VGND sg13cmos5l_decap_4
X_17661_ _17663_/B _17661_/A _17662_/A VPWR VGND sg13cmos5l_nor2b_1
X_14873_ _14873_/Y _14873_/A _14873_/B VPWR VGND sg13cmos5l_nor2_1
XFILLER_85_97 VPWR VGND sg13cmos5l_fill_2
X_16612_ _16612_/Y _16596_/A fanout31/X _16655_/A VPWR VGND sg13cmos5l_o21ai_1
XFILLER_78_1028 VPWR VGND sg13cmos5l_fill_1
XFILLER_62_103 VPWR VGND sg13cmos5l_fill_2
X_13824_ _13824_/Y _19083_/Q _10253_/Y _10254_/Y _19082_/Q _13823_/Y VPWR VGND sg13cmos5l_a221oi_1
X_19400_ _19400_/Q clkload6/A _19400_/D _19400_/RESET_B VPWR VGND sg13cmos5l_dfrbpq_1
XFILLER_35_306 VPWR VGND sg13cmos5l_fill_1
X_19133__1118 _19133_/RESET_B VPWR VGND sg13cmos5l_tiehi
X_17592_ _17593_/B _17592_/A _17613_/B VPWR VGND sg13cmos5l_nand2_1
X_19331_ _19331_/Q clkload18/A _19331_/D _19331_/RESET_B VPWR VGND sg13cmos5l_dfrbpq_1
X_13755_ _13756_/B _13755_/A _13755_/B VPWR VGND sg13cmos5l_xor2_1
X_10967_ _10989_/B _10955_/Y _10962_/Y _10966_/Y VPWR VGND sg13cmos5l_o21ai_1
X_16543_ _16543_/Y _16520_/Y fanout33/X _16561_/A VPWR VGND sg13cmos5l_o21ai_1
X_13686_ _16648_/A _19044_/Q _13687_/B VPWR VGND sg13cmos5l_xnor2_1
X_12706_ _12706_/Y _12706_/A _12706_/B VPWR VGND sg13cmos5l_nor2_1
X_19262_ _19262_/Q _19262_/CLK _19262_/D _19262_/RESET_B VPWR VGND sg13cmos5l_dfrbpq_1
X_16474_ _16474_/Y _16562_/B VPWR VGND sg13cmos5l_inv_1
XFILLER_31_534 VPWR VGND sg13cmos5l_fill_1
X_10898_ _10898_/Y _10898_/A _10928_/A VPWR VGND sg13cmos5l_nor2_1
X_12637_ _12637_/Y _12633_/Y _12635_/Y _12630_/Y VPWR VGND sg13cmos5l_a21oi_1
X_18213_ _19702_/D _18213_/A _18213_/B VPWR VGND sg13cmos5l_nor2_1
X_15425_ _15425_/Y _15420_/A _15422_/Y _15423_/Y _15417_/X _15424_/Y VPWR VGND sg13cmos5l_a221oi_1
XFILLER_15_1012 VPWR VGND sg13cmos5l_decap_8
X_19458__762 _19458_/RESET_B VPWR VGND sg13cmos5l_tiehi
X_19193_ _19193_/Q _19805_/CLK _19193_/D _19193_/RESET_B VPWR VGND sg13cmos5l_dfrbpq_1
X_18144_ _18144_/Y _18309_/A _18157_/B VPWR VGND sg13cmos5l_nand2_1
X_12568_ _18865_/D _12732_/A _12568_/B VPWR VGND sg13cmos5l_nor2_1
X_15356_ _15360_/A _19309_/Q _15357_/B VPWR VGND sg13cmos5l_xnor2_1
X_12499_ _12499_/Y _13020_/A _18876_/Q VPWR VGND sg13cmos5l_nor2_1
X_11519_ _11713_/A _18707_/Q _11519_/B VPWR VGND sg13cmos5l_xnor2_1
X_18075_ _18186_/A _19710_/Q _18091_/B VPWR VGND sg13cmos5l_xnor2_1
XFILLER_7_273 VPWR VGND sg13cmos5l_fill_2
XFILLER_7_251 VPWR VGND sg13cmos5l_fill_2
X_15287_ _19283_/D _15465_/A _15287_/B VPWR VGND sg13cmos5l_and2_1
X_14307_ _14307_/X _14304_/Y _14303_/X _14307_/S VPWR VGND sg13cmos5l_mux2_1
X_17026_ _17040_/B _17053_/A _17090_/B _17023_/Y _17018_/Y _17025_/Y VPWR VGND sg13cmos5l_a221oi_1
X_14238_ _14278_/A _19122_/Q _14468_/A VPWR VGND sg13cmos5l_and2_1
X_18953__504 _18953_/D VPWR VGND sg13cmos5l_tielo
X_14169_ _14169_/X _13982_/Y _14167_/X _14164_/Y VPWR VGND sg13cmos5l_a21o_1
X_18977_ _18977_/Q clkload46/A _18977_/D _18977_/RESET_B VPWR VGND sg13cmos5l_dfrbpq_1
X_19465__755 _19465_/RESET_B VPWR VGND sg13cmos5l_tiehi
X_17928_ _17929_/B _17916_/A _17913_/Y _17928_/S VPWR VGND sg13cmos5l_mux2_1
XFILLER_39_634 VPWR VGND sg13cmos5l_fill_2
XFILLER_39_623 VPWR VGND sg13cmos5l_fill_1
XFILLER_39_612 VPWR VGND sg13cmos5l_fill_1
X_17859_ _17861_/B _18050_/A _17858_/Y _17871_/S VPWR VGND sg13cmos5l_mux2_1
X_19529_ _19529_/Q clkload40/A _19529_/D _19529_/RESET_B VPWR VGND sg13cmos5l_dfrbpq_1
XFILLER_62_681 VPWR VGND sg13cmos5l_decap_4
XFILLER_10_718 VPWR VGND sg13cmos5l_fill_1
X_19472__748 _19472_/RESET_B VPWR VGND sg13cmos5l_tiehi
XFILLER_104_801 VPWR VGND sg13cmos5l_fill_2
XFILLER_2_939 VPWR VGND sg13cmos5l_decap_4
XFILLER_1_449 VPWR VGND sg13cmos5l_fill_1
XFILLER_103_344 VPWR VGND sg13cmos5l_decap_8
XFILLER_89_578 VPWR VGND sg13cmos5l_fill_2
X_09977_ _09977_/Y _09977_/A VPWR VGND sg13cmos5l_inv_1
Xhold2120 _13849_/A _19084_/Q VPWR VGND sg13cmos5l_dlygate4sd3_1
XFILLER_39_35 VPWR VGND sg13cmos5l_fill_2
X_18869__1400 _18869_/RESET_B VPWR VGND sg13cmos5l_tiehi
Xhold2142 _18854_/D _12518_/Y VPWR VGND sg13cmos5l_dlygate4sd3_1
Xhold2164 _17110_/A _19513_/Q VPWR VGND sg13cmos5l_dlygate4sd3_1
Xhold2153 hold2153/X _18284_/Y VPWR VGND sg13cmos5l_dlygate4sd3_1
Xhold2131 _18981_/D _13350_/Y VPWR VGND sg13cmos5l_dlygate4sd3_1
Xhold2197 _18810_/D _12246_/Y VPWR VGND sg13cmos5l_dlygate4sd3_1
Xhold2186 _10369_/A _19471_/Q VPWR VGND sg13cmos5l_dlygate4sd3_1
Xhold2175 _10246_/A _19106_/Q VPWR VGND sg13cmos5l_dlygate4sd3_1
X_11870_ _11870_/Y _11846_/Y _11864_/Y _11869_/Y VPWR VGND sg13cmos5l_o21ai_1
XFILLER_45_648 VPWR VGND sg13cmos5l_fill_1
XFILLER_44_147 VPWR VGND sg13cmos5l_fill_2
X_10821_ _10821_/Y _10818_/Y _10819_/Y _10820_/Y VPWR VGND sg13cmos5l_o21ai_1
XFILLER_44_169 VPWR VGND sg13cmos5l_fill_2
XFILLER_32_309 VPWR VGND sg13cmos5l_fill_2
X_10752_ _10773_/B _10759_/A _10764_/A VPWR VGND sg13cmos5l_nor2b_1
X_13540_ _13542_/A _13441_/B _13555_/A _13540_/C VPWR VGND sg13cmos5l_nand3b_1
XFILLER_41_843 VPWR VGND sg13cmos5l_fill_2
X_13471_ _13479_/A _13461_/X _13464_/Y _13512_/A _13472_/B _13465_/X VPWR VGND sg13cmos5l_a221oi_1
X_12422_ _12422_/Y _12422_/A VPWR VGND sg13cmos5l_inv_1
X_10683_ _18566_/D _10683_/A _10683_/B VPWR VGND sg13cmos5l_nor2_1
X_15210_ _15210_/Y _15210_/A _15210_/B VPWR VGND sg13cmos5l_nand2_1
X_16190_ _16190_/Y _16202_/D _16185_/B _16423_/A VPWR VGND sg13cmos5l_a21oi_1
X_12353_ _12353_/Y _12724_/A _12554_/A VPWR VGND sg13cmos5l_nand2_1
X_15141_ _15141_/X _15190_/B _15156_/B _15139_/Y VPWR VGND sg13cmos5l_a21o_1
X_12284_ _12307_/B _18785_/Q _12284_/B VPWR VGND sg13cmos5l_xor2_1
X_11304_ _11304_/Y _11304_/A _11325_/B VPWR VGND sg13cmos5l_nor2_1
X_15072_ _15114_/A _15457_/A _15072_/B VPWR VGND sg13cmos5l_xnor2_1
X_18900_ _18900_/Q _19003_/CLK _18900_/D _18900_/RESET_B VPWR VGND sg13cmos5l_dfrbpq_1
X_11235_ _11313_/A _11315_/B _11332_/A _11235_/C VPWR VGND sg13cmos5l_nand3_1
X_14023_ _14024_/B _13922_/B _14045_/S _14022_/Y VPWR VGND sg13cmos5l_o21ai_1
XFILLER_106_171 VPWR VGND sg13cmos5l_decap_8
X_18674__1619 _18674_/RESET_B VPWR VGND sg13cmos5l_tiehi
X_18831_ _18831_/Q clkload69/A _18831_/D _18831_/RESET_B VPWR VGND sg13cmos5l_dfrbpq_1
X_11166_ _11173_/B _11166_/A _11167_/B VPWR VGND sg13cmos5l_nor2b_1
X_18762_ _18762_/Q clkload39/A _18762_/D _18762_/RESET_B VPWR VGND sg13cmos5l_dfrbpq_1
X_11097_ _11097_/Y _11622_/A _18601_/Q _18602_/Q _11623_/A _11096_/Y VPWR VGND sg13cmos5l_a221oi_1
XFILLER_49_932 VPWR VGND sg13cmos5l_fill_1
XFILLER_0_471 VPWR VGND sg13cmos5l_fill_2
X_15974_ _15974_/Y _15888_/X _15973_/A _15971_/Y VPWR VGND sg13cmos5l_o21ai_1
X_10117_ _15741_/A _10117_/A VPWR VGND sg13cmos5l_inv_1
X_10048_ _12728_/A _10048_/A VPWR VGND sg13cmos5l_inv_1
X_17713_ _17713_/Y _19663_/Q _18227_/A _17693_/B _19601_/Q VPWR VGND sg13cmos5l_a22oi_1
X_14925_ _14926_/B _19254_/Q _14932_/B _19191_/Q _15459_/A VPWR VGND sg13cmos5l_a22oi_1
X_18693_ _18693_/Q _18733_/CLK _18693_/D _18693_/RESET_B VPWR VGND sg13cmos5l_dfrbpq_1
XFILLER_64_946 VPWR VGND sg13cmos5l_decap_4
X_17644_ _17645_/B _17644_/A _17644_/B VPWR VGND sg13cmos5l_xnor2_1
X_14856_ _14857_/B _14781_/A _14781_/B _14760_/Y VPWR VGND sg13cmos5l_a21oi_1
X_13807_ _19045_/D _13807_/A _13807_/B VPWR VGND sg13cmos5l_and2_1
X_17575_ _17593_/A _17561_/Y _17569_/Y _17607_/B _17766_/A _17573_/Y VPWR VGND sg13cmos5l_a221oi_1
X_14787_ _14796_/B _19221_/Q _19222_/Q _19223_/Q VPWR VGND sg13cmos5l_nor3_1
XFILLER_35_158 VPWR VGND sg13cmos5l_fill_1
X_11999_ _12024_/A _11999_/A _11999_/B VPWR VGND sg13cmos5l_nor2_1
X_13738_ _13778_/B _19049_/Q _13751_/B VPWR VGND sg13cmos5l_nand2_1
X_19790__542 _19790_/D VPWR VGND sg13cmos5l_tielo
X_19314_ _19314_/Q clkload19/A _19314_/D _19314_/RESET_B VPWR VGND sg13cmos5l_dfrbpq_1
X_16526_ _16526_/Y _16561_/B _16526_/B VPWR VGND sg13cmos5l_nor2_1
X_19245_ _19245_/Q _19308_/CLK _19245_/D _19245_/RESET_B VPWR VGND sg13cmos5l_dfrbpq_1
X_13669_ _13671_/B _16820_/A _13669_/B VPWR VGND sg13cmos5l_xnor2_1
X_18620__1676 _18620_/RESET_B VPWR VGND sg13cmos5l_tiehi
X_16457_ _16465_/D _16457_/A _16457_/B _16457_/C _16457_/D VPWR VGND sg13cmos5l_nand4_1
X_19176_ _19176_/Q _19220_/CLK _19176_/D _19176_/RESET_B VPWR VGND sg13cmos5l_dfrbpq_1
X_15408_ _15409_/B _19298_/Q _15331_/B _15308_/Y VPWR VGND sg13cmos5l_a21oi_1
X_19454__456 _19454_/D VPWR VGND sg13cmos5l_tielo
X_16388_ _16417_/C _19463_/Q _19464_/Q VPWR VGND sg13cmos5l_xnor2_1
X_15339_ _15340_/B _19310_/Q _15366_/B VPWR VGND sg13cmos5l_nor2b_1
X_18127_ _18159_/B _19721_/Q _18127_/B VPWR VGND sg13cmos5l_xor2_1
X_18058_ _18059_/B _18045_/B _18039_/B _18057_/Y VPWR VGND sg13cmos5l_o21ai_1
X_17009_ _17009_/Y _17179_/A _16989_/C VPWR VGND sg13cmos5l_nor2b_1
X_19432__798 _19432_/RESET_B VPWR VGND sg13cmos5l_tiehi
XFILLER_101_804 VPWR VGND sg13cmos5l_fill_1
X_18857__1415 _18857_/RESET_B VPWR VGND sg13cmos5l_tiehi
XFILLER_55_979 VPWR VGND sg13cmos5l_fill_2
XFILLER_55_968 VPWR VGND sg13cmos5l_fill_2
XFILLER_55_946 VPWR VGND sg13cmos5l_fill_1
XFILLER_81_242 VPWR VGND sg13cmos5l_fill_1
XFILLER_63_990 VPWR VGND sg13cmos5l_fill_1
XFILLER_41_58 VPWR VGND sg13cmos5l_fill_2
XFILLER_68_1027 VPWR VGND sg13cmos5l_fill_2
X_18803__1472 _18803_/RESET_B VPWR VGND sg13cmos5l_tiehi
XFILLER_103_141 VPWR VGND sg13cmos5l_fill_2
X_11020_ _11056_/A _18631_/Q _11022_/B VPWR VGND sg13cmos5l_nor2_1
XFILLER_2_769 VPWR VGND sg13cmos5l_fill_2
X_19448__772 _19448_/RESET_B VPWR VGND sg13cmos5l_tiehi
XFILLER_77_559 VPWR VGND sg13cmos5l_fill_1
X_19173__1075 _19173_/RESET_B VPWR VGND sg13cmos5l_tiehi
X_12971_ _12971_/Y _12969_/Y _13002_/A VPWR VGND sg13cmos5l_nand2b_1
XFILLER_66_77 VPWR VGND sg13cmos5l_fill_2
XFILLER_57_261 VPWR VGND sg13cmos5l_fill_2
X_11922_ _11922_/Y _18726_/Q _11922_/B _11922_/C VPWR VGND sg13cmos5l_nand3_1
XFILLER_46_968 VPWR VGND sg13cmos5l_decap_4
XFILLER_46_946 VPWR VGND sg13cmos5l_fill_2
X_15690_ _15690_/Y _15690_/A _15690_/B VPWR VGND sg13cmos5l_nor2_1
X_14710_ _19198_/D _14710_/A _14760_/B VPWR VGND sg13cmos5l_and2_1
X_11853_ _11853_/Y _11853_/A _11853_/B VPWR VGND sg13cmos5l_nor2_1
X_14641_ _19176_/D _14641_/A _14643_/B VPWR VGND sg13cmos5l_nor2_1
X_10804_ _13650_/A _10804_/A _10804_/B VPWR VGND sg13cmos5l_nand2_1
XFILLER_72_297 VPWR VGND sg13cmos5l_fill_2
X_17360_ _17360_/Y _17343_/B fanout27/X _17365_/B VPWR VGND sg13cmos5l_o21ai_1
X_11784_ _11784_/X _11820_/A _11820_/B _11975_/A VPWR VGND sg13cmos5l_and3_1
X_14572_ _14572_/Y _14572_/A _14737_/A VPWR VGND sg13cmos5l_nor2b_1
X_16311_ _19427_/D _16311_/A _16312_/B VPWR VGND sg13cmos5l_nor2_1
XFILLER_13_320 VPWR VGND sg13cmos5l_fill_1
XFILLER_32_139 VPWR VGND sg13cmos5l_decap_8
X_10735_ _10735_/Y _10719_/Y _10734_/Y _10721_/Y VPWR VGND sg13cmos5l_o21ai_1
X_17291_ _17292_/B _17291_/A _17309_/B VPWR VGND sg13cmos5l_and2_1
X_13523_ _13586_/B _13482_/Y _13907_/A _13503_/C _13485_/X VPWR VGND sg13cmos5l_a22oi_1
X_19030_ _19030_/Q clkload29/A _19030_/D _19030_/RESET_B VPWR VGND sg13cmos5l_dfrbpq_1
X_10666_ _18563_/D _10683_/A _10666_/B VPWR VGND sg13cmos5l_nor2_1
X_13454_ _13531_/A _13555_/A _13454_/B VPWR VGND sg13cmos5l_nand2_1
X_16242_ _16243_/B _16433_/A _16248_/B VPWR VGND sg13cmos5l_nand2_1
X_19455__765 _19455_/RESET_B VPWR VGND sg13cmos5l_tiehi
X_12405_ _12405_/Y _12466_/B _12429_/B VPWR VGND sg13cmos5l_nor2_1
X_13385_ _13385_/Y _13387_/A _13387_/B _13384_/Y VPWR VGND sg13cmos5l_a21oi_1
X_16173_ _16174_/B _16173_/A _16173_/B VPWR VGND sg13cmos5l_xor2_1
X_15124_ _15124_/Y _15026_/B _15193_/B _15123_/Y VPWR VGND sg13cmos5l_a21oi_1
X_10597_ _10606_/B _10644_/A _18543_/A _10616_/B VPWR VGND sg13cmos5l_mux2_1
X_12336_ _12345_/B _18846_/Q _18848_/Q _18847_/Q _12336_/D VPWR VGND sg13cmos5l_nor4_1
XFILLER_99_117 VPWR VGND sg13cmos5l_fill_1
X_12267_ _12267_/X _12267_/A _12278_/D _12267_/C VPWR VGND sg13cmos5l_and3_1
XFILLER_5_585 VPWR VGND sg13cmos5l_decap_8
X_15055_ _15055_/Y _15147_/B _15055_/B VPWR VGND sg13cmos5l_nand2_1
X_12198_ _18803_/D _12199_/A _12198_/B VPWR VGND sg13cmos5l_and2_1
X_11218_ _11236_/A _18671_/Q _11234_/B VPWR VGND sg13cmos5l_or2_1
X_14006_ _14022_/A _13966_/X _14010_/B _14003_/Y VPWR VGND sg13cmos5l_o21ai_1
X_18814_ _18814_/Q clkload68/A _18814_/D _18814_/RESET_B VPWR VGND sg13cmos5l_dfrbpq_1
X_11149_ _11149_/Y hold2047/X fanout94/X _11423_/A VPWR VGND sg13cmos5l_o21ai_1
XFILLER_83_507 VPWR VGND sg13cmos5l_fill_2
X_19794_ _19794_/Q clkload22/A _19794_/D _19794_/RESET_B VPWR VGND sg13cmos5l_dfrbpq_1
XFILLER_0_290 VPWR VGND sg13cmos5l_fill_2
X_18745_ _18745_/Q _18750_/CLK _18745_/D _18745_/RESET_B VPWR VGND sg13cmos5l_dfrbpq_1
XFILLER_95_378 VPWR VGND sg13cmos5l_fill_1
XFILLER_49_762 VPWR VGND sg13cmos5l_fill_1
X_18638__1658 _18638_/RESET_B VPWR VGND sg13cmos5l_tiehi
X_15957_ _15957_/Y _15862_/B _16021_/B _15956_/Y VPWR VGND sg13cmos5l_o21ai_1
X_19462__758 _19462_/RESET_B VPWR VGND sg13cmos5l_tiehi
XFILLER_76_581 VPWR VGND sg13cmos5l_decap_4
X_18676_ _18676_/Q _19087_/CLK _18676_/D _18676_/RESET_B VPWR VGND sg13cmos5l_dfrbpq_1
X_14908_ _19218_/D _14908_/A _14915_/A VPWR VGND sg13cmos5l_nor2_1
X_15888_ _15888_/X _15975_/B _15991_/A _15889_/C VPWR VGND sg13cmos5l_and3_1
X_17627_ _17627_/X _17627_/A _17652_/A VPWR VGND sg13cmos5l_and2_1
XFILLER_63_264 VPWR VGND sg13cmos5l_fill_2
XFILLER_52_927 VPWR VGND sg13cmos5l_fill_2
XFILLER_52_905 VPWR VGND sg13cmos5l_fill_2
X_14839_ _14914_/B _14838_/A _14810_/A _14843_/S VPWR VGND sg13cmos5l_mux2_1
XFILLER_91_584 VPWR VGND sg13cmos5l_fill_1
X_17558_ _17558_/Y _17607_/A VPWR VGND sg13cmos5l_inv_1
X_17489_ _17492_/A _17489_/A _17494_/B VPWR VGND sg13cmos5l_nand2_1
XFILLER_60_971 VPWR VGND sg13cmos5l_decap_8
X_16509_ _16510_/B _16512_/B _16532_/A _16509_/C VPWR VGND sg13cmos5l_nand3_1
XFILLER_82_0 VPWR VGND sg13cmos5l_fill_2
X_19228_ _19228_/Q clkload44/A _19228_/D _19228_/RESET_B VPWR VGND sg13cmos5l_dfrbpq_1
X_19159_ _19159_/Q _19227_/CLK _19159_/D _19159_/RESET_B VPWR VGND sg13cmos5l_dfrbpq_1
Xfanout303 _12192_/B _12199_/A VPWR VGND sg13cmos5l_buf_1
Xfanout314 _11358_/A _11363_/A VPWR VGND sg13cmos5l_buf_1
X_19647__559 _19647_/RESET_B VPWR VGND sg13cmos5l_tiehi
Xfanout325 _18560_/A _10722_/Y VPWR VGND sg13cmos5l_buf_1
Xfanout347 _12751_/A _18913_/Q VPWR VGND sg13cmos5l_buf_1
Xfanout336 _17751_/A hold2875/X VPWR VGND sg13cmos5l_buf_1
Xfanout369 _10746_/A _10750_/A VPWR VGND sg13cmos5l_buf_1
XFILLER_86_356 VPWR VGND sg13cmos5l_fill_2
Xfanout358 _13337_/A _10859_/A VPWR VGND sg13cmos5l_buf_1
XFILLER_101_678 VPWR VGND sg13cmos5l_fill_2
XFILLER_28_935 VPWR VGND sg13cmos5l_fill_2
XFILLER_54_231 VPWR VGND sg13cmos5l_fill_2
X_10520_ _10520_/Y _10526_/B _10906_/A VPWR VGND sg13cmos5l_nand2b_1
X_10451_ _10464_/B _19795_/Q _10621_/B VPWR VGND sg13cmos5l_nand2_1
X_10382_ _19810_/D _10418_/A _10746_/A VPWR VGND sg13cmos5l_and2_1
X_13170_ _13177_/A _18974_/Q _13170_/B VPWR VGND sg13cmos5l_xnor2_1
X_12121_ _12121_/Y _12109_/Y _12116_/Y _12198_/B _12016_/B _12117_/Y VPWR VGND sg13cmos5l_a221oi_1
X_12052_ _12148_/B _12052_/A _12052_/B _12168_/B VPWR VGND sg13cmos5l_nor3_1
XFILLER_105_995 VPWR VGND sg13cmos5l_decap_8
XFILLER_81_1024 VPWR VGND sg13cmos5l_decap_4
X_11003_ _11003_/Y _18607_/Q _19776_/Q VPWR VGND sg13cmos5l_nand2_1
X_16860_ _16860_/Y _16860_/A _16860_/B VPWR VGND sg13cmos5l_nand2_1
X_16791_ _16792_/C _16791_/A _16791_/B _16791_/C VPWR VGND sg13cmos5l_nand3_1
XFILLER_93_838 VPWR VGND sg13cmos5l_fill_1
XFILLER_77_378 VPWR VGND sg13cmos5l_fill_1
X_15811_ _15828_/D _19327_/Q _19325_/Q _19326_/Q VPWR VGND sg13cmos5l_or3_1
XFILLER_92_348 VPWR VGND sg13cmos5l_fill_2
X_12954_ _12954_/Y _12954_/A _12954_/B VPWR VGND sg13cmos5l_nor2_1
X_18530_ _18531_/B _18516_/Y _10849_/B _18530_/S VPWR VGND sg13cmos5l_mux2_1
X_15742_ _19346_/D _15742_/A _15742_/B VPWR VGND sg13cmos5l_nor2_1
X_11905_ _18764_/D _11905_/A _11905_/B VPWR VGND sg13cmos5l_nor2_1
X_18461_ _19743_/D _18427_/A _18462_/S _18460_/Y VPWR VGND sg13cmos5l_a21oi_1
X_12885_ _12905_/B _18915_/Q _12932_/A _18914_/Q VPWR VGND sg13cmos5l_nor3_1
X_18964__1299 _18964_/RESET_B VPWR VGND sg13cmos5l_tiehi
X_17412_ _17412_/Y _17702_/A _17406_/B _17411_/A _17708_/B _17407_/Y VPWR VGND sg13cmos5l_a221oi_1
X_15673_ _15673_/Y _15576_/Y _15745_/B _15746_/B _15688_/A VPWR VGND sg13cmos5l_a22oi_1
XFILLER_34_938 VPWR VGND sg13cmos5l_decap_8
XFILLER_34_949 VPWR VGND sg13cmos5l_fill_1
X_11836_ _11905_/B hold2891/X _11820_/D _12029_/A VPWR VGND sg13cmos5l_a21oi_1
X_14624_ _14624_/Y _14600_/Y _14628_/S _14637_/B VPWR VGND sg13cmos5l_o21ai_1
XFILLER_26_91 VPWR VGND sg13cmos5l_fill_2
X_18392_ _18392_/Y _18387_/A _18414_/A _18390_/Y _10481_/X VPWR VGND sg13cmos5l_a22oi_1
X_11767_ _11767_/Y _11767_/A _11767_/B _11872_/B VPWR VGND sg13cmos5l_nor3_1
X_17343_ _17343_/Y _17343_/A _17343_/B VPWR VGND sg13cmos5l_nand2_1
XFILLER_60_267 VPWR VGND sg13cmos5l_fill_1
XFILLER_42_960 VPWR VGND sg13cmos5l_fill_1
X_14555_ _14556_/B _14555_/A _14737_/A VPWR VGND sg13cmos5l_nand2_1
X_10718_ _10718_/Y _10718_/A _10718_/B VPWR VGND sg13cmos5l_nor2_1
X_17274_ _17274_/Y _17278_/A _17467_/A _17273_/Y VPWR VGND sg13cmos5l_a21oi_1
X_13506_ _13506_/X _13506_/A _13907_/A VPWR VGND sg13cmos5l_and2_1
X_11698_ _11698_/X _11708_/D _11697_/B _11553_/B VPWR VGND sg13cmos5l_a21o_1
X_19013_ _19013_/Q clkload66/A _19013_/D _19013_/RESET_B VPWR VGND sg13cmos5l_dfrbpq_1
X_16225_ _16225_/Y _16226_/C _16226_/D VPWR VGND sg13cmos5l_nand2_1
X_19392__841 _19392_/RESET_B VPWR VGND sg13cmos5l_tiehi
X_14486_ _14486_/Y _14486_/A _14489_/B VPWR VGND sg13cmos5l_nor2_1
X_10649_ _10650_/A input9/X _10400_/B _10405_/Y VPWR VGND sg13cmos5l_a21oi_1
X_13437_ _13539_/A _13437_/A _13450_/B VPWR VGND sg13cmos5l_xnor2_1
X_13368_ _13401_/A _18947_/Q _18948_/Q VPWR VGND sg13cmos5l_xor2_1
X_16156_ _16161_/A _19426_/Q _16170_/B VPWR VGND sg13cmos5l_and2_1
X_12319_ _12322_/B _18843_/Q _18844_/Q _18845_/Q VPWR VGND sg13cmos5l_o21ai_1
X_15107_ _15108_/C _15271_/A _15119_/B VPWR VGND sg13cmos5l_nand2_1
XFILLER_5_360 VPWR VGND sg13cmos5l_fill_1
X_16087_ _16087_/Y _16100_/A _16136_/A VPWR VGND sg13cmos5l_nor2_1
X_13299_ _13299_/Y _18998_/Q _13299_/B VPWR VGND sg13cmos5l_nand2_1
X_15038_ _15043_/A _19258_/Q _15039_/B VPWR VGND sg13cmos5l_and2_1
Xhold2719 _17326_/A _17325_/Y VPWR VGND sg13cmos5l_dlygate4sd3_1
Xhold2708 _15721_/A _19346_/Q VPWR VGND sg13cmos5l_dlygate4sd3_1
X_16989_ _16989_/X _17011_/A _17011_/B _16989_/C VPWR VGND sg13cmos5l_and3_1
X_18897__1372 _18897_/RESET_B VPWR VGND sg13cmos5l_tiehi
X_19777_ _19777_/Q clkload48/A _19777_/D _19777_/RESET_B VPWR VGND sg13cmos5l_dfrbpq_1
X_18728_ _18728_/Q clkload59/A _18728_/D _18728_/RESET_B VPWR VGND sg13cmos5l_dfrbpq_1
XFILLER_37_765 VPWR VGND sg13cmos5l_fill_2
XFILLER_92_882 VPWR VGND sg13cmos5l_fill_1
X_18659_ _18659_/Q clkload57/A _18659_/D _18659_/RESET_B VPWR VGND sg13cmos5l_dfrbpq_1
XFILLER_24_426 VPWR VGND sg13cmos5l_fill_2
XFILLER_60_790 VPWR VGND sg13cmos5l_fill_1
X_19146__1105 _19146_/RESET_B VPWR VGND sg13cmos5l_tiehi
XFILLER_32_481 VPWR VGND sg13cmos5l_fill_1
X_19653__552 _19653_/RESET_B VPWR VGND sg13cmos5l_tiehi
XFILLER_106_715 VPWR VGND sg13cmos5l_decap_4
XFILLER_105_258 VPWR VGND sg13cmos5l_fill_1
XFILLER_99_470 VPWR VGND sg13cmos5l_decap_8
Xfanout122 _16255_/B _16244_/B VPWR VGND sg13cmos5l_buf_1
Xfanout111 _18057_/B _18061_/B VPWR VGND sg13cmos5l_buf_1
Xfanout100 _18340_/B _18320_/X VPWR VGND sg13cmos5l_buf_1
Xfanout144 _18091_/B _18071_/Y VPWR VGND sg13cmos5l_buf_1
Xfanout155 _16500_/B _16484_/Y VPWR VGND sg13cmos5l_buf_1
Xfanout133 _14310_/B _14285_/B VPWR VGND sg13cmos5l_buf_1
Xfanout188 _12051_/B _12034_/Y VPWR VGND sg13cmos5l_buf_1
XFILLER_74_304 VPWR VGND sg13cmos5l_fill_2
Xfanout177 _13450_/B _13430_/Y VPWR VGND sg13cmos5l_buf_1
X_19660__545 _19660_/RESET_B VPWR VGND sg13cmos5l_tiehi
Xfanout199 _18480_/A _18481_/A VPWR VGND sg13cmos5l_buf_1
Xfanout166 _15039_/B _15033_/Y VPWR VGND sg13cmos5l_buf_1
XFILLER_55_540 VPWR VGND sg13cmos5l_decap_4
XFILLER_103_52 VPWR VGND sg13cmos5l_fill_2
XFILLER_43_713 VPWR VGND sg13cmos5l_fill_2
XFILLER_15_426 VPWR VGND sg13cmos5l_fill_1
X_12670_ _12685_/B _12662_/Y _12665_/Y _12669_/Y VPWR VGND sg13cmos5l_a21oi_1
XFILLER_70_576 VPWR VGND sg13cmos5l_fill_1
X_11621_ _18712_/D _11621_/A _11625_/B VPWR VGND sg13cmos5l_nor2_1
XFILLER_70_598 VPWR VGND sg13cmos5l_decap_8
X_14340_ _14340_/Y _14340_/A VPWR VGND sg13cmos5l_inv_1
X_11552_ _11552_/Y _11456_/X _11626_/B _11551_/Y _11461_/X VPWR VGND sg13cmos5l_a22oi_1
X_18949__1314 _18949_/RESET_B VPWR VGND sg13cmos5l_tiehi
X_11483_ _11483_/Y _11481_/Y _11482_/Y _11480_/Y VPWR VGND sg13cmos5l_a21oi_1
X_14271_ _14271_/Y _14271_/A _14463_/A VPWR VGND sg13cmos5l_nor2_1
X_10503_ _10506_/A _10485_/X _10502_/Y _10482_/Y VPWR VGND sg13cmos5l_o21ai_1
X_13222_ _13251_/A _13250_/B _13250_/C _13250_/A VPWR VGND sg13cmos5l_a21oi_1
X_10434_ _10437_/A _19707_/Q _19749_/Q _19791_/Q _10434_/D VPWR VGND sg13cmos5l_nor4_1
X_16010_ _19382_/D _16010_/A _16016_/B VPWR VGND sg13cmos5l_nor2_1
X_19452__768 _19452_/RESET_B VPWR VGND sg13cmos5l_tiehi
X_10365_ _10365_/Y _19517_/Q VPWR VGND sg13cmos5l_inv_1
X_13153_ _13363_/B _18957_/Q _13154_/B VPWR VGND sg13cmos5l_xnor2_1
X_12104_ _12133_/S _12104_/A _12104_/B VPWR VGND sg13cmos5l_nor2_1
XFILLER_2_330 VPWR VGND sg13cmos5l_fill_1
XFILLER_105_781 VPWR VGND sg13cmos5l_fill_2
X_10296_ _11937_/B _10296_/A VPWR VGND sg13cmos5l_inv_1
X_18852__1420 _18852_/RESET_B VPWR VGND sg13cmos5l_tiehi
X_13084_ _18943_/D _10002_/Y fanout77/X _13083_/Y VPWR VGND sg13cmos5l_a21oi_1
X_17961_ _17968_/B _17975_/C _17960_/Y _17959_/Y VPWR VGND sg13cmos5l_o21ai_1
X_16912_ _16940_/B _19489_/Q _16912_/B VPWR VGND sg13cmos5l_xor2_1
X_12035_ _12052_/A _12036_/A _12054_/B VPWR VGND sg13cmos5l_nor2_1
X_17892_ _17892_/Y _17939_/B _17898_/S _17889_/B _17912_/A _17890_/Y VPWR VGND sg13cmos5l_a221oi_1
X_19700_ _19700_/Q clkload13/A _19700_/D _19700_/RESET_B VPWR VGND sg13cmos5l_dfrbpq_1
XFILLER_93_602 VPWR VGND sg13cmos5l_fill_1
X_16843_ _16843_/Y _19476_/Q _16840_/Y _16842_/Y VPWR VGND sg13cmos5l_o21ai_1
X_19631_ _19631_/Q clkload27/A _19631_/D _19631_/RESET_B VPWR VGND sg13cmos5l_dfrbpq_1
XFILLER_38_507 VPWR VGND sg13cmos5l_fill_1
X_19562_ _19562_/Q clkload28/A _19562_/D _19562_/RESET_B VPWR VGND sg13cmos5l_dfrbpq_1
X_16774_ _16774_/X _16660_/B _16825_/B _16788_/S VPWR VGND sg13cmos5l_mux2_1
X_18513_ _18513_/Y _19728_/Q _18513_/B VPWR VGND sg13cmos5l_nor2_1
X_13986_ _14176_/A _19086_/Q _13987_/B VPWR VGND sg13cmos5l_xnor2_1
X_19493_ _19493_/Q _19546_/CLK _19493_/D _19493_/RESET_B VPWR VGND sg13cmos5l_dfrbpq_1
X_12937_ _12937_/Y _13024_/B VPWR VGND sg13cmos5l_inv_1
X_15725_ _15726_/B _15696_/X _15694_/A _15727_/S VPWR VGND sg13cmos5l_mux2_1
X_12868_ _12869_/B _12974_/B _12974_/C _12974_/A VPWR VGND sg13cmos5l_a21oi_1
X_18444_ _18453_/A _18444_/A _18452_/A _18444_/C VPWR VGND sg13cmos5l_or3_1
X_15656_ _15656_/Y _15656_/A _15656_/B VPWR VGND sg13cmos5l_nand2_1
X_11819_ _11819_/Y _11852_/A _11901_/B _11900_/B _11725_/Y VPWR VGND sg13cmos5l_a22oi_1
XFILLER_15_982 VPWR VGND sg13cmos5l_fill_2
X_14607_ _14607_/Y _14607_/A _14607_/B VPWR VGND sg13cmos5l_nor2_1
X_18375_ _18375_/X _18382_/B _18380_/C _18380_/A VPWR VGND sg13cmos5l_a21o_1
XFILLER_105_1002 VPWR VGND sg13cmos5l_decap_8
X_12799_ _12810_/B _18865_/Q _18866_/Q _18863_/Q _18864_/Q VPWR VGND sg13cmos5l_nor4_1
X_17326_ _17334_/A _17326_/A VPWR VGND sg13cmos5l_inv_1
X_15587_ _15587_/Y _19321_/Q _19282_/Q VPWR VGND sg13cmos5l_nand2_1
X_14538_ _14541_/C _19179_/Q _19180_/Q VPWR VGND sg13cmos5l_nand2_1
X_17257_ _17257_/Y _17259_/A _17450_/B _17250_/Y VPWR VGND sg13cmos5l_a21oi_1
X_14469_ _14487_/S _14478_/B _14469_/B VPWR VGND sg13cmos5l_or2_1
X_17188_ _17290_/A _17188_/A _17194_/B _17194_/C VPWR VGND sg13cmos5l_nand3_1
X_16208_ _16208_/Y _16213_/A _16256_/A _16201_/Y VPWR VGND sg13cmos5l_a21oi_1
X_16139_ _19412_/D _16320_/A _16139_/B VPWR VGND sg13cmos5l_nor2_1
XFILLER_69_621 VPWR VGND sg13cmos5l_fill_1
Xhold2527 _17219_/A _19585_/Q VPWR VGND sg13cmos5l_dlygate4sd3_1
Xhold2516 _10085_/A _19083_/Q VPWR VGND sg13cmos5l_dlygate4sd3_1
Xhold2505 _09983_/A _19441_/Q VPWR VGND sg13cmos5l_dlygate4sd3_1
Xhold2538 _10095_/A _19128_/Q VPWR VGND sg13cmos5l_dlygate4sd3_1
XFILLER_96_462 VPWR VGND sg13cmos5l_fill_1
Xhold1826 _17438_/B _19565_/Q VPWR VGND sg13cmos5l_dlygate4sd3_1
XFILLER_56_304 VPWR VGND sg13cmos5l_fill_1
Xhold1815 _18003_/B _19648_/Q VPWR VGND sg13cmos5l_dlygate4sd3_1
Xhold2549 hold2549/X _19449_/Q VPWR VGND sg13cmos5l_dlygate4sd3_1
XFILLER_83_123 VPWR VGND sg13cmos5l_fill_2
Xhold1859 _12796_/B _18861_/Q VPWR VGND sg13cmos5l_dlygate4sd3_1
Xhold1848 _18077_/B _19650_/Q VPWR VGND sg13cmos5l_dlygate4sd3_1
XFILLER_29_529 VPWR VGND sg13cmos5l_fill_1
Xhold1837 _14438_/B _19114_/Q VPWR VGND sg13cmos5l_dlygate4sd3_1
X_18687__1606 _18687_/RESET_B VPWR VGND sg13cmos5l_tiehi
XFILLER_21_963 VPWR VGND sg13cmos5l_fill_2
X_18937__1329 _18937_/RESET_B VPWR VGND sg13cmos5l_tiehi
X_18633__1663 _18633_/RESET_B VPWR VGND sg13cmos5l_tiehi
XFILLER_3_138 VPWR VGND sg13cmos5l_decap_8
X_10150_ _17368_/A _10150_/A VPWR VGND sg13cmos5l_inv_1
XFILLER_0_801 VPWR VGND sg13cmos5l_decap_8
XFILLER_0_812 VPWR VGND sg13cmos5l_fill_2
X_10081_ _16818_/A _10081_/A VPWR VGND sg13cmos5l_inv_1
XFILLER_75_635 VPWR VGND sg13cmos5l_fill_1
X_19382__851 _19382_/RESET_B VPWR VGND sg13cmos5l_tiehi
XFILLER_74_33 VPWR VGND sg13cmos5l_fill_2
XFILLER_47_359 VPWR VGND sg13cmos5l_fill_1
X_13840_ _13840_/Y _19060_/Q _13832_/Y _13839_/Y _19061_/Q VPWR VGND sg13cmos5l_a22oi_1
X_13771_ _13771_/Y _13816_/B _13780_/B VPWR VGND sg13cmos5l_nor2_1
X_10983_ _10983_/Y _11036_/A _11087_/B _10982_/Y VPWR VGND sg13cmos5l_o21ai_1
X_12722_ _18877_/D _12797_/A _12722_/B VPWR VGND sg13cmos5l_and2_1
X_15510_ _15510_/Y _15489_/A _15516_/S _15736_/B VPWR VGND sg13cmos5l_o21ai_1
X_16490_ _16512_/A _19458_/Q _16508_/B VPWR VGND sg13cmos5l_xnor2_1
XFILLER_90_10 VPWR VGND sg13cmos5l_fill_1
XFILLER_70_351 VPWR VGND sg13cmos5l_fill_2
X_15441_ _15441_/Y _15416_/X _15447_/S _15465_/A VPWR VGND sg13cmos5l_o21ai_1
X_12653_ _12653_/Y _12664_/S _12838_/A _12652_/X VPWR VGND sg13cmos5l_a21oi_1
X_12584_ _12600_/A _12584_/A _12602_/B VPWR VGND sg13cmos5l_nor2_1
X_11604_ _11606_/A _11614_/B _11604_/B VPWR VGND sg13cmos5l_nand2b_1
X_15372_ _15395_/S _15389_/A _15389_/C VPWR VGND sg13cmos5l_nand2_1
XFILLER_12_974 VPWR VGND sg13cmos5l_fill_1
X_18160_ _18232_/B _18133_/X _18159_/Y _18158_/Y VPWR VGND sg13cmos5l_a21oi_1
X_18750__1528 _18750_/RESET_B VPWR VGND sg13cmos5l_tiehi
X_11535_ _11535_/X _11534_/A _11534_/B _11553_/B VPWR VGND sg13cmos5l_a21o_1
X_17111_ _17111_/Y _17111_/A _17673_/A VPWR VGND sg13cmos5l_nand2_1
X_18091_ _18092_/B _18091_/A _18091_/B VPWR VGND sg13cmos5l_xor2_1
X_14323_ _14323_/X _14323_/A _14323_/B VPWR VGND sg13cmos5l_or2_1
X_17042_ _17042_/X _16965_/Y _17041_/Y _17039_/Y VPWR VGND sg13cmos5l_a21o_1
X_14254_ _14460_/B _19126_/Q _14255_/B VPWR VGND sg13cmos5l_xnor2_1
X_11466_ _11466_/X _11473_/B _11464_/X _11463_/Y VPWR VGND sg13cmos5l_a21o_1
X_13205_ _13205_/Y _13259_/A _13296_/B _13204_/Y VPWR VGND sg13cmos5l_a21oi_1
X_11397_ _11397_/Y _11655_/A _11391_/B _11396_/A _11661_/B _11392_/Y VPWR VGND sg13cmos5l_a221oi_1
X_10417_ _10419_/C input9/X _19810_/Q _10403_/Y VPWR VGND sg13cmos5l_o21ai_1
X_14185_ _14185_/Y _14151_/X _14185_/B VPWR VGND sg13cmos5l_nand2b_1
X_13136_ _13136_/Y _13136_/A _13136_/B _13136_/C VPWR VGND sg13cmos5l_nor3_1
X_18993_ _18993_/Q clkload53/A _18993_/D _18993_/RESET_B VPWR VGND sg13cmos5l_dfrbpq_1
X_10348_ _17702_/A _10348_/A VPWR VGND sg13cmos5l_inv_1
X_10279_ _12492_/A _10279_/A VPWR VGND sg13cmos5l_inv_1
X_13067_ _13068_/B _13047_/Y _10263_/Y _13067_/S VPWR VGND sg13cmos5l_mux2_1
X_17944_ _17944_/Y _19701_/Q _17944_/B VPWR VGND sg13cmos5l_nand2_1
X_12018_ _12018_/Y _12018_/A _12018_/B VPWR VGND sg13cmos5l_nor2_1
XFILLER_79_985 VPWR VGND sg13cmos5l_fill_1
XFILLER_94_955 VPWR VGND sg13cmos5l_fill_2
XFILLER_65_123 VPWR VGND sg13cmos5l_decap_8
XFILLER_38_326 VPWR VGND sg13cmos5l_fill_2
X_17875_ _17875_/X _17875_/A _17875_/B VPWR VGND sg13cmos5l_and2_1
X_16826_ _19507_/D _16827_/A _16826_/B VPWR VGND sg13cmos5l_nor2_1
XFILLER_94_966 VPWR VGND sg13cmos5l_fill_2
X_19614_ _19614_/Q clkload26/A _19614_/D _19614_/RESET_B VPWR VGND sg13cmos5l_dfrbpq_1
XFILLER_38_348 VPWR VGND sg13cmos5l_fill_1
XFILLER_19_540 VPWR VGND sg13cmos5l_fill_2
X_16757_ _16759_/A _16757_/A _16828_/B VPWR VGND sg13cmos5l_nor2_1
X_19545_ _19545_/Q _19546_/CLK _19545_/D _19545_/RESET_B VPWR VGND sg13cmos5l_dfrbpq_1
XFILLER_80_115 VPWR VGND sg13cmos5l_fill_1
X_13969_ _14002_/A _19083_/Q _13970_/B VPWR VGND sg13cmos5l_xnor2_1
XFILLER_0_1027 VPWR VGND sg13cmos5l_fill_2
XFILLER_0_74 VPWR VGND sg13cmos5l_fill_1
X_15708_ _15708_/Y _15708_/A _15708_/B _15708_/C VPWR VGND sg13cmos5l_nand3_1
X_16688_ _16762_/A _19503_/Q _16785_/B VPWR VGND sg13cmos5l_nor2_1
X_19476_ _19476_/Q clkload37/A _19476_/D _19476_/RESET_B VPWR VGND sg13cmos5l_dfrbpq_1
X_19186__1062 _19186_/RESET_B VPWR VGND sg13cmos5l_tiehi
X_18427_ _18427_/Y _18427_/A VPWR VGND sg13cmos5l_inv_1
X_15639_ _15642_/A _16013_/A _15639_/B VPWR VGND sg13cmos5l_xnor2_1
X_18358_ _18370_/A _19752_/Q _18369_/B _18437_/A VPWR VGND sg13cmos5l_a21o_1
X_17309_ _17494_/A _17464_/A _17309_/B VPWR VGND sg13cmos5l_and2_1
X_18289_ _19730_/D _09968_/Y fanout71/X _18288_/Y VPWR VGND sg13cmos5l_a21oi_1
XFILLER_9_83 VPWR VGND sg13cmos5l_decap_4
X_19650__555 _19650_/RESET_B VPWR VGND sg13cmos5l_tiehi
Xhold3003 _13660_/B _19054_/Q VPWR VGND sg13cmos5l_dlygate4sd3_1
XFILLER_89_727 VPWR VGND sg13cmos5l_fill_2
Xhold3014 _11528_/A _18720_/Q VPWR VGND sg13cmos5l_dlygate4sd3_1
X_09993_ _09993_/Y _09993_/A VPWR VGND sg13cmos5l_inv_1
Xhold3047 _12333_/A _18847_/Q VPWR VGND sg13cmos5l_dlygate4sd3_1
XFILLER_103_559 VPWR VGND sg13cmos5l_fill_1
Xhold3025 hold3025/X _16736_/B VPWR VGND sg13cmos5l_dlygate4sd3_1
Xhold2302 _16614_/B _19475_/Q VPWR VGND sg13cmos5l_dlygate4sd3_1
Xhold3036 hold3036/X _19417_/Q VPWR VGND sg13cmos5l_dlygate4sd3_1
Xhold2313 _10292_/A _18726_/Q VPWR VGND sg13cmos5l_dlygate4sd3_1
Xhold2324 _10348_/A _19599_/Q VPWR VGND sg13cmos5l_dlygate4sd3_1
Xhold3058 _14769_/A _19214_/Q VPWR VGND sg13cmos5l_dlygate4sd3_1
Xhold2346 hold2346/X _14700_/Y VPWR VGND sg13cmos5l_dlygate4sd3_1
Xhold2335 _19232_/D _14967_/Y VPWR VGND sg13cmos5l_dlygate4sd3_1
XFILLER_84_410 VPWR VGND sg13cmos5l_fill_2
Xhold2368 _18643_/D _11140_/Y VPWR VGND sg13cmos5l_dlygate4sd3_1
XFILLER_69_495 VPWR VGND sg13cmos5l_fill_1
XFILLER_57_635 VPWR VGND sg13cmos5l_fill_1
Xhold2379 hold2379/X _13077_/Y VPWR VGND sg13cmos5l_dlygate4sd3_1
Xhold2357 _19273_/D _15244_/Y VPWR VGND sg13cmos5l_dlygate4sd3_1
XFILLER_85_966 VPWR VGND sg13cmos5l_fill_1
XFILLER_72_616 VPWR VGND sg13cmos5l_fill_2
XFILLER_37_381 VPWR VGND sg13cmos5l_fill_1
X_18989__1271 _18989_/RESET_B VPWR VGND sg13cmos5l_tiehi
XFILLER_40_535 VPWR VGND sg13cmos5l_fill_2
X_11320_ _11320_/Y _11309_/X _11311_/A _11321_/A _11321_/B VPWR VGND sg13cmos5l_a22oi_1
XFILLER_5_904 VPWR VGND sg13cmos5l_decap_8
XFILLER_20_281 VPWR VGND sg13cmos5l_fill_2
X_11251_ _11251_/Y _11245_/A _11245_/B _11295_/A _11266_/A VPWR VGND sg13cmos5l_a22oi_1
XFILLER_4_436 VPWR VGND sg13cmos5l_decap_4
X_11182_ _11204_/B _11169_/Y _11176_/X _11180_/Y VPWR VGND sg13cmos5l_o21ai_1
X_10202_ _16073_/A _19402_/Q VPWR VGND sg13cmos5l_inv_1
X_19238__1004 _19238_/RESET_B VPWR VGND sg13cmos5l_tiehi
X_10133_ _16551_/A _16227_/A VPWR VGND sg13cmos5l_inv_1
X_15990_ _15991_/B _15990_/A _15990_/B VPWR VGND sg13cmos5l_xor2_1
X_10064_ _10064_/Y _18931_/Q VPWR VGND sg13cmos5l_inv_1
X_14941_ _14946_/B _15196_/B _14941_/B VPWR VGND sg13cmos5l_nor2_1
Xhold2891 hold2891/X _11803_/X VPWR VGND sg13cmos5l_dlygate4sd3_1
X_17660_ _19619_/D _17679_/A _17660_/B _17660_/C VPWR VGND sg13cmos5l_nor3_1
Xhold2880 hold2880/X _13542_/A VPWR VGND sg13cmos5l_dlygate4sd3_1
X_14872_ _14872_/Y _14859_/X _14862_/X _14873_/A _14873_/B VPWR VGND sg13cmos5l_a22oi_1
XFILLER_91_925 VPWR VGND sg13cmos5l_fill_1
XFILLER_90_413 VPWR VGND sg13cmos5l_fill_2
X_16611_ _16611_/Y _16854_/A fanout31/X _16610_/Y VPWR VGND sg13cmos5l_a21oi_1
XFILLER_75_465 VPWR VGND sg13cmos5l_fill_2
X_17591_ _17591_/Y _17591_/A _17591_/B _17591_/C _17591_/D VPWR VGND sg13cmos5l_nand4_1
X_13823_ _13823_/Y _14367_/A _18978_/Q _13820_/Y _13821_/Y _13822_/Y VPWR VGND sg13cmos5l_a221oi_1
X_19141__1110 _19141_/RESET_B VPWR VGND sg13cmos5l_tiehi
XFILLER_62_115 VPWR VGND sg13cmos5l_fill_1
X_19330_ _19330_/Q clkload18/A _19330_/D _19330_/RESET_B VPWR VGND sg13cmos5l_dfrbpq_1
XFILLER_18_81 VPWR VGND sg13cmos5l_fill_2
X_16542_ _19450_/D hold2782/X fanout33/X _16541_/Y VPWR VGND sg13cmos5l_a21oi_1
X_13754_ _13755_/B _13754_/A _13778_/B VPWR VGND sg13cmos5l_nand2_1
X_10966_ _10966_/Y _10965_/A _10960_/X _11183_/A VPWR VGND sg13cmos5l_a21oi_1
XFILLER_31_502 VPWR VGND sg13cmos5l_fill_1
X_13685_ _13685_/Y _13720_/A _16632_/A _13681_/Y _13683_/Y VPWR VGND sg13cmos5l_a22oi_1
X_12705_ _12705_/Y _12708_/B VPWR VGND sg13cmos5l_inv_1
X_10897_ _10897_/Y _10892_/Y _10893_/Y _10896_/Y VPWR VGND sg13cmos5l_o21ai_1
X_19261_ _19261_/Q _19262_/CLK _19261_/D _19261_/RESET_B VPWR VGND sg13cmos5l_dfrbpq_1
X_16473_ _16562_/B _16406_/Y _16410_/A _16411_/Y VPWR VGND sg13cmos5l_a21oi_1
XFILLER_31_513 VPWR VGND sg13cmos5l_fill_2
X_12636_ _12636_/X _12636_/A _12636_/B VPWR VGND sg13cmos5l_xor2_1
X_18212_ _18213_/B _18191_/B _18188_/A _18212_/S VPWR VGND sg13cmos5l_mux2_1
X_15424_ _15424_/Y _15424_/A _15407_/A VPWR VGND sg13cmos5l_nor2b_1
X_19192_ _19192_/Q clkload44/A _19192_/D _19192_/RESET_B VPWR VGND sg13cmos5l_dfrbpq_1
X_15355_ _15361_/B _15389_/B _15544_/A VPWR VGND sg13cmos5l_nor2_1
X_18143_ _18143_/X _18048_/X _18229_/B _18142_/Y VPWR VGND sg13cmos5l_a21o_1
X_12567_ _12567_/X _12574_/B _12565_/Y _12564_/Y VPWR VGND sg13cmos5l_a21o_1
X_14306_ _14376_/B _14307_/S _14303_/X _14305_/Y VPWR VGND sg13cmos5l_a21oi_1
X_12498_ _12498_/Y _18814_/Q _12498_/B _12498_/C VPWR VGND sg13cmos5l_nor3_1
X_11518_ _11548_/B _11899_/A _11518_/B VPWR VGND sg13cmos5l_xnor2_1
X_18074_ _18193_/B _18091_/A _18200_/B VPWR VGND sg13cmos5l_nand2_1
X_15286_ _15287_/B _15283_/X _15284_/X _15285_/Y VPWR VGND sg13cmos5l_a21oi_1
X_17025_ _17025_/Y _17025_/A _17091_/B VPWR VGND sg13cmos5l_nor2b_1
X_11449_ _11474_/B _18659_/Q _11449_/B VPWR VGND sg13cmos5l_xor2_1
X_18714__1567 _18714_/RESET_B VPWR VGND sg13cmos5l_tiehi
X_14237_ _14237_/Y _14643_/A _14237_/B VPWR VGND sg13cmos5l_xnor2_1
X_14168_ _14168_/Y _13982_/Y _14167_/X _14164_/Y VPWR VGND sg13cmos5l_a21oi_1
X_13119_ _13119_/X _13116_/Y _12927_/B _13136_/C VPWR VGND sg13cmos5l_mux2_1
XFILLER_67_911 VPWR VGND sg13cmos5l_decap_4
X_18976_ _18976_/Q clkload46/A _18976_/D _18976_/RESET_B VPWR VGND sg13cmos5l_dfrbpq_1
X_14099_ _14099_/Y _19123_/Q _14643_/A _14114_/C VPWR VGND sg13cmos5l_nand3_1
X_17927_ _19662_/D _17914_/A _17928_/S _17926_/Y VPWR VGND sg13cmos5l_a21oi_1
XFILLER_67_966 VPWR VGND sg13cmos5l_fill_2
XFILLER_66_454 VPWR VGND sg13cmos5l_fill_2
XFILLER_39_668 VPWR VGND sg13cmos5l_fill_1
X_17858_ _17858_/Y _17837_/A _17837_/B _17845_/A VPWR VGND sg13cmos5l_a21oi_1
XFILLER_22_1028 VPWR VGND sg13cmos5l_fill_1
X_16809_ _16810_/B _16787_/Y _16795_/B _16809_/S VPWR VGND sg13cmos5l_mux2_1
XFILLER_26_318 VPWR VGND sg13cmos5l_fill_1
XFILLER_81_446 VPWR VGND sg13cmos5l_fill_2
X_17789_ _17804_/A _17789_/A _17803_/B VPWR VGND sg13cmos5l_nor2_1
XFILLER_38_189 VPWR VGND sg13cmos5l_fill_2
X_19528_ _19528_/Q clkload41/A _19528_/D _19528_/RESET_B VPWR VGND sg13cmos5l_dfrbpq_1
XFILLER_34_340 VPWR VGND sg13cmos5l_fill_2
X_19459_ _19459_/Q _19462_/CLK _19459_/D _19459_/RESET_B VPWR VGND sg13cmos5l_dfrbpq_1
XFILLER_34_362 VPWR VGND sg13cmos5l_fill_1
XFILLER_34_373 VPWR VGND sg13cmos5l_fill_2
X_18977__1286 _18977_/RESET_B VPWR VGND sg13cmos5l_tiehi
X_19372__861 _19372_/RESET_B VPWR VGND sg13cmos5l_tiehi
XFILLER_89_535 VPWR VGND sg13cmos5l_fill_2
X_09976_ _09976_/Y _09976_/A VPWR VGND sg13cmos5l_inv_1
Xhold2110 _13290_/A _18917_/Q VPWR VGND sg13cmos5l_dlygate4sd3_1
Xhold2121 _14664_/A _19145_/Q VPWR VGND sg13cmos5l_dlygate4sd3_1
Xhold2143 _12750_/A _18851_/Q VPWR VGND sg13cmos5l_dlygate4sd3_1
Xhold2154 _19727_/D _18285_/Y VPWR VGND sg13cmos5l_dlygate4sd3_1
X_19226__1019 _19226_/RESET_B VPWR VGND sg13cmos5l_tiehi
Xhold2132 _10233_/A _19190_/Q VPWR VGND sg13cmos5l_dlygate4sd3_1
Xhold2187 _19471_/D _16607_/Y VPWR VGND sg13cmos5l_dlygate4sd3_1
Xhold2165 _19513_/D _16874_/Y VPWR VGND sg13cmos5l_dlygate4sd3_1
Xhold2176 _19106_/D _14134_/Y VPWR VGND sg13cmos5l_dlygate4sd3_1
XFILLER_58_999 VPWR VGND sg13cmos5l_fill_2
Xhold2198 _10854_/B _19769_/Q VPWR VGND sg13cmos5l_dlygate4sd3_1
X_10820_ _10820_/Y _18621_/Q _10844_/A VPWR VGND sg13cmos5l_nand2_1
X_10751_ _10764_/A _18593_/Q _18591_/Q _18592_/Q VPWR VGND sg13cmos5l_nor3_1
XFILLER_38_1024 VPWR VGND sg13cmos5l_decap_4
X_18790__1485 _18790_/RESET_B VPWR VGND sg13cmos5l_tiehi
X_13470_ _13472_/B _14074_/A _13470_/B VPWR VGND sg13cmos5l_xnor2_1
XFILLER_40_321 VPWR VGND sg13cmos5l_fill_1
X_12421_ _12422_/A _12465_/B _12302_/B _12429_/B VPWR VGND sg13cmos5l_mux2_1
X_10682_ _10683_/B _10384_/C _10678_/X _10681_/Y VPWR VGND sg13cmos5l_a21oi_1
XFILLER_41_899 VPWR VGND sg13cmos5l_fill_1
X_19723__1367 _19723_/RESET_B VPWR VGND sg13cmos5l_tiehi
X_12352_ _12352_/Y _12292_/A _12292_/B _12463_/B VPWR VGND sg13cmos5l_o21ai_1
X_15140_ _15140_/Y _15190_/B _15156_/B _15139_/Y VPWR VGND sg13cmos5l_a21oi_1
X_12283_ _12294_/B _18785_/Q _12284_/B VPWR VGND sg13cmos5l_xnor2_1
X_11303_ _11325_/B _11299_/Y _11301_/Y _11302_/Y VPWR VGND sg13cmos5l_a21oi_1
X_15071_ _15071_/Y _19251_/Q _15072_/B VPWR VGND sg13cmos5l_xnor2_1
X_11234_ _11235_/C _11234_/A _11234_/B VPWR VGND sg13cmos5l_or2_1
X_14022_ _14022_/Y _14022_/A _14045_/S VPWR VGND sg13cmos5l_nand2_1
XFILLER_106_194 VPWR VGND sg13cmos5l_fill_1
X_18830_ _18830_/Q clkload69/A _18830_/D _18830_/RESET_B VPWR VGND sg13cmos5l_dfrbpq_1
X_18682__1611 _18682_/RESET_B VPWR VGND sg13cmos5l_tiehi
X_11165_ _11169_/A _10946_/Y _11199_/A _11159_/Y _11163_/Y _11164_/Y VPWR VGND sg13cmos5l_a221oi_1
X_18761_ _18761_/Q clkload39/A _18761_/D _18761_/RESET_B VPWR VGND sg13cmos5l_dfrbpq_1
X_11096_ _11096_/Y _18663_/Q _11116_/A _11093_/Y _11094_/Y _11095_/Y VPWR VGND sg13cmos5l_a221oi_1
X_15973_ _15973_/Y _15973_/A VPWR VGND sg13cmos5l_inv_1
X_10116_ _15737_/A _15351_/C VPWR VGND sg13cmos5l_inv_1
X_10047_ _12724_/A _10047_/A VPWR VGND sg13cmos5l_inv_1
XFILLER_49_966 VPWR VGND sg13cmos5l_fill_1
XFILLER_49_955 VPWR VGND sg13cmos5l_decap_8
X_17712_ _17712_/Y _17969_/A _17705_/B _17711_/A _17974_/B _17707_/Y VPWR VGND sg13cmos5l_a221oi_1
X_14924_ _14926_/A _15459_/A _19191_/Q _14923_/Y VPWR VGND sg13cmos5l_o21ai_1
X_18692_ _18692_/Q _18733_/CLK _18692_/D _18692_/RESET_B VPWR VGND sg13cmos5l_dfrbpq_1
XFILLER_49_988 VPWR VGND sg13cmos5l_decap_4
XFILLER_36_616 VPWR VGND sg13cmos5l_fill_2
XFILLER_90_210 VPWR VGND sg13cmos5l_fill_1
X_17643_ _17644_/B _17643_/A _17643_/B VPWR VGND sg13cmos5l_or2_1
X_14855_ _14855_/Y _14855_/A _14855_/B VPWR VGND sg13cmos5l_nor2_1
X_11998_ _12023_/C _12018_/B _11998_/B VPWR VGND sg13cmos5l_nand2b_1
X_13806_ _19043_/D _13790_/A hold2744/X _13804_/A VPWR VGND sg13cmos5l_a21oi_1
XFILLER_90_254 VPWR VGND sg13cmos5l_fill_2
X_17574_ _17574_/Y _17563_/Y _17613_/A _17607_/B _17766_/A VPWR VGND sg13cmos5l_a22oi_1
X_14786_ _14800_/B _19221_/Q _19222_/Q VPWR VGND sg13cmos5l_nor2_1
X_13737_ _13754_/A _19049_/Q _13765_/B VPWR VGND sg13cmos5l_or2_1
X_10949_ _10960_/B _18637_/Q _10950_/B VPWR VGND sg13cmos5l_nor2b_1
X_19313_ _19313_/Q clkload19/A _19313_/D _19313_/RESET_B VPWR VGND sg13cmos5l_dfrbpq_1
X_16525_ _16525_/Y _16496_/Y _16532_/A _16525_/C VPWR VGND sg13cmos5l_nand3b_1
X_18932__1334 _18932_/RESET_B VPWR VGND sg13cmos5l_tiehi
X_19244_ _19244_/Q _19308_/CLK _19244_/D _19244_/RESET_B VPWR VGND sg13cmos5l_dfrbpq_1
X_16456_ _16465_/C _16469_/B _16469_/C _16238_/C VPWR VGND sg13cmos5l_o21ai_1
Xclkbuf_leaf_70_clk _19262_/CLK clkbuf_4_10_0_clk/X VPWR VGND sg13cmos5l_buf_8
XFILLER_31_343 VPWR VGND sg13cmos5l_decap_8
X_13668_ _13713_/A _19041_/Q _13669_/B VPWR VGND sg13cmos5l_xnor2_1
X_15407_ _15407_/Y _15407_/A _15424_/A VPWR VGND sg13cmos5l_nor2b_1
X_13599_ _13616_/S _19044_/Q _13587_/B _13598_/B VPWR VGND sg13cmos5l_o21ai_1
X_12619_ _12627_/B _18873_/Q _18872_/Q _12625_/D VPWR VGND sg13cmos5l_nor3_1
X_19175_ _19175_/Q _19220_/CLK _19175_/D _19175_/RESET_B VPWR VGND sg13cmos5l_dfrbpq_1
X_16387_ _16387_/X _16396_/A _16396_/B _16454_/A VPWR VGND sg13cmos5l_a21o_1
X_15338_ _15366_/B _19309_/Q _15357_/B VPWR VGND sg13cmos5l_nor2b_1
XFILLER_8_561 VPWR VGND sg13cmos5l_fill_2
X_18126_ _18135_/B _19721_/Q _18127_/B VPWR VGND sg13cmos5l_xnor2_1
X_15269_ _15270_/C _15455_/A _15267_/B _15288_/A VPWR VGND sg13cmos5l_a21oi_1
X_18057_ _18057_/Y _18057_/A _18057_/B VPWR VGND sg13cmos5l_nor2_1
X_17008_ _17008_/Y _17040_/A _17086_/B _17087_/B _17037_/A VPWR VGND sg13cmos5l_a22oi_1
XFILLER_101_849 VPWR VGND sg13cmos5l_fill_2
XFILLER_98_387 VPWR VGND sg13cmos5l_decap_8
X_18959_ _18959_/Q clkload66/A _18959_/D _18959_/RESET_B VPWR VGND sg13cmos5l_dfrbpq_1
XFILLER_82_755 VPWR VGND sg13cmos5l_fill_2
XFILLER_42_608 VPWR VGND sg13cmos5l_fill_1
XFILLER_82_799 VPWR VGND sg13cmos5l_fill_2
XFILLER_41_107 VPWR VGND sg13cmos5l_fill_1
Xclkbuf_leaf_61_clk _19092_/CLK clkload2/A VPWR VGND sg13cmos5l_buf_8
XFILLER_41_48 VPWR VGND sg13cmos5l_fill_1
XFILLER_89_332 VPWR VGND sg13cmos5l_decap_8
XFILLER_66_12 VPWR VGND sg13cmos5l_fill_1
XFILLER_100_871 VPWR VGND sg13cmos5l_fill_1
X_12970_ _13002_/A _12937_/Y _12836_/Y _12986_/B VPWR VGND sg13cmos5l_mux2_1
XFILLER_58_785 VPWR VGND sg13cmos5l_fill_2
XFILLER_46_914 VPWR VGND sg13cmos5l_fill_2
X_11921_ _11921_/Y _11921_/A _11921_/B VPWR VGND sg13cmos5l_nand2_1
XFILLER_57_295 VPWR VGND sg13cmos5l_fill_2
XFILLER_57_284 VPWR VGND sg13cmos5l_fill_2
X_11852_ _11853_/B _11852_/A _11852_/B _11852_/C VPWR VGND sg13cmos5l_and3_1
X_14640_ _19175_/D _14640_/A _14643_/B VPWR VGND sg13cmos5l_nor2_1
X_10803_ _13716_/A _10804_/A _10804_/B VPWR VGND sg13cmos5l_and2_1
XFILLER_60_427 VPWR VGND sg13cmos5l_fill_1
X_14571_ _14571_/Y _14477_/B _14645_/B _14575_/B _14575_/A VPWR VGND sg13cmos5l_a22oi_1
X_11783_ _11783_/Y _11775_/Y _11781_/Y _11782_/Y _18745_/Q VPWR VGND sg13cmos5l_a22oi_1
Xclkbuf_leaf_52_clk clkload66/A clkbuf_4_14_0_clk/X VPWR VGND sg13cmos5l_buf_8
X_13522_ _13526_/A _13510_/Y _13516_/X _13521_/Y VPWR VGND sg13cmos5l_o21ai_1
X_16310_ _19426_/D _16310_/A _16312_/B VPWR VGND sg13cmos5l_nor2_1
X_10734_ _10734_/Y _10734_/A _10734_/B VPWR VGND sg13cmos5l_nor2_1
X_17290_ _17290_/Y _17290_/A _17290_/B _17290_/C _17290_/D VPWR VGND sg13cmos5l_nand4_1
X_10665_ _10665_/Y _10392_/B _10658_/Y _10663_/Y _10391_/A _10664_/Y VPWR VGND sg13cmos5l_a221oi_1
X_13453_ _13454_/B _13453_/A _13453_/B VPWR VGND sg13cmos5l_xor2_1
XFILLER_40_184 VPWR VGND sg13cmos5l_fill_1
X_16241_ _16247_/A _15931_/Y _16117_/Y _16239_/A _16239_/B _16131_/Y VPWR VGND sg13cmos5l_a221oi_1
XFILLER_9_336 VPWR VGND sg13cmos5l_decap_8
X_12404_ _12408_/A _12436_/A _12404_/B VPWR VGND sg13cmos5l_nand2_1
X_18580__1719 _18580_/RESET_B VPWR VGND sg13cmos5l_tiehi
X_13384_ _13384_/Y _13384_/A _13419_/A VPWR VGND sg13cmos5l_nor2_1
X_16172_ _16173_/B _16172_/A _16280_/B VPWR VGND sg13cmos5l_nand2_1
X_12335_ _12335_/Y _12335_/A _12335_/B _12335_/C VPWR VGND sg13cmos5l_nor3_1
X_15123_ _15123_/Y _15132_/A _15192_/B VPWR VGND sg13cmos5l_nor2_1
X_10596_ _10616_/B _10588_/Y _10594_/Y _10595_/Y VPWR VGND sg13cmos5l_a21oi_1
X_12266_ _12267_/C _18779_/Q _18780_/Q hold2904/X VPWR VGND sg13cmos5l_o21ai_1
X_15054_ _15054_/Y _15162_/A _15054_/B VPWR VGND sg13cmos5l_nor2_1
X_12197_ _18802_/D _12200_/A _12197_/B VPWR VGND sg13cmos5l_nor2_1
X_11217_ _11323_/A _18672_/Q _11231_/B VPWR VGND sg13cmos5l_xnor2_1
X_14005_ _14007_/B _13967_/Y _14010_/B _14004_/X VPWR VGND sg13cmos5l_o21ai_1
X_18813_ _18813_/Q clkload63/A _18813_/D _18813_/RESET_B VPWR VGND sg13cmos5l_dfrbpq_1
X_11148_ _11148_/Y _10015_/Y fanout89/X _11147_/Y VPWR VGND sg13cmos5l_a21oi_1
X_19793_ _19793_/Q clkload21/A _19793_/D _19793_/RESET_B VPWR VGND sg13cmos5l_dfrbpq_1
X_18744_ _18744_/Q _18750_/CLK _18744_/D _18744_/RESET_B VPWR VGND sg13cmos5l_dfrbpq_1
X_18646__1650 _18646_/RESET_B VPWR VGND sg13cmos5l_tiehi
X_19003__1257 _19003_/RESET_B VPWR VGND sg13cmos5l_tiehi
X_11079_ _18626_/D _18496_/A _11085_/B VPWR VGND sg13cmos5l_nor2_1
X_15956_ _15956_/Y _15959_/A _16022_/B VPWR VGND sg13cmos5l_nand2_1
X_18675_ _18675_/Q _19087_/CLK _18675_/D _18675_/RESET_B VPWR VGND sg13cmos5l_dfrbpq_1
X_15887_ _15889_/C _15887_/A _15887_/B VPWR VGND sg13cmos5l_or2_1
X_14907_ _19217_/D _14907_/A _14915_/A VPWR VGND sg13cmos5l_nor2_1
X_17626_ _17652_/A _17590_/Y _17479_/B _17639_/B VPWR VGND sg13cmos5l_mux2_1
X_14838_ _14838_/Y _14838_/A VPWR VGND sg13cmos5l_inv_1
XFILLER_63_276 VPWR VGND sg13cmos5l_fill_2
Xclkbuf_leaf_43_clk clkload68/A clkload4/A VPWR VGND sg13cmos5l_buf_8
X_17557_ _17607_/A _19635_/Q _17557_/B VPWR VGND sg13cmos5l_xnor2_1
XFILLER_51_449 VPWR VGND sg13cmos5l_fill_2
X_14769_ _14868_/B _14769_/A _14781_/B VPWR VGND sg13cmos5l_nand2_1
X_17488_ _19611_/D _17678_/A _17488_/B VPWR VGND sg13cmos5l_nor2_1
X_16508_ _16509_/C _16508_/A _16508_/B VPWR VGND sg13cmos5l_or2_1
XFILLER_32_663 VPWR VGND sg13cmos5l_fill_2
X_19227_ _19227_/Q _19227_/CLK _19227_/D _19227_/RESET_B VPWR VGND sg13cmos5l_dfrbpq_1
X_16439_ _16439_/Y _16207_/Y _16436_/Y _16248_/B VPWR VGND sg13cmos5l_o21ai_1
XFILLER_75_0 VPWR VGND sg13cmos5l_fill_2
X_19158_ _19158_/Q clkload50/A _19158_/D _19158_/RESET_B VPWR VGND sg13cmos5l_dfrbpq_1
X_18109_ _18109_/X _18300_/A _18159_/A VPWR VGND sg13cmos5l_and2_1
X_19089_ _19089_/Q _19092_/CLK _19089_/D _19089_/RESET_B VPWR VGND sg13cmos5l_dfrbpq_1
X_18763__1515 _18763_/RESET_B VPWR VGND sg13cmos5l_tiehi
Xfanout304 _12199_/A _11946_/Y VPWR VGND sg13cmos5l_buf_1
Xfanout348 _12625_/D hold2990/X VPWR VGND sg13cmos5l_buf_1
Xfanout337 _16982_/B _17006_/A VPWR VGND sg13cmos5l_buf_1
Xfanout315 _11363_/A _11355_/B VPWR VGND sg13cmos5l_buf_1
Xfanout326 _10642_/B _18529_/A VPWR VGND sg13cmos5l_buf_1
Xfanout359 _15234_/A _10859_/A VPWR VGND sg13cmos5l_buf_1
XFILLER_39_262 VPWR VGND sg13cmos5l_fill_1
XFILLER_55_722 VPWR VGND sg13cmos5l_fill_2
XFILLER_70_703 VPWR VGND sg13cmos5l_fill_1
XFILLER_54_276 VPWR VGND sg13cmos5l_fill_2
Xclkbuf_leaf_34_clk _18733_/CLK clkbuf_4_6_0_clk/X VPWR VGND sg13cmos5l_buf_8
XFILLER_51_950 VPWR VGND sg13cmos5l_fill_2
XFILLER_51_983 VPWR VGND sg13cmos5l_fill_2
X_10450_ _10464_/A _19796_/Q _10621_/B VPWR VGND sg13cmos5l_xnor2_1
XFILLER_6_339 VPWR VGND sg13cmos5l_fill_1
XFILLER_6_328 VPWR VGND sg13cmos5l_decap_8
X_10381_ _10734_/B _10381_/A VPWR VGND sg13cmos5l_inv_1
X_12120_ _12198_/B _12133_/S _12299_/A _12119_/Y VPWR VGND sg13cmos5l_a21o_1
X_12051_ _12168_/B _18799_/Q _12051_/B VPWR VGND sg13cmos5l_and2_1
XFILLER_81_1014 VPWR VGND sg13cmos5l_fill_1
XFILLER_104_451 VPWR VGND sg13cmos5l_fill_1
X_11002_ _11002_/X _10912_/B _11086_/B _11051_/B VPWR VGND sg13cmos5l_mux2_1
X_16790_ _16790_/Y _16781_/Y _16783_/Y _16784_/Y _16778_/X _16789_/Y VPWR VGND sg13cmos5l_a221oi_1
X_15810_ _19366_/D _16081_/A _15810_/B VPWR VGND sg13cmos5l_and2_1
X_12953_ _12953_/Y _12953_/A _12960_/B VPWR VGND sg13cmos5l_nor2_1
X_15741_ _19345_/D _15741_/A _15742_/B VPWR VGND sg13cmos5l_nor2_1
X_11904_ _18763_/D _11904_/A _11904_/B VPWR VGND sg13cmos5l_and2_1
X_15672_ _15746_/B _15678_/A _15671_/Y _15670_/Y VPWR VGND sg13cmos5l_a21oi_1
X_18460_ _18460_/Y _18429_/Y _18462_/S _18482_/A VPWR VGND sg13cmos5l_o21ai_1
X_12884_ _12981_/A _12985_/B _12884_/B VPWR VGND sg13cmos5l_nand2_1
X_18972__1291 _18972_/RESET_B VPWR VGND sg13cmos5l_tiehi
X_17411_ _17411_/Y _17411_/A VPWR VGND sg13cmos5l_inv_1
X_14623_ _14628_/S _14513_/A _14513_/B _14614_/Y _14620_/Y _14622_/Y VPWR VGND sg13cmos5l_a221oi_1
Xclkbuf_leaf_25_clk clkload31/A clkbuf_4_5_0_clk/X VPWR VGND sg13cmos5l_buf_8
X_11835_ _11835_/Y _11741_/B _11829_/X _11904_/B _11744_/B VPWR VGND sg13cmos5l_a22oi_1
X_18391_ _18391_/X _18391_/A _18391_/B VPWR VGND sg13cmos5l_xor2_1
X_11766_ _11872_/B _18757_/Q _11766_/B VPWR VGND sg13cmos5l_and2_1
X_17342_ _17343_/B _17376_/B _17341_/B _17341_/Y VPWR VGND sg13cmos5l_o21ai_1
X_14554_ _14556_/A _14731_/A _14737_/A VPWR VGND sg13cmos5l_nand2_1
X_10717_ _10718_/B _10381_/A _10713_/Y _13587_/B VPWR VGND sg13cmos5l_o21ai_1
X_17273_ _17273_/Y _17464_/A _17310_/A VPWR VGND sg13cmos5l_nor2_1
X_13505_ _13505_/Y _13505_/A _13505_/B _13505_/C _13505_/D VPWR VGND sg13cmos5l_nand4_1
XFILLER_41_471 VPWR VGND sg13cmos5l_fill_2
X_14485_ _19160_/D _14648_/A _14580_/A VPWR VGND sg13cmos5l_nor2_1
XFILLER_13_184 VPWR VGND sg13cmos5l_fill_2
X_11697_ _11697_/X _11708_/D _11697_/B VPWR VGND sg13cmos5l_and2_1
X_13436_ _13441_/A _19006_/Q _13450_/B VPWR VGND sg13cmos5l_and2_1
X_19012_ _19012_/Q clkload65/A _19012_/D _19012_/RESET_B VPWR VGND sg13cmos5l_dfrbpq_1
X_16224_ _16226_/D _16243_/A _16220_/B _16223_/Y VPWR VGND sg13cmos5l_o21ai_1
X_10648_ _19804_/D _10648_/A _18531_/A VPWR VGND sg13cmos5l_nor2_1
X_13367_ _13367_/X _18954_/Q _18947_/Q VPWR VGND sg13cmos5l_or2_1
X_19221__1024 _19221_/RESET_B VPWR VGND sg13cmos5l_tiehi
X_16155_ _16280_/B _16155_/A _16167_/B VPWR VGND sg13cmos5l_nand2_1
X_10579_ _10580_/B _10579_/A _18387_/A VPWR VGND sg13cmos5l_nand2_1
X_12318_ _12329_/B _12331_/B _12317_/Y VPWR VGND sg13cmos5l_nor2b_1
X_13298_ _13298_/Y _14076_/A _18939_/Q VPWR VGND sg13cmos5l_nor2_1
X_19703__1689 _19703_/RESET_B VPWR VGND sg13cmos5l_tiehi
X_15106_ _15106_/Y _15139_/A _15190_/B _15189_/B _15142_/A VPWR VGND sg13cmos5l_a22oi_1
X_16086_ _16136_/A _19370_/Q _16104_/D VPWR VGND sg13cmos5l_xor2_1
X_12249_ _12249_/Y _12233_/A _12241_/S _12468_/A VPWR VGND sg13cmos5l_o21ai_1
XFILLER_47_4 VPWR VGND sg13cmos5l_decap_4
X_15037_ _15154_/B _19259_/Q _15039_/B VPWR VGND sg13cmos5l_nand2_1
Xhold2709 _19337_/D _15734_/Y VPWR VGND sg13cmos5l_dlygate4sd3_1
X_16988_ _16988_/Y _16985_/A _16986_/Y _16987_/Y _16982_/B VPWR VGND sg13cmos5l_a22oi_1
X_19776_ _19776_/Q clkload21/A _19776_/D _19776_/RESET_B VPWR VGND sg13cmos5l_dfrbpq_1
XFILLER_95_198 VPWR VGND sg13cmos5l_fill_2
X_18727_ _18727_/Q clkload59/A _18727_/D _18727_/RESET_B VPWR VGND sg13cmos5l_dfrbpq_1
X_15939_ _15942_/A _15939_/A _15939_/B _15939_/C VPWR VGND sg13cmos5l_nand3_1
XFILLER_92_850 VPWR VGND sg13cmos5l_fill_1
X_18658_ _18658_/Q clkload57/A _18658_/D _18658_/RESET_B VPWR VGND sg13cmos5l_dfrbpq_1
XFILLER_36_287 VPWR VGND sg13cmos5l_fill_2
X_18589_ _18589_/Q _18594_/CLK _18589_/D _18589_/RESET_B VPWR VGND sg13cmos5l_dfrbpq_1
X_17609_ _17678_/B _17610_/S _17606_/X _17608_/Y VPWR VGND sg13cmos5l_a21oi_1
Xclkbuf_leaf_16_clk clkload24/A clkbuf_4_4_0_clk/X VPWR VGND sg13cmos5l_buf_8
XFILLER_33_983 VPWR VGND sg13cmos5l_fill_1
XFILLER_106_727 VPWR VGND sg13cmos5l_decap_8
XFILLER_99_460 VPWR VGND sg13cmos5l_decap_4
Xfanout112 _17875_/B _18038_/A VPWR VGND sg13cmos5l_buf_1
Xfanout101 _18154_/B1 _18133_/X VPWR VGND sg13cmos5l_buf_1
XFILLER_102_955 VPWR VGND sg13cmos5l_decap_8
XFILLER_102_944 VPWR VGND sg13cmos5l_fill_2
Xfanout145 _17803_/B _17808_/B VPWR VGND sg13cmos5l_buf_1
Xfanout123 _16136_/B _16141_/B VPWR VGND sg13cmos5l_buf_1
Xfanout156 _16508_/B _16484_/Y VPWR VGND sg13cmos5l_buf_1
Xfanout134 _14468_/A _14303_/A VPWR VGND sg13cmos5l_buf_1
X_19797__1759 _19797_/RESET_B VPWR VGND sg13cmos5l_tiehi
X_18727__1554 _18727_/RESET_B VPWR VGND sg13cmos5l_tiehi
Xfanout189 _11766_/B _11769_/B VPWR VGND sg13cmos5l_buf_1
Xfanout178 _13447_/B _13430_/Y VPWR VGND sg13cmos5l_buf_1
Xfanout167 _14783_/B _14781_/B VPWR VGND sg13cmos5l_buf_1
XFILLER_101_476 VPWR VGND sg13cmos5l_decap_4
XFILLER_28_733 VPWR VGND sg13cmos5l_fill_1
XFILLER_70_522 VPWR VGND sg13cmos5l_fill_1
X_19097__1157 _19097_/RESET_B VPWR VGND sg13cmos5l_tiehi
X_11620_ _18711_/D _11620_/A _11625_/B VPWR VGND sg13cmos5l_nor2_1
X_11551_ _11551_/Y _11539_/B _11560_/B _11549_/Y VPWR VGND sg13cmos5l_a21oi_1
X_10502_ _10502_/Y _10487_/Y _10572_/B _10499_/Y _10500_/Y _10501_/Y VPWR VGND sg13cmos5l_a221oi_1
X_11482_ _11482_/Y _18690_/Q _18651_/Q VPWR VGND sg13cmos5l_xnor2_1
XFILLER_7_637 VPWR VGND sg13cmos5l_fill_1
XFILLER_6_103 VPWR VGND sg13cmos5l_fill_2
X_14270_ _14285_/B _19143_/Q _14270_/B VPWR VGND sg13cmos5l_xor2_1
X_13221_ _13250_/C _18943_/Q _18904_/Q _18963_/Q VPWR VGND sg13cmos5l_nand3_1
X_10433_ _10434_/D _19539_/Q _19581_/Q _19623_/Q _19665_/Q VPWR VGND sg13cmos5l_or4_1
X_13152_ _13167_/A _18972_/Q _13159_/A VPWR VGND sg13cmos5l_xnor2_1
X_10364_ _17110_/B _19518_/Q VPWR VGND sg13cmos5l_inv_1
X_12103_ _12103_/Y _12096_/X _12287_/A VPWR VGND sg13cmos5l_nand2b_1
X_10295_ _11922_/B _18730_/Q VPWR VGND sg13cmos5l_inv_1
X_13083_ _13083_/Y hold2000/X fanout78/X _12797_/A VPWR VGND sg13cmos5l_o21ai_1
XFILLER_78_611 VPWR VGND sg13cmos5l_fill_1
X_17960_ _17960_/Y _17960_/A _18477_/A VPWR VGND sg13cmos5l_nand2_1
X_16911_ _16911_/Y _16729_/A _16940_/A _16910_/X VPWR VGND sg13cmos5l_o21ai_1
X_18870__1399 _18870_/RESET_B VPWR VGND sg13cmos5l_tiehi
X_12034_ _12034_/Y _12032_/Y _12033_/Y _12031_/Y VPWR VGND sg13cmos5l_a21oi_1
X_19706__432 _19706_/D VPWR VGND sg13cmos5l_tielo
X_17891_ _17891_/X _17939_/B _17898_/S _17890_/Y VPWR VGND sg13cmos5l_a21o_1
XFILLER_2_397 VPWR VGND sg13cmos5l_fill_2
X_16842_ _16842_/Y _16842_/A _17371_/A _16861_/C VPWR VGND sg13cmos5l_nand3_1
X_19630_ _19630_/Q clkload24/A _19630_/D _19630_/RESET_B VPWR VGND sg13cmos5l_dfrbpq_1
X_19671__1788 _19671_/RESET_B VPWR VGND sg13cmos5l_tiehi
X_19561_ _19561_/Q _19814_/CLK _19561_/D _19561_/RESET_B VPWR VGND sg13cmos5l_dfrbpq_1
XFILLER_59_891 VPWR VGND sg13cmos5l_fill_2
XFILLER_19_8 VPWR VGND sg13cmos5l_fill_1
X_16773_ _16773_/X _16659_/X _16737_/Y _16788_/S VPWR VGND sg13cmos5l_mux2_1
X_18512_ _18512_/Y _19766_/Q _18501_/Y _18511_/Y _19767_/Q _18507_/Y VPWR VGND sg13cmos5l_a221oi_1
X_13985_ _13985_/Y _13980_/X _13982_/Y _13984_/Y VPWR VGND sg13cmos5l_o21ai_1
X_19492_ _19492_/Q clkload32/A _19492_/D _19492_/RESET_B VPWR VGND sg13cmos5l_dfrbpq_1
XFILLER_92_168 VPWR VGND sg13cmos5l_fill_2
X_12936_ _13024_/B _12938_/C _12938_/D VPWR VGND sg13cmos5l_and2_1
XFILLER_61_500 VPWR VGND sg13cmos5l_fill_2
XFILLER_37_91 VPWR VGND sg13cmos5l_decap_4
X_15724_ _19332_/D _15607_/Y _15727_/S _15723_/Y VPWR VGND sg13cmos5l_a21oi_1
X_12867_ _12974_/C _18901_/Q _18862_/Q _18921_/Q VPWR VGND sg13cmos5l_nand3_1
X_18443_ _18444_/C _18443_/A _18443_/B _18443_/C VPWR VGND sg13cmos5l_and3_1
X_15655_ _15846_/A _15655_/A _15676_/A VPWR VGND sg13cmos5l_nor2_1
X_11818_ _11900_/B hold2702/X _12001_/A _11833_/B VPWR VGND sg13cmos5l_mux2_1
X_15586_ _19330_/D _15586_/A _15586_/B VPWR VGND sg13cmos5l_nor2_1
X_14606_ _14606_/Y _14595_/Y _14597_/X _14607_/A _14607_/B VPWR VGND sg13cmos5l_a22oi_1
XFILLER_18_1000 VPWR VGND sg13cmos5l_fill_2
X_18374_ _18405_/A _18382_/B _18380_/C VPWR VGND sg13cmos5l_nand2_1
X_12798_ _12814_/D _18865_/Q _18863_/Q _18864_/Q VPWR VGND sg13cmos5l_or3_1
X_17325_ _17325_/Y _17325_/A _17325_/B _17325_/C VPWR VGND sg13cmos5l_nor3_1
XFILLER_61_599 VPWR VGND sg13cmos5l_fill_2
X_14537_ _14542_/A _14537_/A _14537_/B _14725_/A VPWR VGND sg13cmos5l_nand3_1
XFILLER_14_482 VPWR VGND sg13cmos5l_fill_1
X_11749_ _11749_/Y _18732_/Q _18693_/Q VPWR VGND sg13cmos5l_xnor2_1
X_17256_ _17256_/Y _17256_/A _17256_/B _17256_/C VPWR VGND sg13cmos5l_nand3_1
X_14468_ _14469_/B _14468_/A _14489_/B VPWR VGND sg13cmos5l_nor2_1
XFILLER_30_986 VPWR VGND sg13cmos5l_fill_2
X_17187_ _17187_/Y _17187_/A _17199_/B VPWR VGND sg13cmos5l_nand2_1
X_13419_ _13421_/B _13419_/A _13419_/B VPWR VGND sg13cmos5l_nor2_1
X_16207_ _16207_/Y _16555_/A _16207_/B VPWR VGND sg13cmos5l_xnor2_1
X_14399_ _14399_/Y _14399_/A VPWR VGND sg13cmos5l_inv_1
X_16138_ _16139_/B _16138_/A _16138_/B VPWR VGND sg13cmos5l_and2_1
XFILLER_103_708 VPWR VGND sg13cmos5l_fill_2
Xclkbuf_leaf_5_clk clkload11/A clkbuf_4_1_0_clk/X VPWR VGND sg13cmos5l_buf_8
X_16069_ _16069_/Y _16049_/Y _16063_/S _16318_/A VPWR VGND sg13cmos5l_o21ai_1
XFILLER_69_644 VPWR VGND sg13cmos5l_decap_8
Xhold2528 hold2528/X _17343_/A VPWR VGND sg13cmos5l_dlygate4sd3_1
Xhold2506 _16367_/B _16366_/X VPWR VGND sg13cmos5l_dlygate4sd3_1
Xhold2517 _10090_/A _19125_/Q VPWR VGND sg13cmos5l_dlygate4sd3_1
Xhold1827 _11966_/B _18734_/Q VPWR VGND sg13cmos5l_dlygate4sd3_1
XFILLER_69_655 VPWR VGND sg13cmos5l_fill_2
Xhold1816 _11223_/B _18610_/Q VPWR VGND sg13cmos5l_dlygate4sd3_1
Xhold2539 _10560_/A _19784_/Q VPWR VGND sg13cmos5l_dlygate4sd3_1
Xhold1849 _13810_/A _18586_/Q VPWR VGND sg13cmos5l_dlygate4sd3_1
Xhold1838 _12795_/B _18860_/Q VPWR VGND sg13cmos5l_dlygate4sd3_1
X_19052__1205 _19052_/RESET_B VPWR VGND sg13cmos5l_tiehi
XFILLER_83_135 VPWR VGND sg13cmos5l_fill_2
XFILLER_49_390 VPWR VGND sg13cmos5l_fill_2
X_19759_ _19759_/Q clkload23/A _19759_/D _19759_/RESET_B VPWR VGND sg13cmos5l_dfrbpq_1
XFILLER_37_585 VPWR VGND sg13cmos5l_fill_1
XFILLER_52_522 VPWR VGND sg13cmos5l_fill_2
XFILLER_106_546 VPWR VGND sg13cmos5l_decap_8
XFILLER_106_579 VPWR VGND sg13cmos5l_decap_8
X_10080_ _16821_/A _10080_/A VPWR VGND sg13cmos5l_inv_1
XFILLER_102_741 VPWR VGND sg13cmos5l_fill_2
XFILLER_87_463 VPWR VGND sg13cmos5l_fill_2
XFILLER_102_796 VPWR VGND sg13cmos5l_fill_1
X_13770_ _13770_/Y _13770_/A _13770_/B VPWR VGND sg13cmos5l_nor2_1
XFILLER_74_67 VPWR VGND sg13cmos5l_fill_2
X_10982_ _10982_/Y _10982_/A _10982_/B _10982_/C _10982_/D VPWR VGND sg13cmos5l_nand4_1
X_12721_ _18875_/D _12735_/A _12721_/B VPWR VGND sg13cmos5l_nor2_1
XFILLER_43_544 VPWR VGND sg13cmos5l_fill_1
XFILLER_15_213 VPWR VGND sg13cmos5l_fill_2
X_12652_ _12652_/X _12652_/A _12652_/B _12658_/B _12658_/C VPWR VGND sg13cmos5l_and4_1
X_15440_ _15447_/S _15312_/Y _15327_/Y _15431_/Y _15437_/Y _15439_/Y VPWR VGND sg13cmos5l_a221oi_1
XFILLER_31_717 VPWR VGND sg13cmos5l_fill_1
X_11603_ _11614_/B _11600_/Y _11602_/Y _11573_/Y VPWR VGND sg13cmos5l_a21o_1
X_12583_ _12583_/Y _12581_/Y _12582_/Y _12580_/Y VPWR VGND sg13cmos5l_a21oi_1
X_15371_ _15389_/C _15361_/X _15367_/Y _15369_/Y VPWR VGND sg13cmos5l_a21o_1
XFILLER_8_913 VPWR VGND sg13cmos5l_decap_4
X_11534_ _11540_/A _11534_/A _11534_/B _11553_/B VPWR VGND sg13cmos5l_and3_1
X_17110_ _17110_/Y _17110_/A _17110_/B _17110_/C VPWR VGND sg13cmos5l_nand3_1
X_18090_ _18090_/Y _18186_/B _18202_/A _18090_/C VPWR VGND sg13cmos5l_nand3_1
XFILLER_7_423 VPWR VGND sg13cmos5l_decap_4
X_14322_ _14323_/B _14374_/B _14192_/Y _14336_/B VPWR VGND sg13cmos5l_mux2_1
X_17041_ _17041_/Y _17086_/B _17047_/S _17040_/Y VPWR VGND sg13cmos5l_a21oi_1
X_11465_ _11467_/B _11473_/B _11464_/X _11463_/Y VPWR VGND sg13cmos5l_a21oi_1
X_14253_ _14260_/A _14239_/Y _14298_/B _14248_/Y _14252_/Y _14247_/Y VPWR VGND sg13cmos5l_a221oi_1
XFILLER_99_53 VPWR VGND sg13cmos5l_fill_2
X_10416_ _10419_/B _10402_/Y _10415_/Y hold2672/X VPWR VGND sg13cmos5l_o21ai_1
X_13204_ _13204_/Y _13207_/A _13297_/B VPWR VGND sg13cmos5l_nor2_1
X_11396_ _11396_/Y _11396_/A VPWR VGND sg13cmos5l_inv_1
X_14184_ _19115_/D _14377_/A _14184_/B VPWR VGND sg13cmos5l_nor2_1
X_13135_ _18950_/D _13296_/A _13200_/A VPWR VGND sg13cmos5l_nor2_1
X_18992_ _18992_/Q clkload65/A _18992_/D _18992_/RESET_B VPWR VGND sg13cmos5l_dfrbpq_1
X_10347_ _17974_/B _10347_/A VPWR VGND sg13cmos5l_inv_1
X_10278_ _12766_/B _10278_/A VPWR VGND sg13cmos5l_inv_1
X_13066_ _13291_/B _13573_/B _13284_/A VPWR VGND sg13cmos5l_nand2b_1
X_17943_ _19678_/D _17943_/A _17943_/B VPWR VGND sg13cmos5l_and2_1
X_12017_ _12020_/A _12017_/A _12023_/B VPWR VGND sg13cmos5l_nand2_1
XFILLER_78_441 VPWR VGND sg13cmos5l_fill_1
X_19613_ _19613_/Q clkload26/A _19613_/D _19613_/RESET_B VPWR VGND sg13cmos5l_dfrbpq_1
X_17874_ _17874_/Y _17863_/Y _17868_/Y _17873_/Y VPWR VGND sg13cmos5l_o21ai_1
X_19760__787 _19760_/RESET_B VPWR VGND sg13cmos5l_tiehi
X_16825_ _19506_/D _16825_/A _16825_/B VPWR VGND sg13cmos5l_nor2_1
XFILLER_38_338 VPWR VGND sg13cmos5l_fill_1
X_16756_ _16756_/Y _16745_/Y _16751_/Y _16755_/Y VPWR VGND sg13cmos5l_o21ai_1
X_19544_ _19544_/Q _19546_/CLK _19544_/D _19544_/RESET_B VPWR VGND sg13cmos5l_dfrbpq_1
X_13968_ _13976_/B _19083_/Q _19082_/Q _19081_/Q VPWR VGND sg13cmos5l_nor3_1
XFILLER_0_53 VPWR VGND sg13cmos5l_fill_1
XFILLER_0_1006 VPWR VGND sg13cmos5l_decap_8
XFILLER_34_500 VPWR VGND sg13cmos5l_decap_8
X_19475_ _19475_/Q clkload37/A _19475_/D _19475_/RESET_B VPWR VGND sg13cmos5l_dfrbpq_1
X_12919_ _12919_/Y _12916_/B _12919_/B _13108_/A VPWR VGND sg13cmos5l_nand3b_1
X_15707_ _15707_/Y _15690_/A _15690_/B _15700_/X _15705_/Y _15706_/Y VPWR VGND sg13cmos5l_a221oi_1
X_19781__1769 _19781_/RESET_B VPWR VGND sg13cmos5l_tiehi
X_16687_ _16763_/A _19502_/Q _16785_/B _16686_/Y VPWR VGND sg13cmos5l_a21oi_1
XFILLER_55_1019 VPWR VGND sg13cmos5l_decap_8
X_13899_ _13899_/Y _13899_/A _13923_/A VPWR VGND sg13cmos5l_nor2_1
X_18426_ _18427_/A _18452_/A _18426_/B VPWR VGND sg13cmos5l_nand2b_1
X_15638_ _15668_/B _19335_/Q _15639_/B VPWR VGND sg13cmos5l_xnor2_1
X_18357_ _18437_/A _18436_/B _18436_/C _18436_/A VPWR VGND sg13cmos5l_a21oi_1
X_15569_ _15569_/Y _15569_/A _15569_/B VPWR VGND sg13cmos5l_nand2_1
X_17308_ _17308_/Y _17202_/B _17375_/B _17304_/Y VPWR VGND sg13cmos5l_o21ai_1
X_18288_ _18288_/Y hold1961/X fanout71/X _17930_/A VPWR VGND sg13cmos5l_o21ai_1
X_17239_ _17267_/D _19589_/Q _19590_/Q _19591_/Q VPWR VGND sg13cmos5l_or3_1
Xhold3015 _16785_/A _19501_/Q VPWR VGND sg13cmos5l_dlygate4sd3_1
X_09992_ _09992_/Y _09992_/A VPWR VGND sg13cmos5l_inv_1
Xhold3004 _18098_/A _19720_/Q VPWR VGND sg13cmos5l_dlygate4sd3_1
X_18593__1706 _18593_/RESET_B VPWR VGND sg13cmos5l_tiehi
Xhold2303 hold2303/X _16614_/Y VPWR VGND sg13cmos5l_dlygate4sd3_1
Xhold3026 _10938_/B _18634_/Q VPWR VGND sg13cmos5l_dlygate4sd3_1
Xhold3048 _15633_/B _19348_/Q VPWR VGND sg13cmos5l_dlygate4sd3_1
X_19736__1140 _19736_/RESET_B VPWR VGND sg13cmos5l_tiehi
Xhold3037 _10530_/B _19800_/Q VPWR VGND sg13cmos5l_dlygate4sd3_1
Xhold2314 _18726_/D _11677_/Y VPWR VGND sg13cmos5l_dlygate4sd3_1
Xclkbuf_4_15_0_clk clkload4/A clkbuf_0_clk/X VPWR VGND sg13cmos5l_buf_8
Xhold3059 _13473_/A _19015_/Q VPWR VGND sg13cmos5l_dlygate4sd3_1
Xhold2325 _19599_/D _17426_/Y VPWR VGND sg13cmos5l_dlygate4sd3_1
Xhold2336 _10200_/A _19397_/Q VPWR VGND sg13cmos5l_dlygate4sd3_1
Xhold2358 _16842_/A _19534_/Q VPWR VGND sg13cmos5l_dlygate4sd3_1
Xhold2369 _10166_/A _18622_/Q VPWR VGND sg13cmos5l_dlygate4sd3_1
Xhold2347 _17429_/B _19601_/Q VPWR VGND sg13cmos5l_dlygate4sd3_1
XFILLER_72_628 VPWR VGND sg13cmos5l_fill_1
XFILLER_56_168 VPWR VGND sg13cmos5l_fill_1
XFILLER_65_691 VPWR VGND sg13cmos5l_fill_2
XFILLER_44_15 VPWR VGND sg13cmos5l_fill_2
X_18843__1429 _18843_/RESET_B VPWR VGND sg13cmos5l_tiehi
X_19016__1244 _19016_/RESET_B VPWR VGND sg13cmos5l_tiehi
XFILLER_40_503 VPWR VGND sg13cmos5l_fill_1
XFILLER_60_25 VPWR VGND sg13cmos5l_fill_1
XFILLER_60_14 VPWR VGND sg13cmos5l_decap_8
X_11250_ _11295_/A _18679_/Q _11250_/B VPWR VGND sg13cmos5l_xor2_1
XFILLER_106_365 VPWR VGND sg13cmos5l_fill_1
X_11181_ _11198_/B _10958_/Y _11172_/Y _11175_/Y _11170_/Y _11179_/Y VPWR VGND sg13cmos5l_a221oi_1
X_10201_ _10201_/Y _16339_/A VPWR VGND sg13cmos5l_inv_1
XFILLER_106_387 VPWR VGND sg13cmos5l_decap_8
X_10132_ _16554_/A _10132_/A VPWR VGND sg13cmos5l_inv_1
XFILLER_48_603 VPWR VGND sg13cmos5l_fill_1
X_10063_ _10063_/Y _18932_/Q VPWR VGND sg13cmos5l_inv_1
XFILLER_0_676 VPWR VGND sg13cmos5l_fill_1
X_14940_ _14946_/A _15196_/B _14941_/B _14938_/A _10224_/Y _14939_/Y VPWR VGND sg13cmos5l_a221oi_1
Xhold2870 _10779_/A _18596_/Q VPWR VGND sg13cmos5l_dlygate4sd3_1
Xhold2892 _17768_/A _19609_/Q VPWR VGND sg13cmos5l_dlygate4sd3_1
X_14871_ _14873_/B _14750_/B _14913_/B _14871_/S VPWR VGND sg13cmos5l_mux2_1
Xhold2881 _15373_/A _19305_/Q VPWR VGND sg13cmos5l_dlygate4sd3_1
XFILLER_85_99 VPWR VGND sg13cmos5l_fill_1
X_16610_ _16610_/Y _16591_/A fanout31/X _16655_/A VPWR VGND sg13cmos5l_o21ai_1
X_17590_ _17590_/Y _17591_/C _17591_/D VPWR VGND sg13cmos5l_nand2_1
XFILLER_63_628 VPWR VGND sg13cmos5l_decap_8
XFILLER_62_105 VPWR VGND sg13cmos5l_fill_1
X_13822_ _13822_/Y _19081_/Q _18977_/Q VPWR VGND sg13cmos5l_nor2b_1
X_13753_ _13786_/A _19052_/Q _13765_/B _13752_/Y VPWR VGND sg13cmos5l_a21oi_1
X_16541_ _16541_/Y _16521_/B fanout33/X _16561_/A VPWR VGND sg13cmos5l_o21ai_1
X_12704_ _12708_/B _12704_/A _12704_/B VPWR VGND sg13cmos5l_and2_1
X_10965_ _10965_/Y _10965_/A _11183_/A VPWR VGND sg13cmos5l_nor2_1
X_13684_ _13684_/X _13684_/A _13684_/B VPWR VGND sg13cmos5l_xor2_1
XFILLER_43_374 VPWR VGND sg13cmos5l_fill_1
X_10896_ _10896_/Y _10536_/Y _10924_/A _10928_/A _10898_/A VPWR VGND sg13cmos5l_a22oi_1
X_19260_ _19260_/Q _19262_/CLK _19260_/D _19260_/RESET_B VPWR VGND sg13cmos5l_dfrbpq_1
X_16472_ _16472_/Y _16461_/Y _16466_/Y _16471_/Y VPWR VGND sg13cmos5l_o21ai_1
X_12635_ _12635_/Y _18890_/Q _12636_/B VPWR VGND sg13cmos5l_xnor2_1
X_18819__1453 _18819_/RESET_B VPWR VGND sg13cmos5l_tiehi
X_18211_ _19701_/D _18227_/B _18211_/B VPWR VGND sg13cmos5l_nor2_1
X_15423_ _15423_/Y _15411_/Y _15413_/X _15420_/Y _15422_/A VPWR VGND sg13cmos5l_a22oi_1
X_19191_ _19191_/Q clkload42/A _19191_/D _19191_/RESET_B VPWR VGND sg13cmos5l_dfrbpq_1
X_12566_ _12568_/B _12574_/B _12565_/Y _12564_/Y VPWR VGND sg13cmos5l_a21oi_1
X_15354_ _15361_/A _15344_/X _15348_/Y _15389_/B _15544_/A _15349_/X VPWR VGND sg13cmos5l_a221oi_1
X_18142_ _18142_/Y _18043_/A _18043_/B _18154_/B1 _18140_/Y _18139_/Y VPWR VGND sg13cmos5l_a221oi_1
X_11517_ _11720_/A _18708_/Q _11518_/B VPWR VGND sg13cmos5l_xnor2_1
X_14305_ _14305_/Y _14307_/S _14304_/Y VPWR VGND sg13cmos5l_nor2b_1
X_12497_ _12497_/Y _10273_/Y _12482_/Y _12496_/Y VPWR VGND sg13cmos5l_o21ai_1
X_19792__1764 _19792_/RESET_B VPWR VGND sg13cmos5l_tiehi
X_18073_ _18193_/A _19712_/Q _18200_/B VPWR VGND sg13cmos5l_xnor2_1
XFILLER_7_264 VPWR VGND sg13cmos5l_fill_1
X_15285_ _15285_/Y _15103_/A _15282_/A _15279_/X _15281_/Y _15282_/Y VPWR VGND sg13cmos5l_a221oi_1
X_17024_ _17091_/B hold2916/X _17011_/D _16974_/Y VPWR VGND sg13cmos5l_a21oi_1
X_11448_ _11469_/B _18659_/Q _11449_/B VPWR VGND sg13cmos5l_xnor2_1
X_14236_ _14237_/B _14642_/A _14265_/B VPWR VGND sg13cmos5l_nand2_1
XFILLER_98_503 VPWR VGND sg13cmos5l_decap_8
X_11379_ _11379_/Y _11533_/B _11899_/A _11393_/C VPWR VGND sg13cmos5l_nand3_1
X_14167_ _14167_/X _19078_/Q _14167_/B VPWR VGND sg13cmos5l_xor2_1
X_13118_ _13210_/A _12927_/B _13136_/C _13117_/Y VPWR VGND sg13cmos5l_a21oi_1
XFILLER_100_508 VPWR VGND sg13cmos5l_decap_4
X_18975_ _18975_/Q _18975_/CLK _18975_/D _18975_/RESET_B VPWR VGND sg13cmos5l_dfrbpq_1
X_14098_ _14098_/Y _19061_/Q _14098_/B VPWR VGND sg13cmos5l_nand2_1
X_13049_ _13055_/A _13299_/B _13054_/B _13044_/A _10262_/Y _13048_/Y VPWR VGND sg13cmos5l_a221oi_1
X_17926_ _17926_/Y _17914_/B _17928_/S _17943_/A VPWR VGND sg13cmos5l_o21ai_1
XFILLER_78_282 VPWR VGND sg13cmos5l_fill_2
XFILLER_66_444 VPWR VGND sg13cmos5l_fill_2
X_19092__1162 _19092_/RESET_B VPWR VGND sg13cmos5l_tiehi
X_17857_ _18050_/A _18012_/A _17875_/B VPWR VGND sg13cmos5l_and2_1
X_16808_ _19492_/D _16783_/A _16809_/S _16807_/Y VPWR VGND sg13cmos5l_a21oi_1
XFILLER_54_628 VPWR VGND sg13cmos5l_fill_1
XFILLER_38_157 VPWR VGND sg13cmos5l_fill_2
X_19527_ _19527_/Q clkload41/A _19527_/D _19527_/RESET_B VPWR VGND sg13cmos5l_dfrbpq_1
X_17788_ _17788_/Y _17786_/Y _17787_/Y _17785_/Y VPWR VGND sg13cmos5l_a21oi_1
X_16739_ _16739_/Y _16655_/B _16824_/B _16825_/B _16659_/X VPWR VGND sg13cmos5l_a22oi_1
XFILLER_62_661 VPWR VGND sg13cmos5l_decap_8
X_19458_ _19458_/Q _19462_/CLK _19458_/D _19458_/RESET_B VPWR VGND sg13cmos5l_dfrbpq_1
XFILLER_34_385 VPWR VGND sg13cmos5l_fill_2
X_19389_ _19389_/Q clkload18/A _19389_/D _19389_/RESET_B VPWR VGND sg13cmos5l_dfrbpq_1
XFILLER_22_558 VPWR VGND sg13cmos5l_fill_1
X_18409_ _18409_/Y _18409_/A _18409_/B _18409_/C VPWR VGND sg13cmos5l_nor3_1
Xhold2100 _16861_/A _19536_/Q VPWR VGND sg13cmos5l_dlygate4sd3_1
X_09975_ _09975_/Y _09975_/A VPWR VGND sg13cmos5l_inv_1
Xhold2111 _11281_/A _18660_/Q VPWR VGND sg13cmos5l_dlygate4sd3_1
Xhold2122 _16881_/B _19517_/Q VPWR VGND sg13cmos5l_dlygate4sd3_1
Xhold2144 _17962_/A _19639_/Q VPWR VGND sg13cmos5l_dlygate4sd3_1
Xhold2133 _19190_/D _14699_/Y VPWR VGND sg13cmos5l_dlygate4sd3_1
X_19234__1011 _19234_/RESET_B VPWR VGND sg13cmos5l_tiehi
Xhold2177 _10268_/A _18893_/Q VPWR VGND sg13cmos5l_dlygate4sd3_1
Xhold2188 _10828_/A _19766_/Q VPWR VGND sg13cmos5l_dlygate4sd3_1
Xhold2155 _13328_/B _18938_/Q VPWR VGND sg13cmos5l_dlygate4sd3_1
Xhold2166 _16308_/A _19374_/Q VPWR VGND sg13cmos5l_dlygate4sd3_1
XFILLER_72_403 VPWR VGND sg13cmos5l_fill_1
Xhold2199 hold2199/X _10854_/Y VPWR VGND sg13cmos5l_dlygate4sd3_1
XFILLER_84_274 VPWR VGND sg13cmos5l_fill_2
X_10750_ _18582_/D _10750_/A _10794_/B VPWR VGND sg13cmos5l_and2_1
X_10681_ _10681_/Y _10384_/C _10680_/Y _10679_/Y VPWR VGND sg13cmos5l_o21ai_1
XFILLER_13_536 VPWR VGND sg13cmos5l_decap_4
XFILLER_13_558 VPWR VGND sg13cmos5l_fill_2
X_12420_ _12420_/Y _12419_/B _12436_/A VPWR VGND sg13cmos5l_nand2b_1
X_18807__1468 _18807_/RESET_B VPWR VGND sg13cmos5l_tiehi
X_12351_ _12463_/B hold2705/X _12350_/Y _12368_/B VPWR VGND sg13cmos5l_mux2_1
X_12282_ _12282_/Y _12137_/A _12279_/Y _12281_/Y VPWR VGND sg13cmos5l_o21ai_1
X_11302_ _11302_/Y _11302_/A _11363_/B VPWR VGND sg13cmos5l_nor2_1
X_19002__499 _19002_/D VPWR VGND sg13cmos5l_tielo
XFILLER_5_746 VPWR VGND sg13cmos5l_fill_1
XFILLER_4_212 VPWR VGND sg13cmos5l_fill_2
X_15070_ _15078_/B _19251_/Q _19249_/Q _19250_/Q VPWR VGND sg13cmos5l_nor3_1
XFILLER_84_1001 VPWR VGND sg13cmos5l_fill_1
X_11233_ _11332_/A _11216_/A _11231_/B _11232_/Y VPWR VGND sg13cmos5l_a21oi_1
X_14021_ _14045_/S _14015_/Y _14019_/Y _14020_/Y VPWR VGND sg13cmos5l_a21o_1
XFILLER_5_768 VPWR VGND sg13cmos5l_fill_1
XFILLER_96_32 VPWR VGND sg13cmos5l_fill_1
X_11164_ _11164_/Y _11171_/D _11159_/C _11159_/A VPWR VGND sg13cmos5l_a21oi_1
X_18760_ _18760_/Q clkload39/A _18760_/D _18760_/RESET_B VPWR VGND sg13cmos5l_dfrbpq_1
X_11095_ _11095_/Y _11621_/A _18600_/Q VPWR VGND sg13cmos5l_nor2_1
X_15972_ _15973_/A _15845_/B _15942_/Y _15984_/B VPWR VGND sg13cmos5l_mux2_1
X_10115_ _15738_/A _10115_/A VPWR VGND sg13cmos5l_inv_1
X_10046_ _12725_/A _10046_/A VPWR VGND sg13cmos5l_inv_1
X_18691_ _18691_/Q _18733_/CLK _18691_/D _18691_/RESET_B VPWR VGND sg13cmos5l_dfrbpq_1
X_17711_ _17711_/Y _17711_/A VPWR VGND sg13cmos5l_inv_1
X_14923_ _14923_/Y _19252_/Q _14947_/B _14922_/Y VPWR VGND sg13cmos5l_a21oi_1
X_17642_ _17649_/A _17642_/A _17642_/B VPWR VGND sg13cmos5l_nor2_1
XFILLER_48_499 VPWR VGND sg13cmos5l_fill_2
X_14854_ _14855_/B _14840_/A _14877_/B _14853_/Y VPWR VGND sg13cmos5l_a21oi_1
X_11997_ _11999_/B _11997_/A _12018_/B VPWR VGND sg13cmos5l_nor2_1
X_13805_ _13805_/Y _13805_/A _13805_/B _13805_/C VPWR VGND sg13cmos5l_nand3_1
X_17573_ _17573_/Y _17573_/A _17573_/B VPWR VGND sg13cmos5l_nor2_1
X_19745__1005 _19745_/RESET_B VPWR VGND sg13cmos5l_tiehi
X_14785_ _14855_/A _14876_/B _14785_/B VPWR VGND sg13cmos5l_nand2_1
XFILLER_35_149 VPWR VGND sg13cmos5l_fill_2
X_13736_ _13778_/A _19050_/Q _13765_/B VPWR VGND sg13cmos5l_xnor2_1
X_10948_ _10955_/A _10937_/X _10941_/Y _10954_/A _10984_/A _10942_/X VPWR VGND sg13cmos5l_a221oi_1
XFILLER_44_661 VPWR VGND sg13cmos5l_fill_2
XFILLER_43_160 VPWR VGND sg13cmos5l_fill_2
X_19312_ _19312_/Q clkload7/A _19312_/D _19312_/RESET_B VPWR VGND sg13cmos5l_dfrbpq_1
X_16524_ _16525_/C _16524_/A _16524_/B _16524_/C VPWR VGND sg13cmos5l_nand3_1
X_19243_ _19243_/Q _19308_/CLK _19243_/D _19243_/RESET_B VPWR VGND sg13cmos5l_dfrbpq_1
X_16455_ _16455_/Y _16465_/A _16465_/B VPWR VGND sg13cmos5l_nand2_1
X_13667_ _13676_/B _19041_/Q _19039_/Q _19040_/Q VPWR VGND sg13cmos5l_nor3_1
X_10879_ _18608_/D _11152_/A _10879_/B VPWR VGND sg13cmos5l_and2_1
X_15406_ _15424_/A _15392_/A _15464_/B _15428_/B VPWR VGND sg13cmos5l_mux2_1
X_12618_ _12658_/A _12618_/A _12652_/A VPWR VGND sg13cmos5l_xnor2_1
X_13598_ _13601_/A _13598_/A _13598_/B VPWR VGND sg13cmos5l_nand2_1
X_19174_ _19174_/Q _19220_/CLK _19174_/D _19174_/RESET_B VPWR VGND sg13cmos5l_dfrbpq_1
X_16386_ _16454_/A _19450_/Q _16399_/D VPWR VGND sg13cmos5l_xnor2_1
X_12549_ _12549_/Y _12334_/A _12537_/X _12539_/Y _12329_/B VPWR VGND sg13cmos5l_a22oi_1
X_15337_ _15357_/B _19305_/Q _19306_/Q _19307_/Q _19308_/Q VPWR VGND sg13cmos5l_nor4_1
X_18125_ _18125_/Y _18109_/X _18124_/Y _18105_/Y VPWR VGND sg13cmos5l_o21ai_1
XANTENNA_1 _10443_/D VPWR VGND sg13cmos5l_antennanp
X_18056_ _18059_/A _18056_/A _18056_/B VPWR VGND sg13cmos5l_nand2_1
X_15268_ _15288_/A _19241_/Q _19242_/Q VPWR VGND sg13cmos5l_xor2_1
X_17007_ _17087_/B _16985_/Y _17188_/A _17020_/S VPWR VGND sg13cmos5l_mux2_1
X_14219_ _14220_/B _14320_/B _14320_/C _14320_/A VPWR VGND sg13cmos5l_a21oi_1
X_15199_ _15199_/Y _15197_/Y _15199_/B VPWR VGND sg13cmos5l_nand2b_1
XFILLER_98_366 VPWR VGND sg13cmos5l_fill_2
X_18958_ _18958_/Q clkload67/A _18958_/D _18958_/RESET_B VPWR VGND sg13cmos5l_dfrbpq_1
X_17909_ _17916_/A _17943_/B _17909_/B VPWR VGND sg13cmos5l_nor2_1
X_18889_ _18889_/Q clkload71/A _18889_/D _18889_/RESET_B VPWR VGND sg13cmos5l_dfrbpq_1
X_18883__1386 _18883_/RESET_B VPWR VGND sg13cmos5l_tiehi
X_19684__1775 _19684_/RESET_B VPWR VGND sg13cmos5l_tiehi
XFILLER_35_683 VPWR VGND sg13cmos5l_fill_2
X_19132__1119 _19132_/RESET_B VPWR VGND sg13cmos5l_tiehi
X_18775__1501 _18775_/RESET_B VPWR VGND sg13cmos5l_tiehi
XFILLER_89_311 VPWR VGND sg13cmos5l_fill_2
XFILLER_104_677 VPWR VGND sg13cmos5l_fill_2
XFILLER_77_539 VPWR VGND sg13cmos5l_fill_2
XFILLER_66_79 VPWR VGND sg13cmos5l_fill_1
X_11920_ _11920_/X _11921_/A _11921_/B VPWR VGND sg13cmos5l_and2_1
XFILLER_72_211 VPWR VGND sg13cmos5l_fill_1
XFILLER_46_948 VPWR VGND sg13cmos5l_fill_1
X_11851_ _11853_/A _11852_/B _11852_/C _11901_/B VPWR VGND sg13cmos5l_a21oi_1
XFILLER_45_469 VPWR VGND sg13cmos5l_fill_2
X_11782_ _11782_/Y _18760_/Q _18759_/Q _18744_/Q VPWR VGND sg13cmos5l_nand3b_1
X_10802_ _18558_/B hold2828/X _10784_/Y _10800_/Y _10784_/B VPWR VGND sg13cmos5l_a22oi_1
XFILLER_82_34 VPWR VGND sg13cmos5l_fill_1
X_14570_ _14646_/B _14577_/B _14568_/X _14567_/Y VPWR VGND sg13cmos5l_o21ai_1
X_10733_ _18573_/D _10710_/Y fanout99/X _10732_/Y VPWR VGND sg13cmos5l_a21oi_1
X_13521_ _13521_/Y _13418_/B _13515_/X _13519_/X _13424_/B VPWR VGND sg13cmos5l_a22oi_1
XFILLER_40_152 VPWR VGND sg13cmos5l_fill_1
X_10664_ _10664_/Y _10664_/A _10664_/B VPWR VGND sg13cmos5l_nor2_1
X_13452_ _13453_/B _13452_/A _13546_/B VPWR VGND sg13cmos5l_nand2_1
X_16240_ _16240_/Y _16226_/Y _16233_/Y _16317_/B _16134_/B _16234_/Y VPWR VGND sg13cmos5l_a221oi_1
X_12403_ _12404_/B _12403_/A _12403_/B VPWR VGND sg13cmos5l_xor2_1
X_13383_ _13387_/B _18952_/Q _13383_/B VPWR VGND sg13cmos5l_xor2_1
X_16171_ _16171_/Y _16273_/B _16289_/A _16171_/C VPWR VGND sg13cmos5l_nand3_1
X_10595_ _10595_/Y _10595_/A _10648_/A VPWR VGND sg13cmos5l_nor2_1
X_12334_ _12335_/C _12334_/A _12368_/A VPWR VGND sg13cmos5l_nor2_1
X_15122_ _15193_/B _15121_/C _15120_/A _15121_/Y VPWR VGND sg13cmos5l_a21o_1
X_15053_ _15054_/B _15053_/A _15053_/B VPWR VGND sg13cmos5l_nor2_1
XFILLER_31_82 VPWR VGND sg13cmos5l_fill_1
X_12265_ _12265_/Y _12303_/A _12265_/B VPWR VGND sg13cmos5l_nand2b_1
X_14004_ _14004_/X _13991_/A _13991_/B _14194_/A VPWR VGND sg13cmos5l_a21o_1
X_12196_ _18801_/D _12109_/C _12109_/D _12200_/A VPWR VGND sg13cmos5l_a21oi_1
X_11216_ _11232_/A _11216_/A _11234_/B VPWR VGND sg13cmos5l_nor2_1
X_18812_ _18812_/Q clkload69/A _18812_/D _18812_/RESET_B VPWR VGND sg13cmos5l_dfrbpq_1
X_11147_ _11147_/Y _18648_/Q fanout89/X _11152_/A VPWR VGND sg13cmos5l_o21ai_1
X_19792_ _19792_/Q clkload22/A _19792_/D _19792_/RESET_B VPWR VGND sg13cmos5l_dfrbpq_1
X_19427__803 _19427_/RESET_B VPWR VGND sg13cmos5l_tiehi
X_18743_ _18743_/Q _18750_/CLK _18743_/D _18743_/RESET_B VPWR VGND sg13cmos5l_dfrbpq_1
X_11078_ _18625_/D _11152_/A _11078_/B VPWR VGND sg13cmos5l_and2_1
X_15955_ _16022_/B _15924_/A _15951_/B _15939_/C _15921_/Y VPWR VGND sg13cmos5l_a22oi_1
XFILLER_0_292 VPWR VGND sg13cmos5l_fill_1
X_10029_ _11624_/A _10029_/A VPWR VGND sg13cmos5l_inv_1
X_18674_ _18674_/Q clkload58/A _18674_/D _18674_/RESET_B VPWR VGND sg13cmos5l_dfrbpq_1
X_15886_ _15991_/A _15869_/A _15884_/B _15885_/Y VPWR VGND sg13cmos5l_a21oi_1
X_14906_ _19216_/D _14906_/A _14915_/A VPWR VGND sg13cmos5l_nor2_1
X_17625_ _17625_/Y _17625_/A _17625_/B VPWR VGND sg13cmos5l_nor2_1
X_14837_ _14838_/A _14997_/A _14837_/B VPWR VGND sg13cmos5l_nor2_1
X_17556_ _17564_/B _19635_/Q _17557_/B VPWR VGND sg13cmos5l_nor2b_1
X_14768_ _14868_/A _19216_/Q _14781_/B VPWR VGND sg13cmos5l_xnor2_1
X_16507_ _16507_/X _16447_/X _16526_/B _16506_/Y VPWR VGND sg13cmos5l_a21o_1
X_13719_ _13719_/Y _13719_/A VPWR VGND sg13cmos5l_inv_1
X_17487_ _17487_/X _17298_/B _17494_/B _17485_/Y VPWR VGND sg13cmos5l_a21o_1
XFILLER_60_962 VPWR VGND sg13cmos5l_fill_1
X_14699_ _14699_/Y _14947_/B _14690_/S _14698_/Y VPWR VGND sg13cmos5l_a21oi_1
XFILLER_32_653 VPWR VGND sg13cmos5l_fill_2
X_19226_ _19226_/Q _19227_/CLK _19226_/D _19226_/RESET_B VPWR VGND sg13cmos5l_dfrbpq_1
X_16438_ _16438_/Y _16432_/A _16469_/A _16436_/Y _16207_/Y VPWR VGND sg13cmos5l_a22oi_1
X_18868__1401 _18868_/RESET_B VPWR VGND sg13cmos5l_tiehi
X_16369_ _16369_/Y _09982_/Y _16370_/B _16368_/Y VPWR VGND sg13cmos5l_a21oi_1
XFILLER_9_860 VPWR VGND sg13cmos5l_fill_2
X_19157_ _19157_/Q _19227_/CLK _19157_/D _19157_/RESET_B VPWR VGND sg13cmos5l_dfrbpq_1
XFILLER_68_0 VPWR VGND sg13cmos5l_fill_2
X_18108_ _18159_/A _19719_/Q _18108_/B VPWR VGND sg13cmos5l_xnor2_1
X_19088_ _19088_/Q _19092_/CLK _19088_/D _19088_/RESET_B VPWR VGND sg13cmos5l_dfrbpq_1
X_18039_ _18039_/X _18045_/B _18039_/B VPWR VGND sg13cmos5l_or2_1
Xfanout305 _11905_/A _11899_/B VPWR VGND sg13cmos5l_buf_1
XFILLER_87_804 VPWR VGND sg13cmos5l_fill_2
Xfanout338 _16722_/A _19491_/Q VPWR VGND sg13cmos5l_buf_1
Xfanout316 _11355_/B _11132_/Y VPWR VGND sg13cmos5l_buf_1
Xfanout327 _18547_/B _18531_/A VPWR VGND sg13cmos5l_buf_1
Xfanout349 _12110_/A _18787_/Q VPWR VGND sg13cmos5l_buf_1
XFILLER_100_146 VPWR VGND sg13cmos5l_fill_1
XFILLER_86_358 VPWR VGND sg13cmos5l_fill_1
XFILLER_82_531 VPWR VGND sg13cmos5l_fill_2
XFILLER_82_597 VPWR VGND sg13cmos5l_fill_1
XFILLER_82_586 VPWR VGND sg13cmos5l_decap_8
XFILLER_74_1000 VPWR VGND sg13cmos5l_fill_1
XFILLER_35_1017 VPWR VGND sg13cmos5l_decap_8
XFILLER_35_1028 VPWR VGND sg13cmos5l_fill_1
XFILLER_10_303 VPWR VGND sg13cmos5l_fill_1
X_10380_ _13587_/B _18576_/Q VPWR VGND sg13cmos5l_inv_1
X_12050_ _12052_/B _12169_/A _12168_/A VPWR VGND sg13cmos5l_nor2_1
XFILLER_78_815 VPWR VGND sg13cmos5l_fill_1
X_11001_ _11051_/B _11036_/B _11036_/C VPWR VGND sg13cmos5l_nand2_1
X_18576__540 _18576_/D VPWR VGND sg13cmos5l_tielo
X_12952_ _12952_/X _12841_/X _13025_/B _12951_/Y VPWR VGND sg13cmos5l_a21o_1
XFILLER_73_520 VPWR VGND sg13cmos5l_decap_4
X_19444__457 _19444_/D VPWR VGND sg13cmos5l_tielo
X_15740_ _19344_/D _15740_/A _15742_/B VPWR VGND sg13cmos5l_nor2_1
X_11903_ _18762_/D _11905_/A _11903_/B VPWR VGND sg13cmos5l_nor2_1
X_15671_ _15671_/Y _15671_/A _15671_/B VPWR VGND sg13cmos5l_nor2_1
X_12883_ _12884_/B _12883_/A _12883_/B VPWR VGND sg13cmos5l_xor2_1
X_17410_ _17411_/A _17408_/C _17409_/Y _17408_/Y VPWR VGND sg13cmos5l_a21o_1
X_14622_ _14622_/Y _14622_/A _14622_/B VPWR VGND sg13cmos5l_nor2_1
X_11834_ _11904_/B _11796_/A _11833_/B _11833_/Y VPWR VGND sg13cmos5l_o21ai_1
X_18390_ _18390_/Y _19762_/Q _18391_/B VPWR VGND sg13cmos5l_xnor2_1
X_11765_ _11767_/B _11873_/A _11872_/A VPWR VGND sg13cmos5l_nor2_1
X_17341_ _17341_/Y _17341_/A _17341_/B VPWR VGND sg13cmos5l_nand2_1
X_14553_ _14553_/Y _19170_/Q _14553_/B VPWR VGND sg13cmos5l_xnor2_1
X_10716_ _10718_/A _10716_/A _10716_/B VPWR VGND sg13cmos5l_nor2_1
X_11696_ _11697_/B _18695_/Q _18696_/Q _18697_/Q VPWR VGND sg13cmos5l_o21ai_1
X_17272_ _17467_/A _17272_/A VPWR VGND sg13cmos5l_inv_1
X_13504_ _13504_/Y _13505_/C _13505_/D VPWR VGND sg13cmos5l_nand2_1
XFILLER_41_494 VPWR VGND sg13cmos5l_fill_2
X_14484_ _14589_/A _14580_/A VPWR VGND sg13cmos5l_inv_1
X_13435_ _13546_/B _13435_/A _13450_/B VPWR VGND sg13cmos5l_nand2_1
X_19011_ _19011_/Q clkload65/A _19011_/D _19011_/RESET_B VPWR VGND sg13cmos5l_dfrbpq_1
X_16223_ _16223_/Y _16223_/A _16255_/B VPWR VGND sg13cmos5l_nor2_1
X_10647_ _19803_/D _10647_/A _18531_/A VPWR VGND sg13cmos5l_nor2_1
XFILLER_42_81 VPWR VGND sg13cmos5l_decap_8
XFILLER_10_881 VPWR VGND sg13cmos5l_fill_1
X_18856__1416 _18856_/RESET_B VPWR VGND sg13cmos5l_tiehi
X_13366_ _13366_/X _18954_/Q _18947_/Q _18948_/Q VPWR VGND sg13cmos5l_or3_1
X_16154_ _16172_/A _16154_/A _16167_/B VPWR VGND sg13cmos5l_or2_1
X_10578_ _10578_/Y _18544_/A _10569_/Y _10577_/X VPWR VGND sg13cmos5l_o21ai_1
X_12317_ _12317_/Y _18830_/Q _18829_/Q _18831_/Q VPWR VGND sg13cmos5l_o21ai_1
X_13297_ _18974_/D _13297_/A _13297_/B VPWR VGND sg13cmos5l_and2_1
X_16085_ _16099_/B _19369_/Q _19370_/Q _19367_/Q _19368_/Q VPWR VGND sg13cmos5l_nor4_1
X_15105_ _15189_/B _15104_/X _15103_/Y _15121_/C VPWR VGND sg13cmos5l_mux2_1
X_12248_ _12248_/Y _12492_/A _12241_/S _12247_/Y VPWR VGND sg13cmos5l_a21oi_1
X_15036_ _15056_/A _19259_/Q _15039_/B VPWR VGND sg13cmos5l_or2_1
X_19646__561 _19646_/RESET_B VPWR VGND sg13cmos5l_tiehi
X_12179_ _18787_/D _12157_/A _12186_/S _12178_/Y VPWR VGND sg13cmos5l_a21oi_1
X_16987_ _16987_/Y _19548_/Q _19547_/Q _19532_/Q VPWR VGND sg13cmos5l_nand3b_1
X_19775_ _19775_/Q clkload34/A _19775_/D _19775_/RESET_B VPWR VGND sg13cmos5l_dfrbpq_1
X_18726_ _18726_/Q clkload59/A _18726_/D _18726_/RESET_B VPWR VGND sg13cmos5l_dfrbpq_1
X_15938_ _15938_/Y _15944_/A _15944_/B _15944_/C _15944_/D VPWR VGND sg13cmos5l_a22oi_1
X_18657_ _18657_/Q _19087_/CLK _18657_/D _18657_/RESET_B VPWR VGND sg13cmos5l_dfrbpq_1
X_17608_ _17608_/Y _17610_/S _17607_/Y VPWR VGND sg13cmos5l_nor2b_1
X_15869_ _15885_/A _15869_/A _15884_/B VPWR VGND sg13cmos5l_nor2_1
X_18802__1473 _18802_/RESET_B VPWR VGND sg13cmos5l_tiehi
X_18588_ _18588_/Q _18594_/CLK _18588_/D _18588_/RESET_B VPWR VGND sg13cmos5l_dfrbpq_1
XFILLER_24_428 VPWR VGND sg13cmos5l_fill_1
X_17539_ _17755_/A _17934_/A _17539_/B VPWR VGND sg13cmos5l_xnor2_1
XFILLER_33_951 VPWR VGND sg13cmos5l_decap_4
X_19209_ _19209_/Q clkload51/A _19209_/D _19209_/RESET_B VPWR VGND sg13cmos5l_dfrbpq_1
X_19172__1076 _19172_/RESET_B VPWR VGND sg13cmos5l_tiehi
X_19782__1749 _19782_/RESET_B VPWR VGND sg13cmos5l_tiehi
XFILLER_105_227 VPWR VGND sg13cmos5l_fill_2
Xfanout102 _16753_/A _16731_/Y VPWR VGND sg13cmos5l_buf_1
Xfanout113 _17766_/A _17572_/Y VPWR VGND sg13cmos5l_buf_1
Xfanout146 _17808_/B _17788_/Y VPWR VGND sg13cmos5l_buf_1
Xfanout124 _16116_/A _15923_/Y VPWR VGND sg13cmos5l_buf_1
Xfanout135 _14303_/A _14237_/Y VPWR VGND sg13cmos5l_buf_1
Xfanout179 _13232_/B _13263_/B VPWR VGND sg13cmos5l_buf_1
XFILLER_74_306 VPWR VGND sg13cmos5l_fill_1
XFILLER_47_26 VPWR VGND sg13cmos5l_fill_2
Xfanout157 _16167_/B _16150_/Y VPWR VGND sg13cmos5l_buf_1
Xfanout168 _14781_/B _14763_/Y VPWR VGND sg13cmos5l_buf_1
X_19740__1054 _19740_/RESET_B VPWR VGND sg13cmos5l_tiehi
XFILLER_103_21 VPWR VGND sg13cmos5l_fill_1
XFILLER_70_567 VPWR VGND sg13cmos5l_fill_1
X_11550_ _11550_/X _11539_/B _11560_/B _11549_/Y VPWR VGND sg13cmos5l_a21o_1
XFILLER_11_623 VPWR VGND sg13cmos5l_fill_1
XFILLER_7_616 VPWR VGND sg13cmos5l_fill_1
X_19417__813 _19417_/RESET_B VPWR VGND sg13cmos5l_tiehi
X_10501_ _10501_/Y _10501_/A _18387_/A VPWR VGND sg13cmos5l_nor2_1
X_13220_ _13250_/B _13245_/A _13263_/B VPWR VGND sg13cmos5l_nand2_1
X_11481_ _11481_/Y _18689_/Q _18650_/Q VPWR VGND sg13cmos5l_xnor2_1
X_10432_ _10443_/B _10432_/A _10432_/B _10432_/C _10432_/D VPWR VGND sg13cmos5l_nor4_1
X_18637__1659 _18637_/RESET_B VPWR VGND sg13cmos5l_tiehi
XFILLER_6_148 VPWR VGND sg13cmos5l_decap_8
X_10363_ _16852_/A _10363_/A VPWR VGND sg13cmos5l_inv_1
X_13151_ _13151_/Y _13151_/A _13384_/A VPWR VGND sg13cmos5l_nor2_1
X_12102_ _12104_/B _12137_/B _12136_/B VPWR VGND sg13cmos5l_nor2_1
X_13082_ _18942_/D _10003_/Y fanout77/X _13081_/Y VPWR VGND sg13cmos5l_a21oi_1
XFILLER_3_855 VPWR VGND sg13cmos5l_fill_1
X_16910_ _16910_/X _16910_/A _16937_/A VPWR VGND sg13cmos5l_or2_1
X_10294_ _10294_/Y _10294_/A VPWR VGND sg13cmos5l_inv_1
X_12033_ _12033_/Y _18774_/Q _18735_/Q VPWR VGND sg13cmos5l_xnor2_1
XFILLER_2_343 VPWR VGND sg13cmos5l_fill_2
XFILLER_2_354 VPWR VGND sg13cmos5l_decap_4
X_17890_ _17890_/Y _17879_/A _17943_/B _17878_/Y _17874_/Y _17862_/A VPWR VGND sg13cmos5l_a221oi_1
X_16841_ _16861_/C _19538_/Q _16860_/A _16849_/B VPWR VGND sg13cmos5l_o21ai_1
X_16772_ _16788_/S _16756_/Y _16759_/Y _16770_/X VPWR VGND sg13cmos5l_a21o_1
XFILLER_93_626 VPWR VGND sg13cmos5l_fill_2
XFILLER_92_114 VPWR VGND sg13cmos5l_fill_1
X_19560_ _19560_/Q clkload25/A _19560_/D _19560_/RESET_B VPWR VGND sg13cmos5l_dfrbpq_1
X_19424__806 _19424_/RESET_B VPWR VGND sg13cmos5l_tiehi
X_18511_ _18511_/Y _18511_/A VPWR VGND sg13cmos5l_inv_1
X_19602__442 _19602_/D VPWR VGND sg13cmos5l_tielo
X_13984_ _13984_/Y _13984_/A _14164_/A VPWR VGND sg13cmos5l_nand2_1
X_15723_ _15723_/Y _15699_/Y _15727_/S _15747_/A VPWR VGND sg13cmos5l_o21ai_1
X_19491_ _19491_/Q clkload32/A _19491_/D _19491_/RESET_B VPWR VGND sg13cmos5l_dfrbpq_1
X_12935_ _12938_/D _12940_/A _12926_/B _12934_/Y VPWR VGND sg13cmos5l_o21ai_1
X_12866_ _12974_/B _12879_/A _12879_/B VPWR VGND sg13cmos5l_nand2_1
X_18442_ _18442_/Y _18423_/A _18423_/B _18435_/X _18440_/Y _18441_/Y VPWR VGND sg13cmos5l_a221oi_1
X_15654_ _15743_/B _15678_/A _15653_/Y _15652_/Y VPWR VGND sg13cmos5l_a21oi_1
X_11817_ _12001_/A _12189_/A _11997_/A VPWR VGND sg13cmos5l_nand2_1
X_18373_ _18380_/C _19757_/Q _19758_/Q _19759_/Q VPWR VGND sg13cmos5l_o21ai_1
X_15585_ _15586_/B _15364_/Y _15562_/A _15556_/B _15569_/B VPWR VGND sg13cmos5l_a22oi_1
X_14605_ _14607_/B _14575_/A _14646_/B _14605_/S VPWR VGND sg13cmos5l_mux2_1
X_12797_ _18904_/D _12797_/A _12797_/B VPWR VGND sg13cmos5l_and2_1
X_17324_ _17325_/C _17324_/A _17324_/B VPWR VGND sg13cmos5l_xnor2_1
X_14536_ _14725_/A _14721_/A _19166_/Q VPWR VGND sg13cmos5l_xnor2_1
XFILLER_15_984 VPWR VGND sg13cmos5l_fill_1
X_11748_ _11748_/Y _18731_/Q _18692_/Q VPWR VGND sg13cmos5l_xnor2_1
X_11679_ _18727_/D _11932_/A _11672_/S _11678_/Y VPWR VGND sg13cmos5l_a21oi_1
X_17255_ _17255_/X _17256_/A _17256_/B _17256_/C VPWR VGND sg13cmos5l_and3_1
X_14467_ _14473_/B _14455_/Y _14462_/Y _14465_/Y VPWR VGND sg13cmos5l_o21ai_1
X_17186_ _19567_/D _17377_/A _17186_/B VPWR VGND sg13cmos5l_nor2_1
X_13418_ _18992_/D _13585_/A _13418_/B VPWR VGND sg13cmos5l_nor2_1
X_16206_ _16256_/A _19421_/Q _16207_/B VPWR VGND sg13cmos5l_xnor2_1
X_14398_ _14399_/A _14397_/Y _14396_/Y _14408_/C VPWR VGND sg13cmos5l_mux2_1
X_13349_ _13349_/Y _13848_/A _13349_/B VPWR VGND sg13cmos5l_nand2_1
XFILLER_6_671 VPWR VGND sg13cmos5l_fill_2
X_16137_ _16138_/B _16117_/A _16117_/B _16136_/Y VPWR VGND sg13cmos5l_o21ai_1
XFILLER_69_601 VPWR VGND sg13cmos5l_decap_8
X_16068_ _16068_/Y _16329_/A _16060_/Y _16067_/Y VPWR VGND sg13cmos5l_a21oi_1
Xhold2529 _10057_/A _18916_/Q VPWR VGND sg13cmos5l_dlygate4sd3_1
Xhold2518 _10338_/A _19680_/Q VPWR VGND sg13cmos5l_dlygate4sd3_1
X_15019_ _19243_/D _15191_/A _15019_/B VPWR VGND sg13cmos5l_nor2_1
Xhold2507 _19441_/D _16367_/Y VPWR VGND sg13cmos5l_dlygate4sd3_1
Xhold1817 _16622_/B _19028_/Q VPWR VGND sg13cmos5l_dlygate4sd3_1
XFILLER_69_678 VPWR VGND sg13cmos5l_fill_2
XFILLER_69_667 VPWR VGND sg13cmos5l_fill_2
XFILLER_68_144 VPWR VGND sg13cmos5l_fill_2
Xhold1839 _13644_/B _18580_/Q VPWR VGND sg13cmos5l_dlygate4sd3_1
Xhold1828 _14436_/B _19112_/Q VPWR VGND sg13cmos5l_dlygate4sd3_1
XFILLER_83_125 VPWR VGND sg13cmos5l_fill_1
XFILLER_68_199 VPWR VGND sg13cmos5l_fill_2
X_19758_ _19758_/Q clkload23/A _19758_/D _19758_/RESET_B VPWR VGND sg13cmos5l_dfrbpq_1
X_18709_ _18709_/Q _18902_/CLK _18709_/D _18709_/RESET_B VPWR VGND sg13cmos5l_dfrbpq_1
X_19689_ _19689_/Q clkload13/A _19689_/D _19689_/RESET_B VPWR VGND sg13cmos5l_dfrbpq_1
X_19516__701 _19516_/RESET_B VPWR VGND sg13cmos5l_tiehi
XFILLER_21_998 VPWR VGND sg13cmos5l_decap_4
XFILLER_106_514 VPWR VGND sg13cmos5l_decap_4
XFILLER_106_558 VPWR VGND sg13cmos5l_fill_1
XFILLER_0_825 VPWR VGND sg13cmos5l_decap_4
XFILLER_0_858 VPWR VGND sg13cmos5l_decap_4
XFILLER_102_786 VPWR VGND sg13cmos5l_fill_2
XFILLER_75_626 VPWR VGND sg13cmos5l_fill_2
XFILLER_90_607 VPWR VGND sg13cmos5l_fill_2
X_10981_ _11088_/B _10982_/C _10982_/D VPWR VGND sg13cmos5l_nand2_1
XFILLER_28_553 VPWR VGND sg13cmos5l_fill_2
X_12720_ _12721_/B _12708_/A _12705_/Y _12720_/S VPWR VGND sg13cmos5l_mux2_1
XFILLER_16_759 VPWR VGND sg13cmos5l_fill_1
X_12651_ _12838_/A _12651_/A _12824_/A VPWR VGND sg13cmos5l_nand2_1
XFILLER_15_247 VPWR VGND sg13cmos5l_fill_2
XFILLER_90_45 VPWR VGND sg13cmos5l_fill_1
X_11602_ _11602_/Y _11484_/Y _11497_/Y _11598_/A _11614_/A _11601_/X VPWR VGND sg13cmos5l_a221oi_1
X_12582_ _12582_/Y _18858_/Q _18819_/Q VPWR VGND sg13cmos5l_xnor2_1
X_15370_ _15378_/C _15361_/X _15367_/Y _15369_/Y VPWR VGND sg13cmos5l_a21oi_1
X_11533_ _11553_/B _18704_/Q _11533_/B VPWR VGND sg13cmos5l_xnor2_1
X_18896__1373 _18896_/RESET_B VPWR VGND sg13cmos5l_tiehi
XFILLER_7_402 VPWR VGND sg13cmos5l_fill_1
XFILLER_11_453 VPWR VGND sg13cmos5l_decap_8
X_14321_ _14323_/A _14220_/B _14343_/A _14321_/C VPWR VGND sg13cmos5l_nand3b_1
X_17040_ _17040_/Y _17040_/A _17040_/B _17040_/C VPWR VGND sg13cmos5l_nor3_1
X_11464_ _11464_/X _11464_/A _11469_/B VPWR VGND sg13cmos5l_and2_1
XFILLER_7_457 VPWR VGND sg13cmos5l_fill_1
X_14252_ _14252_/Y _14638_/A _14285_/A _14251_/Y _14249_/X VPWR VGND sg13cmos5l_a22oi_1
X_10415_ _10415_/Y input8/X _10673_/B _10658_/A VPWR VGND sg13cmos5l_o21ai_1
X_13203_ _13297_/B _13177_/A _13179_/Y _13202_/Y VPWR VGND sg13cmos5l_o21ai_1
X_11395_ _11396_/A _11393_/C _11394_/Y _11393_/Y VPWR VGND sg13cmos5l_a21o_1
X_14183_ _14184_/B _14183_/A VPWR VGND sg13cmos5l_inv_1
X_13134_ _13235_/A _13133_/A _13134_/B VPWR VGND sg13cmos5l_nand2b_1
X_18991_ _18991_/Q clkload65/A _18991_/D _18991_/RESET_B VPWR VGND sg13cmos5l_dfrbpq_1
X_10346_ _17962_/B _19644_/Q VPWR VGND sg13cmos5l_inv_1
XFILLER_2_140 VPWR VGND sg13cmos5l_decap_8
X_10277_ _10277_/Y _18855_/Q VPWR VGND sg13cmos5l_inv_1
X_13065_ _13297_/A _15234_/A _13573_/B VPWR VGND sg13cmos5l_nor2_1
X_17942_ _19677_/D _17942_/A _17942_/B VPWR VGND sg13cmos5l_nor2_1
XFILLER_31_8 VPWR VGND sg13cmos5l_fill_2
X_12016_ _18781_/D _12200_/A _12016_/B VPWR VGND sg13cmos5l_nor2_1
X_17873_ _17873_/Y _17867_/A _17941_/B _17872_/Y VPWR VGND sg13cmos5l_a21oi_1
XFILLER_2_195 VPWR VGND sg13cmos5l_fill_2
X_16824_ _19505_/D _16825_/A _16824_/B VPWR VGND sg13cmos5l_nor2_1
X_19612_ _19612_/Q clkload26/A _19612_/D _19612_/RESET_B VPWR VGND sg13cmos5l_dfrbpq_1
X_19145__1106 _19145_/RESET_B VPWR VGND sg13cmos5l_tiehi
XFILLER_94_968 VPWR VGND sg13cmos5l_fill_1
X_16755_ _16755_/Y _16666_/B _16749_/Y _16828_/B _16757_/A VPWR VGND sg13cmos5l_a22oi_1
X_19543_ _19543_/Q clkload33/A _19543_/D _19543_/RESET_B VPWR VGND sg13cmos5l_dfrbpq_1
X_13967_ _13967_/Y _13967_/A _13967_/B VPWR VGND sg13cmos5l_xnor2_1
X_16686_ _16686_/Y _16791_/B _16791_/C _16791_/A VPWR VGND sg13cmos5l_a21oi_1
X_19474_ _19474_/Q clkload38/A _19474_/D _19474_/RESET_B VPWR VGND sg13cmos5l_dfrbpq_1
X_12918_ _12960_/B _13291_/A _12918_/B VPWR VGND sg13cmos5l_xnor2_1
X_15706_ _15706_/Y _15706_/A _15706_/B VPWR VGND sg13cmos5l_nor2_1
X_13898_ _13898_/Y _13472_/B _13920_/A _13891_/X _13506_/A VPWR VGND sg13cmos5l_a22oi_1
X_18425_ _18425_/X _18425_/A _18425_/B VPWR VGND sg13cmos5l_xor2_1
X_15637_ _15637_/Y _15631_/X _15821_/A _15636_/Y VPWR VGND sg13cmos5l_o21ai_1
X_12849_ _12849_/X _12849_/A _12849_/B VPWR VGND sg13cmos5l_and2_1
X_18356_ _18436_/C _19731_/Q _19692_/Q _19751_/Q VPWR VGND sg13cmos5l_nand3_1
X_15568_ _19325_/D _15747_/A _15698_/A VPWR VGND sg13cmos5l_and2_1
X_19359__877 _19359_/RESET_B VPWR VGND sg13cmos5l_tiehi
X_17307_ _17375_/B _17306_/Y _17489_/A _17313_/S VPWR VGND sg13cmos5l_mux2_1
X_18287_ _19729_/D _09969_/Y fanout67/X _18286_/Y VPWR VGND sg13cmos5l_a21oi_1
X_15499_ _15500_/A _15498_/C _15497_/Y _15498_/Y VPWR VGND sg13cmos5l_a21o_1
X_14519_ _14519_/Y _14519_/A _14519_/B VPWR VGND sg13cmos5l_xnor2_1
X_17238_ _17322_/A _17347_/A _17238_/B VPWR VGND sg13cmos5l_nand2_1
X_17169_ _17173_/C _17168_/B _17168_/C _17168_/A VPWR VGND sg13cmos5l_a21o_1
XFILLER_103_517 VPWR VGND sg13cmos5l_fill_2
X_09991_ _09991_/Y _09991_/A VPWR VGND sg13cmos5l_inv_1
Xhold3005 _18233_/B _18164_/Y VPWR VGND sg13cmos5l_dlygate4sd3_1
Xhold3038 _11722_/A _18695_/Q VPWR VGND sg13cmos5l_dlygate4sd3_1
Xhold3016 _10496_/B _19736_/Q VPWR VGND sg13cmos5l_dlygate4sd3_1
Xhold3027 _18301_/A _19696_/Q VPWR VGND sg13cmos5l_dlygate4sd3_1
Xhold3049 hold3049/X _19507_/Q VPWR VGND sg13cmos5l_dlygate4sd3_1
Xhold2337 _10379_/A _18573_/Q VPWR VGND sg13cmos5l_dlygate4sd3_1
Xhold2315 _10734_/A _18576_/Q VPWR VGND sg13cmos5l_dlygate4sd3_1
Xhold2304 _19475_/D _16615_/Y VPWR VGND sg13cmos5l_dlygate4sd3_1
Xhold2326 _10347_/A _19642_/Q VPWR VGND sg13cmos5l_dlygate4sd3_1
XFILLER_97_784 VPWR VGND sg13cmos5l_fill_1
Xhold2359 _10040_/A _18788_/Q VPWR VGND sg13cmos5l_dlygate4sd3_1
XFILLER_84_412 VPWR VGND sg13cmos5l_fill_1
XFILLER_56_103 VPWR VGND sg13cmos5l_fill_2
Xhold2348 hold2348/X _17429_/Y VPWR VGND sg13cmos5l_dlygate4sd3_1
XFILLER_29_328 VPWR VGND sg13cmos5l_decap_8
XFILLER_96_294 VPWR VGND sg13cmos5l_fill_2
XFILLER_85_979 VPWR VGND sg13cmos5l_fill_2
X_18948__1315 _18948_/RESET_B VPWR VGND sg13cmos5l_tiehi
X_19407__823 _19407_/RESET_B VPWR VGND sg13cmos5l_tiehi
XFILLER_84_478 VPWR VGND sg13cmos5l_fill_2
XFILLER_72_618 VPWR VGND sg13cmos5l_fill_1
X_18851__1421 _18851_/RESET_B VPWR VGND sg13cmos5l_tiehi
XFILLER_80_673 VPWR VGND sg13cmos5l_fill_2
X_19414__816 _19414_/RESET_B VPWR VGND sg13cmos5l_tiehi
XFILLER_4_427 VPWR VGND sg13cmos5l_fill_1
X_10200_ _16335_/A _10200_/A VPWR VGND sg13cmos5l_inv_1
X_11180_ _11180_/Y _10958_/Y _11172_/Y _11203_/B _10990_/B VPWR VGND sg13cmos5l_a22oi_1
XFILLER_106_377 VPWR VGND sg13cmos5l_fill_2
X_10131_ _16314_/A _10131_/A VPWR VGND sg13cmos5l_inv_1
X_10062_ _13285_/A _10062_/A VPWR VGND sg13cmos5l_inv_1
XFILLER_102_561 VPWR VGND sg13cmos5l_decap_8
Xhold2871 hold2871/X _10781_/B VPWR VGND sg13cmos5l_dlygate4sd3_1
Xhold2860 _12039_/A _18797_/Q VPWR VGND sg13cmos5l_dlygate4sd3_1
Xhold2893 _12679_/A _18879_/Q VPWR VGND sg13cmos5l_dlygate4sd3_1
XFILLER_48_659 VPWR VGND sg13cmos5l_fill_2
X_14870_ _14870_/Y _14870_/A _14876_/B _14870_/C VPWR VGND sg13cmos5l_nand3_1
Xhold2882 _14783_/A _19217_/Q VPWR VGND sg13cmos5l_dlygate4sd3_1
XFILLER_91_905 VPWR VGND sg13cmos5l_fill_2
X_19597__614 _19597_/RESET_B VPWR VGND sg13cmos5l_tiehi
X_13821_ _13821_/Y _18976_/Q _19080_/Q VPWR VGND sg13cmos5l_nand2b_1
X_19421__809 _19421_/RESET_B VPWR VGND sg13cmos5l_tiehi
XFILLER_29_851 VPWR VGND sg13cmos5l_fill_1
X_13752_ _13752_/Y _13752_/A _13752_/B _13784_/B VPWR VGND sg13cmos5l_nor3_1
X_16540_ _19449_/D hold2561/X fanout32/X _16539_/Y VPWR VGND sg13cmos5l_a21oi_1
XFILLER_28_372 VPWR VGND sg13cmos5l_fill_1
X_12703_ _12704_/B _12703_/A _12703_/B VPWR VGND sg13cmos5l_xor2_1
X_10964_ _11183_/A _11357_/A _10964_/B VPWR VGND sg13cmos5l_xnor2_1
X_13683_ _13683_/Y _19058_/Q _13684_/B VPWR VGND sg13cmos5l_xnor2_1
X_18210_ _18211_/B _18181_/Y _18178_/A _18212_/S VPWR VGND sg13cmos5l_mux2_1
X_10895_ _10928_/A _19781_/Q _10895_/B VPWR VGND sg13cmos5l_xnor2_1
X_16471_ _16471_/Y _16462_/X _16560_/B _16561_/B _16477_/B VPWR VGND sg13cmos5l_a22oi_1
X_12634_ _12642_/B _18890_/Q _12636_/B VPWR VGND sg13cmos5l_nor2b_1
XFILLER_54_1020 VPWR VGND sg13cmos5l_decap_8
X_15422_ _15422_/Y _15422_/A VPWR VGND sg13cmos5l_inv_1
X_19190_ _19190_/Q _19302_/CLK _19190_/D _19190_/RESET_B VPWR VGND sg13cmos5l_dfrbpq_1
X_12565_ _12565_/Y _12546_/B _12546_/C _12575_/B VPWR VGND sg13cmos5l_a21oi_1
X_15353_ _15544_/A _15359_/B _15353_/B VPWR VGND sg13cmos5l_nand2b_1
XFILLER_15_1026 VPWR VGND sg13cmos5l_fill_2
X_18141_ _18228_/B _18154_/B1 _18140_/Y _18139_/Y VPWR VGND sg13cmos5l_a21oi_1
X_11516_ _11518_/B _11898_/A _11519_/B VPWR VGND sg13cmos5l_and2_1
X_18072_ _18072_/Y _19714_/Q _18200_/B VPWR VGND sg13cmos5l_nor2_1
X_14304_ _14304_/Y _14304_/A _14310_/B VPWR VGND sg13cmos5l_nor2_1
X_17023_ _17023_/Y _17023_/A _17023_/B VPWR VGND sg13cmos5l_nor2_1
X_12496_ _12496_/Y _18853_/Q _12495_/Y _12491_/Y VPWR VGND sg13cmos5l_a21oi_1
X_15284_ _15284_/X _15284_/A _15303_/B VPWR VGND sg13cmos5l_or2_1
X_18686__1607 _18686_/RESET_B VPWR VGND sg13cmos5l_tiehi
X_11447_ _11447_/Y _11447_/A _11447_/B VPWR VGND sg13cmos5l_nor2_1
X_14235_ _14265_/B _19125_/Q _19126_/Q _19123_/Q _19124_/Q VPWR VGND sg13cmos5l_nor4_1
X_11378_ _11378_/Y _11378_/A _11378_/B VPWR VGND sg13cmos5l_nand2_1
X_14166_ _14166_/Y _19078_/Q _14167_/B VPWR VGND sg13cmos5l_xnor2_1
XFILLER_98_537 VPWR VGND sg13cmos5l_decap_8
X_13117_ _13117_/Y _13136_/C _13116_/Y VPWR VGND sg13cmos5l_nor2b_1
X_10329_ _10329_/Y _10329_/A VPWR VGND sg13cmos5l_inv_1
XFILLER_4_994 VPWR VGND sg13cmos5l_fill_1
X_18974_ _18974_/Q _18975_/CLK _18974_/D _18974_/RESET_B VPWR VGND sg13cmos5l_dfrbpq_1
X_14097_ _14097_/Y _19066_/Q _14094_/Y _14096_/Y VPWR VGND sg13cmos5l_o21ai_1
X_19506__711 _19506_/RESET_B VPWR VGND sg13cmos5l_tiehi
XFILLER_67_924 VPWR VGND sg13cmos5l_fill_2
X_13048_ _13048_/Y _18935_/Q _13044_/Y _13047_/Y _18934_/Q VPWR VGND sg13cmos5l_a22oi_1
X_17925_ _19661_/D _17884_/A _17917_/Y _17924_/Y VPWR VGND sg13cmos5l_a21oi_1
XFILLER_94_754 VPWR VGND sg13cmos5l_fill_2
XFILLER_67_968 VPWR VGND sg13cmos5l_fill_1
X_17856_ _17863_/A _17770_/B _17938_/B _17939_/B _17862_/A VPWR VGND sg13cmos5l_a22oi_1
XFILLER_22_1019 VPWR VGND sg13cmos5l_decap_8
X_16807_ _16807_/Y _16780_/X _16809_/S _16655_/A VPWR VGND sg13cmos5l_o21ai_1
X_17787_ _17787_/Y _19646_/Q _19607_/Q VPWR VGND sg13cmos5l_xnor2_1
X_16738_ _16825_/B _16735_/Y _16721_/X _16753_/A VPWR VGND sg13cmos5l_mux2_1
X_19526_ _19526_/Q clkload41/A _19526_/D _19526_/RESET_B VPWR VGND sg13cmos5l_dfrbpq_1
XFILLER_75_990 VPWR VGND sg13cmos5l_fill_1
X_19109__1145 _19109_/RESET_B VPWR VGND sg13cmos5l_tiehi
X_14999_ _14999_/Y _14986_/Y _14998_/Y _14983_/Y VPWR VGND sg13cmos5l_o21ai_1
XFILLER_90_960 VPWR VGND sg13cmos5l_decap_4
X_16669_ _19487_/D _16825_/A _16757_/A VPWR VGND sg13cmos5l_nor2_1
X_18632__1664 _18632_/RESET_B VPWR VGND sg13cmos5l_tiehi
X_19457_ _19457_/Q _19462_/CLK _19457_/D _19457_/RESET_B VPWR VGND sg13cmos5l_dfrbpq_1
XFILLER_22_515 VPWR VGND sg13cmos5l_fill_2
XFILLER_34_375 VPWR VGND sg13cmos5l_fill_1
XFILLER_98_0 VPWR VGND sg13cmos5l_fill_2
X_19388_ _19388_/Q clkload19/A _19388_/D _19388_/RESET_B VPWR VGND sg13cmos5l_dfrbpq_1
X_18408_ _18408_/X _18329_/B _18400_/Y _18407_/Y VPWR VGND sg13cmos5l_a21o_1
X_18339_ _19738_/D _18480_/A _18339_/B VPWR VGND sg13cmos5l_nor2_1
X_19513__704 _19513_/RESET_B VPWR VGND sg13cmos5l_tiehi
X_19615__441 _19615_/D VPWR VGND sg13cmos5l_tielo
Xhold2101 _10652_/B _19806_/Q VPWR VGND sg13cmos5l_dlygate4sd3_1
X_09974_ _09974_/Y _09974_/A VPWR VGND sg13cmos5l_inv_1
Xhold2112 _10188_/A _19745_/Q VPWR VGND sg13cmos5l_dlygate4sd3_1
Xhold2134 _10083_/A _19043_/Q VPWR VGND sg13cmos5l_dlygate4sd3_1
Xhold2123 hold2123/X _16881_/Y VPWR VGND sg13cmos5l_dlygate4sd3_1
XFILLER_57_401 VPWR VGND sg13cmos5l_fill_2
Xhold2145 _19639_/D _17722_/Y VPWR VGND sg13cmos5l_dlygate4sd3_1
Xhold2156 _18938_/D _13076_/Y VPWR VGND sg13cmos5l_dlygate4sd3_1
Xhold2167 _15764_/A _19313_/Q VPWR VGND sg13cmos5l_dlygate4sd3_1
Xhold2178 _10222_/A _19231_/Q VPWR VGND sg13cmos5l_dlygate4sd3_1
Xhold2189 _19766_/D _18527_/Y VPWR VGND sg13cmos5l_dlygate4sd3_1
XFILLER_55_59 VPWR VGND sg13cmos5l_fill_1
XFILLER_26_854 VPWR VGND sg13cmos5l_fill_2
XFILLER_81_971 VPWR VGND sg13cmos5l_decap_4
X_10680_ _10680_/Y _10680_/A _10680_/B _10680_/C _10680_/D VPWR VGND sg13cmos5l_nand4_1
XFILLER_53_695 VPWR VGND sg13cmos5l_decap_8
XFILLER_40_345 VPWR VGND sg13cmos5l_fill_1
X_12350_ _12350_/Y _12350_/A _12554_/A VPWR VGND sg13cmos5l_nand2_1
X_18815__1460 _18815_/RESET_B VPWR VGND sg13cmos5l_tiehi
XFILLER_5_703 VPWR VGND sg13cmos5l_fill_2
X_12281_ _12281_/Y _12307_/A _12281_/B VPWR VGND sg13cmos5l_nand2b_1
X_11301_ _11301_/Y _11325_/A _11362_/B _11363_/B _11302_/A VPWR VGND sg13cmos5l_a22oi_1
X_11232_ _11232_/Y _11232_/A _11232_/B _11330_/B VPWR VGND sg13cmos5l_nor3_1
X_14020_ _14020_/Y _14020_/A _14049_/B VPWR VGND sg13cmos5l_nor2_1
X_11163_ _11163_/Y _11352_/A _11160_/X _11161_/X _11190_/A VPWR VGND sg13cmos5l_a22oi_1
XFILLER_20_73 VPWR VGND sg13cmos5l_fill_1
XFILLER_106_185 VPWR VGND sg13cmos5l_fill_1
X_19185__1063 _19185_/RESET_B VPWR VGND sg13cmos5l_tiehi
X_10114_ _15740_/A _10114_/A VPWR VGND sg13cmos5l_inv_1
X_11094_ _11094_/Y _11621_/A _18600_/Q _18599_/Q _11620_/A VPWR VGND sg13cmos5l_a22oi_1
XFILLER_49_902 VPWR VGND sg13cmos5l_decap_4
X_15971_ _15971_/Y _15970_/A _15970_/B _15967_/A VPWR VGND sg13cmos5l_o21ai_1
XFILLER_102_380 VPWR VGND sg13cmos5l_fill_1
X_10045_ _12726_/A _10045_/A VPWR VGND sg13cmos5l_inv_1
XFILLER_88_581 VPWR VGND sg13cmos5l_fill_2
X_18690_ _18690_/Q _18733_/CLK _18690_/D _18690_/RESET_B VPWR VGND sg13cmos5l_dfrbpq_1
X_17710_ _17711_/A _17709_/C _17708_/Y _17709_/Y VPWR VGND sg13cmos5l_a21o_1
X_19349__887 _19349_/RESET_B VPWR VGND sg13cmos5l_tiehi
X_14922_ _14922_/Y _15457_/A _19189_/Q _19190_/Q _15458_/A _14921_/Y VPWR VGND sg13cmos5l_a221oi_1
X_17641_ _17641_/X _17646_/A _17661_/A VPWR VGND sg13cmos5l_and2_1
Xhold2690 hold2690/X _19011_/Q VPWR VGND sg13cmos5l_dlygate4sd3_1
X_14853_ _14853_/Y _14914_/B _14877_/B VPWR VGND sg13cmos5l_nor2_1
X_13804_ _19042_/D _13804_/A _13804_/B _13804_/C VPWR VGND sg13cmos5l_nor3_1
XFILLER_17_821 VPWR VGND sg13cmos5l_fill_2
X_11996_ _12023_/B _11984_/Y _11991_/X _11994_/Y VPWR VGND sg13cmos5l_o21ai_1
X_17572_ _17572_/Y _17937_/A _17572_/B VPWR VGND sg13cmos5l_xnor2_1
X_19311_ _19311_/Q clkload17/A _19311_/D _19311_/RESET_B VPWR VGND sg13cmos5l_dfrbpq_1
X_14784_ _14784_/Y _14784_/A _14784_/B VPWR VGND sg13cmos5l_xnor2_1
X_13735_ _13752_/A _13735_/A _13765_/B VPWR VGND sg13cmos5l_nor2_1
XFILLER_90_278 VPWR VGND sg13cmos5l_fill_1
X_10947_ _10984_/A _11354_/A _10947_/B VPWR VGND sg13cmos5l_xnor2_1
XFILLER_44_673 VPWR VGND sg13cmos5l_fill_1
X_16523_ _16523_/X _16511_/Y _16515_/Y _16522_/Y VPWR VGND sg13cmos5l_a21o_1
X_13666_ _13714_/A _19056_/Q _13666_/B VPWR VGND sg13cmos5l_xor2_1
XFILLER_91_1028 VPWR VGND sg13cmos5l_fill_1
X_19242_ _19242_/Q _19308_/CLK _19242_/D _19242_/RESET_B VPWR VGND sg13cmos5l_dfrbpq_1
X_16454_ _16465_/B _16454_/A _16467_/B VPWR VGND sg13cmos5l_nand2_1
XFILLER_32_846 VPWR VGND sg13cmos5l_fill_1
X_12617_ _12624_/B _18885_/Q _18886_/Q _18887_/Q _18888_/Q VPWR VGND sg13cmos5l_nor4_1
XFILLER_84_6 VPWR VGND sg13cmos5l_fill_2
X_10878_ _10878_/Y _10014_/Y fanout75/X _10877_/Y VPWR VGND sg13cmos5l_a21oi_1
X_15405_ _15428_/B _15405_/A _15405_/B VPWR VGND sg13cmos5l_nand2_1
X_19173_ _19173_/Q _19220_/CLK _19173_/D _19173_/RESET_B VPWR VGND sg13cmos5l_dfrbpq_1
X_13597_ _13598_/B _13588_/Y _13596_/Y _13587_/Y VPWR VGND sg13cmos5l_o21ai_1
Xclkbuf_4_14_0_clk clkbuf_4_14_0_clk/X clkbuf_0_clk/X VPWR VGND sg13cmos5l_buf_8
X_16385_ _16453_/C _16396_/A _16396_/B VPWR VGND sg13cmos5l_nand2_1
X_18124_ _18124_/Y _18124_/A _18124_/B _18124_/C VPWR VGND sg13cmos5l_nor3_1
X_12548_ _12548_/Y _12329_/B _12539_/Y _12546_/Y VPWR VGND sg13cmos5l_o21ai_1
X_15336_ _15383_/A _19305_/Q _19306_/Q _19307_/Q VPWR VGND sg13cmos5l_or3_1
X_12479_ _12479_/Y _18810_/Q _12479_/B VPWR VGND sg13cmos5l_nand2_1
X_15267_ _15270_/B _15455_/A _15267_/B VPWR VGND sg13cmos5l_nor2_1
X_18055_ _19695_/D _18233_/A _18055_/B VPWR VGND sg13cmos5l_nor2_1
X_17006_ _17188_/A _17006_/A _17179_/A VPWR VGND sg13cmos5l_or2_1
X_14218_ _14320_/C _14218_/A _14218_/B _19131_/Q VPWR VGND sg13cmos5l_nand3_1
X_15198_ _15199_/B _15738_/A _19230_/Q _19229_/Q _15737_/A VPWR VGND sg13cmos5l_a22oi_1
X_14149_ _14149_/Y _14149_/A _14165_/D _14149_/C VPWR VGND sg13cmos5l_nand3_1
X_18957_ _18957_/Q clkload67/A _18957_/D _18957_/RESET_B VPWR VGND sg13cmos5l_dfrbpq_1
X_18988__1272 _18988_/RESET_B VPWR VGND sg13cmos5l_tiehi
XFILLER_100_328 VPWR VGND sg13cmos5l_fill_2
X_17908_ _17909_/B _17874_/Y _17878_/Y _17879_/A VPWR VGND sg13cmos5l_a21oi_1
X_18888_ _18888_/Q clkload71/A _18888_/D _18888_/RESET_B VPWR VGND sg13cmos5l_dfrbpq_1
XFILLER_54_426 VPWR VGND sg13cmos5l_fill_1
X_17839_ _17839_/Y _17822_/Y _17870_/A _18010_/B _17865_/A VPWR VGND sg13cmos5l_a22oi_1
X_19704__1648 _19704_/RESET_B VPWR VGND sg13cmos5l_tiehi
XFILLER_70_908 VPWR VGND sg13cmos5l_fill_1
XFILLER_63_960 VPWR VGND sg13cmos5l_fill_2
X_19509_ _19509_/Q clkload39/A _19509_/D _19509_/RESET_B VPWR VGND sg13cmos5l_dfrbpq_1
XFILLER_63_971 VPWR VGND sg13cmos5l_fill_1
XFILLER_62_492 VPWR VGND sg13cmos5l_fill_1
XFILLER_50_632 VPWR VGND sg13cmos5l_fill_1
XFILLER_50_676 VPWR VGND sg13cmos5l_fill_2
XFILLER_23_879 VPWR VGND sg13cmos5l_fill_2
X_19587__624 _19587_/RESET_B VPWR VGND sg13cmos5l_tiehi
X_19411__819 _19411_/RESET_B VPWR VGND sg13cmos5l_tiehi
XFILLER_2_706 VPWR VGND sg13cmos5l_fill_2
X_19140__1111 _19140_/RESET_B VPWR VGND sg13cmos5l_tiehi
XFILLER_66_25 VPWR VGND sg13cmos5l_fill_1
XFILLER_45_415 VPWR VGND sg13cmos5l_fill_2
X_11850_ _11850_/Y _11850_/A VPWR VGND sg13cmos5l_inv_1
X_11781_ _11781_/Y _18744_/Q _18759_/Q VPWR VGND sg13cmos5l_nand2_1
X_10801_ _13651_/A _13649_/B _10801_/B VPWR VGND sg13cmos5l_or2_1
X_19594__617 _19594_/RESET_B VPWR VGND sg13cmos5l_tiehi
X_18713__1568 _18713_/RESET_B VPWR VGND sg13cmos5l_tiehi
XFILLER_32_109 VPWR VGND sg13cmos5l_decap_8
X_10732_ _10732_/Y fanout99/X _10731_/Y _10721_/Y VPWR VGND sg13cmos5l_o21ai_1
X_13520_ _13585_/B _13519_/S _13517_/X _13518_/Y VPWR VGND sg13cmos5l_a21oi_1
XFILLER_41_643 VPWR VGND sg13cmos5l_decap_8
XFILLER_41_610 VPWR VGND sg13cmos5l_decap_8
XFILLER_40_131 VPWR VGND sg13cmos5l_decap_4
X_10663_ _10663_/Y _10663_/A _10663_/B VPWR VGND sg13cmos5l_nand2_1
X_13451_ _13451_/Y _13539_/B _13555_/A _13451_/C VPWR VGND sg13cmos5l_nand3_1
XFILLER_51_1001 VPWR VGND sg13cmos5l_fill_1
XFILLER_15_95 VPWR VGND sg13cmos5l_fill_2
X_12402_ _12403_/B _12402_/A _12427_/B VPWR VGND sg13cmos5l_nand2_1
X_13382_ _13382_/Y _18952_/Q _13383_/B VPWR VGND sg13cmos5l_xnor2_1
X_16170_ _16171_/C _16170_/A _16170_/B VPWR VGND sg13cmos5l_or2_1
X_10594_ _10594_/Y _10583_/Y _10647_/A _10595_/A _10648_/A VPWR VGND sg13cmos5l_a22oi_1
X_12333_ _12368_/A _12333_/A _12333_/B VPWR VGND sg13cmos5l_xor2_1
X_15121_ _15121_/Y _15121_/A _15121_/B _15121_/C VPWR VGND sg13cmos5l_nor3_1
X_15052_ _15155_/B _15034_/A _15053_/B _15050_/Y VPWR VGND sg13cmos5l_a21oi_1
X_12264_ _12303_/A _18782_/Q _12278_/D VPWR VGND sg13cmos5l_xor2_1
X_14003_ _14003_/Y _14010_/B _14194_/A VPWR VGND sg13cmos5l_nand2_1
X_12195_ _18800_/D _12195_/A _12201_/A VPWR VGND sg13cmos5l_nor2_1
X_11215_ _11215_/Y _11213_/Y _11214_/Y _11212_/Y VPWR VGND sg13cmos5l_a21oi_1
X_18811_ _18811_/Q clkload63/A _18811_/D _18811_/RESET_B VPWR VGND sg13cmos5l_dfrbpq_1
X_11146_ _11146_/Y _10016_/Y fanout94/X _11145_/Y VPWR VGND sg13cmos5l_a21oi_1
X_19791_ _19791_/Q clkload20/A _19791_/D _19791_/RESET_B VPWR VGND sg13cmos5l_dfrbpq_1
X_18742_ _18742_/Q clkload39/A _18742_/D _18742_/RESET_B VPWR VGND sg13cmos5l_dfrbpq_1
XFILLER_96_849 VPWR VGND sg13cmos5l_fill_1
XFILLER_49_721 VPWR VGND sg13cmos5l_fill_1
X_11077_ _18623_/D _11091_/A _11077_/B _11077_/C VPWR VGND sg13cmos5l_nor3_1
X_15954_ _15954_/Y _15862_/B _16021_/B _15950_/Y VPWR VGND sg13cmos5l_a21oi_1
X_10028_ _11619_/A _11281_/A VPWR VGND sg13cmos5l_inv_1
X_18976__1287 _18976_/RESET_B VPWR VGND sg13cmos5l_tiehi
XFILLER_37_916 VPWR VGND sg13cmos5l_fill_2
X_14905_ _19215_/D _14905_/A _14909_/B VPWR VGND sg13cmos5l_and2_1
X_19503__714 _19503_/RESET_B VPWR VGND sg13cmos5l_tiehi
XFILLER_76_595 VPWR VGND sg13cmos5l_fill_1
X_18673_ _18673_/Q clkload58/A _18673_/D _18673_/RESET_B VPWR VGND sg13cmos5l_dfrbpq_1
XFILLER_49_787 VPWR VGND sg13cmos5l_fill_1
XFILLER_37_949 VPWR VGND sg13cmos5l_fill_1
X_15885_ _15885_/Y _15885_/A _15885_/B _15989_/B VPWR VGND sg13cmos5l_nor3_1
X_17624_ _17625_/B _17675_/B _17484_/B _17639_/B VPWR VGND sg13cmos5l_mux2_1
X_14836_ _14836_/Y _14747_/B _14829_/Y _14835_/A _14750_/B _14831_/Y VPWR VGND sg13cmos5l_a221oi_1
X_19362__873 _19362_/RESET_B VPWR VGND sg13cmos5l_tiehi
X_17555_ _17759_/A _17935_/A _17555_/B VPWR VGND sg13cmos5l_xnor2_1
X_14767_ _14772_/A _19216_/Q _14781_/B VPWR VGND sg13cmos5l_nand2_1
X_13718_ _13719_/A _16632_/A _16648_/A VPWR VGND sg13cmos5l_nand2_1
X_11979_ _11979_/Y _18740_/Q _11986_/D VPWR VGND sg13cmos5l_xnor2_1
X_16506_ _16506_/Y _16448_/A _16448_/B _16526_/B VPWR VGND sg13cmos5l_a21oi_1
X_17486_ _17488_/B _17298_/B _17494_/B _17485_/Y VPWR VGND sg13cmos5l_a21oi_1
XFILLER_60_952 VPWR VGND sg13cmos5l_fill_2
X_14698_ _14698_/Y _14684_/B _14690_/S _14909_/B VPWR VGND sg13cmos5l_o21ai_1
X_13649_ _19032_/D _13649_/A _13649_/B _13804_/A VPWR VGND sg13cmos5l_nor3_1
X_19225_ _19225_/Q clkload51/A _19225_/D _19225_/RESET_B VPWR VGND sg13cmos5l_dfrbpq_1
X_16437_ _16437_/X _19414_/Q _16437_/B VPWR VGND sg13cmos5l_xor2_1
X_16368_ _16368_/Y _16352_/A _16370_/B _16561_/A VPWR VGND sg13cmos5l_o21ai_1
X_19156_ _19156_/Q clkload42/A _19156_/D _19156_/RESET_B VPWR VGND sg13cmos5l_dfrbpq_1
X_19087_ _19087_/Q _19087_/CLK _19087_/D _19087_/RESET_B VPWR VGND sg13cmos5l_dfrbpq_1
X_15319_ _15418_/B _15331_/A _15331_/B VPWR VGND sg13cmos5l_nand2_1
X_18107_ _18300_/A _18475_/A _18107_/B VPWR VGND sg13cmos5l_xnor2_1
X_19510__707 _19510_/RESET_B VPWR VGND sg13cmos5l_tiehi
X_16299_ _16299_/Y _16276_/B fanout34/X _16308_/B VPWR VGND sg13cmos5l_o21ai_1
X_18038_ _18039_/B _18038_/A _18057_/B VPWR VGND sg13cmos5l_nor2_1
Xfanout306 _11891_/A _11899_/B VPWR VGND sg13cmos5l_buf_1
Xfanout317 _11351_/B _11131_/Y VPWR VGND sg13cmos5l_buf_1
Xfanout328 _18531_/A _18529_/A VPWR VGND sg13cmos5l_buf_1
Xfanout339 _16399_/D _19449_/Q VPWR VGND sg13cmos5l_buf_1
XFILLER_100_136 VPWR VGND sg13cmos5l_fill_2
XFILLER_67_540 VPWR VGND sg13cmos5l_fill_2
XFILLER_51_941 VPWR VGND sg13cmos5l_fill_1
X_18681__1612 _18681_/RESET_B VPWR VGND sg13cmos5l_tiehi
XFILLER_51_952 VPWR VGND sg13cmos5l_fill_1
X_19804__1752 _19804_/RESET_B VPWR VGND sg13cmos5l_tiehi
X_19339__897 _19339_/RESET_B VPWR VGND sg13cmos5l_tiehi
XFILLER_104_431 VPWR VGND sg13cmos5l_fill_1
XFILLER_81_1005 VPWR VGND sg13cmos5l_fill_2
X_18931__1335 _18931_/RESET_B VPWR VGND sg13cmos5l_tiehi
X_11000_ _11036_/C _11000_/A VPWR VGND sg13cmos5l_inv_1
X_19104__1150 _19104_/RESET_B VPWR VGND sg13cmos5l_tiehi
X_12951_ _12951_/Y _12846_/A _12846_/B _12957_/S _13130_/A _12949_/Y VPWR VGND sg13cmos5l_a221oi_1
XFILLER_19_949 VPWR VGND sg13cmos5l_fill_1
X_11902_ _18761_/D _11905_/A _11902_/B VPWR VGND sg13cmos5l_nor2_1
X_12882_ _12883_/B _12882_/A _12984_/B VPWR VGND sg13cmos5l_nand2_1
X_15670_ _15670_/Y _15644_/Y _15648_/Y _15669_/Y VPWR VGND sg13cmos5l_a21oi_1
X_11833_ _11833_/Y _12023_/A _11833_/B VPWR VGND sg13cmos5l_nand2b_1
X_14621_ _14634_/B _14513_/A _14513_/B _14614_/Y _14620_/Y VPWR VGND sg13cmos5l_a22oi_1
X_17340_ _17343_/A _17227_/Y _17347_/A _17340_/C VPWR VGND sg13cmos5l_nand3b_1
XFILLER_14_621 VPWR VGND sg13cmos5l_fill_1
X_11764_ _11872_/A _18757_/Q _11766_/B VPWR VGND sg13cmos5l_nor2_1
XFILLER_42_974 VPWR VGND sg13cmos5l_fill_2
X_14552_ _14552_/Y _14530_/Y _14546_/Y _14551_/Y VPWR VGND sg13cmos5l_o21ai_1
X_10715_ _10715_/Y _10709_/Y _10712_/Y _10714_/Y VPWR VGND sg13cmos5l_o21ai_1
X_11695_ _11737_/A _18698_/Q _11708_/D VPWR VGND sg13cmos5l_xor2_1
X_17271_ _17272_/A _19579_/Q _17271_/B VPWR VGND sg13cmos5l_xor2_1
X_18649__1645 _18649_/RESET_B VPWR VGND sg13cmos5l_tiehi
X_13503_ _13505_/D hold2690/X _13503_/B _13503_/C VPWR VGND sg13cmos5l_nand3b_1
X_14483_ _14580_/A _14297_/X _14473_/B _14487_/S _14482_/Y VPWR VGND sg13cmos5l_a22oi_1
X_13434_ _13452_/A _13435_/A _13450_/B VPWR VGND sg13cmos5l_or2_1
X_19010_ _19010_/Q clkload66/A _19010_/D _19010_/RESET_B VPWR VGND sg13cmos5l_dfrbpq_1
X_16222_ _16226_/C _16238_/A _16222_/B VPWR VGND sg13cmos5l_nand2_1
XFILLER_9_135 VPWR VGND sg13cmos5l_fill_1
X_10646_ _19802_/D _10646_/A _10646_/B VPWR VGND sg13cmos5l_and2_1
XFILLER_10_871 VPWR VGND sg13cmos5l_fill_1
X_16153_ _16280_/A _19428_/Q _16167_/B VPWR VGND sg13cmos5l_xnor2_1
X_13365_ _13373_/A _13365_/A _13381_/D _13365_/C VPWR VGND sg13cmos5l_nand3_1
X_15104_ _15104_/X _15104_/A _15121_/B VPWR VGND sg13cmos5l_or2_1
X_10577_ _10577_/X _18545_/A _10646_/A VPWR VGND sg13cmos5l_or2_1
X_12316_ _12331_/B _18831_/Q _18830_/Q _18829_/Q VPWR VGND sg13cmos5l_nor3_1
X_13296_ _18973_/D _13296_/A _13296_/B VPWR VGND sg13cmos5l_nor2_1
XFILLER_5_341 VPWR VGND sg13cmos5l_fill_2
X_16084_ _16104_/D _19369_/Q _19367_/Q _19368_/Q VPWR VGND sg13cmos5l_or3_1
X_12247_ _12247_/Y _12227_/B _12241_/S _12468_/A VPWR VGND sg13cmos5l_o21ai_1
X_15035_ _15154_/A _19260_/Q _15039_/B VPWR VGND sg13cmos5l_xnor2_1
X_12178_ _12178_/Y _12157_/B _12186_/S _12192_/B VPWR VGND sg13cmos5l_o21ai_1
X_16986_ _16986_/Y _19532_/Q _19547_/Q VPWR VGND sg13cmos5l_nand2_1
X_11129_ _11130_/B _18645_/Q _11127_/Y _11378_/B VPWR VGND sg13cmos5l_o21ai_1
X_19774_ _19774_/Q clkload21/A _19774_/D _19774_/RESET_B VPWR VGND sg13cmos5l_dfrbpq_1
XFILLER_95_178 VPWR VGND sg13cmos5l_fill_1
X_18725_ _18725_/Q clkload59/A _18725_/D _18725_/RESET_B VPWR VGND sg13cmos5l_dfrbpq_1
X_15937_ _16018_/B _15944_/C _15944_/D VPWR VGND sg13cmos5l_nand2_1
XFILLER_3_1027 VPWR VGND sg13cmos5l_fill_2
X_18656_ _18656_/Q clkload58/A _18656_/D _18656_/RESET_B VPWR VGND sg13cmos5l_dfrbpq_1
X_15868_ _15868_/Y _15866_/Y _15867_/Y _15865_/Y VPWR VGND sg13cmos5l_a21oi_1
X_17607_ _17607_/Y _17607_/A _17607_/B VPWR VGND sg13cmos5l_nor2_1
X_14819_ _14837_/B _15188_/A _14819_/B VPWR VGND sg13cmos5l_xnor2_1
X_18587_ _18587_/Q _18594_/CLK _18587_/D _18587_/RESET_B VPWR VGND sg13cmos5l_dfrbpq_1
X_19577__634 _19577_/RESET_B VPWR VGND sg13cmos5l_tiehi
X_15799_ _19358_/D _16022_/A _15799_/B VPWR VGND sg13cmos5l_nor2_1
X_17538_ _17552_/B _19619_/Q _17539_/B VPWR VGND sg13cmos5l_xnor2_1
X_17469_ _17469_/Y _17272_/A _17499_/A _17495_/B _17473_/A VPWR VGND sg13cmos5l_a22oi_1
XFILLER_80_0 VPWR VGND sg13cmos5l_fill_1
X_19208_ _19208_/Q _19262_/CLK _19208_/D _19208_/RESET_B VPWR VGND sg13cmos5l_dfrbpq_1
XFILLER_9_680 VPWR VGND sg13cmos5l_decap_4
X_19139_ _19139_/Q clkload49/A _19139_/D _19139_/RESET_B VPWR VGND sg13cmos5l_dfrbpq_1
X_19584__627 _19584_/RESET_B VPWR VGND sg13cmos5l_tiehi
Xfanout103 _14010_/B _14012_/S VPWR VGND sg13cmos5l_buf_1
XFILLER_102_946 VPWR VGND sg13cmos5l_fill_1
Xfanout147 _17522_/B _17506_/Y VPWR VGND sg13cmos5l_buf_1
Xfanout136 _13419_/B _13401_/B VPWR VGND sg13cmos5l_buf_1
Xfanout114 _17613_/B _17572_/Y VPWR VGND sg13cmos5l_buf_1
Xfanout125 _15951_/B _15923_/Y VPWR VGND sg13cmos5l_buf_1
Xfanout158 _16170_/B _16150_/Y VPWR VGND sg13cmos5l_buf_1
Xfanout169 _14516_/B _14496_/Y VPWR VGND sg13cmos5l_buf_1
X_19445__778 _19445_/RESET_B VPWR VGND sg13cmos5l_tiehi
XFILLER_82_351 VPWR VGND sg13cmos5l_fill_1
XFILLER_27_267 VPWR VGND sg13cmos5l_fill_2
XFILLER_42_215 VPWR VGND sg13cmos5l_fill_2
X_10500_ _10500_/Y _10573_/A _18384_/A _18380_/A _10565_/A VPWR VGND sg13cmos5l_a22oi_1
X_11480_ _11480_/Y _18691_/Q _18652_/Q VPWR VGND sg13cmos5l_nand2_1
X_19002__1258 _19002_/RESET_B VPWR VGND sg13cmos5l_tiehi
XFILLER_10_156 VPWR VGND sg13cmos5l_fill_2
X_18645__1651 _18645_/RESET_B VPWR VGND sg13cmos5l_tiehi
X_10431_ _10795_/C _10739_/B _10739_/A VPWR VGND sg13cmos5l_nor2b_1
X_10362_ _16848_/A _17110_/A VPWR VGND sg13cmos5l_inv_1
X_13150_ _13384_/A _13578_/A _13150_/B VPWR VGND sg13cmos5l_xnor2_1
X_12101_ _12291_/A _12456_/A _12287_/A VPWR VGND sg13cmos5l_nor2_1
X_10293_ _11926_/A _10293_/A VPWR VGND sg13cmos5l_inv_1
X_13081_ _13081_/Y hold2067/X fanout77/X _13284_/A VPWR VGND sg13cmos5l_o21ai_1
X_12032_ _12032_/Y _18773_/Q _18734_/Q VPWR VGND sg13cmos5l_xnor2_1
XFILLER_78_624 VPWR VGND sg13cmos5l_decap_4
X_16840_ _16840_/Y _19472_/Q _16849_/B VPWR VGND sg13cmos5l_nand2_1
X_16771_ _16793_/B _16756_/Y _16759_/Y _16770_/X VPWR VGND sg13cmos5l_a21oi_1
XFILLER_59_893 VPWR VGND sg13cmos5l_fill_1
X_13983_ _14016_/A _19085_/Q _13983_/B VPWR VGND sg13cmos5l_xor2_1
X_12934_ _12934_/Y _12934_/A _12954_/B VPWR VGND sg13cmos5l_nor2_1
X_18510_ _18511_/A _18514_/C _18508_/Y _18509_/Y VPWR VGND sg13cmos5l_a21o_1
X_15722_ _15722_/Y _15718_/A _15718_/B _15720_/Y _15713_/Y _15721_/Y VPWR VGND sg13cmos5l_a221oi_1
X_19490_ _19490_/Q _19546_/CLK _19490_/D _19490_/RESET_B VPWR VGND sg13cmos5l_dfrbpq_1
X_19500__717 _19500_/RESET_B VPWR VGND sg13cmos5l_tiehi
X_12865_ _12974_/A _18922_/Q _12879_/B VPWR VGND sg13cmos5l_xnor2_1
X_15653_ _15653_/Y _15653_/A _15671_/B VPWR VGND sg13cmos5l_nor2_1
X_18441_ _18441_/Y _18441_/A _18441_/B VPWR VGND sg13cmos5l_nor2_1
X_11816_ _11901_/B _11775_/Y _11833_/B _11815_/Y VPWR VGND sg13cmos5l_o21ai_1
X_12796_ _18903_/D _13284_/A _12796_/B VPWR VGND sg13cmos5l_and2_1
XFILLER_61_546 VPWR VGND sg13cmos5l_decap_4
X_15584_ _19329_/D _15748_/A _15584_/B VPWR VGND sg13cmos5l_nor2_1
X_14604_ _14607_/A _14604_/A VPWR VGND sg13cmos5l_inv_1
X_18372_ _18382_/B _19757_/Q _19758_/Q _19759_/Q VPWR VGND sg13cmos5l_or3_1
X_18762__1516 _18762_/RESET_B VPWR VGND sg13cmos5l_tiehi
X_11747_ _11747_/Y _18733_/Q _18694_/Q VPWR VGND sg13cmos5l_nand2_1
X_17323_ _17324_/B _17234_/A _17234_/B _17211_/Y VPWR VGND sg13cmos5l_a21oi_1
X_14535_ _14535_/Y _14537_/A _14537_/B VPWR VGND sg13cmos5l_nand2_1
XFILLER_105_1027 VPWR VGND sg13cmos5l_fill_2
XFILLER_105_1016 VPWR VGND sg13cmos5l_decap_8
X_17254_ _17256_/C _19575_/Q _17251_/Y _17252_/Y VPWR VGND sg13cmos5l_a21o_1
X_11678_ _11678_/Y _11658_/A _11672_/S _11680_/B1 VPWR VGND sg13cmos5l_o21ai_1
X_16205_ _16211_/B _16555_/A _16207_/B VPWR VGND sg13cmos5l_and2_1
X_14466_ _14478_/B _14456_/Y _14461_/Y _14489_/B _14468_/A _14463_/Y VPWR VGND sg13cmos5l_a221oi_1
XFILLER_30_988 VPWR VGND sg13cmos5l_fill_1
X_17185_ _17185_/Y _17186_/B VPWR VGND sg13cmos5l_inv_1
X_13417_ _13529_/A _13421_/A _13415_/Y _13413_/Y VPWR VGND sg13cmos5l_o21ai_1
X_10629_ _10629_/Y _11078_/B _15735_/A VPWR VGND sg13cmos5l_nand2b_1
X_14397_ _14397_/Y _19170_/Q _14380_/A VPWR VGND sg13cmos5l_nor2b_1
X_13348_ _18980_/D _13578_/B _13348_/B VPWR VGND sg13cmos5l_nor2_1
X_16136_ _16136_/Y _16136_/A _16136_/B VPWR VGND sg13cmos5l_nor2_1
XFILLER_52_4 VPWR VGND sg13cmos5l_fill_1
X_16067_ _16067_/Y _16037_/A _16063_/S _16318_/A VPWR VGND sg13cmos5l_o21ai_1
X_13279_ _18957_/D hold2940/X _13276_/S _13278_/Y VPWR VGND sg13cmos5l_a21oi_1
XFILLER_64_1011 VPWR VGND sg13cmos5l_fill_1
X_15018_ _15018_/X _15025_/S _15016_/Y _15015_/Y VPWR VGND sg13cmos5l_a21o_1
XFILLER_68_101 VPWR VGND sg13cmos5l_fill_2
Xhold2508 _10322_/A _19764_/Q VPWR VGND sg13cmos5l_dlygate4sd3_1
Xhold2519 _17986_/B _17985_/X VPWR VGND sg13cmos5l_dlygate4sd3_1
XFILLER_57_819 VPWR VGND sg13cmos5l_fill_1
Xhold1818 _16081_/B _19364_/Q VPWR VGND sg13cmos5l_dlygate4sd3_1
XFILLER_25_1028 VPWR VGND sg13cmos5l_fill_1
X_19718__1455 _19718_/RESET_B VPWR VGND sg13cmos5l_tiehi
Xhold1829 _18539_/B _19732_/Q VPWR VGND sg13cmos5l_dlygate4sd3_1
X_19757_ _19757_/Q clkload23/A _19757_/D _19757_/RESET_B VPWR VGND sg13cmos5l_dfrbpq_1
XFILLER_83_137 VPWR VGND sg13cmos5l_fill_1
X_18708_ _18708_/Q clkload40/A _18708_/D _18708_/RESET_B VPWR VGND sg13cmos5l_dfrbpq_1
X_16969_ _16996_/B _19535_/Q _19534_/Q _16982_/B VPWR VGND sg13cmos5l_nor3_1
XFILLER_92_660 VPWR VGND sg13cmos5l_fill_2
X_19688_ _19688_/Q clkload35/A _19688_/D _19688_/RESET_B VPWR VGND sg13cmos5l_dfrbpq_1
X_18639_ _18639_/Q clkload46/A _18639_/D _18639_/RESET_B VPWR VGND sg13cmos5l_dfrbpq_1
X_19299__940 _19299_/RESET_B VPWR VGND sg13cmos5l_tiehi
X_19538__448 _19538_/D VPWR VGND sg13cmos5l_tielo
XFILLER_52_579 VPWR VGND sg13cmos5l_fill_2
XFILLER_21_900 VPWR VGND sg13cmos5l_fill_2
X_18738__1540 _18738_/RESET_B VPWR VGND sg13cmos5l_tiehi
XFILLER_106_526 VPWR VGND sg13cmos5l_decap_8
X_18971__1292 _18971_/RESET_B VPWR VGND sg13cmos5l_tiehi
XFILLER_88_977 VPWR VGND sg13cmos5l_fill_1
XFILLER_102_776 VPWR VGND sg13cmos5l_fill_2
XFILLER_87_465 VPWR VGND sg13cmos5l_fill_1
X_10980_ _10982_/D _10989_/B _10989_/C _10978_/X VPWR VGND sg13cmos5l_a21o_1
X_19220__1025 _19220_/RESET_B VPWR VGND sg13cmos5l_tiehi
X_12650_ _12650_/Y _12685_/A _12645_/X _12731_/B _12682_/A VPWR VGND sg13cmos5l_a22oi_1
X_11601_ _11601_/X _11601_/A _11601_/B VPWR VGND sg13cmos5l_and2_1
X_12581_ _12581_/Y _18857_/Q _18818_/Q VPWR VGND sg13cmos5l_xnor2_1
X_19636__572 _19636_/RESET_B VPWR VGND sg13cmos5l_tiehi
XFILLER_11_421 VPWR VGND sg13cmos5l_decap_4
X_14320_ _14320_/Y _14320_/A _14320_/B _14320_/C VPWR VGND sg13cmos5l_nand3_1
X_11532_ _11555_/A _11534_/A _11534_/B VPWR VGND sg13cmos5l_nand2_1
X_11463_ _11463_/Y _11446_/X _11450_/Y _11285_/Y VPWR VGND sg13cmos5l_a21oi_1
X_14251_ _14251_/Y _19123_/Q _19138_/Q VPWR VGND sg13cmos5l_nand2_1
XFILLER_99_55 VPWR VGND sg13cmos5l_fill_1
XFILLER_99_33 VPWR VGND sg13cmos5l_fill_2
XFILLER_87_1011 VPWR VGND sg13cmos5l_fill_1
X_10414_ _21226_/A _10680_/A _10673_/B VPWR VGND sg13cmos5l_nand2b_1
X_13202_ _13202_/Y _13202_/A _13202_/B VPWR VGND sg13cmos5l_nand2_1
X_19430__800 _19430_/RESET_B VPWR VGND sg13cmos5l_tiehi
X_14182_ _14183_/A _14282_/A _14282_/B VPWR VGND sg13cmos5l_and2_1
X_11394_ _11394_/Y _11897_/A _18708_/Q VPWR VGND sg13cmos5l_nor2_1
X_13133_ _13200_/A _13133_/A _13134_/B VPWR VGND sg13cmos5l_nor2b_1
X_19567__644 _19567_/RESET_B VPWR VGND sg13cmos5l_tiehi
X_18990_ _18990_/Q clkload65/A _18990_/D _18990_/RESET_B VPWR VGND sg13cmos5l_dfrbpq_1
X_10345_ _10345_/Y _17954_/A VPWR VGND sg13cmos5l_inv_1
X_10276_ _12754_/B _18856_/Q VPWR VGND sg13cmos5l_inv_1
XFILLER_78_410 VPWR VGND sg13cmos5l_fill_1
X_13064_ _13064_/Y _13064_/A _13064_/B VPWR VGND sg13cmos5l_nor2_1
X_17941_ _19676_/D _17943_/A _17941_/B VPWR VGND sg13cmos5l_and2_1
XFILLER_3_697 VPWR VGND sg13cmos5l_fill_1
X_12015_ _12015_/Y _12016_/B VPWR VGND sg13cmos5l_inv_1
X_17872_ _17872_/Y _17904_/A _17942_/B VPWR VGND sg13cmos5l_nor2_1
X_16823_ _19504_/D _16823_/A _16823_/B VPWR VGND sg13cmos5l_nor2_1
X_19611_ _19611_/Q clkload25/A _19611_/D _19611_/RESET_B VPWR VGND sg13cmos5l_dfrbpq_1
X_19643__565 _19643_/RESET_B VPWR VGND sg13cmos5l_tiehi
X_16754_ _16828_/B _16712_/B _16731_/Y _16753_/Y VPWR VGND sg13cmos5l_a21oi_1
X_19542_ _19542_/Q clkload33/A _19542_/D _19542_/RESET_B VPWR VGND sg13cmos5l_dfrbpq_1
XFILLER_74_660 VPWR VGND sg13cmos5l_fill_1
X_13966_ _13966_/X _19098_/Q _13967_/B VPWR VGND sg13cmos5l_xor2_1
X_16685_ _16791_/C _19501_/Q _16785_/B _16786_/A VPWR VGND sg13cmos5l_o21ai_1
X_19473_ _19473_/Q clkload28/A _19473_/D _19473_/RESET_B VPWR VGND sg13cmos5l_dfrbpq_1
X_12917_ _13114_/A _18918_/Q _12918_/B VPWR VGND sg13cmos5l_xnor2_1
X_13897_ _13897_/X _13897_/A _13897_/B _13897_/C VPWR VGND sg13cmos5l_or3_1
X_15705_ _15705_/Y _15694_/Y _15696_/X _15706_/A _15706_/B VPWR VGND sg13cmos5l_a22oi_1
X_12848_ _18908_/D _13025_/A _12848_/B VPWR VGND sg13cmos5l_nor2_1
X_18424_ _18425_/B _19750_/Q _18349_/Y _18346_/Y VPWR VGND sg13cmos5l_a21oi_1
X_15636_ _15636_/Y _15656_/A _15634_/Y _15635_/Y _19333_/Q VPWR VGND sg13cmos5l_a22oi_1
X_19574__637 _19574_/RESET_B VPWR VGND sg13cmos5l_tiehi
X_12779_ _12779_/Y _12753_/A fanout50/X _13019_/B VPWR VGND sg13cmos5l_o21ai_1
X_18355_ _18436_/B _18366_/A _18369_/B VPWR VGND sg13cmos5l_nand2_1
X_15567_ _15698_/A _15374_/Y _15564_/A _15566_/Y VPWR VGND sg13cmos5l_o21ai_1
X_17306_ _17306_/Y _17306_/A _17316_/B VPWR VGND sg13cmos5l_nor2_1
X_18286_ _18286_/Y hold2019/X fanout67/X _18273_/B VPWR VGND sg13cmos5l_o21ai_1
X_14518_ _14519_/B _14518_/A _14609_/B VPWR VGND sg13cmos5l_nand2_1
X_15498_ _15498_/Y _16014_/A _19338_/Q _15498_/C VPWR VGND sg13cmos5l_nor3_1
X_18726__1555 _18726_/RESET_B VPWR VGND sg13cmos5l_tiehi
X_17237_ _17238_/B _17237_/A _17237_/B VPWR VGND sg13cmos5l_xor2_1
X_14449_ _14449_/Y _14457_/D _14441_/C _14441_/A VPWR VGND sg13cmos5l_a21oi_1
XFILLER_30_785 VPWR VGND sg13cmos5l_fill_2
X_17168_ _17174_/B _17168_/A _17168_/B _17168_/C VPWR VGND sg13cmos5l_nand3_1
X_19353__466 _19353_/D VPWR VGND sg13cmos5l_tielo
X_16119_ _16119_/X _19367_/Q _16136_/B VPWR VGND sg13cmos5l_or2_1
Xhold3006 _12280_/A _18784_/Q VPWR VGND sg13cmos5l_dlygate4sd3_1
X_17099_ _17099_/Y _19580_/Q _17110_/B _17098_/Y VPWR VGND sg13cmos5l_a21oi_1
XFILLER_43_0 VPWR VGND sg13cmos5l_fill_2
XFILLER_6_491 VPWR VGND sg13cmos5l_fill_2
X_09990_ _09990_/Y _15030_/A VPWR VGND sg13cmos5l_inv_1
XFILLER_103_529 VPWR VGND sg13cmos5l_decap_8
Xhold3039 hold3039/X _19033_/Q VPWR VGND sg13cmos5l_dlygate4sd3_1
Xhold3017 _13959_/B _19096_/Q VPWR VGND sg13cmos5l_dlygate4sd3_1
Xhold3028 _15929_/A _19395_/Q VPWR VGND sg13cmos5l_dlygate4sd3_1
X_19096__1158 _19096_/RESET_B VPWR VGND sg13cmos5l_tiehi
Xhold2316 hold2316/X _13598_/A VPWR VGND sg13cmos5l_dlygate4sd3_1
Xhold2327 _19642_/D _17728_/Y VPWR VGND sg13cmos5l_dlygate4sd3_1
Xhold2305 _18351_/A _19756_/Q VPWR VGND sg13cmos5l_dlygate4sd3_1
X_19809_ _19809_/Q clkload27/A _19809_/D _19809_/RESET_B VPWR VGND sg13cmos5l_dfrbpq_1
Xhold2349 _19601_/D _17430_/Y VPWR VGND sg13cmos5l_dlygate4sd3_1
Xhold2338 _13869_/B _19065_/Q VPWR VGND sg13cmos5l_dlygate4sd3_1
XFILLER_44_17 VPWR VGND sg13cmos5l_fill_1
XFILLER_80_630 VPWR VGND sg13cmos5l_fill_2
X_19670__1789 _19670_/RESET_B VPWR VGND sg13cmos5l_tiehi
X_10130_ _16313_/A _10130_/A VPWR VGND sg13cmos5l_inv_1
X_10061_ _13291_/A _10061_/A VPWR VGND sg13cmos5l_inv_1
Xhold2850 _18200_/A _19713_/Q VPWR VGND sg13cmos5l_dlygate4sd3_1
XFILLER_0_667 VPWR VGND sg13cmos5l_decap_8
Xhold2861 _12161_/C _12160_/Y VPWR VGND sg13cmos5l_dlygate4sd3_1
Xhold2872 _16966_/A _19543_/Q VPWR VGND sg13cmos5l_dlygate4sd3_1
Xhold2883 _14785_/B _14784_/Y VPWR VGND sg13cmos5l_dlygate4sd3_1
Xhold2894 _12681_/B _12680_/B VPWR VGND sg13cmos5l_dlygate4sd3_1
X_13820_ _13820_/Y _18977_/Q _19081_/Q VPWR VGND sg13cmos5l_nand2b_1
X_13751_ _13784_/B _19051_/Q _13751_/B VPWR VGND sg13cmos5l_and2_1
XFILLER_84_980 VPWR VGND sg13cmos5l_fill_2
X_10963_ _10990_/B _18624_/Q _10964_/B VPWR VGND sg13cmos5l_xnor2_1
X_12702_ _12703_/B _12702_/A _12702_/B VPWR VGND sg13cmos5l_or2_1
X_16470_ _16477_/B _16248_/X _16462_/S _16469_/Y VPWR VGND sg13cmos5l_a21oi_1
Xclkbuf_leaf_82_clk _19738_/CLK clkbuf_4_2_0_clk/X VPWR VGND sg13cmos5l_buf_8
X_13682_ _13693_/B _19058_/Q _13684_/B VPWR VGND sg13cmos5l_nor2b_1
XFILLER_70_151 VPWR VGND sg13cmos5l_decap_4
X_15421_ _15422_/A _15297_/B _15463_/B _15428_/B VPWR VGND sg13cmos5l_mux2_1
X_10894_ _10901_/B _19781_/Q _10895_/B VPWR VGND sg13cmos5l_nor2b_1
X_12633_ _12633_/Y _13021_/A _12633_/B VPWR VGND sg13cmos5l_xnor2_1
X_12564_ _12564_/Y _12551_/X _12553_/Y _12356_/Y VPWR VGND sg13cmos5l_a21oi_1
X_15352_ _15353_/B _19292_/Q _19291_/Q _19293_/Q VPWR VGND sg13cmos5l_o21ai_1
X_18140_ _18140_/Y _18140_/A _18159_/B VPWR VGND sg13cmos5l_nor2_1
X_11515_ _11519_/B _18706_/Q _18705_/Q _18704_/Q _11533_/B VPWR VGND sg13cmos5l_nor4_1
X_18071_ _18071_/Y _18069_/Y _18070_/Y _18068_/Y VPWR VGND sg13cmos5l_a21oi_1
X_15283_ _15283_/X _15279_/X _15281_/Y _15282_/Y VPWR VGND sg13cmos5l_a21o_1
X_14303_ _14303_/X _14303_/A _14303_/B VPWR VGND sg13cmos5l_and2_1
X_17022_ _17023_/B _17030_/A _17089_/B VPWR VGND sg13cmos5l_nor2_1
X_12495_ _12495_/Y _12495_/A VPWR VGND sg13cmos5l_inv_1
X_14234_ _14255_/B _19125_/Q _19123_/Q _19124_/Q VPWR VGND sg13cmos5l_nor3_1
X_19051__1206 _19051_/RESET_B VPWR VGND sg13cmos5l_tiehi
X_11446_ _11446_/X _11430_/Y _11442_/Y _11445_/X VPWR VGND sg13cmos5l_a21o_1
XFILLER_7_288 VPWR VGND sg13cmos5l_decap_4
X_11377_ _11387_/B _18646_/Q _11374_/Y _11376_/Y VPWR VGND sg13cmos5l_o21ai_1
X_14165_ _14171_/B _19078_/Q _19077_/Q _19076_/Q _14165_/D VPWR VGND sg13cmos5l_nor4_1
X_13116_ _13116_/Y _13116_/A _13136_/B VPWR VGND sg13cmos5l_nor2_1
X_18973_ _18973_/Q _18975_/CLK _18973_/D _18973_/RESET_B VPWR VGND sg13cmos5l_dfrbpq_1
X_10328_ _18502_/A _10328_/A VPWR VGND sg13cmos5l_inv_1
XFILLER_3_472 VPWR VGND sg13cmos5l_fill_2
X_14096_ _14096_/Y _19124_/Q _14643_/A _14114_/C VPWR VGND sg13cmos5l_nand3_1
X_13047_ _13047_/Y _12787_/A _13045_/X _13046_/Y _13056_/C VPWR VGND sg13cmos5l_a22oi_1
X_17924_ _17924_/Y _17884_/B _17928_/S _17943_/A VPWR VGND sg13cmos5l_o21ai_1
X_19289__950 _19289_/RESET_B VPWR VGND sg13cmos5l_tiehi
X_10259_ _10259_/Y _10259_/A VPWR VGND sg13cmos5l_inv_1
X_17855_ _17939_/B _18045_/A _17853_/Y _17871_/S VPWR VGND sg13cmos5l_mux2_1
X_16806_ _19491_/D _16774_/X _16809_/S _16805_/Y VPWR VGND sg13cmos5l_a21oi_1
X_17786_ _17786_/Y _19645_/Q _19606_/Q VPWR VGND sg13cmos5l_xnor2_1
X_16737_ _16737_/Y _16721_/X _16753_/A _16736_/Y VPWR VGND sg13cmos5l_a21oi_1
X_19525_ _19525_/Q clkload41/A _19525_/D _19525_/RESET_B VPWR VGND sg13cmos5l_dfrbpq_1
X_14998_ _14998_/Y _14986_/A _15024_/A _14988_/X _14996_/X _14997_/X VPWR VGND sg13cmos5l_a221oi_1
XFILLER_74_490 VPWR VGND sg13cmos5l_fill_2
XFILLER_46_192 VPWR VGND sg13cmos5l_fill_1
X_13949_ _13950_/B _13949_/A _13951_/B VPWR VGND sg13cmos5l_xor2_1
Xclkbuf_leaf_73_clk _19308_/CLK clkbuf_4_8_0_clk/X VPWR VGND sg13cmos5l_buf_8
X_16668_ _16757_/A _13719_/Y _16659_/S _16667_/Y VPWR VGND sg13cmos5l_o21ai_1
XFILLER_62_685 VPWR VGND sg13cmos5l_fill_1
X_19456_ _19456_/Q _19462_/CLK _19456_/D _19456_/RESET_B VPWR VGND sg13cmos5l_dfrbpq_1
X_16599_ _16601_/A _16860_/B _16596_/Y _16598_/Y _19475_/Q _16597_/Y VPWR VGND sg13cmos5l_a221oi_1
X_15619_ _15621_/B _19350_/Q _19351_/Q _15640_/B VPWR VGND sg13cmos5l_nor3_1
X_19387_ _19387_/Q clkload19/A _19387_/D _19387_/RESET_B VPWR VGND sg13cmos5l_dfrbpq_1
X_18407_ _18407_/Y _18320_/X _18330_/Y _18406_/A _18406_/B _18331_/Y VPWR VGND sg13cmos5l_a221oi_1
XFILLER_34_387 VPWR VGND sg13cmos5l_fill_1
X_19296__943 _19296_/RESET_B VPWR VGND sg13cmos5l_tiehi
X_18338_ _18338_/X _18340_/B _18336_/Y _18335_/Y VPWR VGND sg13cmos5l_a21o_1
X_18269_ _18271_/A _19726_/Q _18266_/Y _18268_/Y _19727_/Q _18267_/Y VPWR VGND sg13cmos5l_a221oi_1
X_19511__451 _19511_/D VPWR VGND sg13cmos5l_tielo
X_09973_ _09973_/Y _17223_/A VPWR VGND sg13cmos5l_inv_1
XFILLER_39_28 VPWR VGND sg13cmos5l_decap_8
Xhold2102 _10113_/A _19293_/Q VPWR VGND sg13cmos5l_dlygate4sd3_1
Xhold2124 _19517_/D _16882_/Y VPWR VGND sg13cmos5l_dlygate4sd3_1
Xhold2135 _13313_/A _18935_/Q VPWR VGND sg13cmos5l_dlygate4sd3_1
Xhold2113 _15210_/A _19229_/Q VPWR VGND sg13cmos5l_dlygate4sd3_1
Xhold2146 _11644_/A _18746_/Q VPWR VGND sg13cmos5l_dlygate4sd3_1
XFILLER_85_733 VPWR VGND sg13cmos5l_fill_1
X_19626__582 _19626_/RESET_B VPWR VGND sg13cmos5l_tiehi
XFILLER_58_958 VPWR VGND sg13cmos5l_fill_1
Xhold2157 _10097_/A _19167_/Q VPWR VGND sg13cmos5l_dlygate4sd3_1
Xhold2168 _19313_/D _15511_/Y VPWR VGND sg13cmos5l_dlygate4sd3_1
Xhold2179 _19231_/D _14965_/Y VPWR VGND sg13cmos5l_dlygate4sd3_1
XFILLER_29_104 VPWR VGND sg13cmos5l_fill_2
XFILLER_72_427 VPWR VGND sg13cmos5l_fill_1
X_19420__810 _19420_/RESET_B VPWR VGND sg13cmos5l_tiehi
Xclkbuf_leaf_64_clk clkload49/A clkbuf_4_10_0_clk/X VPWR VGND sg13cmos5l_buf_8
XFILLER_80_460 VPWR VGND sg13cmos5l_fill_1
XFILLER_13_549 VPWR VGND sg13cmos5l_fill_1
X_11300_ _11363_/B _11300_/A _11300_/B VPWR VGND sg13cmos5l_nor2_1
X_19633__575 _19633_/RESET_B VPWR VGND sg13cmos5l_tiehi
X_12280_ _12280_/X _12280_/A _12280_/B VPWR VGND sg13cmos5l_xor2_1
XFILLER_5_737 VPWR VGND sg13cmos5l_decap_4
XFILLER_4_214 VPWR VGND sg13cmos5l_fill_1
XFILLER_106_120 VPWR VGND sg13cmos5l_fill_1
X_11231_ _11330_/B _18673_/Q _11231_/B VPWR VGND sg13cmos5l_and2_1
XFILLER_106_164 VPWR VGND sg13cmos5l_decap_8
X_11162_ _11190_/A _18611_/Q _18612_/Q VPWR VGND sg13cmos5l_xor2_1
XFILLER_0_431 VPWR VGND sg13cmos5l_fill_1
X_10113_ _15739_/A _10113_/A VPWR VGND sg13cmos5l_inv_1
XFILLER_95_508 VPWR VGND sg13cmos5l_fill_2
X_19564__647 _19564_/RESET_B VPWR VGND sg13cmos5l_tiehi
X_11093_ _11093_/Y _11619_/A _18598_/Q _11092_/Y VPWR VGND sg13cmos5l_o21ai_1
X_15970_ _15970_/Y _15970_/A _15970_/B VPWR VGND sg13cmos5l_nor2_1
X_10044_ _12727_/A _10044_/A VPWR VGND sg13cmos5l_inv_1
X_14921_ _14921_/Y _19250_/Q _10229_/Y _14918_/Y _14919_/Y _14920_/Y VPWR VGND sg13cmos5l_a221oi_1
XFILLER_91_703 VPWR VGND sg13cmos5l_fill_2
X_17640_ _17661_/A _17678_/B _17639_/B _17639_/Y VPWR VGND sg13cmos5l_o21ai_1
Xhold2691 hold2691/X _13505_/D VPWR VGND sg13cmos5l_dlygate4sd3_1
X_14852_ _14871_/S _14846_/Y _14849_/Y _14850_/X VPWR VGND sg13cmos5l_a21o_1
Xhold2680 hold2680/X _16171_/Y VPWR VGND sg13cmos5l_dlygate4sd3_1
X_13803_ _13804_/C _13803_/A _13782_/A VPWR VGND sg13cmos5l_nor2b_1
Xhold1990 hold1990/X _18899_/Q VPWR VGND sg13cmos5l_dlygate4sd3_1
X_19640__568 _19640_/RESET_B VPWR VGND sg13cmos5l_tiehi
X_11995_ _11999_/A _11985_/Y _11990_/Y _12018_/B _11997_/A _11992_/Y VPWR VGND sg13cmos5l_a221oi_1
X_17571_ _17588_/B _19637_/Q _17571_/B VPWR VGND sg13cmos5l_xor2_1
Xclkbuf_leaf_55_clk _19087_/CLK clkbuf_4_12_0_clk/X VPWR VGND sg13cmos5l_buf_8
X_19310_ _19310_/Q clkload17/A _19310_/D _19310_/RESET_B VPWR VGND sg13cmos5l_dfrbpq_1
X_14783_ _14784_/B _14783_/A _14783_/B VPWR VGND sg13cmos5l_xnor2_1
X_13734_ _13734_/Y _13732_/Y _13733_/Y _13731_/Y VPWR VGND sg13cmos5l_a21oi_1
X_10946_ _10946_/Y _18621_/Q _10947_/B VPWR VGND sg13cmos5l_xnor2_1
X_16522_ _16522_/Y _16518_/Y _16520_/Y _16521_/X VPWR VGND sg13cmos5l_o21ai_1
X_13665_ _13673_/B _19053_/Q _19054_/Q _19055_/Q _19056_/Q VPWR VGND sg13cmos5l_nor4_1
X_10877_ _10877_/Y _19773_/Q fanout75/X _15735_/A VPWR VGND sg13cmos5l_o21ai_1
X_19241_ _19241_/Q _19308_/CLK _19241_/D _19241_/RESET_B VPWR VGND sg13cmos5l_dfrbpq_1
X_16453_ _16465_/A _16467_/B _16453_/B _16453_/C VPWR VGND sg13cmos5l_nand3b_1
X_18592__1707 _18592_/RESET_B VPWR VGND sg13cmos5l_tiehi
X_12616_ _12616_/Y _12652_/A _12652_/B _12651_/A VPWR VGND sg13cmos5l_nand3_1
X_15404_ _15404_/X _15405_/A _15405_/B VPWR VGND sg13cmos5l_and2_1
X_19172_ _19172_/Q _19220_/CLK _19172_/D _19172_/RESET_B VPWR VGND sg13cmos5l_dfrbpq_1
X_16384_ _16396_/B _19463_/Q _19464_/Q _19465_/Q VPWR VGND sg13cmos5l_o21ai_1
X_13596_ _13596_/Y _16822_/A _18575_/Q _18574_/Q _16821_/A _13595_/Y VPWR VGND sg13cmos5l_a221oi_1
XFILLER_61_70 VPWR VGND sg13cmos5l_decap_8
X_15335_ _15407_/A _15435_/A _15335_/B VPWR VGND sg13cmos5l_or2_1
XFILLER_31_379 VPWR VGND sg13cmos5l_fill_2
X_18123_ _18124_/C _18300_/A _18159_/A VPWR VGND sg13cmos5l_nor2_1
X_12547_ _12547_/Y _12543_/X _12545_/Y _12541_/Y VPWR VGND sg13cmos5l_a21oi_1
XFILLER_8_542 VPWR VGND sg13cmos5l_decap_8
X_12478_ _12479_/B _12469_/Y _12476_/Y _12477_/Y VPWR VGND sg13cmos5l_o21ai_1
X_15266_ _15267_/B _19248_/Q _19241_/Q VPWR VGND sg13cmos5l_or2_1
X_18054_ _18054_/Y _18054_/A _18054_/B VPWR VGND sg13cmos5l_nand2_1
X_17005_ _17086_/B hold2695/X _17182_/A _17020_/S VPWR VGND sg13cmos5l_mux2_1
X_11429_ _11429_/X _18657_/Q _11429_/B VPWR VGND sg13cmos5l_xor2_1
X_15197_ _15197_/Y _15351_/C _10224_/Y _10225_/Y _19290_/Q VPWR VGND sg13cmos5l_a22oi_1
X_14217_ _14320_/B _14229_/A _14229_/B VPWR VGND sg13cmos5l_nand2_1
X_14148_ _14148_/Y _14165_/D _14149_/C VPWR VGND sg13cmos5l_nand2_1
XFILLER_98_324 VPWR VGND sg13cmos5l_fill_2
X_18956_ _18956_/Q clkload67/A _18956_/D _18956_/RESET_B VPWR VGND sg13cmos5l_dfrbpq_1
X_19015__1245 _19015_/RESET_B VPWR VGND sg13cmos5l_tiehi
X_14079_ _19096_/D _14080_/A _14079_/B VPWR VGND sg13cmos5l_nor2_1
X_18887_ _18887_/Q clkload71/A _18887_/D _18887_/RESET_B VPWR VGND sg13cmos5l_dfrbpq_1
XFILLER_79_593 VPWR VGND sg13cmos5l_fill_2
X_17907_ _17907_/Y _17884_/Y _17901_/Y _17906_/Y VPWR VGND sg13cmos5l_o21ai_1
X_17838_ _17838_/Y _17832_/Y _17837_/Y _17828_/Y VPWR VGND sg13cmos5l_a21oi_1
Xclkbuf_leaf_46_clk clkload71/A clkload4/A VPWR VGND sg13cmos5l_buf_8
X_17769_ _17770_/B _17587_/B _17768_/Y _17781_/S VPWR VGND sg13cmos5l_mux2_1
X_19508_ _19508_/Q _19546_/CLK _19508_/D _19508_/RESET_B VPWR VGND sg13cmos5l_dfrbpq_1
XFILLER_63_983 VPWR VGND sg13cmos5l_decap_8
X_19439_ _19439_/Q clkload6/A _19439_/D _19439_/RESET_B VPWR VGND sg13cmos5l_dfrbpq_1
X_19237__1006 _19237_/RESET_B VPWR VGND sg13cmos5l_tiehi
X_19699__1722 _19699_/RESET_B VPWR VGND sg13cmos5l_tiehi
XFILLER_31_880 VPWR VGND sg13cmos5l_fill_2
XFILLER_104_679 VPWR VGND sg13cmos5l_fill_1
X_18818__1454 _18818_/RESET_B VPWR VGND sg13cmos5l_tiehi
XFILLER_106_99 VPWR VGND sg13cmos5l_fill_1
XFILLER_97_390 VPWR VGND sg13cmos5l_fill_2
XFILLER_58_755 VPWR VGND sg13cmos5l_fill_2
XFILLER_100_896 VPWR VGND sg13cmos5l_decap_4
XFILLER_46_939 VPWR VGND sg13cmos5l_decap_8
Xclkbuf_leaf_37_clk clkload57/A clkbuf_4_12_0_clk/X VPWR VGND sg13cmos5l_buf_8
X_19791__1765 _19791_/RESET_B VPWR VGND sg13cmos5l_tiehi
XFILLER_45_449 VPWR VGND sg13cmos5l_fill_1
XFILLER_45_438 VPWR VGND sg13cmos5l_fill_2
X_18982__501 _18982_/D VPWR VGND sg13cmos5l_tielo
X_19785__1189 _19785_/RESET_B VPWR VGND sg13cmos5l_tiehi
X_11780_ _11780_/X _11820_/A _11820_/B _11975_/A VPWR VGND sg13cmos5l_a21o_1
X_10800_ _10800_/Y _13649_/B _10801_/B VPWR VGND sg13cmos5l_nor2_1
X_18721__1560 _18721_/RESET_B VPWR VGND sg13cmos5l_tiehi
XFILLER_60_408 VPWR VGND sg13cmos5l_fill_2
X_10731_ _10731_/Y _10731_/A _10734_/A VPWR VGND sg13cmos5l_nor2_1
XFILLER_25_162 VPWR VGND sg13cmos5l_fill_1
X_13450_ _13451_/C _13450_/A _13450_/B VPWR VGND sg13cmos5l_or2_1
XFILLER_41_666 VPWR VGND sg13cmos5l_fill_1
XFILLER_40_143 VPWR VGND sg13cmos5l_decap_4
XFILLER_15_63 VPWR VGND sg13cmos5l_fill_1
X_12401_ _12436_/A _12382_/A _12398_/B _12399_/Y VPWR VGND sg13cmos5l_a21oi_1
X_10662_ _10663_/B _18562_/Q _18561_/Q _19808_/Q VPWR VGND sg13cmos5l_o21ai_1
X_13381_ _13388_/B _18952_/Q _18951_/Q _18950_/Q _13381_/D VPWR VGND sg13cmos5l_nor4_1
X_19091__1163 _19091_/RESET_B VPWR VGND sg13cmos5l_tiehi
XFILLER_21_390 VPWR VGND sg13cmos5l_fill_1
X_10593_ _10648_/A _10906_/A _10549_/B _10547_/X _10552_/A VPWR VGND sg13cmos5l_a22oi_1
X_12332_ _12337_/B _18847_/Q _12333_/B VPWR VGND sg13cmos5l_nor2b_1
X_15120_ _15120_/Y _15120_/A VPWR VGND sg13cmos5l_inv_1
X_19355__881 _19355_/RESET_B VPWR VGND sg13cmos5l_tiehi
X_12263_ _12276_/B _18781_/Q _18782_/Q _18779_/Q _18780_/Q VPWR VGND sg13cmos5l_nor4_1
X_15051_ _15162_/A _15034_/A _15053_/B _15050_/Y VPWR VGND sg13cmos5l_a21o_1
X_18943__1321 _18943_/RESET_B VPWR VGND sg13cmos5l_tiehi
X_11214_ _11214_/Y _18648_/Q _18609_/Q VPWR VGND sg13cmos5l_xnor2_1
X_14002_ _14194_/A _14002_/A _14177_/A VPWR VGND sg13cmos5l_nor2_1
XFILLER_5_567 VPWR VGND sg13cmos5l_decap_4
X_12194_ _18799_/D _12194_/A _12201_/A VPWR VGND sg13cmos5l_nor2_1
X_18810_ _18810_/Q clkload68/A _18810_/D _18810_/RESET_B VPWR VGND sg13cmos5l_dfrbpq_1
X_11145_ _11145_/Y _18647_/Q fanout94/X _11152_/A VPWR VGND sg13cmos5l_o21ai_1
X_19790_ _19790_/Q _19790_/CLK _19790_/D _19790_/RESET_B VPWR VGND sg13cmos5l_dfrbpq_1
X_18741_ _18741_/Q _18750_/CLK _18741_/D _18741_/RESET_B VPWR VGND sg13cmos5l_dfrbpq_1
X_11076_ _11077_/C _11076_/A _11076_/B VPWR VGND sg13cmos5l_and2_1
X_15953_ _16021_/B _15914_/A _15952_/A _15952_/Y VPWR VGND sg13cmos5l_o21ai_1
X_19286__953 _19286_/RESET_B VPWR VGND sg13cmos5l_tiehi
X_10027_ _11622_/A _10027_/A VPWR VGND sg13cmos5l_inv_1
X_14904_ _19214_/D _14904_/A _14915_/A VPWR VGND sg13cmos5l_nor2_1
XFILLER_76_585 VPWR VGND sg13cmos5l_fill_1
X_18672_ _18672_/Q clkload58/A _18672_/D _18672_/RESET_B VPWR VGND sg13cmos5l_dfrbpq_1
X_15884_ _15989_/B _19387_/Q _15884_/B VPWR VGND sg13cmos5l_and2_1
Xclkbuf_leaf_28_clk _19546_/CLK clkload1/A VPWR VGND sg13cmos5l_buf_8
X_17623_ _17625_/A _17645_/A _17623_/B VPWR VGND sg13cmos5l_nor2_1
XFILLER_56_81 VPWR VGND sg13cmos5l_fill_2
X_14835_ _14913_/B _14835_/A VPWR VGND sg13cmos5l_inv_1
X_11978_ _12018_/A _18740_/Q _11986_/D VPWR VGND sg13cmos5l_xor2_1
X_17554_ _17568_/B _19620_/Q _17555_/B VPWR VGND sg13cmos5l_xnor2_1
X_14766_ _14875_/B _14783_/A _14783_/B VPWR VGND sg13cmos5l_nand2_1
X_13717_ _13717_/Y _13651_/A _13817_/B _13716_/Y VPWR VGND sg13cmos5l_o21ai_1
XFILLER_72_791 VPWR VGND sg13cmos5l_fill_2
XFILLER_60_920 VPWR VGND sg13cmos5l_decap_8
X_10929_ _10930_/B _10928_/X _10584_/Y _10929_/S VPWR VGND sg13cmos5l_mux2_1
X_16505_ _16505_/Y _16532_/A _16505_/B VPWR VGND sg13cmos5l_nand2_1
X_17485_ _17485_/Y _17461_/D _17442_/C _17494_/B _17473_/A _17495_/B VPWR VGND sg13cmos5l_a221oi_1
X_19224_ _19224_/Q clkload51/A _19224_/D _19224_/RESET_B VPWR VGND sg13cmos5l_dfrbpq_1
X_14697_ _14697_/Y _14942_/A _14690_/S _14696_/Y VPWR VGND sg13cmos5l_a21oi_1
X_13648_ _19031_/D _13648_/A _13819_/A VPWR VGND sg13cmos5l_nor2_1
XFILLER_60_997 VPWR VGND sg13cmos5l_decap_8
X_16436_ _16436_/Y _19414_/Q _16437_/B VPWR VGND sg13cmos5l_xnor2_1
X_13579_ _19009_/D _13579_/A _13586_/A VPWR VGND sg13cmos5l_nor2_1
X_16367_ _16367_/Y _16555_/B _16367_/B VPWR VGND sg13cmos5l_nor2_1
X_19293__946 _19293_/RESET_B VPWR VGND sg13cmos5l_tiehi
X_19233__1012 _19233_/RESET_B VPWR VGND sg13cmos5l_tiehi
X_19155_ _19155_/Q clkload52/A _19155_/D _19155_/RESET_B VPWR VGND sg13cmos5l_dfrbpq_1
X_19616__592 _19616_/RESET_B VPWR VGND sg13cmos5l_tiehi
X_19086_ _19086_/Q clkload47/A _19086_/D _19086_/RESET_B VPWR VGND sg13cmos5l_dfrbpq_1
X_18106_ _18106_/Y _19704_/Q _18107_/B VPWR VGND sg13cmos5l_xnor2_1
X_16298_ _19417_/D _16277_/A fanout34/X _16297_/Y VPWR VGND sg13cmos5l_a21oi_1
X_15318_ _15418_/A _19300_/Q _15331_/B VPWR VGND sg13cmos5l_xnor2_1
X_18037_ _18056_/B _18024_/Y _18031_/X _18035_/Y VPWR VGND sg13cmos5l_o21ai_1
X_15249_ _15249_/Y _19277_/Q fanout92/X _15453_/A VPWR VGND sg13cmos5l_o21ai_1
X_19410__820 _19410_/RESET_B VPWR VGND sg13cmos5l_tiehi
Xfanout307 _11899_/B _11673_/A VPWR VGND sg13cmos5l_buf_1
Xfanout318 _11360_/A _11131_/Y VPWR VGND sg13cmos5l_buf_1
Xfanout329 _18529_/A _10629_/Y VPWR VGND sg13cmos5l_buf_1
X_18939_ _18939_/Q clkload66/A _18939_/D _18939_/RESET_B VPWR VGND sg13cmos5l_dfrbpq_1
XFILLER_67_530 VPWR VGND sg13cmos5l_fill_2
X_18806__1469 _18806_/RESET_B VPWR VGND sg13cmos5l_tiehi
X_19722__1369 _19722_/RESET_B VPWR VGND sg13cmos5l_tiehi
Xclkbuf_leaf_19_clk clkload27/A clkbuf_4_4_0_clk/X VPWR VGND sg13cmos5l_buf_8
X_19623__585 _19623_/RESET_B VPWR VGND sg13cmos5l_tiehi
XFILLER_54_224 VPWR VGND sg13cmos5l_fill_2
XFILLER_82_566 VPWR VGND sg13cmos5l_fill_2
XFILLER_36_972 VPWR VGND sg13cmos5l_fill_2
XFILLER_36_983 VPWR VGND sg13cmos5l_fill_2
XFILLER_23_622 VPWR VGND sg13cmos5l_fill_2
XFILLER_10_327 VPWR VGND sg13cmos5l_fill_1
X_19630__578 _19630_/RESET_B VPWR VGND sg13cmos5l_tiehi
XFILLER_81_1028 VPWR VGND sg13cmos5l_fill_1
Xclkbuf_4_13_0_clk clkload3/A clkbuf_0_clk/X VPWR VGND sg13cmos5l_buf_8
X_12950_ _13026_/B _12957_/S _13130_/A _12949_/Y VPWR VGND sg13cmos5l_a21o_1
X_11901_ _18760_/D _11905_/A _11901_/B VPWR VGND sg13cmos5l_nor2_1
X_12881_ _12998_/A _12881_/A _12881_/B VPWR VGND sg13cmos5l_nand2_1
X_11832_ _12023_/A _11989_/A _11997_/A VPWR VGND sg13cmos5l_nand2_1
X_14620_ _14620_/Y _14622_/A _14622_/B _14619_/Y VPWR VGND sg13cmos5l_a21oi_1
XFILLER_27_961 VPWR VGND sg13cmos5l_fill_1
X_14551_ _14551_/Y _14555_/A _14731_/A VPWR VGND sg13cmos5l_nand2_1
X_11763_ _11873_/A _18756_/Q _11766_/B _11762_/Y VPWR VGND sg13cmos5l_a21oi_1
X_10714_ _10714_/Y _10379_/A _10710_/Y _10713_/Y _10381_/A VPWR VGND sg13cmos5l_a22oi_1
X_11694_ _11705_/B _18697_/Q _18698_/Q _18695_/Q _18696_/Q VPWR VGND sg13cmos5l_nor4_1
X_17270_ _17277_/B _19579_/Q _17271_/B VPWR VGND sg13cmos5l_nor2b_1
X_13502_ _13505_/C _13512_/B _13512_/C _13501_/X VPWR VGND sg13cmos5l_o21ai_1
XFILLER_41_485 VPWR VGND sg13cmos5l_fill_1
XFILLER_14_699 VPWR VGND sg13cmos5l_fill_2
X_14482_ _14482_/Y _14482_/A _14489_/B VPWR VGND sg13cmos5l_nor2_1
X_13433_ _13546_/A _19008_/Q _13447_/B VPWR VGND sg13cmos5l_xnor2_1
XFILLER_41_496 VPWR VGND sg13cmos5l_fill_1
X_16221_ _16252_/S _16238_/A _16238_/B VPWR VGND sg13cmos5l_nand2_1
X_10645_ _19801_/D _10645_/A _18531_/A VPWR VGND sg13cmos5l_nor2_1
X_13364_ _13365_/C _18947_/Q _18948_/Q _18949_/Q VPWR VGND sg13cmos5l_o21ai_1
X_16152_ _16268_/A _16152_/A _16167_/B VPWR VGND sg13cmos5l_and2_1
X_12315_ _12364_/A _18846_/Q _12336_/D VPWR VGND sg13cmos5l_xnor2_1
X_15103_ _15103_/Y _15103_/A _15282_/A VPWR VGND sg13cmos5l_nand2_1
X_10576_ _10646_/A _10538_/Y _10923_/B _10585_/S VPWR VGND sg13cmos5l_mux2_1
X_13295_ _18972_/D _13296_/A _13295_/B VPWR VGND sg13cmos5l_nor2_1
XFILLER_54_8 VPWR VGND sg13cmos5l_fill_2
XFILLER_5_353 VPWR VGND sg13cmos5l_fill_2
X_16083_ _19408_/D _16549_/A _16159_/B VPWR VGND sg13cmos5l_and2_1
X_18882__1387 _18882_/RESET_B VPWR VGND sg13cmos5l_tiehi
X_12246_ _12246_/Y _12228_/A _12241_/S _12245_/Y VPWR VGND sg13cmos5l_a21oi_1
XFILLER_5_397 VPWR VGND sg13cmos5l_fill_2
X_15034_ _15050_/A _15034_/A _15053_/B VPWR VGND sg13cmos5l_nor2_1
X_12177_ _18786_/D hold2619/X _12186_/S _12176_/Y VPWR VGND sg13cmos5l_a21oi_1
X_19683__1776 _19683_/RESET_B VPWR VGND sg13cmos5l_tiehi
X_11128_ _11130_/A _10308_/A _11125_/Y _11127_/Y _18645_/Q _11126_/Y VPWR VGND sg13cmos5l_a221oi_1
XFILLER_3_44 VPWR VGND sg13cmos5l_fill_2
X_16985_ _16985_/Y _16985_/A VPWR VGND sg13cmos5l_inv_1
X_19773_ _19773_/Q clkload20/A _19773_/D _19773_/RESET_B VPWR VGND sg13cmos5l_dfrbpq_1
XFILLER_1_581 VPWR VGND sg13cmos5l_fill_1
X_18724_ _18724_/Q clkload59/A _18724_/D _18724_/RESET_B VPWR VGND sg13cmos5l_dfrbpq_1
XFILLER_64_500 VPWR VGND sg13cmos5l_fill_2
X_11059_ _11059_/Y _11059_/A _11059_/B VPWR VGND sg13cmos5l_nor2_1
X_15936_ _15944_/D _15926_/Y _15929_/X _16125_/A VPWR VGND sg13cmos5l_o21ai_1
XFILLER_97_1024 VPWR VGND sg13cmos5l_decap_4
X_18655_ _18655_/Q _19087_/CLK _18655_/D _18655_/RESET_B VPWR VGND sg13cmos5l_dfrbpq_1
X_15867_ _15867_/Y _19362_/Q _19323_/Q VPWR VGND sg13cmos5l_xnor2_1
X_17606_ _17606_/X _17759_/A _17766_/A VPWR VGND sg13cmos5l_and2_1
XFILLER_52_706 VPWR VGND sg13cmos5l_fill_1
X_14818_ _15004_/A _19212_/Q _14819_/B VPWR VGND sg13cmos5l_xnor2_1
X_18586_ _18586_/Q _18594_/CLK _18586_/D _18586_/RESET_B VPWR VGND sg13cmos5l_dfrbpq_1
XFILLER_52_739 VPWR VGND sg13cmos5l_fill_2
X_15798_ _15799_/B _15782_/Y _16052_/B _15798_/S VPWR VGND sg13cmos5l_mux2_1
XFILLER_18_983 VPWR VGND sg13cmos5l_fill_2
X_17537_ _17555_/B _19619_/Q _19618_/Q _17751_/A VPWR VGND sg13cmos5l_nor3_1
X_14749_ _14750_/B _14568_/X _14743_/B _14748_/Y VPWR VGND sg13cmos5l_a21oi_1
X_17468_ _17499_/B _19573_/Q _17468_/B VPWR VGND sg13cmos5l_xor2_1
X_16419_ _16457_/A _19411_/Q _19409_/Q _19410_/Q VPWR VGND sg13cmos5l_or3_1
X_19207_ _19207_/Q clkload51/A _19207_/D _19207_/RESET_B VPWR VGND sg13cmos5l_dfrbpq_1
X_17399_ _17400_/B _19560_/Q _17397_/Y _17398_/Y VPWR VGND sg13cmos5l_o21ai_1
X_19138_ _19138_/Q clkload49/A _19138_/D _19138_/RESET_B VPWR VGND sg13cmos5l_dfrbpq_1
XFILLER_106_708 VPWR VGND sg13cmos5l_decap_8
X_19069_ _19069_/Q clkload46/A _19069_/D _19069_/RESET_B VPWR VGND sg13cmos5l_dfrbpq_1
XFILLER_8_191 VPWR VGND sg13cmos5l_fill_2
Xclkbuf_leaf_8_clk clkload14/A clkbuf_4_1_0_clk/X VPWR VGND sg13cmos5l_buf_8
XFILLER_105_229 VPWR VGND sg13cmos5l_fill_1
Xfanout104 _12574_/B _12555_/X VPWR VGND sg13cmos5l_buf_1
XFILLER_102_903 VPWR VGND sg13cmos5l_decap_4
XFILLER_87_603 VPWR VGND sg13cmos5l_fill_1
X_18933__506 _18933_/D VPWR VGND sg13cmos5l_tielo
Xfanout115 _17607_/B _17588_/B VPWR VGND sg13cmos5l_buf_1
Xfanout137 _13202_/B _13393_/A VPWR VGND sg13cmos5l_buf_1
Xfanout126 _15856_/B _15860_/B VPWR VGND sg13cmos5l_buf_1
Xfanout148 _17526_/B _17506_/Y VPWR VGND sg13cmos5l_buf_1
Xfanout159 _15884_/B _15887_/B VPWR VGND sg13cmos5l_buf_1
XFILLER_55_544 VPWR VGND sg13cmos5l_fill_2
X_19345__891 _19345_/RESET_B VPWR VGND sg13cmos5l_tiehi
XFILLER_70_514 VPWR VGND sg13cmos5l_decap_4
XFILLER_10_124 VPWR VGND sg13cmos5l_fill_1
X_10430_ _10739_/B _10432_/C _10432_/D VPWR VGND sg13cmos5l_nand2_1
XFILLER_10_146 VPWR VGND sg13cmos5l_fill_2
X_19010__1250 _19010_/RESET_B VPWR VGND sg13cmos5l_tiehi
X_10361_ _10361_/Y _17106_/A VPWR VGND sg13cmos5l_inv_1
XFILLER_12_75 VPWR VGND sg13cmos5l_fill_1
X_12100_ _12111_/A _12083_/Y _12093_/Y _12098_/Y VPWR VGND sg13cmos5l_o21ai_1
X_10292_ _10292_/Y _10292_/A VPWR VGND sg13cmos5l_inv_1
X_13080_ _18941_/D _10004_/Y fanout77/X _13079_/Y VPWR VGND sg13cmos5l_a21oi_1
X_19352__884 _19352_/RESET_B VPWR VGND sg13cmos5l_tiehi
X_12031_ _12031_/Y _12043_/A _12043_/B VPWR VGND sg13cmos5l_nand2_1
XFILLER_2_345 VPWR VGND sg13cmos5l_fill_1
XFILLER_104_262 VPWR VGND sg13cmos5l_decap_8
XFILLER_104_284 VPWR VGND sg13cmos5l_fill_2
X_16770_ _16770_/X _16770_/A _16829_/B VPWR VGND sg13cmos5l_and2_1
X_18867__1402 _18867_/RESET_B VPWR VGND sg13cmos5l_tiehi
X_13982_ _13982_/Y _19085_/Q _13983_/B VPWR VGND sg13cmos5l_xnor2_1
X_12933_ _12938_/C _12933_/A _13121_/A VPWR VGND sg13cmos5l_nand2_1
XFILLER_58_382 VPWR VGND sg13cmos5l_fill_2
X_19283__956 _19283_/RESET_B VPWR VGND sg13cmos5l_tiehi
X_15721_ _15721_/Y _15721_/A _15721_/B _15721_/C VPWR VGND sg13cmos5l_nor3_1
XFILLER_19_736 VPWR VGND sg13cmos5l_fill_2
XFILLER_19_758 VPWR VGND sg13cmos5l_fill_2
X_18440_ _18440_/Y _18427_/Y _18430_/X _18441_/A _18441_/B VPWR VGND sg13cmos5l_a22oi_1
X_12864_ _12869_/A _18922_/Q _12879_/B VPWR VGND sg13cmos5l_and2_1
X_15652_ _15652_/Y _15644_/Y _15648_/Y _15617_/Y VPWR VGND sg13cmos5l_a21oi_1
XFILLER_33_227 VPWR VGND sg13cmos5l_fill_1
X_11815_ _11815_/Y _11827_/B _11827_/C _12006_/A VPWR VGND sg13cmos5l_o21ai_1
X_12795_ _18902_/D _12797_/A _12795_/B VPWR VGND sg13cmos5l_and2_1
X_18371_ _18423_/A _18452_/A _18371_/B VPWR VGND sg13cmos5l_or2_1
X_15583_ _15584_/B _15394_/X _15582_/C _15582_/Y VPWR VGND sg13cmos5l_a21oi_1
X_14603_ _14604_/A _14506_/B _14610_/B _14603_/C VPWR VGND sg13cmos5l_nand3b_1
X_11746_ _18742_/D _11904_/A _11841_/A VPWR VGND sg13cmos5l_and2_1
X_17322_ _17322_/X _17322_/A _17322_/B VPWR VGND sg13cmos5l_or2_1
X_14534_ _14537_/B _19179_/Q _19180_/Q hold2987/X VPWR VGND sg13cmos5l_o21ai_1
X_17253_ _17256_/B _17251_/Y _17668_/A VPWR VGND sg13cmos5l_nand2b_1
X_11677_ _11677_/Y _10292_/Y _11672_/S _11676_/Y VPWR VGND sg13cmos5l_a21oi_1
X_18995__500 _18995_/D VPWR VGND sg13cmos5l_tielo
X_16204_ _16213_/A _19436_/Q _16204_/B VPWR VGND sg13cmos5l_xor2_1
X_14465_ _14465_/Y _14266_/A _14489_/A _14489_/B _14468_/A VPWR VGND sg13cmos5l_a22oi_1
X_17184_ _17186_/B _17296_/A _17296_/B VPWR VGND sg13cmos5l_nand2_1
X_13416_ _13418_/B _13413_/A _13420_/B _13395_/Y _13415_/A VPWR VGND sg13cmos5l_a22oi_1
X_10628_ _10646_/B _15234_/A _11078_/B VPWR VGND sg13cmos5l_nor2_1
X_14396_ _14396_/Y _14396_/A _19108_/Q VPWR VGND sg13cmos5l_nor2_1
X_19613__595 _19613_/RESET_B VPWR VGND sg13cmos5l_tiehi
X_13347_ _13348_/B _13331_/Y _10259_/Y _13347_/S VPWR VGND sg13cmos5l_mux2_1
X_10559_ _10559_/Y _18496_/A _10575_/A VPWR VGND sg13cmos5l_nor2_1
X_16135_ _16138_/A _15946_/Y _16140_/B VPWR VGND sg13cmos5l_nand2b_1
X_19290__949 _19290_/RESET_B VPWR VGND sg13cmos5l_tiehi
X_13278_ _13278_/Y _13237_/B _13276_/S _13290_/B VPWR VGND sg13cmos5l_o21ai_1
XFILLER_6_695 VPWR VGND sg13cmos5l_fill_2
X_16066_ _19397_/D _16335_/A _16063_/S _16065_/Y VPWR VGND sg13cmos5l_a21oi_1
XFILLER_97_912 VPWR VGND sg13cmos5l_fill_1
X_12229_ _12229_/Y _12229_/A _12229_/B _12229_/C VPWR VGND sg13cmos5l_nor3_1
XFILLER_45_4 VPWR VGND sg13cmos5l_decap_8
X_15017_ _15019_/B _15025_/S _15016_/Y _15015_/Y VPWR VGND sg13cmos5l_a21oi_1
XFILLER_5_183 VPWR VGND sg13cmos5l_fill_2
XFILLER_97_934 VPWR VGND sg13cmos5l_fill_2
Xhold2509 _18523_/B _18522_/X VPWR VGND sg13cmos5l_dlygate4sd3_1
XFILLER_97_956 VPWR VGND sg13cmos5l_fill_1
XFILLER_69_669 VPWR VGND sg13cmos5l_fill_1
XFILLER_68_146 VPWR VGND sg13cmos5l_fill_1
X_16968_ _17032_/A _16967_/Y _17060_/A VPWR VGND sg13cmos5l_nand2b_1
Xhold1819 _17737_/B _19606_/Q VPWR VGND sg13cmos5l_dlygate4sd3_1
X_19756_ _19756_/Q _19756_/CLK _19756_/D _19756_/RESET_B VPWR VGND sg13cmos5l_dfrbpq_1
X_18707_ _18707_/Q clkload56/A _18707_/D _18707_/RESET_B VPWR VGND sg13cmos5l_dfrbpq_1
X_15919_ _15929_/B _19394_/Q _15920_/B VPWR VGND sg13cmos5l_nor2b_1
X_16899_ _16899_/Y _19490_/Q _19483_/Q VPWR VGND sg13cmos5l_nor2_1
X_19687_ _19687_/Q _19756_/CLK _19687_/D _19687_/RESET_B VPWR VGND sg13cmos5l_dfrbpq_1
XFILLER_91_160 VPWR VGND sg13cmos5l_fill_2
X_19620__588 _19620_/RESET_B VPWR VGND sg13cmos5l_tiehi
X_18638_ _18638_/Q clkload46/A _18638_/D _18638_/RESET_B VPWR VGND sg13cmos5l_dfrbpq_1
X_18569_ _18569_/Q _19814_/CLK _18569_/D _18569_/RESET_B VPWR VGND sg13cmos5l_dfrbpq_1
X_19590__621 _19590_/RESET_B VPWR VGND sg13cmos5l_tiehi
XFILLER_71_1027 VPWR VGND sg13cmos5l_fill_2
XFILLER_88_945 VPWR VGND sg13cmos5l_fill_2
XFILLER_87_411 VPWR VGND sg13cmos5l_fill_2
XFILLER_59_179 VPWR VGND sg13cmos5l_fill_1
XFILLER_28_511 VPWR VGND sg13cmos5l_fill_1
X_18855__1417 _18855_/RESET_B VPWR VGND sg13cmos5l_tiehi
X_12580_ _12580_/Y _18859_/Q _18820_/Q VPWR VGND sg13cmos5l_nand2_1
X_11600_ _11600_/Y _11587_/Y _11594_/Y _11599_/Y VPWR VGND sg13cmos5l_o21ai_1
X_11531_ _11534_/B _18717_/Q _18718_/Q hold2995/X VPWR VGND sg13cmos5l_o21ai_1
XFILLER_12_967 VPWR VGND sg13cmos5l_decap_8
X_11462_ _18696_/D _11479_/A _11462_/B VPWR VGND sg13cmos5l_nor2_1
X_18566__1740 _18566_/RESET_B VPWR VGND sg13cmos5l_tiehi
X_14250_ _14285_/A _19137_/Q _19138_/Q VPWR VGND sg13cmos5l_xor2_1
X_11393_ _11393_/Y _18646_/Q _11393_/B _11393_/C VPWR VGND sg13cmos5l_nor3_1
X_10413_ _19806_/D _10400_/A _10680_/D _10746_/A VPWR VGND sg13cmos5l_o21ai_1
X_13201_ _13201_/Y _13259_/A _13296_/B _13200_/Y VPWR VGND sg13cmos5l_o21ai_1
X_14181_ _14282_/B _14178_/A _14178_/B _14179_/Y VPWR VGND sg13cmos5l_o21ai_1
X_13132_ _13134_/B _13115_/A _13115_/B _13131_/Y VPWR VGND sg13cmos5l_o21ai_1
X_10344_ _17944_/B _17962_/A VPWR VGND sg13cmos5l_inv_1
X_18801__1474 _18801_/RESET_B VPWR VGND sg13cmos5l_tiehi
X_10275_ _10275_/Y _10275_/A VPWR VGND sg13cmos5l_inv_1
XFILLER_78_400 VPWR VGND sg13cmos5l_fill_2
X_13063_ _13064_/B _18939_/Q _13061_/Y _13328_/A VPWR VGND sg13cmos5l_o21ai_1
X_17940_ _19675_/D _17942_/A _17940_/B VPWR VGND sg13cmos5l_nor2_1
X_12014_ _12016_/B _12014_/A _12014_/B VPWR VGND sg13cmos5l_and2_1
XFILLER_79_978 VPWR VGND sg13cmos5l_decap_8
XFILLER_79_956 VPWR VGND sg13cmos5l_fill_2
X_17871_ _17942_/B _17869_/Y _17870_/Y _17871_/S VPWR VGND sg13cmos5l_mux2_1
XFILLER_2_197 VPWR VGND sg13cmos5l_fill_1
X_16822_ _19503_/D _16822_/A _16823_/B VPWR VGND sg13cmos5l_nor2_1
X_19610_ _19610_/Q clkload25/A _19610_/D _19610_/RESET_B VPWR VGND sg13cmos5l_dfrbpq_1
X_19541_ _19541_/Q clkload33/A _19541_/D _19541_/RESET_B VPWR VGND sg13cmos5l_dfrbpq_1
X_19171__1077 _19171_/RESET_B VPWR VGND sg13cmos5l_tiehi
X_16753_ _16753_/Y _16753_/A _16753_/B VPWR VGND sg13cmos5l_nor2_1
XFILLER_74_650 VPWR VGND sg13cmos5l_decap_4
X_13965_ _13974_/B _19095_/Q _19096_/Q _19097_/Q _19098_/Q VPWR VGND sg13cmos5l_nor4_1
XFILLER_19_555 VPWR VGND sg13cmos5l_fill_1
X_16684_ _16786_/A _16684_/A _16781_/A VPWR VGND sg13cmos5l_nand2_1
XFILLER_94_1027 VPWR VGND sg13cmos5l_fill_2
X_19472_ _19472_/Q clkload33/A _19472_/D _19472_/RESET_B VPWR VGND sg13cmos5l_dfrbpq_1
X_12916_ _12954_/B _18933_/Q _12916_/B VPWR VGND sg13cmos5l_xor2_1
X_13896_ _13897_/C _14072_/A _13912_/A VPWR VGND sg13cmos5l_nor2_1
X_15704_ _15706_/B _15577_/B _15745_/B _15710_/B VPWR VGND sg13cmos5l_mux2_1
X_12847_ _12847_/Y _12848_/B VPWR VGND sg13cmos5l_inv_1
X_18423_ _18423_/Y _18423_/A _18423_/B VPWR VGND sg13cmos5l_nor2_1
X_15635_ _15635_/Y _19348_/Q _19347_/Q _19332_/Q VPWR VGND sg13cmos5l_nand3b_1
X_19496__452 _19496_/D VPWR VGND sg13cmos5l_tielo
XFILLER_61_355 VPWR VGND sg13cmos5l_fill_1
X_18354_ _18436_/A _19752_/Q _18369_/B VPWR VGND sg13cmos5l_xnor2_1
X_17305_ _17489_/A _17455_/A _17309_/B VPWR VGND sg13cmos5l_and2_1
X_12778_ _12778_/Y _12757_/A fanout50/X _12777_/Y VPWR VGND sg13cmos5l_a21oi_1
X_15566_ _15566_/Y _15564_/A _15564_/B _15565_/Y VPWR VGND sg13cmos5l_o21ai_1
X_11729_ _18738_/D _11904_/A _11852_/A VPWR VGND sg13cmos5l_and2_1
X_18285_ _18285_/Y _18268_/Y hold2153/X _18483_/A VPWR VGND sg13cmos5l_a21oi_1
X_15497_ _15497_/Y _19276_/Q _15497_/B VPWR VGND sg13cmos5l_nor2_1
X_14517_ _14517_/Y _14602_/B _14610_/B _14517_/C VPWR VGND sg13cmos5l_nand3_1
X_17236_ _17237_/B _17236_/A _17339_/B VPWR VGND sg13cmos5l_nand2_1
X_14448_ _14448_/Y _19118_/Q _14457_/D VPWR VGND sg13cmos5l_xnor2_1
X_17167_ _17167_/Y _17160_/Y _17164_/Y _17166_/Y VPWR VGND sg13cmos5l_o21ai_1
X_16118_ _16118_/Y _16140_/B _16125_/C VPWR VGND sg13cmos5l_nand2_1
X_14379_ _14379_/Y _19102_/Q _19164_/Q VPWR VGND sg13cmos5l_nand2b_1
X_17098_ _17098_/Y _19579_/Q _10365_/Y _17121_/B _19578_/Q _17097_/Y VPWR VGND sg13cmos5l_a221oi_1
XFILLER_103_519 VPWR VGND sg13cmos5l_fill_1
XFILLER_69_411 VPWR VGND sg13cmos5l_fill_1
Xhold3007 _13474_/A _19015_/Q VPWR VGND sg13cmos5l_dlygate4sd3_1
Xhold3029 _11167_/A _18615_/Q VPWR VGND sg13cmos5l_dlygate4sd3_1
X_16049_ _16049_/Y _16047_/Y _16049_/B VPWR VGND sg13cmos5l_nand2b_1
Xhold3018 _14263_/A _19142_/Q VPWR VGND sg13cmos5l_dlygate4sd3_1
Xhold2317 hold2317/X _10729_/Y VPWR VGND sg13cmos5l_dlygate4sd3_1
Xhold2328 _10304_/A _18642_/Q VPWR VGND sg13cmos5l_dlygate4sd3_1
Xhold2306 _19746_/D _18467_/Y VPWR VGND sg13cmos5l_dlygate4sd3_1
XFILLER_96_241 VPWR VGND sg13cmos5l_fill_1
X_19808_ _19808_/Q clkload27/A _19808_/D _19808_/RESET_B VPWR VGND sg13cmos5l_dfrbpq_1
Xhold2339 hold2339/X _13869_/Y VPWR VGND sg13cmos5l_dlygate4sd3_1
XFILLER_38_831 VPWR VGND sg13cmos5l_fill_1
X_19739_ _19739_/Q clkload23/A _19739_/D _19739_/RESET_B VPWR VGND sg13cmos5l_dfrbpq_1
XFILLER_92_491 VPWR VGND sg13cmos5l_fill_1
X_19342__894 _19342_/RESET_B VPWR VGND sg13cmos5l_tiehi
XFILLER_52_399 VPWR VGND sg13cmos5l_fill_1
XFILLER_106_302 VPWR VGND sg13cmos5l_fill_1
XFILLER_106_346 VPWR VGND sg13cmos5l_fill_2
X_10060_ _13287_/A _10060_/A VPWR VGND sg13cmos5l_inv_1
XFILLER_0_624 VPWR VGND sg13cmos5l_fill_1
Xhold2840 hold2840/X _18409_/Y VPWR VGND sg13cmos5l_dlygate4sd3_1
Xhold2862 hold2862/X _12172_/A VPWR VGND sg13cmos5l_dlygate4sd3_1
Xhold2873 _17052_/C _17051_/Y VPWR VGND sg13cmos5l_dlygate4sd3_1
Xhold2851 _18202_/B _18201_/Y VPWR VGND sg13cmos5l_dlygate4sd3_1
Xhold2884 hold2884/X _14855_/A VPWR VGND sg13cmos5l_dlygate4sd3_1
Xhold2895 hold2895/X _19134_/Q VPWR VGND sg13cmos5l_dlygate4sd3_1
X_13750_ _13791_/A _13752_/A _13752_/B VPWR VGND sg13cmos5l_nand2_1
X_10962_ _10962_/Y _10965_/A _10960_/X _10961_/Y VPWR VGND sg13cmos5l_o21ai_1
XFILLER_44_812 VPWR VGND sg13cmos5l_fill_2
XFILLER_18_63 VPWR VGND sg13cmos5l_fill_1
X_19280__959 _19280_/RESET_B VPWR VGND sg13cmos5l_tiehi
X_12701_ _12708_/A _12672_/A _12674_/A _12667_/Y VPWR VGND sg13cmos5l_a21oi_1
X_13681_ _13681_/Y _13688_/A VPWR VGND sg13cmos5l_inv_1
XFILLER_70_130 VPWR VGND sg13cmos5l_decap_8
X_10893_ _10893_/Y _10536_/Y _10924_/A _10891_/X VPWR VGND sg13cmos5l_o21ai_1
X_15420_ _15420_/Y _15420_/A VPWR VGND sg13cmos5l_inv_1
X_12632_ _12818_/A _18875_/Q _12633_/B VPWR VGND sg13cmos5l_xnor2_1
X_12563_ _18864_/D _12579_/A _12682_/A VPWR VGND sg13cmos5l_and2_1
XFILLER_15_1028 VPWR VGND sg13cmos5l_fill_1
X_15351_ _15359_/B _19293_/Q _19292_/Q _15351_/C VPWR VGND sg13cmos5l_nor3_1
X_12494_ _12495_/A _12492_/Y _12494_/B VPWR VGND sg13cmos5l_nand2b_1
X_11514_ _11524_/B _18705_/Q _18704_/Q _11533_/B VPWR VGND sg13cmos5l_nor3_1
X_18070_ _18070_/Y _19688_/Q _19649_/Q VPWR VGND sg13cmos5l_xnor2_1
X_15282_ _15282_/Y _15282_/A _15303_/B VPWR VGND sg13cmos5l_nor2_1
X_14302_ _14302_/X _14302_/A _14302_/B VPWR VGND sg13cmos5l_or2_1
X_17021_ _17023_/A _17053_/A _17090_/B VPWR VGND sg13cmos5l_nor2_1
X_11445_ _11445_/X _11447_/A _11447_/B VPWR VGND sg13cmos5l_and2_1
X_14233_ _14240_/B _19123_/Q _19124_/Q VPWR VGND sg13cmos5l_nor2_1
X_19189__1059 _19189_/RESET_B VPWR VGND sg13cmos5l_tiehi
X_11376_ _11376_/Y _18704_/Q _11899_/A _11393_/C VPWR VGND sg13cmos5l_nand3_1
X_14164_ _14164_/Y _14164_/A _14199_/A VPWR VGND sg13cmos5l_nor2_1
XFILLER_106_880 VPWR VGND sg13cmos5l_fill_2
X_13115_ _13136_/C _13115_/A _13115_/B VPWR VGND sg13cmos5l_nor2_1
X_18972_ _18972_/Q _18975_/CLK _18972_/D _18972_/RESET_B VPWR VGND sg13cmos5l_dfrbpq_1
X_19610__598 _19610_/RESET_B VPWR VGND sg13cmos5l_tiehi
X_10327_ _11081_/A _10327_/A VPWR VGND sg13cmos5l_inv_1
X_14095_ _14114_/C _19128_/Q _14098_/B _14103_/B VPWR VGND sg13cmos5l_o21ai_1
X_13046_ _13046_/Y _13046_/A _18954_/Q VPWR VGND sg13cmos5l_nor2b_1
X_17923_ _19660_/D _17937_/B _17923_/B VPWR VGND sg13cmos5l_nor2_1
X_10258_ _10258_/Y _18981_/Q VPWR VGND sg13cmos5l_inv_1
XFILLER_79_786 VPWR VGND sg13cmos5l_fill_1
XFILLER_61_1026 VPWR VGND sg13cmos5l_fill_2
X_19580__631 _19580_/RESET_B VPWR VGND sg13cmos5l_tiehi
XFILLER_67_959 VPWR VGND sg13cmos5l_decap_8
X_10189_ _18264_/A _10189_/A VPWR VGND sg13cmos5l_inv_1
X_17854_ _18045_/A _18222_/A _17875_/B VPWR VGND sg13cmos5l_nand2_1
X_16805_ _16805_/Y _16768_/X _16809_/S _16655_/A VPWR VGND sg13cmos5l_o21ai_1
X_17785_ _17785_/Y _19647_/Q _19608_/Q VPWR VGND sg13cmos5l_nand2_1
X_14997_ _14997_/X _14997_/A _15021_/A VPWR VGND sg13cmos5l_and2_1
X_16736_ _16736_/Y _16753_/A _16736_/B VPWR VGND sg13cmos5l_nor2_1
X_19524_ _19524_/Q clkload28/A _19524_/D _19524_/RESET_B VPWR VGND sg13cmos5l_dfrbpq_1
X_13948_ _14052_/A hold2966/X _14050_/B _13946_/A _13947_/Y VPWR VGND sg13cmos5l_a22oi_1
XFILLER_62_631 VPWR VGND sg13cmos5l_decap_4
X_19455_ _21227_/A clkload10/A _19455_/D _19455_/RESET_B VPWR VGND sg13cmos5l_dfrbpq_1
XFILLER_34_333 VPWR VGND sg13cmos5l_decap_8
X_16667_ _16667_/Y _16632_/B _16664_/A _16659_/S VPWR VGND sg13cmos5l_o21ai_1
X_18406_ _18480_/B _18406_/A _18406_/B VPWR VGND sg13cmos5l_and2_1
X_13879_ _19072_/D _14636_/A _13929_/B VPWR VGND sg13cmos5l_and2_1
X_16598_ _16598_/Y _10148_/A _17085_/A _16578_/B _19023_/Q VPWR VGND sg13cmos5l_a22oi_1
X_15618_ _15640_/B _19347_/Q _19348_/Q _19349_/Q VPWR VGND sg13cmos5l_or3_1
X_19386_ _19386_/Q clkload19/A _19386_/D _19386_/RESET_B VPWR VGND sg13cmos5l_dfrbpq_1
X_15549_ _15549_/Y _15542_/Y _15543_/Y _15547_/Y VPWR VGND sg13cmos5l_o21ai_1
X_18337_ _18339_/B _18340_/B _18336_/Y _18335_/Y VPWR VGND sg13cmos5l_a21oi_1
X_18268_ _18268_/Y _19747_/Q _18246_/B _18243_/B _19685_/Q VPWR VGND sg13cmos5l_a22oi_1
X_17219_ _17339_/B _17219_/A _17221_/B VPWR VGND sg13cmos5l_nand2_1
X_18199_ _18206_/A _18169_/B _18180_/B _18164_/Y VPWR VGND sg13cmos5l_o21ai_1
X_19027__1231 _19027_/RESET_B VPWR VGND sg13cmos5l_tiehi
X_09972_ _09972_/Y _09972_/A VPWR VGND sg13cmos5l_inv_1
Xhold2103 _15185_/A _19209_/Q VPWR VGND sg13cmos5l_dlygate4sd3_1
Xhold2125 _10045_/A _18831_/Q VPWR VGND sg13cmos5l_dlygate4sd3_1
Xhold2136 _18935_/D _13070_/Y VPWR VGND sg13cmos5l_dlygate4sd3_1
Xhold2114 _10242_/A _19103_/Q VPWR VGND sg13cmos5l_dlygate4sd3_1
Xhold2169 _12519_/B _18855_/Q VPWR VGND sg13cmos5l_dlygate4sd3_1
Xhold2147 _10058_/A _18915_/Q VPWR VGND sg13cmos5l_dlygate4sd3_1
Xhold2158 _17672_/A _19579_/Q VPWR VGND sg13cmos5l_dlygate4sd3_1
X_18895__1374 _18895_/RESET_B VPWR VGND sg13cmos5l_tiehi
XFILLER_29_138 VPWR VGND sg13cmos5l_fill_2
XFILLER_41_815 VPWR VGND sg13cmos5l_fill_1
XFILLER_38_1028 VPWR VGND sg13cmos5l_fill_1
X_19754__870 _19754_/RESET_B VPWR VGND sg13cmos5l_tiehi
X_19144__1107 _19144_/RESET_B VPWR VGND sg13cmos5l_tiehi
X_11230_ _11232_/B _11331_/A _11330_/A VPWR VGND sg13cmos5l_nor2_1
X_11161_ _11161_/X _18611_/Q _18618_/Q VPWR VGND sg13cmos5l_or2_1
XFILLER_1_911 VPWR VGND sg13cmos5l_fill_1
X_10112_ _15454_/A _15103_/A VPWR VGND sg13cmos5l_inv_1
X_11092_ _11092_/Y _11110_/A _11437_/A VPWR VGND sg13cmos5l_nand2_1
X_10043_ _12456_/A _10043_/A VPWR VGND sg13cmos5l_inv_1
XFILLER_88_583 VPWR VGND sg13cmos5l_fill_1
XFILLER_49_948 VPWR VGND sg13cmos5l_decap_8
X_14920_ _14920_/Y _15457_/A _19189_/Q VPWR VGND sg13cmos5l_nor2_1
Xhold2670 _12149_/A _12148_/Y VPWR VGND sg13cmos5l_dlygate4sd3_1
XFILLER_75_233 VPWR VGND sg13cmos5l_fill_1
Xhold2692 _19011_/D _13581_/Y VPWR VGND sg13cmos5l_dlygate4sd3_1
X_14851_ _14877_/B _14846_/Y _14849_/Y _14850_/X VPWR VGND sg13cmos5l_a21oi_1
XFILLER_21_1010 VPWR VGND sg13cmos5l_fill_2
Xhold2681 _14516_/A _19172_/Q VPWR VGND sg13cmos5l_dlygate4sd3_1
X_13802_ _13804_/B _13802_/A _13803_/A VPWR VGND sg13cmos5l_nor2b_1
Xhold1980 hold1980/X _18731_/Q VPWR VGND sg13cmos5l_dlygate4sd3_1
X_17570_ _17570_/Y _17563_/Y _17613_/A _17568_/Y VPWR VGND sg13cmos5l_o21ai_1
XFILLER_57_992 VPWR VGND sg13cmos5l_decap_4
X_11994_ _11994_/Y _11800_/Y _12028_/A _12018_/B _11997_/A VPWR VGND sg13cmos5l_a22oi_1
X_14782_ _14782_/Y _14876_/B _14782_/B VPWR VGND sg13cmos5l_nand2_1
X_16521_ _16521_/X _16521_/A _16521_/B VPWR VGND sg13cmos5l_or2_1
XFILLER_28_182 VPWR VGND sg13cmos5l_fill_2
Xhold1991 _16307_/B _19381_/Q VPWR VGND sg13cmos5l_dlygate4sd3_1
X_13733_ _13733_/Y _19026_/Q _18581_/Q VPWR VGND sg13cmos5l_xnor2_1
X_10945_ _10952_/B _18621_/Q _18620_/Q _10945_/C VPWR VGND sg13cmos5l_nor3_1
X_13664_ _13664_/X _13666_/B _13664_/B _16641_/A VPWR VGND sg13cmos5l_and3_1
X_10876_ _18606_/D _10015_/Y fanout76/X _10875_/Y VPWR VGND sg13cmos5l_a21oi_1
X_16452_ _16452_/Y _16452_/A _16452_/B _16452_/C _16452_/D VPWR VGND sg13cmos5l_nand4_1
X_19240_ _19240_/Q _19302_/CLK _19240_/D _19240_/RESET_B VPWR VGND sg13cmos5l_dfrbpq_1
X_12615_ _12615_/Y _12647_/A _12613_/Y _12614_/Y _12625_/D _12611_/Y VPWR VGND sg13cmos5l_a221oi_1
X_15403_ _15405_/B _15403_/A _15466_/B VPWR VGND sg13cmos5l_or2_1
X_19171_ _19171_/Q clkload52/A _19171_/D _19171_/RESET_B VPWR VGND sg13cmos5l_dfrbpq_1
X_19735__1142 _19735_/RESET_B VPWR VGND sg13cmos5l_tiehi
X_16383_ _16414_/B _19469_/Q _16383_/B VPWR VGND sg13cmos5l_xor2_1
X_13595_ _13595_/Y _19041_/Q _10731_/A _10734_/B _19042_/Q _13594_/Y VPWR VGND sg13cmos5l_a221oi_1
X_15334_ _15335_/B _15334_/A _15334_/B VPWR VGND sg13cmos5l_xnor2_1
X_18122_ _18124_/B _18150_/A _18152_/A VPWR VGND sg13cmos5l_nor2_1
X_12546_ _12546_/Y _12546_/A _12546_/B _12546_/C VPWR VGND sg13cmos5l_nand3_1
X_18947__1316 _18947_/RESET_B VPWR VGND sg13cmos5l_tiehi
X_12477_ _12477_/Y _18876_/Q _12483_/B _18813_/Q _13021_/A VPWR VGND sg13cmos5l_a22oi_1
X_15265_ _15270_/A _15272_/B _15271_/C _15271_/A VPWR VGND sg13cmos5l_a21oi_1
X_18053_ _18055_/B _18054_/A _18054_/B VPWR VGND sg13cmos5l_and2_1
X_17004_ _17182_/A _17179_/A _17365_/A VPWR VGND sg13cmos5l_nand2b_1
X_11428_ _11474_/A _18657_/Q _11429_/B VPWR VGND sg13cmos5l_xnor2_1
X_15196_ _15196_/Y _19292_/Q _15196_/B VPWR VGND sg13cmos5l_nand2_1
X_14216_ _14320_/A _19132_/Q _14229_/B VPWR VGND sg13cmos5l_xnor2_1
X_11359_ _18676_/D _11363_/A _11359_/B VPWR VGND sg13cmos5l_nor2_1
X_14147_ _14149_/C _19073_/Q _19074_/Q _19075_/Q VPWR VGND sg13cmos5l_o21ai_1
XFILLER_4_782 VPWR VGND sg13cmos5l_decap_8
X_18850__1422 _18850_/RESET_B VPWR VGND sg13cmos5l_tiehi
X_19809__1579 _19809_/RESET_B VPWR VGND sg13cmos5l_tiehi
X_18955_ _18955_/Q clkload66/A _18955_/D _18955_/RESET_B VPWR VGND sg13cmos5l_dfrbpq_1
X_14078_ _19095_/D _14080_/A _14078_/B VPWR VGND sg13cmos5l_nor2_1
X_18886_ _18886_/Q clkload71/A _18886_/D _18886_/RESET_B VPWR VGND sg13cmos5l_dfrbpq_1
X_13029_ _13029_/Y _18955_/Q _13041_/A _12757_/A _18954_/Q VPWR VGND sg13cmos5l_a22oi_1
X_17906_ _17906_/Y _17914_/A _17914_/B VPWR VGND sg13cmos5l_nand2_1
XFILLER_6_1026 VPWR VGND sg13cmos5l_fill_2
X_17837_ _17837_/Y _17837_/A _17837_/B _18012_/A VPWR VGND sg13cmos5l_nand3_1
XFILLER_48_970 VPWR VGND sg13cmos5l_decap_4
X_17768_ _17768_/Y _17768_/A _17780_/B VPWR VGND sg13cmos5l_nor2_1
X_19404__828 _19404_/RESET_B VPWR VGND sg13cmos5l_tiehi
XFILLER_35_631 VPWR VGND sg13cmos5l_fill_2
X_19507_ _19507_/Q _19546_/CLK _19507_/D _19507_/RESET_B VPWR VGND sg13cmos5l_dfrbpq_1
X_16719_ _16719_/Y _16742_/A _16742_/B _16897_/A VPWR VGND sg13cmos5l_nand3_1
X_17699_ _17699_/Y _17699_/A VPWR VGND sg13cmos5l_inv_1
XFILLER_90_781 VPWR VGND sg13cmos5l_fill_1
X_19438_ _19438_/Q clkload5/A _19438_/D _19438_/RESET_B VPWR VGND sg13cmos5l_dfrbpq_1
X_19369_ _19369_/Q clkload8/A _19369_/D _19369_/RESET_B VPWR VGND sg13cmos5l_dfrbpq_1
XFILLER_50_678 VPWR VGND sg13cmos5l_fill_1
XFILLER_58_701 VPWR VGND sg13cmos5l_decap_4
XFILLER_103_179 VPWR VGND sg13cmos5l_fill_1
XFILLER_100_886 VPWR VGND sg13cmos5l_fill_2
XFILLER_85_586 VPWR VGND sg13cmos5l_fill_2
X_18685__1608 _18685_/RESET_B VPWR VGND sg13cmos5l_tiehi
XFILLER_54_962 VPWR VGND sg13cmos5l_fill_2
X_10730_ _18572_/D _10708_/Y fanout99/X hold2317/X VPWR VGND sg13cmos5l_a21oi_1
X_10661_ _18562_/D _10683_/A _10661_/B VPWR VGND sg13cmos5l_nor2_1
X_12400_ _12419_/A _18842_/Q _12398_/B _12399_/Y VPWR VGND sg13cmos5l_a21o_1
X_19279__961 _19279_/RESET_B VPWR VGND sg13cmos5l_tiehi
X_19570__641 _19570_/RESET_B VPWR VGND sg13cmos5l_tiehi
X_13380_ _13380_/Y _13373_/X _13374_/Y _13378_/Y VPWR VGND sg13cmos5l_o21ai_1
XFILLER_21_380 VPWR VGND sg13cmos5l_fill_1
X_10592_ _10595_/A _10592_/A _10592_/B VPWR VGND sg13cmos5l_or2_1
X_12331_ _12334_/A _18832_/Q _12331_/B VPWR VGND sg13cmos5l_xnor2_1
X_12262_ _12278_/D _18781_/Q _18779_/Q _18780_/Q VPWR VGND sg13cmos5l_or3_1
X_15050_ _15050_/Y _15050_/A _15050_/B _15160_/B VPWR VGND sg13cmos5l_nor3_1
XFILLER_103_0 VPWR VGND sg13cmos5l_fill_1
X_11213_ _11213_/Y _18647_/Q _18608_/Q VPWR VGND sg13cmos5l_xnor2_1
X_14001_ _14001_/Y _13916_/B _13996_/Y _14000_/Y _13919_/B _13997_/Y VPWR VGND sg13cmos5l_a221oi_1
X_19108__1146 _19108_/RESET_B VPWR VGND sg13cmos5l_tiehi
X_12193_ _18798_/D _12193_/A _12201_/A VPWR VGND sg13cmos5l_nor2_1
X_18631__1665 _18631_/RESET_B VPWR VGND sg13cmos5l_tiehi
XFILLER_96_807 VPWR VGND sg13cmos5l_fill_2
X_11144_ _18645_/D _11127_/Y hold2463/X _11355_/B VPWR VGND sg13cmos5l_a21oi_1
XFILLER_103_680 VPWR VGND sg13cmos5l_fill_2
X_18740_ _18740_/Q _18750_/CLK _18740_/D _18740_/RESET_B VPWR VGND sg13cmos5l_dfrbpq_1
X_11075_ _11077_/B _11075_/A _11076_/B VPWR VGND sg13cmos5l_nor2_1
X_15952_ _15952_/Y _15952_/A _16140_/A VPWR VGND sg13cmos5l_nand2_1
X_10026_ _11899_/A _10026_/A VPWR VGND sg13cmos5l_inv_1
X_18671_ _18671_/Q clkload58/A _18671_/D _18671_/RESET_B VPWR VGND sg13cmos5l_dfrbpq_1
X_14903_ _19213_/D _15453_/A _14903_/B VPWR VGND sg13cmos5l_and2_1
X_17622_ _17623_/B _17622_/A _17622_/B VPWR VGND sg13cmos5l_xnor2_1
XFILLER_37_918 VPWR VGND sg13cmos5l_fill_1
X_15883_ _15885_/B _15990_/A _15989_/A VPWR VGND sg13cmos5l_nor2_1
X_14834_ _14835_/A _14843_/S _14832_/Y _14833_/Y VPWR VGND sg13cmos5l_o21ai_1
X_11977_ _11982_/B _18739_/Q _18740_/Q _18737_/Q _18738_/Q VPWR VGND sg13cmos5l_nor4_1
X_17553_ _17566_/B _19619_/Q _19620_/Q _19618_/Q _17751_/A VPWR VGND sg13cmos5l_nor4_1
X_14765_ _14875_/A _14765_/A _14783_/B VPWR VGND sg13cmos5l_xnor2_1
X_13716_ _13716_/Y _13716_/A _13716_/B _13716_/C VPWR VGND sg13cmos5l_nand3_1
X_17484_ _19610_/D _17678_/A _17484_/B VPWR VGND sg13cmos5l_nor2_1
X_10928_ _10928_/X _10928_/A _10928_/B VPWR VGND sg13cmos5l_or2_1
X_16504_ _16504_/X _16504_/A _16504_/B VPWR VGND sg13cmos5l_xor2_1
XFILLER_60_954 VPWR VGND sg13cmos5l_fill_1
X_19223_ _19223_/Q clkload51/A _19223_/D _19223_/RESET_B VPWR VGND sg13cmos5l_dfrbpq_1
X_16435_ _16443_/B _19414_/Q _16437_/B VPWR VGND sg13cmos5l_nor2b_1
X_14696_ _14696_/Y _14676_/A _14690_/S _14909_/B VPWR VGND sg13cmos5l_o21ai_1
X_13647_ _19046_/D _13647_/A _13813_/B VPWR VGND sg13cmos5l_and2_1
X_10859_ _10859_/Y _10859_/A _11350_/B VPWR VGND sg13cmos5l_nor2_1
X_13578_ _19008_/D _13578_/A _13578_/B VPWR VGND sg13cmos5l_nor2_1
XFILLER_9_852 VPWR VGND sg13cmos5l_fill_2
X_16366_ _16366_/X _16347_/Y _09983_/Y _16370_/B VPWR VGND sg13cmos5l_mux2_1
X_19154_ _19154_/Q _19805_/CLK _19154_/D _19154_/RESET_B VPWR VGND sg13cmos5l_dfrbpq_1
X_12529_ _18862_/D _12529_/A _12529_/B VPWR VGND sg13cmos5l_and2_1
X_19085_ _19085_/Q clkload53/A _19085_/D _19085_/RESET_B VPWR VGND sg13cmos5l_dfrbpq_1
X_16297_ _16297_/Y _16277_/B fanout34/X _16308_/B VPWR VGND sg13cmos5l_o21ai_1
X_15317_ _15322_/A _19300_/Q _15331_/B VPWR VGND sg13cmos5l_and2_1
X_18105_ _18105_/Y _18129_/A _18129_/B VPWR VGND sg13cmos5l_nand2_1
X_18036_ _18045_/B _18025_/Y _18030_/Y _18057_/B _18038_/A _18032_/Y VPWR VGND sg13cmos5l_a221oi_1
X_15248_ _15248_/Y _15230_/Y hold2281/X _15466_/A VPWR VGND sg13cmos5l_a21oi_1
X_15179_ _15179_/Y _15179_/A _15179_/B VPWR VGND sg13cmos5l_nand2_1
Xfanout308 _11904_/A _11670_/Y VPWR VGND sg13cmos5l_buf_1
Xfanout319 _11089_/A _11091_/A VPWR VGND sg13cmos5l_buf_1
XFILLER_101_628 VPWR VGND sg13cmos5l_fill_2
X_18938_ _18938_/Q _19092_/CLK _18938_/D _18938_/RESET_B VPWR VGND sg13cmos5l_dfrbpq_1
.ends
