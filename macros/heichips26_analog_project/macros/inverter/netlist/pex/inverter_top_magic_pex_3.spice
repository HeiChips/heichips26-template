* PEX produced on Sun Aug  2 02:10:13 CEST 2026 using scripts/sak-pex.sh with m=3 and s=1 (extresist threshold=10000 mOhm, minres=1000 mOhm, mindelay=1 ps)
* NGSPICE file created from inverter_top_pex.ext - technology: ihp-sg13cmos5l

.subckt inverter_top_pex VDD vin4 vout4 VSS vin3 vout3 vin2 vout2 vout1 vin1
X0 vout4 vin4 VDD VDD sg13_lv_pmos ad=1.14p pd=6.38u as=1.14p ps=6.38u w=6u l=1u
X1 VDD vin2 vout2 VDD sg13_lv_pmos ad=1.14p pd=6.38u as=1.14p ps=6.38u w=6u l=1u
X2 VSS.t128 vin2 vout2 VSS.t48 sg13_lv_nmos ad=0.19p pd=1.38u as=0.19p ps=1.38u w=1u l=1u
X3 vout2 vin2 VSS.t130 VSS.t53 sg13_lv_nmos ad=0.19p pd=1.38u as=0.19p ps=1.38u w=1u l=1u
X4 vout2 vin2 VDD VDD sg13_lv_pmos ad=1.14p pd=6.38u as=1.14p ps=6.38u w=6u l=1u
X5 VSS.t96 vin4 vout4 VSS.t95 sg13_lv_nmos ad=0.19p pd=1.38u as=0.19p ps=1.38u w=1u l=1u
X6 vout1 vin1 VSS.t24 VSS.t25 sg13_lv_nmos ad=0.19p pd=1.38u as=0.19p ps=1.38u w=1u l=1u
X7 VDD vin2 vout2 VDD sg13_lv_pmos ad=1.14p pd=6.38u as=1.14p ps=6.38u w=6u l=1u
X8 vout4 vin4 VSS.t64 VSS.t88 sg13_lv_nmos ad=0.19p pd=1.38u as=0.19p ps=1.38u w=1u l=1u
X9 VDD vin2 vout2 VDD sg13_lv_pmos ad=1.14p pd=6.38u as=1.14p ps=6.38u w=6u l=1u
X10 VSS.t58 vin3 vout3 VSS.t57 sg13_lv_nmos ad=0.19p pd=1.38u as=0.19p ps=1.38u w=1u l=1u
X11 vout4 vin4 VSS.t105 VSS.t106 sg13_lv_nmos ad=0.19p pd=1.38u as=0.19p ps=1.38u w=1u l=1u
X12 VDD vin3 vout3 VDD sg13_lv_pmos ad=1.14p pd=6.38u as=1.14p ps=6.38u w=6u l=1u
X13 VSS.t99 vin4 vout4 VSS.t98 sg13_lv_nmos ad=0.19p pd=1.38u as=0.19p ps=1.38u w=1u l=1u
X14 VDD vin2 vout2 VDD sg13_lv_pmos ad=1.14p pd=6.38u as=1.14p ps=6.38u w=6u l=1u
X15 vout3 vin3 VDD VDD sg13_lv_pmos ad=1.14p pd=6.38u as=1.14p ps=6.38u w=6u l=1u
X16 vout2 vin2 VDD VDD sg13_lv_pmos ad=1.14p pd=6.38u as=1.14p ps=6.38u w=6u l=1u
X17 VSS.t124 vin2 vout2 VSS.t42 sg13_lv_nmos ad=0.19p pd=1.38u as=0.19p ps=1.38u w=1u l=1u
X18 VDD vin3 vout3 VDD sg13_lv_pmos ad=1.14p pd=6.38u as=1.14p ps=6.38u w=6u l=1u
X19 VSS.t72 VSS.t70 VSS.t32 VSS.t71 sg13_lv_nmos ad=0.34p pd=2.68u as=0 ps=0 w=1u l=1u
X20 vout2 vin2 VSS.t126 VSS.t47 sg13_lv_nmos ad=0.19p pd=1.38u as=0.19p ps=1.38u w=1u l=1u
X21 vout1 vin1 VSS.t18 VSS.t19 sg13_lv_nmos ad=0.19p pd=1.38u as=0.19p ps=1.38u w=1u l=1u
X22 VSS.t130 vin2 vout2 VSS.t51 sg13_lv_nmos ad=0.19p pd=1.38u as=0.19p ps=1.38u w=1u l=1u
X23 vout4 vin4 VSS.t102 VSS.t103 sg13_lv_nmos ad=0.19p pd=1.38u as=0.19p ps=1.38u w=1u l=1u
X24 vout1 vin1 VDD VDD sg13_lv_pmos ad=1.14p pd=6.38u as=1.14p ps=6.38u w=6u l=1u
X25 vout1 vin1 VSS.t12 VSS.t13 sg13_lv_nmos ad=0.19p pd=1.38u as=0.19p ps=1.38u w=1u l=1u
X26 VSS.t108 vin4 vout4 VSS.t107 sg13_lv_nmos ad=0.19p pd=1.38u as=0.19p ps=1.38u w=1u l=1u
X27 VDD VDD VDD VDD sg13_lv_pmos ad=1.14p pd=6.38u as=0.56797n ps=1.006m w=6u l=1u
X28 VSS.t18 vin1 vout1 VSS.t17 sg13_lv_nmos ad=0.19p pd=1.38u as=0.19p ps=1.38u w=1u l=1u
X29 vout2 vin2 VDD VDD sg13_lv_pmos ad=1.14p pd=6.38u as=1.14p ps=6.38u w=6u l=1u
X30 VDD vin4 vout4 VDD sg13_lv_pmos ad=1.14p pd=6.38u as=1.14p ps=6.38u w=6u l=1u
X31 vout1 vin1 VSS.t21 VSS.t22 sg13_lv_nmos ad=0.19p pd=1.38u as=0.19p ps=1.38u w=1u l=1u
X32 vout3 vin3 VSS.t55 VSS.t56 sg13_lv_nmos ad=0.19p pd=1.38u as=0.19p ps=1.38u w=1u l=1u
X33 vout4 vin4 VDD VDD sg13_lv_pmos ad=1.14p pd=6.38u as=1.14p ps=6.38u w=6u l=1u
X34 VDD vin3 vout3 VDD sg13_lv_pmos ad=1.14p pd=6.38u as=1.14p ps=6.38u w=6u l=1u
X35 VDD vin4 vout4 VDD sg13_lv_pmos ad=1.14p pd=6.38u as=1.14p ps=6.38u w=6u l=1u
X36 vout3 vin3 VDD VDD sg13_lv_pmos ad=1.14p pd=6.38u as=1.14p ps=6.38u w=6u l=1u
X37 VDD vin3 vout3 VDD sg13_lv_pmos ad=1.14p pd=6.38u as=1.14p ps=6.38u w=6u l=1u
X38 VSS.t69 VSS.t66 VSS.t68 VSS.t67 sg13_lv_nmos ad=0.19p pd=1.38u as=0 ps=0 w=1u l=1u
X39 VDD vin4 vout4 VDD sg13_lv_pmos ad=1.14p pd=6.38u as=1.14p ps=6.38u w=6u l=1u
X40 VDD vin2 vout2 VDD sg13_lv_pmos ad=1.14p pd=6.38u as=1.14p ps=6.38u w=6u l=1u
X41 VSS.t111 vin4 vout4 VSS.t110 sg13_lv_nmos ad=0.19p pd=1.38u as=0.19p ps=1.38u w=1u l=1u
X42 VDD vin3 vout3 VDD sg13_lv_pmos ad=1.14p pd=6.38u as=1.14p ps=6.38u w=6u l=1u
X43 VSS.t12 vin1 vout1 VSS.t11 sg13_lv_nmos ad=0.19p pd=1.38u as=0.19p ps=1.38u w=1u l=1u
X44 VDD vin1 vout1 VDD sg13_lv_pmos ad=1.14p pd=6.38u as=1.14p ps=6.38u w=6u l=1u
X45 vout4 vin4 VSS.t114 VSS.t115 sg13_lv_nmos ad=0.19p pd=1.38u as=0.19p ps=1.38u w=1u l=1u
X46 vout4 vin4 VDD VDD sg13_lv_pmos ad=1.14p pd=6.38u as=1.14p ps=6.38u w=6u l=1u
X47 vout1 vin1 VSS.t15 VSS.t16 sg13_lv_nmos ad=0.19p pd=1.38u as=0.19p ps=1.38u w=1u l=1u
X48 vout1 vin1 VDD VDD sg13_lv_pmos ad=1.14p pd=6.38u as=1.14p ps=6.38u w=6u l=1u
X49 VDD vin1 vout1 VDD sg13_lv_pmos ad=1.14p pd=6.38u as=1.14p ps=6.38u w=6u l=1u
X50 vout3 vin3 VSS.t49 VSS.t50 sg13_lv_nmos ad=0.19p pd=1.38u as=0.19p ps=1.38u w=1u l=1u
X51 VSS.t21 vin1 vout1 VSS.t20 sg13_lv_nmos ad=0.19p pd=1.38u as=0.19p ps=1.38u w=1u l=1u
X52 VDD VDD VDD VDD sg13_lv_pmos ad=2.04p pd=12.68u as=0 ps=0 w=6u l=1u
X53 vout4 vin4 VDD VDD sg13_lv_pmos ad=1.14p pd=6.38u as=1.14p ps=6.38u w=6u l=1u
X54 VDD vin3 vout3 VDD sg13_lv_pmos ad=1.14p pd=6.38u as=1.14p ps=6.38u w=6u l=1u
X55 VDD vin4 vout4 VDD sg13_lv_pmos ad=1.14p pd=6.38u as=1.14p ps=6.38u w=6u l=1u
X56 vout3 vin3 VSS.t43 VSS.t44 sg13_lv_nmos ad=0.19p pd=1.38u as=0.19p ps=1.38u w=1u l=1u
X57 vout3 vin3 VDD VDD sg13_lv_pmos ad=1.14p pd=6.38u as=1.14p ps=6.38u w=6u l=1u
X58 VSS.t49 vin3 vout3 VSS.t48 sg13_lv_nmos ad=0.19p pd=1.38u as=0.19p ps=1.38u w=1u l=1u
X59 VDD VDD VDD VDD sg13_lv_pmos ad=1.14p pd=6.38u as=0 ps=0 w=6u l=1u
X60 vout3 vin3 VSS.t52 VSS.t53 sg13_lv_nmos ad=0.19p pd=1.38u as=0.19p ps=1.38u w=1u l=1u
X61 vout4 vin4 VDD VDD sg13_lv_pmos ad=1.14p pd=6.38u as=1.14p ps=6.38u w=6u l=1u
X62 vout3 vin3 VDD VDD sg13_lv_pmos ad=1.14p pd=6.38u as=1.14p ps=6.38u w=6u l=1u
X63 VDD vin1 vout1 VDD sg13_lv_pmos ad=1.14p pd=6.38u as=1.14p ps=6.38u w=6u l=1u
X64 vout2 vin2 VDD VDD sg13_lv_pmos ad=1.14p pd=6.38u as=1.14p ps=6.38u w=6u l=1u
X65 vout1 vin1 VDD VDD sg13_lv_pmos ad=1.14p pd=6.38u as=1.14p ps=6.38u w=6u l=1u
X66 VDD vin1 vout1 VDD sg13_lv_pmos ad=1.14p pd=6.38u as=1.14p ps=6.38u w=6u l=1u
X67 vout2 vin2 VSS.t120 VSS.t38 sg13_lv_nmos ad=0.19p pd=1.38u as=0.19p ps=1.38u w=1u l=1u
X68 VDD vin1 vout1 VDD sg13_lv_pmos ad=1.14p pd=6.38u as=1.14p ps=6.38u w=6u l=1u
X69 VDD vin3 vout3 VDD sg13_lv_pmos ad=1.14p pd=6.38u as=1.14p ps=6.38u w=6u l=1u
X70 VSS.t43 vin3 vout3 VSS.t42 sg13_lv_nmos ad=0.19p pd=1.38u as=0.19p ps=1.38u w=1u l=1u
X71 vout3 vin3 VSS.t46 VSS.t47 sg13_lv_nmos ad=0.19p pd=1.38u as=0.19p ps=1.38u w=1u l=1u
X72 VSS.t93 vin4 vout4 VSS.t92 sg13_lv_nmos ad=0.19p pd=1.38u as=0.19p ps=1.38u w=1u l=1u
X73 VDD vin4 vout4 VDD sg13_lv_pmos ad=1.14p pd=6.38u as=1.14p ps=6.38u w=6u l=1u
X74 VSS.t52 vin3 vout3 VSS.t51 sg13_lv_nmos ad=0.19p pd=1.38u as=0.19p ps=1.38u w=1u l=1u
X75 vout4 vin4 VSS.t96 VSS.t97 sg13_lv_nmos ad=0.19p pd=1.38u as=0.19p ps=1.38u w=1u l=1u
X76 VDD vin1 vout1 VDD sg13_lv_pmos ad=1.14p pd=6.38u as=1.14p ps=6.38u w=6u l=1u
X77 vout2 vin2 VDD VDD sg13_lv_pmos ad=1.14p pd=6.38u as=1.14p ps=6.38u w=6u l=1u
X78 vout1 vin1 VDD VDD sg13_lv_pmos ad=1.14p pd=6.38u as=1.14p ps=6.38u w=6u l=1u
X79 VSS.t90 vin4 vout4 VSS.t89 sg13_lv_nmos ad=0.19p pd=1.38u as=0.19p ps=1.38u w=1u l=1u
X80 VDD VDD VDD VDD sg13_lv_pmos ad=2.04p pd=12.68u as=0 ps=0 w=6u l=1u
X81 vout2 vin2 VDD VDD sg13_lv_pmos ad=1.14p pd=6.38u as=1.14p ps=6.38u w=6u l=1u
X82 VDD vin2 vout2 VDD sg13_lv_pmos ad=1.14p pd=6.38u as=1.14p ps=6.38u w=6u l=1u
X83 VSS.t120 vin2 vout2 VSS.t36 sg13_lv_nmos ad=0.19p pd=1.38u as=0.19p ps=1.38u w=1u l=1u
X84 VSS.t102 vin4 vout4 VSS.t101 sg13_lv_nmos ad=0.19p pd=1.38u as=0.19p ps=1.38u w=1u l=1u
X85 VDD VDD VDD VDD sg13_lv_pmos ad=2.04p pd=12.68u as=0 ps=0 w=6u l=1u
X86 vout2 vin2 VDD VDD sg13_lv_pmos ad=1.14p pd=6.38u as=1.14p ps=6.38u w=6u l=1u
X87 vout2 vin2 VSS.t122 VSS.t41 sg13_lv_nmos ad=0.19p pd=1.38u as=0.19p ps=1.38u w=1u l=1u
X88 VSS.t126 vin2 vout2 VSS.t45 sg13_lv_nmos ad=0.19p pd=1.38u as=0.19p ps=1.38u w=1u l=1u
X89 vout1 vin1 VDD VDD sg13_lv_pmos ad=1.14p pd=6.38u as=1.14p ps=6.38u w=6u l=1u
X90 vout1 vin1 VSS.t6 VSS.t7 sg13_lv_nmos ad=0.19p pd=1.38u as=0.19p ps=1.38u w=1u l=1u
X91 vout4 vin4 VSS.t99 VSS.t100 sg13_lv_nmos ad=0.19p pd=1.38u as=0.19p ps=1.38u w=1u l=1u
X92 vout3 vin3 VDD VDD sg13_lv_pmos ad=1.14p pd=6.38u as=1.14p ps=6.38u w=6u l=1u
X93 vout4 vin4 VSS.t111 VSS.t112 sg13_lv_nmos ad=0.19p pd=1.38u as=0.19p ps=1.38u w=1u l=1u
X94 VSS.t81 VSS.t79 VSS.t80 VSS.t74 sg13_lv_nmos ad=0.19p pd=1.38u as=0 ps=0 w=1u l=1u
X95 VSS.t105 vin4 vout4 VSS.t104 sg13_lv_nmos ad=0.19p pd=1.38u as=0.19p ps=1.38u w=1u l=1u
X96 VDD vin1 vout1 VDD sg13_lv_pmos ad=1.14p pd=6.38u as=1.14p ps=6.38u w=6u l=1u
X97 VSS.t81 vin2 vout2 VSS.t60 sg13_lv_nmos ad=0.19p pd=1.38u as=0.19p ps=1.38u w=1u l=1u
X98 VDD vin2 vout2 VDD sg13_lv_pmos ad=1.14p pd=6.38u as=1.14p ps=6.38u w=6u l=1u
X99 vout4 vin4 VSS.t108 VSS.t109 sg13_lv_nmos ad=0.19p pd=1.38u as=0.19p ps=1.38u w=1u l=1u
X100 vout4 vin4 VDD VDD sg13_lv_pmos ad=1.14p pd=6.38u as=1.14p ps=6.38u w=6u l=1u
X101 vout2 vin2 VDD VDD sg13_lv_pmos ad=1.14p pd=6.38u as=1.14p ps=6.38u w=6u l=1u
X102 vout2 vin2 VSS.t118 VSS.t35 sg13_lv_nmos ad=0.19p pd=1.38u as=0.19p ps=1.38u w=1u l=1u
X103 VDD vin2 vout2 VDD sg13_lv_pmos ad=1.14p pd=6.38u as=1.14p ps=6.38u w=6u l=1u
X104 VSS.t122 vin2 vout2 VSS.t39 sg13_lv_nmos ad=0.19p pd=1.38u as=0.19p ps=1.38u w=1u l=1u
X105 VDD vin4 vout4 VDD sg13_lv_pmos ad=1.14p pd=6.38u as=1.14p ps=6.38u w=6u l=1u
X106 VDD VDD VDD VDD sg13_lv_pmos ad=2.04p pd=12.68u as=0 ps=0 w=6u l=1u
X107 VSS.t118 vin2 vout2 VSS.t33 sg13_lv_nmos ad=0.19p pd=1.38u as=0.19p ps=1.38u w=1u l=1u
X108 VSS.t6 vin1 vout1 VSS.t5 sg13_lv_nmos ad=0.19p pd=1.38u as=0.19p ps=1.38u w=1u l=1u
X109 vout3 vin3 VDD VDD sg13_lv_pmos ad=1.14p pd=6.38u as=1.14p ps=6.38u w=6u l=1u
X110 vout1 vin1 VSS.t9 VSS.t10 sg13_lv_nmos ad=0.19p pd=1.38u as=0.19p ps=1.38u w=1u l=1u
X111 VSS.t15 vin1 vout1 VSS.t14 sg13_lv_nmos ad=0.19p pd=1.38u as=0.19p ps=1.38u w=1u l=1u
X112 vout3 vin3 VDD VDD sg13_lv_pmos ad=1.14p pd=6.38u as=1.14p ps=6.38u w=6u l=1u
X113 VDD vin3 vout3 VDD sg13_lv_pmos ad=1.14p pd=6.38u as=1.14p ps=6.38u w=6u l=1u
X114 vout3 vin3 VDD VDD sg13_lv_pmos ad=1.14p pd=6.38u as=1.14p ps=6.38u w=6u l=1u
X115 vout3 vin3 VSS.t37 VSS.t38 sg13_lv_nmos ad=0.19p pd=1.38u as=0.19p ps=1.38u w=1u l=1u
X116 VSS.t132 vin2 vout2 VSS.t54 sg13_lv_nmos ad=0.19p pd=1.38u as=0.19p ps=1.38u w=1u l=1u
X117 vout2 vin2 VSS.t134 VSS.t59 sg13_lv_nmos ad=0.19p pd=1.38u as=0.19p ps=1.38u w=1u l=1u
X118 VSS.t69 vin4 vout4 VSS.t116 sg13_lv_nmos ad=0.19p pd=1.38u as=0.19p ps=1.38u w=1u l=1u
X119 vout1 vin1 VDD VDD sg13_lv_pmos ad=1.14p pd=6.38u as=1.14p ps=6.38u w=6u l=1u
X120 VSS.t30 VSS.t85 VSS.t87 VSS.t86 sg13_lv_nmos ad=0.19p pd=1.38u as=0 ps=0 w=1u l=1u
X121 VSS.t30 vin1 vout1 VSS.t29 sg13_lv_nmos ad=0.19p pd=1.38u as=0.19p ps=1.38u w=1u l=1u
X122 vout2 vin2 VSS.t77 VSS.t31 sg13_lv_nmos ad=0.19p pd=1.38u as=0.19p ps=1.38u w=1u l=1u
X123 VSS.t65 VSS.t62 VSS.t64 VSS.t63 sg13_lv_nmos ad=0.34p pd=2.68u as=0 ps=0 w=1u l=1u
X124 vout1 vin1 VSS.t3 VSS.t4 sg13_lv_nmos ad=0.19p pd=1.38u as=0.19p ps=1.38u w=1u l=1u
X125 VSS.t9 vin1 vout1 VSS.t8 sg13_lv_nmos ad=0.19p pd=1.38u as=0.19p ps=1.38u w=1u l=1u
X126 VDD vin3 vout3 VDD sg13_lv_pmos ad=1.14p pd=6.38u as=1.14p ps=6.38u w=6u l=1u
X127 VSS.t3 vin1 vout1 VSS.t2 sg13_lv_nmos ad=0.19p pd=1.38u as=0.19p ps=1.38u w=1u l=1u
X128 vout4 vin4 VDD VDD sg13_lv_pmos ad=1.14p pd=6.38u as=1.14p ps=6.38u w=6u l=1u
X129 vout3 vin3 VDD VDD sg13_lv_pmos ad=1.14p pd=6.38u as=1.14p ps=6.38u w=6u l=1u
X130 VDD vin3 vout3 VDD sg13_lv_pmos ad=1.14p pd=6.38u as=1.14p ps=6.38u w=6u l=1u
X131 VSS.t37 vin3 vout3 VSS.t36 sg13_lv_nmos ad=0.19p pd=1.38u as=0.19p ps=1.38u w=1u l=1u
X132 vout3 vin3 VSS.t40 VSS.t41 sg13_lv_nmos ad=0.19p pd=1.38u as=0.19p ps=1.38u w=1u l=1u
X133 vout1 vin1 VDD VDD sg13_lv_pmos ad=1.14p pd=6.38u as=1.14p ps=6.38u w=6u l=1u
X134 VSS.t134 vin2 vout2 VSS.t57 sg13_lv_nmos ad=0.19p pd=1.38u as=0.19p ps=1.38u w=1u l=1u
X135 VSS.t46 vin3 vout3 VSS.t45 sg13_lv_nmos ad=0.19p pd=1.38u as=0.19p ps=1.38u w=1u l=1u
X136 VDD vin4 vout4 VDD sg13_lv_pmos ad=1.14p pd=6.38u as=1.14p ps=6.38u w=6u l=1u
X137 vout1 vin1 VDD VDD sg13_lv_pmos ad=1.14p pd=6.38u as=1.14p ps=6.38u w=6u l=1u
X138 VDD vin1 vout1 VDD sg13_lv_pmos ad=1.14p pd=6.38u as=1.14p ps=6.38u w=6u l=1u
X139 vout4 vin4 VDD VDD sg13_lv_pmos ad=1.14p pd=6.38u as=1.14p ps=6.38u w=6u l=1u
X140 VSS.t24 vin1 vout1 VSS.t23 sg13_lv_nmos ad=0.19p pd=1.38u as=0.19p ps=1.38u w=1u l=1u
X141 vout1 vin1 VDD VDD sg13_lv_pmos ad=1.14p pd=6.38u as=1.14p ps=6.38u w=6u l=1u
X142 vout1 vin1 VSS.t27 VSS.t28 sg13_lv_nmos ad=0.19p pd=1.38u as=0.19p ps=1.38u w=1u l=1u
X143 vout2 vin2 VDD VDD sg13_lv_pmos ad=1.14p pd=6.38u as=1.14p ps=6.38u w=6u l=1u
X144 vout4 vin4 VSS.t93 VSS.t94 sg13_lv_nmos ad=0.19p pd=1.38u as=0.19p ps=1.38u w=1u l=1u
X145 VSS.t78 VSS.t76 VSS.t77 VSS.t71 sg13_lv_nmos ad=0.34p pd=2.68u as=0 ps=0 w=1u l=1u
X146 VSS.t61 VSS.t73 VSS.t75 VSS.t74 sg13_lv_nmos ad=0.19p pd=1.38u as=0 ps=0 w=1u l=1u
X147 vout4 vin4 VDD VDD sg13_lv_pmos ad=1.14p pd=6.38u as=1.14p ps=6.38u w=6u l=1u
X148 VSS.t61 vin3 vout3 VSS.t60 sg13_lv_nmos ad=0.19p pd=1.38u as=0.19p ps=1.38u w=1u l=1u
X149 VSS.t114 vin4 vout4 VSS.t113 sg13_lv_nmos ad=0.19p pd=1.38u as=0.19p ps=1.38u w=1u l=1u
X150 VDD vin4 vout4 VDD sg13_lv_pmos ad=1.14p pd=6.38u as=1.14p ps=6.38u w=6u l=1u
X151 vout1 vin1 VSS.t1 VSS.t0 sg13_lv_nmos ad=0.19p pd=1.38u as=0.19p ps=1.38u w=1u l=1u
X152 vout3 vin3 VSS.t34 VSS.t35 sg13_lv_nmos ad=0.19p pd=1.38u as=0.19p ps=1.38u w=1u l=1u
X153 VSS.t40 vin3 vout3 VSS.t39 sg13_lv_nmos ad=0.19p pd=1.38u as=0.19p ps=1.38u w=1u l=1u
X154 vout4 vin4 VDD VDD sg13_lv_pmos ad=1.14p pd=6.38u as=1.14p ps=6.38u w=6u l=1u
X155 vout2 vin2 VSS.t132 VSS.t56 sg13_lv_nmos ad=0.19p pd=1.38u as=0.19p ps=1.38u w=1u l=1u
X156 VSS.t34 vin3 vout3 VSS.t33 sg13_lv_nmos ad=0.19p pd=1.38u as=0.19p ps=1.38u w=1u l=1u
X157 VDD vin1 vout1 VDD sg13_lv_pmos ad=1.14p pd=6.38u as=1.14p ps=6.38u w=6u l=1u
X158 vout1 vin1 VDD VDD sg13_lv_pmos ad=1.14p pd=6.38u as=1.14p ps=6.38u w=6u l=1u
X159 VDD vin4 vout4 VDD sg13_lv_pmos ad=1.14p pd=6.38u as=1.14p ps=6.38u w=6u l=1u
X160 VDD vin1 vout1 VDD sg13_lv_pmos ad=1.14p pd=6.38u as=1.14p ps=6.38u w=6u l=1u
X161 VSS.t27 vin1 vout1 VSS.t26 sg13_lv_nmos ad=0.19p pd=1.38u as=0.19p ps=1.38u w=1u l=1u
X162 VDD vin2 vout2 VDD sg13_lv_pmos ad=1.14p pd=6.38u as=1.14p ps=6.38u w=6u l=1u
X163 vout2 vin2 VDD VDD sg13_lv_pmos ad=1.14p pd=6.38u as=1.14p ps=6.38u w=6u l=1u
X164 VDD vin2 vout2 VDD sg13_lv_pmos ad=1.14p pd=6.38u as=1.14p ps=6.38u w=6u l=1u
X165 VSS.t55 vin3 vout3 VSS.t54 sg13_lv_nmos ad=0.19p pd=1.38u as=0.19p ps=1.38u w=1u l=1u
X166 vout3 vin3 VSS.t58 VSS.t59 sg13_lv_nmos ad=0.19p pd=1.38u as=0.19p ps=1.38u w=1u l=1u
X167 VDD VDD VDD VDD sg13_lv_pmos ad=1.14p pd=6.38u as=0 ps=0 w=6u l=1u
X168 VSS.t84 VSS.t82 VSS.t1 VSS.t83 sg13_lv_nmos ad=0.34p pd=2.68u as=0 ps=0 w=1u l=1u
X169 VDD vin4 vout4 VDD sg13_lv_pmos ad=1.14p pd=6.38u as=1.14p ps=6.38u w=6u l=1u
X170 VDD VDD VDD VDD sg13_lv_pmos ad=1.14p pd=6.38u as=0 ps=0 w=6u l=1u
X171 vout2 vin2 VSS.t128 VSS.t50 sg13_lv_nmos ad=0.19p pd=1.38u as=0.19p ps=1.38u w=1u l=1u
X172 vout3 vin3 VDD VDD sg13_lv_pmos ad=1.14p pd=6.38u as=1.14p ps=6.38u w=6u l=1u
X173 vout4 vin4 VSS.t90 VSS.t91 sg13_lv_nmos ad=0.19p pd=1.38u as=0.19p ps=1.38u w=1u l=1u
X174 vout3 vin3 VSS.t32 VSS.t31 sg13_lv_nmos ad=0.19p pd=1.38u as=0.19p ps=1.38u w=1u l=1u
X175 vout2 vin2 VSS.t124 VSS.t44 sg13_lv_nmos ad=0.19p pd=1.38u as=0.19p ps=1.38u w=1u l=1u
R0 VSS.n391 VSS.n10 6777.49
R1 VSS.n397 VSS.n10 6777.49
R2 VSS.n391 VSS.n79 6777.49
R3 VSS.n397 VSS.n396 1580.41
R4 VSS.n132 VSS.n391 1580.41
R5 VSS.t31 VSS.n114 88.7251
R6 VSS.n131 VSS.t60 88.7251
R7 VSS.n231 VSS.t33 83.1798
R8 VSS.n130 VSS.t59 83.1798
R9 VSS.t35 VSS.n229 77.6345
R10 VSS.n129 VSS.t57 77.6345
R11 VSS.t36 VSS.n227 72.0892
R12 VSS.n128 VSS.t56 72.0892
R13 VSS.t116 VSS.n10 9.76925
R14 VSS.t38 VSS.n113 66.5439
R15 VSS.n127 VSS.t54 66.5439
R16 VSS.n10 VSS.t89 12.3005
R17 VSS.t39 VSS.n112 60.9987
R18 VSS.n126 VSS.t53 60.9987
R19 VSS.t113 VSS.n21 14.4648
R20 VSS.n84 VSS.t29 68.3172
R21 VSS.t112 VSS.n371 56.9354
R22 VSS.n11 VSS.t92 16.2727
R23 VSS.n95 VSS.t28 64.5222
R24 VSS.t41 VSS.n111 55.4534
R25 VSS.n121 VSS.t45 55.4534
R26 VSS.t47 VSS.n107 55.4534
R27 VSS.n125 VSS.t51 55.4534
R28 VSS.t110 VSS.n370 53.1403
R29 VSS.n360 VSS.t94 53.1357
R30 VSS.n77 VSS.t26 60.7271
R31 VSS.t42 VSS.n110 49.9081
R32 VSS.n120 VSS.t44 49.9081
R33 VSS.t48 VSS.n106 49.9081
R34 VSS.n124 VSS.t50 49.9081
R35 VSS.t109 VSS.n369 49.3453
R36 VSS.n361 VSS.t95 49.3407
R37 VSS.n76 VSS.t25 56.932
R38 VSS.t107 VSS.n368 45.5502
R39 VSS.t101 VSS.n364 45.5502
R40 VSS.n366 VSS.t103 45.5456
R41 VSS.n362 VSS.t97 45.5456
R42 VSS.n97 VSS.t23 53.1369
R43 VSS.n119 VSS.t42 44.3628
R44 VSS.t44 VSS.n109 44.3628
R45 VSS.n123 VSS.t48 44.3628
R46 VSS.t50 VSS.n105 44.3628
R47 VSS.t106 VSS.n367 41.7551
R48 VSS.t100 VSS.n363 41.7551
R49 VSS.n367 VSS.t104 41.7505
R50 VSS.n363 VSS.t98 41.7505
R51 VSS.n94 VSS.t22 49.3426
R52 VSS.n118 VSS.t41 38.8175
R53 VSS.t45 VSS.n108 38.8175
R54 VSS.n122 VSS.t47 38.8175
R55 VSS.t51 VSS.n104 38.8175
R56 VSS.t104 VSS.n366 37.9601
R57 VSS.t98 VSS.n362 37.9601
R58 VSS.n368 VSS.t106 37.9555
R59 VSS.n364 VSS.t100 37.9555
R60 VSS.n93 VSS.t20 45.5468
R61 VSS.t103 VSS.n365 34.1682
R62 VSS.t97 VSS.n361 34.165
R63 VSS.n365 VSS.t101 34.1635
R64 VSS.n369 VSS.t107 34.1604
R65 VSS.n75 VSS.t13 41.7518
R66 VSS.n117 VSS.t39 33.2722
R67 VSS.t53 VSS.n103 33.2722
R68 VSS.t95 VSS.n360 30.3699
R69 VSS.n370 VSS.t109 30.3653
R70 VSS.n89 VSS.t11 37.9567
R71 VSS.n85 VSS.t17 37.9567
R72 VSS.n258 VSS.t38 27.7269
R73 VSS.t54 VSS.n102 27.7269
R74 VSS.t94 VSS.n11 26.583
R75 VSS.n371 VSS.t110 26.5703
R76 VSS.n90 VSS.t10 34.1616
R77 VSS.t16 VSS.n83 34.1658
R78 VSS.n11 VSS.n10 0.00406306
R79 VSS.n91 VSS.t8 30.3673
R80 VSS.t83 VSS.n88 13.76
R81 VSS.n82 VSS.t83 13.7582
R82 VSS.n86 VSS.t0 68.3166
R83 VSS.n78 VSS.t2 64.5216
R84 VSS.t7 VSS.n92 26.5725
R85 VSS.n91 VSS.t7 53.1364
R86 VSS.t14 VSS.n80 45.5478
R87 VSS.n94 VSS.t20 34.161
R88 VSS.n96 VSS.t86 13.7582
R89 VSS.n255 VSS.t36 22.1816
R90 VSS.t56 VSS.n101 22.1816
R91 VSS.t91 VSS.n10 14.4672
R92 VSS.n96 VSS.t29 11.3996
R93 VSS.n74 VSS.n84 0.0109013
R94 VSS.n84 VSS.t28 15.1866
R95 VSS.n74 VSS.n95 0.0109013
R96 VSS.n95 VSS.t26 18.9817
R97 VSS.n74 VSS.n77 0.0109013
R98 VSS.n77 VSS.t25 22.7768
R99 VSS.n76 VSS.t23 26.5718
R100 VSS.n74 VSS.n97 0.0109013
R101 VSS.n97 VSS.t22 30.3669
R102 VSS.n74 VSS.n94 0.0111485
R103 VSS.n81 VSS.t17 41.7521
R104 VSS.n85 VSS.t16 45.5472
R105 VSS.n74 VSS.n83 0.00931161
R106 VSS.n74 VSS.n80 0.0108886
R107 VSS.n74 VSS.n75 0.0108886
R108 VSS.n74 VSS.n91 0.0111485
R109 VSS.n74 VSS.n78 0.0111485
R110 VSS.n74 VSS.n86 0.0111485
R111 VSS.n7 VSS.n74 0.815553
R112 VSS.n74 VSS.n34 0.00939957
R113 VSS.t30 VSS.n29 5.66266
R114 VSS.n29 VSS.n27 0.00641486
R115 VSS.n28 VSS.n27 0.00359052
R116 VSS.t87 VSS.n28 5.66533
R117 VSS.n34 VSS.n28 1.28088
R118 VSS.n74 VSS.n6 0.816093
R119 VSS.t84 VSS.n26 5.66266
R120 VSS.n26 VSS.n24 0.00641486
R121 VSS.n25 VSS.n24 0.00359052
R122 VSS.n25 VSS.t1 5.66533
R123 VSS.n34 VSS.n25 1.33195
R124 VSS.n13 VSS.n172 17.0005
R125 VSS.n13 VSS.n296 17.0005
R126 VSS.n13 VSS.n71 5.66421
R127 VSS.n13 VSS.n175 17.0005
R128 VSS.n13 VSS.n294 17.0005
R129 VSS.n13 VSS.n98 17.0005
R130 VSS.n13 VSS.n180 17.0005
R131 VSS.n13 VSS.n292 17.0005
R132 VSS.n13 VSS.n99 17.0005
R133 VSS.n13 VSS.n130 17.0005
R134 VSS.n13 VSS.n184 17.0005
R135 VSS.n13 VSS.n290 17.0005
R136 VSS.n13 VSS.n100 17.0005
R137 VSS.n13 VSS.n129 17.0005
R138 VSS.n13 VSS.n186 17.0005
R139 VSS.n13 VSS.n54 3.39608
R140 VSS.n13 VSS.n288 17.0005
R141 VSS.n13 VSS.n101 17.0005
R142 VSS.n13 VSS.n128 17.0005
R143 VSS.n13 VSS.n188 17.0005
R144 VSS.n13 VSS.n285 17.0005
R145 VSS.n13 VSS.n62 5.66316
R146 VSS.n13 VSS.n102 17.0005
R147 VSS.n13 VSS.n127 8.49855
R148 VSS.n13 VSS.n191 17.0005
R149 VSS.n13 VSS.n282 17.0005
R150 VSS.n23 VSS.n103 8.49945
R151 VSS.n13 VSS.n126 17.0005
R152 VSS.n13 VSS.n196 17.0005
R153 VSS.n13 VSS.n39 3.396
R154 VSS.n13 VSS.n280 17.0005
R155 VSS.n13 VSS.n104 17.0005
R156 VSS.n13 VSS.n125 17.0005
R157 VSS.n13 VSS.n198 17.0005
R158 VSS.n39 VSS.n53 0.0212071
R159 VSS.n13 VSS.n278 17.0005
R160 VSS.n13 VSS.n105 17.0005
R161 VSS.n13 VSS.n200 17.0005
R162 VSS.n13 VSS.n274 17.0005
R163 VSS.n13 VSS.n106 17.0005
R164 VSS.n13 VSS.n123 17.0005
R165 VSS.n13 VSS.n202 17.0005
R166 VSS.n13 VSS.n272 17.0005
R167 VSS.n13 VSS.n107 17.0005
R168 VSS.n13 VSS.n14 0.00359486
R169 VSS.n13 VSS.n207 17.0005
R170 VSS.n13 VSS.n50 4.24736
R171 VSS.n13 VSS.n270 17.0005
R172 VSS.n13 VSS.n108 17.0005
R173 VSS.n13 VSS.n121 17.0005
R174 VSS.n13 VSS.n209 17.0005
R175 VSS.n13 VSS.n268 17.0005
R176 VSS.n13 VSS.n120 17.0005
R177 VSS.n13 VSS.n214 17.0005
R178 VSS.n13 VSS.n266 17.0005
R179 VSS.n13 VSS.n56 4.24711
R180 VSS.n13 VSS.n110 8.49918
R181 VSS.n13 VSS.n119 17.0005
R182 VSS.n13 VSS.n216 17.0005
R183 VSS.n13 VSS.n264 17.0005
R184 VSS.n13 VSS.n111 17.0005
R185 VSS.n23 VSS.n118 8.49993
R186 VSS.n13 VSS.n221 17.0005
R187 VSS.n13 VSS.n262 17.0005
R188 VSS.n13 VSS.n112 17.0005
R189 VSS.n13 VSS.n117 8.49656
R190 VSS.n13 VSS.n223 17.0005
R191 VSS.n13 VSS.n260 17.0005
R192 VSS.n13 VSS.n113 17.0005
R193 VSS.n13 VSS.n258 17.0005
R194 VSS.n13 VSS.n226 17.0005
R195 VSS.n13 VSS.n257 17.0005
R196 VSS.n13 VSS.n227 17.0005
R197 VSS.n13 VSS.n44 5.66316
R198 VSS.n13 VSS.n255 17.0005
R199 VSS.n13 VSS.n228 17.0005
R200 VSS.n13 VSS.n254 17.0005
R201 VSS.n13 VSS.n229 17.0005
R202 VSS.n13 VSS.n250 17.0005
R203 VSS.n13 VSS.n230 17.0005
R204 VSS.n13 VSS.n249 17.0005
R205 VSS.n13 VSS.n69 5.66421
R206 VSS.n13 VSS.n231 17.0005
R207 VSS.n13 VSS.n116 8.49968
R208 VSS.n13 VSS.n233 17.0005
R209 VSS.n13 VSS.n247 17.0005
R210 VSS.n13 VSS.n114 17.0005
R211 VSS.n13 VSS.n238 17.0005
R212 VSS.n13 VSS.n41 5.66421
R213 VSS.n13 VSS.n245 17.0005
R214 VSS.n13 VSS.n239 17.0005
R215 VSS.n13 VSS.n241 17.0005
R216 VSS.n393 VSS.n13 17.0005
R217 VSS.n13 VSS.n133 5.66711
R218 VSS.n23 VSS.n141 17.0005
R219 VSS.n23 VSS.n143 17.0005
R220 VSS.n23 VSS.n98 17.0005
R221 VSS.n23 VSS.n131 8.49814
R222 VSS.n23 VSS.n99 17.0005
R223 VSS.n23 VSS.n130 17.0005
R224 VSS.n23 VSS.n100 17.0005
R225 VSS.n23 VSS.n129 17.0005
R226 VSS.n23 VSS.n101 17.0005
R227 VSS.n23 VSS.n128 17.0005
R228 VSS.n23 VSS.n102 17.0005
R229 VSS.n23 VSS.n22 0.00369793
R230 VSS.n23 VSS.n126 17.0005
R231 VSS.n23 VSS.n104 17.0005
R232 VSS.n23 VSS.n125 17.0005
R233 VSS.n23 VSS.n105 17.0005
R234 VSS.n22 VSS.n124 8.49965
R235 VSS.n23 VSS.n106 17.0005
R236 VSS.n23 VSS.n123 17.0005
R237 VSS.n23 VSS.n107 17.0005
R238 VSS.n14 VSS.n122 8.4997
R239 VSS.n23 VSS.n108 17.0005
R240 VSS.n23 VSS.n121 17.0005
R241 VSS.n23 VSS.n109 8.49911
R242 VSS.n23 VSS.n120 17.0005
R243 VSS.n23 VSS.n119 17.0005
R244 VSS.n23 VSS.n111 17.0005
R245 VSS.n23 VSS.n112 17.0005
R246 VSS.n23 VSS.n14 0.00359486
R247 VSS.n23 VSS.n113 17.0005
R248 VSS.n23 VSS.n114 17.0005
R249 VSS.n13 VSS.n115 8.49866
R250 VSS.n23 VSS.n170 17.0005
R251 VSS.n23 VSS.n395 17.0005
R252 VSS.n66 VSS.n32 3.39928
R253 VSS.n72 VSS.n32 5.66316
R254 VSS.n55 VSS.n32 5.66316
R255 VSS.n63 VSS.n32 5.66421
R256 VSS.n53 VSS.n32 5.66316
R257 VSS.n52 VSS.n32 3.39717
R258 VSS.n203 VSS.n52 0.0150012
R259 VSS.n43 VSS.n32 5.66421
R260 VSS.n68 VSS.n32 5.66316
R261 VSS.n42 VSS.n32 5.66316
R262 VSS.n17 VSS.n15 0.0071563
R263 VSS.n4 VSS.n3 0.0153102
R264 VSS.n1 VSS.n0 0.0153621
R265 VSS.n0 VSS.t69 8.49711
R266 VSS.t69 VSS.n35 17.0005
R267 VSS.n0 VSS.n5 0.0123024
R268 VSS.n5 VSS.t68 8.49535
R269 VSS.t65 VSS.n3 8.49711
R270 VSS.n36 VSS.t65 17.0005
R271 VSS.n3 VSS.n2 0.0123024
R272 VSS.n2 VSS.t64 8.49535
R273 VSS.n250 VSS.t35 16.6364
R274 VSS.t57 VSS.n100 16.6364
R275 VSS.n87 VSS.t5 22.7764
R276 VSS.t76 VSS.n16 15.0005
R277 VSS.n343 VSS.t70 15.0005
R278 VSS.n328 VSS.t73 15.0005
R279 VSS.n338 VSS.t79 15.0005
R280 VSS.n207 VSS.n155 13.1592
R281 VSS.n270 VSS.n155 13.1592
R282 VSS.n174 VSS.n173 12.4949
R283 VSS.n297 VSS.t74 12.4949
R284 VSS.n242 VSS.n170 12.4949
R285 VSS.n395 VSS.n12 14.1886
R286 VSS.n172 VSS.n140 12.4949
R287 VSS.t74 VSS.n144 12.4949
R288 VSS.n175 VSS.n145 12.4949
R289 VSS.n180 VSS.n146 12.4949
R290 VSS.n184 VSS.n147 12.4949
R291 VSS.n186 VSS.n148 12.4949
R292 VSS.n188 VSS.n149 12.4949
R293 VSS.n191 VSS.n150 12.4949
R294 VSS.n196 VSS.n151 12.4949
R295 VSS.n198 VSS.n152 12.4949
R296 VSS.n200 VSS.n153 12.4949
R297 VSS.n202 VSS.n154 12.4949
R298 VSS.n209 VSS.n156 12.4949
R299 VSS.n214 VSS.n157 12.4949
R300 VSS.n216 VSS.n158 12.4949
R301 VSS.n221 VSS.n159 12.4949
R302 VSS.n223 VSS.n160 12.4949
R303 VSS.n226 VSS.n161 12.4949
R304 VSS.n227 VSS.n162 12.4949
R305 VSS.n255 VSS.n163 12.4949
R306 VSS.n229 VSS.n164 12.4949
R307 VSS.n230 VSS.n165 12.4949
R308 VSS.n231 VSS.n166 12.4949
R309 VSS.n233 VSS.n167 12.4949
R310 VSS.n238 VSS.n168 12.4949
R311 VSS.n239 VSS.n169 12.4949
R312 VSS.n393 VSS.n171 12.4949
R313 VSS.n241 VSS.n171 12.4949
R314 VSS.n242 VSS.t71 12.4949
R315 VSS.t71 VSS.n169 12.4949
R316 VSS.n245 VSS.n168 12.4949
R317 VSS.n247 VSS.n167 12.4949
R318 VSS.n249 VSS.n166 12.4949
R319 VSS.n250 VSS.n165 12.4949
R320 VSS.n254 VSS.n164 12.4949
R321 VSS.n228 VSS.n163 12.4949
R322 VSS.n257 VSS.n162 12.4949
R323 VSS.n258 VSS.n161 12.4949
R324 VSS.n260 VSS.n160 12.4949
R325 VSS.n262 VSS.n159 12.4949
R326 VSS.n264 VSS.n158 12.4949
R327 VSS.n266 VSS.n157 12.4949
R328 VSS.n268 VSS.n156 12.4949
R329 VSS.n272 VSS.n154 12.4949
R330 VSS.n274 VSS.n153 12.4949
R331 VSS.n278 VSS.n152 12.4949
R332 VSS.n280 VSS.n151 12.4949
R333 VSS.n282 VSS.n150 12.4949
R334 VSS.n285 VSS.n149 12.4949
R335 VSS.n288 VSS.n148 12.4949
R336 VSS.n290 VSS.n147 12.4949
R337 VSS.n292 VSS.n146 12.4949
R338 VSS.n294 VSS.n145 12.4949
R339 VSS.n296 VSS.n144 12.4949
R340 VSS.n297 VSS.n143 12.4949
R341 VSS.n174 VSS.n141 12.4949
R342 VSS.n173 VSS.n140 12.4949
R343 VSS.t88 VSS.n10 9.77299
R344 VSS.n78 VSS.t4 18.9821
R345 VSS.t19 VSS.n81 41.7518
R346 VSS.n397 VSS.n88 6777.49
R347 VSS.n87 VSS.t4 60.7281
R348 VSS.n92 VSS.t5 56.932
R349 VSS.n90 VSS.t8 49.3429
R350 VSS.n89 VSS.t10 45.5478
R351 VSS.n75 VSS.t11 41.7528
R352 VSS.n80 VSS.t13 37.9567
R353 VSS.n83 VSS.t14 34.1648
R354 VSS.t19 VSS.n93 37.9577
R355 VSS.t33 VSS.n116 11.0911
R356 VSS.t59 VSS.n99 11.0911
R357 VSS.n79 VSS.n74 0.00104474
R358 VSS.n396 VSS.n12 1.41975
R359 VSS.n173 VSS.n32 8.5005
R360 VSS.n258 VSS.n32 8.5005
R361 VSS.n255 VSS.n32 8.5005
R362 VSS.n250 VSS.n32 8.5005
R363 VSS.t71 VSS.n32 8.5005
R364 VSS.t74 VSS.n32 8.5005
R365 VSS.n227 VSS.n32 8.5005
R366 VSS.n229 VSS.n32 8.5005
R367 VSS.n231 VSS.n32 8.5005
R368 VSS.n71 VSS.n73 0.0161386
R369 VSS.n13 VSS.n176 8.4984
R370 VSS.n13 VSS.n178 8.4984
R371 VSS.n13 VSS.n182 8.4984
R372 VSS.n13 VSS.n20 8.4984
R373 VSS.n13 VSS.n286 8.4984
R374 VSS.n62 VSS.n61 0.00635632
R375 VSS.n13 VSS.n189 8.4984
R376 VSS.n13 VSS.n193 8.4984
R377 VSS.n13 VSS.n57 8.4984
R378 VSS.n13 VSS.n276 8.4984
R379 VSS.n13 VSS.n37 3.39341
R380 VSS.n37 VSS.n52 0.0255352
R381 VSS.n13 VSS.n203 8.4984
R382 VSS.n13 VSS.n205 8.4984
R383 VSS.n13 VSS.n211 8.4984
R384 VSS.n13 VSS.n47 8.4984
R385 VSS.n13 VSS.n218 8.4984
R386 VSS.n13 VSS.n45 4.24501
R387 VSS.n13 VSS.n59 8.4984
R388 VSS.n13 VSS.n225 8.4984
R389 VSS.n13 VSS.n31 4.24478
R390 VSS.n44 VSS.n43 0.014444
R391 VSS.n13 VSS.n252 8.4984
R392 VSS.n13 VSS.n67 8.4984
R393 VSS.n13 VSS.n235 8.4984
R394 VSS.n41 VSS.n236 0.0161786
R395 VSS.n13 VSS.n243 8.4984
R396 VSS.n13 VSS.n15 2.83632
R397 VSS.n71 VSS.n72 0.014444
R398 VSS.n177 VSS.n32 8.4984
R399 VSS.n181 VSS.n32 8.4984
R400 VSS.n18 VSS.n32 8.4984
R401 VSS.n19 VSS.n32 4.24607
R402 VSS.n54 VSS.n19 0.0189677
R403 VSS.n54 VSS.n55 0.0209066
R404 VSS.n283 VSS.n32 8.4984
R405 VSS.n192 VSS.n32 8.4984
R406 VSS.n194 VSS.n32 8.4984
R407 VSS.n40 VSS.n32 4.24427
R408 VSS.n39 VSS.n40 0.0222697
R409 VSS.n275 VSS.n32 8.4984
R410 VSS.n204 VSS.n32 8.4984
R411 VSS.n65 VSS.n32 8.4984
R412 VSS.n51 VSS.n32 8.4984
R413 VSS.n210 VSS.n32 8.4984
R414 VSS.n212 VSS.n32 8.4984
R415 VSS.n49 VSS.n32 4.24569
R416 VSS.n56 VSS.n49 0.0157198
R417 VSS.n217 VSS.n32 8.4984
R418 VSS.n219 VSS.n32 8.4984
R419 VSS.n46 VSS.n32 4.24661
R420 VSS.n60 VSS.n46 0.00768115
R421 VSS.n224 VSS.n32 8.4984
R422 VSS.n30 VSS.n32 8.4984
R423 VSS.n33 VSS.n32 4.24676
R424 VSS.n251 VSS.n32 8.4984
R425 VSS.n70 VSS.n68 0.00635632
R426 VSS.n234 VSS.n32 8.4984
R427 VSS.n236 VSS.n32 8.4984
R428 VSS.n41 VSS.n42 0.014444
R429 VSS.t82 VSS.n6 0.0757845
R430 VSS.n392 VSS.n172 7.6711
R431 VSS.n10 VSS.t67 6.87897
R432 VSS.n10 VSS.t63 6.87896
R433 VSS.n86 VSS.t2 15.187
R434 VSS.n341 VSS.t76 7.49606
R435 VSS.t70 VSS.n325 7.49606
R436 VSS.t73 VSS.n327 7.49606
R437 VSS.t79 VSS.n337 7.49606
R438 VSS.n296 VSS.n295 7.20236
R439 VSS.n294 VSS.n293 7.20236
R440 VSS.n292 VSS.n291 7.20236
R441 VSS.n183 VSS.n130 7.20236
R442 VSS.n290 VSS.n289 7.20236
R443 VSS.n185 VSS.n129 7.20236
R444 VSS.n285 VSS.n284 7.20236
R445 VSS.n282 VSS.n281 7.20236
R446 VSS.n195 VSS.n126 7.20236
R447 VSS.n280 VSS.n279 7.20236
R448 VSS.n197 VSS.n125 7.20236
R449 VSS.n199 VSS.n124 7.20236
R450 VSS.n274 VSS.n273 7.20236
R451 VSS.n201 VSS.n123 7.20236
R452 VSS.n272 VSS.n271 7.20236
R453 VSS.n206 VSS.n122 7.20236
R454 VSS.n268 VSS.n267 7.20236
R455 VSS.n266 VSS.n265 7.20236
R456 VSS.n215 VSS.n119 7.20236
R457 VSS.n264 VSS.n263 7.20236
R458 VSS.n247 VSS.n246 7.20236
R459 VSS.n142 VSS.n141 7.20236
R460 VSS.n180 VSS.n179 7.20236
R461 VSS.n287 VSS.n101 7.20236
R462 VSS.n188 VSS.n187 7.20236
R463 VSS.n191 VSS.n190 7.20236
R464 VSS.n277 VSS.n105 7.20236
R465 VSS.n269 VSS.n108 7.20236
R466 VSS.n209 VSS.n208 7.20236
R467 VSS.n214 VSS.n213 7.20236
R468 VSS.n221 VSS.n220 7.20236
R469 VSS.n261 VSS.n112 7.20236
R470 VSS.n223 VSS.n222 7.20236
R471 VSS.n259 VSS.n113 7.20236
R472 VSS.n256 VSS.n226 7.20236
R473 VSS.n253 VSS.n228 7.20236
R474 VSS.n248 VSS.n230 7.20236
R475 VSS.n233 VSS.n232 7.20236
R476 VSS.n238 VSS.n237 7.20236
R477 VSS.n244 VSS.n239 7.20236
R478 VSS.n240 VSS.n170 7.20236
R479 VSS.n394 VSS.n393 7.20236
R480 VSS.n395 VSS.n394 7.20236
R481 VSS.n241 VSS.n240 7.20236
R482 VSS.n245 VSS.n244 7.20236
R483 VSS.n237 VSS.n115 7.20236
R484 VSS.n246 VSS.n114 7.20236
R485 VSS.n232 VSS.n116 7.20236
R486 VSS.n249 VSS.n248 7.20236
R487 VSS.n254 VSS.n253 7.20236
R488 VSS.n257 VSS.n256 7.20236
R489 VSS.n260 VSS.n259 7.20236
R490 VSS.n222 VSS.n117 7.20236
R491 VSS.n262 VSS.n261 7.20236
R492 VSS.n220 VSS.n118 7.20236
R493 VSS.n263 VSS.n111 7.20236
R494 VSS.n216 VSS.n215 7.20236
R495 VSS.n265 VSS.n110 7.20236
R496 VSS.n213 VSS.n120 7.20236
R497 VSS.n267 VSS.n109 7.20236
R498 VSS.n208 VSS.n121 7.20236
R499 VSS.n270 VSS.n269 7.20236
R500 VSS.n207 VSS.n206 7.20236
R501 VSS.n271 VSS.n107 7.20236
R502 VSS.n202 VSS.n201 7.20236
R503 VSS.n273 VSS.n106 7.20236
R504 VSS.n200 VSS.n199 7.20236
R505 VSS.n278 VSS.n277 7.20236
R506 VSS.n198 VSS.n197 7.20236
R507 VSS.n279 VSS.n104 7.20236
R508 VSS.n196 VSS.n195 7.20236
R509 VSS.n281 VSS.n103 7.20236
R510 VSS.n190 VSS.n127 7.20236
R511 VSS.n284 VSS.n102 7.20236
R512 VSS.n187 VSS.n128 7.20236
R513 VSS.n288 VSS.n287 7.20236
R514 VSS.n186 VSS.n185 7.20236
R515 VSS.n289 VSS.n100 7.20236
R516 VSS.n184 VSS.n183 7.20236
R517 VSS.n291 VSS.n99 7.20236
R518 VSS.n179 VSS.n131 7.20236
R519 VSS.n293 VSS.n98 7.20236
R520 VSS.n295 VSS.n175 7.20236
R521 VSS.n143 VSS.n142 7.20236
R522 VSS.n23 VSS.n132 1.70031
R523 VSS.n115 VSS.t31 5.54579
R524 VSS.t60 VSS.n98 5.54579
R525 VSS.n342 VSS.t77 4.5005
R526 VSS.t32 VSS.n324 4.5005
R527 VSS.n339 VSS.t81 4.5005
R528 VSS.t61 VSS.n326 4.5005
R529 VSS.n15 VSS.n32 2.42878
R530 VSS.n13 VSS.n66 4.25571
R531 VSS.n320 VSS.n319 3.03506
R532 VSS.n384 VSS.t85 3.0005
R533 VSS.n398 VSS.t82 3.0005
R534 VSS.n313 VSS.t66 3.0005
R535 VSS.n359 VSS.t62 3.0005
R536 VSS.n340 VSS.n323 3.0005
R537 VSS.n345 VSS.n344 3.0005
R538 VSS.n336 VSS.n335 3.0005
R539 VSS.n330 VSS.n329 3.0005
R540 VSS.t86 VSS.n79 13.761
R541 VSS.n96 VSS.n74 0.00289146
R542 VSS.n76 VSS.n74 0.0109013
R543 VSS.n93 VSS.n74 0.0108886
R544 VSS.n81 VSS.n74 0.0109013
R545 VSS.n85 VSS.n74 0.0109013
R546 VSS.n89 VSS.n74 0.0108886
R547 VSS.n90 VSS.n74 0.0108886
R548 VSS.n92 VSS.n74 0.0108886
R549 VSS.n87 VSS.n74 0.0108886
R550 VSS.n82 VSS.t0 11.3996
R551 VSS.n74 VSS.n82 0.00289146
R552 VSS.n74 VSS.n88 0.00104907
R553 VSS.n405 VSS.n404 2.63306
R554 VSS.n315 VSS.t114 2.48177
R555 VSS.n316 VSS.t111 2.48177
R556 VSS.n317 VSS.t108 2.48177
R557 VSS.n318 VSS.t105 2.48177
R558 VSS.n355 VSS.t99 2.48177
R559 VSS.n356 VSS.t96 2.48177
R560 VSS.n357 VSS.t93 2.48177
R561 VSS.n358 VSS.t90 2.48177
R562 VSS.n347 VSS.t118 2.48177
R563 VSS.n348 VSS.t120 2.48177
R564 VSS.n349 VSS.t122 2.48177
R565 VSS.n322 VSS.t124 2.48177
R566 VSS.n321 VSS.t128 2.48177
R567 VSS.n331 VSS.t130 2.48177
R568 VSS.n332 VSS.t132 2.48177
R569 VSS.n333 VSS.t134 2.48177
R570 VSS.n399 VSS.t3 2.48177
R571 VSS.n400 VSS.t6 2.48177
R572 VSS.n401 VSS.t9 2.48177
R573 VSS.n139 VSS.t12 2.48177
R574 VSS.t18 VSS.n138 2.48177
R575 VSS.n387 VSS.t21 2.48177
R576 VSS.n388 VSS.t24 2.48177
R577 VSS.t27 VSS.n389 2.48177
R578 VSS.n347 VSS.t34 2.48177
R579 VSS.n348 VSS.t37 2.48177
R580 VSS.n349 VSS.t40 2.48177
R581 VSS.n322 VSS.t43 2.48177
R582 VSS.n321 VSS.t49 2.48177
R583 VSS.n331 VSS.t52 2.48177
R584 VSS.n332 VSS.t55 2.48177
R585 VSS.n333 VSS.t58 2.48177
R586 VSS.n402 VSS.n134 2.27525
R587 VSS.n403 VSS.n402 2.27525
R588 VSS.n353 VSS.n352 2.27525
R589 VSS.n353 VSS.n319 2.27525
R590 VSS.n13 VSS.n174 2.25406
R591 VSS.n13 VSS.n297 2.25406
R592 VSS.n13 VSS.n242 2.25406
R593 VSS.n13 VSS.n12 0.257022
R594 VSS.n23 VSS.n140 2.25406
R595 VSS.n23 VSS.n144 2.25406
R596 VSS.n23 VSS.n145 2.25406
R597 VSS.n23 VSS.n146 2.25406
R598 VSS.n23 VSS.n147 2.25406
R599 VSS.n23 VSS.n148 2.25406
R600 VSS.n23 VSS.n149 2.25406
R601 VSS.n23 VSS.n150 2.25406
R602 VSS.n23 VSS.n151 2.25406
R603 VSS.n23 VSS.n152 2.25406
R604 VSS.n23 VSS.n153 2.25406
R605 VSS.n23 VSS.n154 2.25406
R606 VSS.n23 VSS.n156 2.25406
R607 VSS.n23 VSS.n157 2.25406
R608 VSS.n23 VSS.n158 2.25406
R609 VSS.n23 VSS.n159 2.25406
R610 VSS.n23 VSS.n160 2.25406
R611 VSS.n23 VSS.n161 2.25406
R612 VSS.n23 VSS.n162 2.25406
R613 VSS.n23 VSS.n163 2.25406
R614 VSS.n23 VSS.n164 2.25406
R615 VSS.n23 VSS.n165 2.25406
R616 VSS.n23 VSS.n166 2.25406
R617 VSS.n23 VSS.n167 2.25406
R618 VSS.n23 VSS.n168 2.25406
R619 VSS.n23 VSS.n169 2.25406
R620 VSS.n23 VSS.n171 2.25406
R621 VSS.t78 VSS.n342 2.2505
R622 VSS.t72 VSS.n324 2.2505
R623 VSS.t80 VSS.n339 2.2505
R624 VSS.n326 VSS.t75 2.2505
R625 VSS.n74 VSS.n383 2.09947
R626 VSS.n74 VSS.n382 2.09947
R627 VSS.n74 VSS.n381 2.09947
R628 VSS.n74 VSS.n379 2.09947
R629 VSS.n74 VSS.n136 2.09947
R630 VSS.n74 VSS.n377 2.09947
R631 VSS.n74 VSS.n375 2.09947
R632 VSS.n74 VSS.n373 2.09947
R633 VSS.n10 VSS.n298 2.09901
R634 VSS.n10 VSS.n299 2.09888
R635 VSS.n10 VSS.n302 2.09868
R636 VSS.n10 VSS.n301 2.09862
R637 VSS.n10 VSS.n304 2.09849
R638 VSS.n10 VSS.n305 2.09849
R639 VSS.n10 VSS.n303 2.09849
R640 VSS.n10 VSS.n300 2.09849
R641 VSS.n23 VSS.n155 1.92189
R642 VSS.n396 VSS.n32 1.7005
R643 VSS.n133 VSS.n23 1.18277
R644 VSS.n132 VSS.n392 1.53502
R645 VSS.n398 VSS.n24 1.52811
R646 VSS.n313 VSS.n0 1.52811
R647 VSS.n3 VSS.n359 1.52811
R648 VSS.n384 VSS.n27 1.52811
R649 VSS.n4 VSS.n10 1.13482
R650 VSS.n1 VSS.n10 1.10812
R651 VSS.n351 VSS.n134 1.1929
R652 VSS.n352 VSS.n351 1.1929
R653 VSS.n403 VSS.n135 1.1929
R654 VSS.n319 VSS.n135 1.1929
R655 VSS.n351 VSS.n350 1.13147
R656 VSS.n350 VSS.n135 1.13089
R657 VSS.t78 VSS.n32 1.12521
R658 VSS.n32 VSS.t80 1.03559
R659 VSS.n352 VSS.n320 0.9537
R660 VSS.n10 VSS.n8 0.910334
R661 VSS.n10 VSS.n9 0.909051
R662 VSS.n142 VSS.n32 0.650322
R663 VSS.n179 VSS.n32 0.650322
R664 VSS.n287 VSS.n32 0.650322
R665 VSS.n187 VSS.n32 0.650322
R666 VSS.n190 VSS.n32 0.650322
R667 VSS.n277 VSS.n32 0.650322
R668 VSS.n269 VSS.n32 0.650322
R669 VSS.n208 VSS.n32 0.650322
R670 VSS.n213 VSS.n32 0.650322
R671 VSS.n220 VSS.n32 0.650322
R672 VSS.n261 VSS.n32 0.650322
R673 VSS.n222 VSS.n32 0.650322
R674 VSS.n259 VSS.n32 0.650322
R675 VSS.n256 VSS.n32 0.650322
R676 VSS.n253 VSS.n32 0.650322
R677 VSS.n248 VSS.n32 0.650322
R678 VSS.n232 VSS.n32 0.650322
R679 VSS.n237 VSS.n32 0.650322
R680 VSS.n244 VSS.n32 0.650322
R681 VSS.n240 VSS.n32 0.650322
R682 VSS.n394 VSS.n32 0.650322
R683 VSS.n295 VSS.n32 0.650322
R684 VSS.n293 VSS.n32 0.650322
R685 VSS.n291 VSS.n32 0.650322
R686 VSS.n183 VSS.n32 0.650322
R687 VSS.n289 VSS.n32 0.650322
R688 VSS.n185 VSS.n32 0.650322
R689 VSS.n284 VSS.n32 0.650322
R690 VSS.n281 VSS.n32 0.650322
R691 VSS.n195 VSS.n32 0.650322
R692 VSS.n279 VSS.n32 0.650322
R693 VSS.n197 VSS.n32 0.650322
R694 VSS.n199 VSS.n32 0.650322
R695 VSS.n273 VSS.n32 0.650322
R696 VSS.n201 VSS.n32 0.650322
R697 VSS.n271 VSS.n32 0.650322
R698 VSS.n206 VSS.n32 0.650322
R699 VSS.n267 VSS.n32 0.650322
R700 VSS.n265 VSS.n32 0.650322
R701 VSS.n215 VSS.n32 0.650322
R702 VSS.n263 VSS.n32 0.650322
R703 VSS.n246 VSS.n32 0.650322
R704 VSS.n406 VSS.n405 0.5517
R705 VSS.n406 VSS.n134 0.4025
R706 VSS.n404 VSS.n403 0.4025
R707 VSS.n399 VSS.n398 0.209825
R708 VSS.n315 VSS.n313 0.209825
R709 VSS.n359 VSS.n358 0.209825
R710 VSS.n389 VSS.n384 0.209825
R711 VSS.n372 VSS.t3 0.200997
R712 VSS.n374 VSS.t6 0.200997
R713 VSS.n376 VSS.t9 0.200997
R714 VSS.n378 VSS.t12 0.200997
R715 VSS.n380 VSS.t18 0.200997
R716 VSS.t21 VSS.n386 0.200997
R717 VSS.t24 VSS.n385 0.200997
R718 VSS.n390 VSS.t27 0.200997
R719 VSS.n70 VSS.t34 0.200997
R720 VSS.n33 VSS.t37 0.200997
R721 VSS.n60 VSS.t40 0.200997
R722 VSS.n48 VSS.t43 0.200997
R723 VSS.n38 VSS.t49 0.200997
R724 VSS.n58 VSS.t52 0.200997
R725 VSS.n61 VSS.t55 0.200997
R726 VSS.n20 VSS.t58 0.200997
R727 VSS.t114 VSS.n314 0.200995
R728 VSS.t111 VSS.n312 0.200995
R729 VSS.t108 VSS.n311 0.200995
R730 VSS.t105 VSS.n310 0.200995
R731 VSS.t99 VSS.n309 0.200995
R732 VSS.t96 VSS.n308 0.200995
R733 VSS.t93 VSS.n307 0.200995
R734 VSS.t90 VSS.n306 0.200995
R735 VSS.t118 VSS.n70 0.200995
R736 VSS.t120 VSS.n33 0.200995
R737 VSS.t122 VSS.n60 0.200995
R738 VSS.t124 VSS.n48 0.200995
R739 VSS.t128 VSS.n38 0.200995
R740 VSS.t130 VSS.n58 0.200995
R741 VSS.t132 VSS.n61 0.200995
R742 VSS.t134 VSS.n20 0.200995
R743 VSS.t46 VSS.t126 0.185126
R744 VSS.n400 VSS.n399 0.16242
R745 VSS.n401 VSS.n400 0.16242
R746 VSS.n139 VSS.n401 0.16242
R747 VSS.n137 VSS.n139 0.16242
R748 VSS.n137 VSS.n138 0.16242
R749 VSS.n387 VSS.n138 0.16242
R750 VSS.n388 VSS.n387 0.16242
R751 VSS.n389 VSS.n388 0.16242
R752 VSS.n358 VSS.n357 0.16242
R753 VSS.n357 VSS.n356 0.16242
R754 VSS.n356 VSS.n355 0.16242
R755 VSS.n355 VSS.n354 0.16242
R756 VSS.n354 VSS.n318 0.16242
R757 VSS.n318 VSS.n317 0.16242
R758 VSS.n317 VSS.n316 0.16242
R759 VSS.n316 VSS.n315 0.16242
R760 VSS.n314 VSS.n9 0.147142
R761 VSS.n306 VSS.n8 0.145358
R762 VSS.n347 VSS.n346 0.117247
R763 VSS.n334 VSS.n333 0.1171
R764 VSS.n373 VSS.n372 0.0952183
R765 VSS.n306 VSS.n298 0.094644
R766 VSS.n314 VSS.n305 0.0940701
R767 VSS.n375 VSS.n374 0.0927738
R768 VSS.n390 VSS.n383 0.0925656
R769 VSS.n307 VSS.n299 0.0920753
R770 VSS.n312 VSS.n304 0.0912432
R771 VSS.n377 VSS.n376 0.0903294
R772 VSS.n379 VSS.t15 0.0903294
R773 VSS.n385 VSS.n382 0.0901212
R774 VSS.t102 VSS.n302 0.089375
R775 VSS.t102 VSS.n301 0.08912
R776 VSS.n308 VSS.n300 0.0890531
R777 VSS.n311 VSS.n303 0.0889922
R778 VSS.n136 VSS.n378 0.0878849
R779 VSS.n381 VSS.n380 0.0878849
R780 VSS.t15 VSS.n136 0.0876767
R781 VSS.n386 VSS.n381 0.0876767
R782 VSS.n310 VSS.n303 0.0865477
R783 VSS.n309 VSS.n300 0.0864836
R784 VSS.n309 VSS.n301 0.0864173
R785 VSS.n310 VSS.n302 0.0861674
R786 VSS.n386 VSS.n382 0.0854405
R787 VSS.n378 VSS.n377 0.0852323
R788 VSS.n380 VSS.n379 0.0852323
R789 VSS.n6 VSS.n372 0.153348
R790 VSS.n311 VSS.n304 0.0842923
R791 VSS.n308 VSS.n299 0.0834745
R792 VSS.t62 VSS.n8 0.0834709
R793 VSS.n385 VSS.n383 0.082996
R794 VSS.n376 VSS.n375 0.0827878
R795 VSS.t66 VSS.n9 0.082562
R796 VSS.n390 VSS.n7 0.156346
R797 VSS.n312 VSS.n305 0.0814654
R798 VSS.n348 VSS.n347 0.08146
R799 VSS.n349 VSS.n348 0.08146
R800 VSS.n322 VSS.n349 0.08146
R801 VSS.n64 VSS.n322 0.08146
R802 VSS.n64 VSS.n321 0.08146
R803 VSS.n331 VSS.n321 0.08146
R804 VSS.n332 VSS.n331 0.08146
R805 VSS.n333 VSS.n332 0.08146
R806 VSS.n307 VSS.n298 0.0809034
R807 VSS.n374 VSS.n373 0.0803434
R808 VSS.n392 VSS.n32 0.143492
R809 VSS.t72 VSS.n23 1.05028
R810 VSS.t75 VSS.n133 0.0592831
R811 VSS.n320 VSS 0.0455795
R812 VSS.n405 VSS 0.0455795
R813 VSS VSS.n406 0.0445
R814 VSS.n404 VSS 0.0445
R815 VSS.t15 VSS.n137 0.0394177
R816 VSS.n354 VSS.t102 0.0394177
R817 VSS.n402 VSS.n137 0.0389615
R818 VSS.n354 VSS.n353 0.0389615
R819 VSS.t77 VSS.n341 0.031258
R820 VSS.n325 VSS.t32 0.031258
R821 VSS.n346 VSS.n345 0.0291125
R822 VSS.n335 VSS.n334 0.0291125
R823 VSS.n334 VSS.n330 0.0291125
R824 VSS.n346 VSS.n323 0.0291125
R825 VSS.n345 VSS.n324 0.0281144
R826 VSS.n339 VSS.n335 0.0281144
R827 VSS.n330 VSS.n326 0.0281144
R828 VSS.n342 VSS.n323 0.0281144
R829 VSS.n327 VSS.n73 0.0216549
R830 VSS.n337 VSS.n73 0.0216549
R831 VSS.n328 VSS.t61 0.0208704
R832 VSS.t81 VSS.n338 0.0208704
R833 VSS.n340 VSS.n16 0.0202884
R834 VSS.n344 VSS.n343 0.0202884
R835 VSS.n329 VSS.n328 0.0202884
R836 VSS.n338 VSS.n336 0.0202884
R837 VSS.n350 VSS.n64 0.0197308
R838 VSS.t46 VSS.n64 0.0194533
R839 VSS.n73 VSS.n66 0.0135839
R840 VSS.t66 VSS.n35 0.0133922
R841 VSS.n36 VSS.t62 0.0133922
R842 VSS.n177 VSS.n176 0.0118857
R843 VSS.n181 VSS.n178 0.0118857
R844 VSS.n18 VSS.n182 0.0118857
R845 VSS.n286 VSS.n63 0.0161786
R846 VSS.n283 VSS.n189 0.0118857
R847 VSS.n192 VSS.n189 0.0118857
R848 VSS.n194 VSS.n193 0.0118857
R849 VSS.n276 VSS.n275 0.0118857
R850 VSS.n204 VSS.n203 0.0118857
R851 VSS.n51 VSS.n50 0.00668938
R852 VSS.n211 VSS.n210 0.0118857
R853 VSS.n212 VSS.n211 0.0118857
R854 VSS.n218 VSS.n217 0.0118857
R855 VSS.n219 VSS.n218 0.0118857
R856 VSS.n224 VSS.n59 0.0118857
R857 VSS.n252 VSS.n251 0.0118857
R858 VSS.n70 VSS.n69 0.00858771
R859 VSS.n234 VSS.n69 0.0161786
R860 VSS.n236 VSS.n235 0.0118857
R861 VSS.n243 VSS.n17 0.0161786
R862 VSS.n235 VSS.n234 0.0118857
R863 VSS.n251 VSS.n67 0.0118857
R864 VSS.n43 VSS.n252 0.0161786
R865 VSS.n30 VSS.n225 0.0118857
R866 VSS.n225 VSS.n224 0.0118857
R867 VSS.n60 VSS.n59 0.0118857
R868 VSS.n217 VSS.n56 0.0180748
R869 VSS.n47 VSS.n212 0.0118857
R870 VSS.n210 VSS.n50 0.0180744
R871 VSS.n65 VSS.n205 0.0118857
R872 VSS.n205 VSS.n204 0.0118857
R873 VSS.n58 VSS.n57 0.0118857
R874 VSS.n57 VSS.n194 0.0118857
R875 VSS.n193 VSS.n192 0.0118857
R876 VSS.n63 VSS.n61 0.00858771
R877 VSS.n20 VSS.n18 0.0118857
R878 VSS.n182 VSS.n181 0.0118857
R879 VSS.n178 VSS.n177 0.0118857
R880 VSS.n17 VSS.n16 0.0115582
R881 VSS.n343 VSS.n17 0.0115582
R882 VSS.n360 VSS.n10 0.0112168
R883 VSS.n361 VSS.n10 0.0112168
R884 VSS.n362 VSS.n10 0.0112168
R885 VSS.n363 VSS.n10 0.0112168
R886 VSS.n364 VSS.n10 0.0112168
R887 VSS.n366 VSS.n10 0.0112168
R888 VSS.n367 VSS.n10 0.0112168
R889 VSS.n368 VSS.n10 0.0112168
R890 VSS.n369 VSS.n10 0.0112168
R891 VSS.n370 VSS.n10 0.0112168
R892 VSS.n371 VSS.n10 0.0112168
R893 VSS.t112 VSS.n21 22.7839
R894 VSS.t115 VSS.n10 12.2976
R895 VSS.n341 VSS.n340 0.0108877
R896 VSS.n344 VSS.n325 0.0108877
R897 VSS.n329 VSS.n327 0.0108877
R898 VSS.n337 VSS.n336 0.0108877
R899 VSS.t75 VSS.n73 0.0101032
R900 VSS.t80 VSS.n73 0.0101032
R901 VSS.n17 VSS.t72 0.00981217
R902 VSS.n365 VSS.n10 0.00963963
R903 VSS.t85 VSS.n7 0.0738339
R904 VSS.t85 VSS.n29 0.03986
R905 VSS.n26 VSS.t82 0.03986
R906 VSS.n17 VSS.t78 0.0293983
R907 VSS.n20 VSS.n19 0.0273751
R908 VSS.n44 VSS.n33 0.0242841
R909 VSS.n10 VSS.n21 0.0237281
R910 VSS.n13 VSS.n22 0.0236688
R911 VSS.n2 VSS.n36 0.0123024
R912 VSS.n5 VSS.n35 0.0123024
R913 VSS.n38 VSS.n37 0.0151377
R914 VSS.n58 VSS.n40 0.0123715
R915 VSS.n45 VSS.n219 0.0227656
R916 VSS.n31 VSS.n30 0.0230704
R917 VSS.n49 VSS.n48 0.00953071
R918 VSS.n48 VSS.n47 0.0175786
R919 VSS.n72 VSS.n176 0.0174081
R920 VSS.n68 VSS.n67 0.0174081
R921 VSS.n62 VSS.n283 0.0174081
R922 VSS.n286 VSS.n55 0.0174081
R923 VSS.n276 VSS.n53 0.0174081
R924 VSS.t46 VSS.n65 0.0146006
R925 VSS.n46 VSS.n45 0.0185622
R926 VSS.t46 VSS.n51 0.0136083
R927 VSS.n33 VSS.n31 0.0185615
R928 VSS.n275 VSS.n38 0.0175786
R929 VSS.n243 VSS.n42 0.0174081
R930 VSS.n4 VSS.t64 17.0032
R931 VSS.n1 VSS.t68 17.0032
C0 vout2 vin2 18.7881f
C1 vin1 vin2 0.22004f
C2 VDD vout1 20.1166f
C3 VDD vin3 30.4066f
C4 VDD vout4 20.1166f
C5 vin3 vin2 0.25462f
C6 vout1 vin1 18.7881f
C7 VDD vin2 30.4066f
C8 vout3 vin3 18.7881f
C9 vout3 VDD 20.1166f
C10 vin3 vin4 0.22004f
C11 vout4 vin4 18.7881f
C12 vout2 VDD 20.1166f
C13 VDD vin1 30.4169f
C14 VDD vin4 30.4169f
C15 vout1 VSS 15.77604f
C16 vout2 VSS 15.75839f
C17 vout3 VSS 15.75839f
C18 vout4 VSS 15.77604f
C19 VSS.t58 VSS 8.608f
C20 VSS.t24 VSS 8.62565f
.ends
