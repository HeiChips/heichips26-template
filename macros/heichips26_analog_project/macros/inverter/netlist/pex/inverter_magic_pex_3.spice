* PEX produced on Sun Aug  2 02:10:11 CEST 2026 using scripts/sak-pex.sh with m=3 and s=1 (extresist threshold=10000 mOhm, minres=1000 mOhm, mindelay=1 ps)
* NGSPICE file created from inverter_pex.ext - technology: ihp-sg13cmos5l

.subckt inverter_pex VDD vin vout VSS
X0 vout vin VDD VDD sg13_lv_pmos ad=1.14p pd=6.38u as=1.14p ps=6.38u w=6u l=1u
X1 VDD vin vout VDD sg13_lv_pmos ad=1.14p pd=6.38u as=1.14p ps=6.38u w=6u l=1u
X2 vout vin VDD VDD sg13_lv_pmos ad=1.14p pd=6.38u as=1.14p ps=6.38u w=6u l=1u
X3 vout vin VSS.t15 VSS.t16 sg13_lv_nmos ad=0.19p pd=1.38u as=0.19p ps=1.38u w=1u l=1u
X4 vout vin VSS.t1 VSS.t0 sg13_lv_nmos ad=0.19p pd=1.38u as=0.19p ps=1.38u w=1u l=1u
X5 VSS.t33 VSS.t31 VSS.t1 VSS.t32 sg13_lv_nmos ad=0.34p pd=2.68u as=0 ps=0 w=1u l=1u
X6 VSS.t24 vin vout VSS.t23 sg13_lv_nmos ad=0.19p pd=1.38u as=0.19p ps=1.38u w=1u l=1u
X7 vout vin VDD VDD sg13_lv_pmos ad=1.14p pd=6.38u as=1.14p ps=6.38u w=6u l=1u
X8 VDD vin vout VDD sg13_lv_pmos ad=1.14p pd=6.38u as=1.14p ps=6.38u w=6u l=1u
X9 vout vin VSS.t21 VSS.t22 sg13_lv_nmos ad=0.19p pd=1.38u as=0.19p ps=1.38u w=1u l=1u
X10 vout vin VDD VDD sg13_lv_pmos ad=1.14p pd=6.38u as=1.14p ps=6.38u w=6u l=1u
X11 VSS.t9 vin vout VSS.t8 sg13_lv_nmos ad=0.19p pd=1.38u as=0.19p ps=1.38u w=1u l=1u
X12 VSS.t30 vin vout VSS.t29 sg13_lv_nmos ad=0.19p pd=1.38u as=0.19p ps=1.38u w=1u l=1u
X13 VDD vin vout VDD sg13_lv_pmos ad=1.14p pd=6.38u as=1.14p ps=6.38u w=6u l=1u
X14 vout vin VDD VDD sg13_lv_pmos ad=1.14p pd=6.38u as=1.14p ps=6.38u w=6u l=1u
X15 VDD vin vout VDD sg13_lv_pmos ad=1.14p pd=6.38u as=1.14p ps=6.38u w=6u l=1u
X16 vout vin VDD VDD sg13_lv_pmos ad=1.14p pd=6.38u as=1.14p ps=6.38u w=6u l=1u
X17 vout vin VSS.t27 VSS.t28 sg13_lv_nmos ad=0.19p pd=1.38u as=0.19p ps=1.38u w=1u l=1u
X18 VSS.t15 vin vout VSS.t14 sg13_lv_nmos ad=0.19p pd=1.38u as=0.19p ps=1.38u w=1u l=1u
X19 VDD vin vout VDD sg13_lv_pmos ad=1.14p pd=6.38u as=1.14p ps=6.38u w=6u l=1u
X20 vout vin VDD VDD sg13_lv_pmos ad=1.14p pd=6.38u as=1.14p ps=6.38u w=6u l=1u
X21 VDD VDD VDD VDD sg13_lv_pmos ad=2.04p pd=12.68u as=0.14199n ps=0.28418m w=6u l=1u
X22 vout vin VSS.t6 VSS.t7 sg13_lv_nmos ad=0.19p pd=1.38u as=0.19p ps=1.38u w=1u l=1u
X23 VSS.t21 vin vout VSS.t20 sg13_lv_nmos ad=0.19p pd=1.38u as=0.19p ps=1.38u w=1u l=1u
X24 VDD vin vout VDD sg13_lv_pmos ad=1.14p pd=6.38u as=1.14p ps=6.38u w=6u l=1u
X25 VDD vin vout VDD sg13_lv_pmos ad=1.14p pd=6.38u as=1.14p ps=6.38u w=6u l=1u
X26 VSS.t6 vin vout VSS.t5 sg13_lv_nmos ad=0.19p pd=1.38u as=0.19p ps=1.38u w=1u l=1u
X27 vout vin VDD VDD sg13_lv_pmos ad=1.14p pd=6.38u as=1.14p ps=6.38u w=6u l=1u
X28 VSS.t3 vin vout VSS.t2 sg13_lv_nmos ad=0.19p pd=1.38u as=0.19p ps=1.38u w=1u l=1u
X29 vout vin VSS.t12 VSS.t13 sg13_lv_nmos ad=0.19p pd=1.38u as=0.19p ps=1.38u w=1u l=1u
X30 VSS.t27 vin vout VSS.t26 sg13_lv_nmos ad=0.19p pd=1.38u as=0.19p ps=1.38u w=1u l=1u
X31 vout vin VSS.t3 VSS.t4 sg13_lv_nmos ad=0.19p pd=1.38u as=0.19p ps=1.38u w=1u l=1u
X32 VDD vin vout VDD sg13_lv_pmos ad=1.14p pd=6.38u as=1.14p ps=6.38u w=6u l=1u
X33 vout vin VSS.t24 VSS.t25 sg13_lv_nmos ad=0.19p pd=1.38u as=0.19p ps=1.38u w=1u l=1u
X34 vout vin VDD VDD sg13_lv_pmos ad=1.14p pd=6.38u as=1.14p ps=6.38u w=6u l=1u
X35 VSS.t12 vin vout VSS.t11 sg13_lv_nmos ad=0.19p pd=1.38u as=0.19p ps=1.38u w=1u l=1u
X36 VDD vin vout VDD sg13_lv_pmos ad=1.14p pd=6.38u as=1.14p ps=6.38u w=6u l=1u
X37 VDD VDD VDD VDD sg13_lv_pmos ad=1.14p pd=6.38u as=0 ps=0 w=6u l=1u
X38 VDD vin vout VDD sg13_lv_pmos ad=1.14p pd=6.38u as=1.14p ps=6.38u w=6u l=1u
X39 vout vin VSS.t9 VSS.t10 sg13_lv_nmos ad=0.19p pd=1.38u as=0.19p ps=1.38u w=1u l=1u
X40 vout vin VSS.t18 VSS.t19 sg13_lv_nmos ad=0.19p pd=1.38u as=0.19p ps=1.38u w=1u l=1u
X41 vout vin VDD VDD sg13_lv_pmos ad=1.14p pd=6.38u as=1.14p ps=6.38u w=6u l=1u
X42 VSS.t18 vin vout VSS.t17 sg13_lv_nmos ad=0.19p pd=1.38u as=0.19p ps=1.38u w=1u l=1u
X43 VSS.t30 VSS.t34 VSS.t36 VSS.t35 sg13_lv_nmos ad=0.19p pd=1.38u as=0 ps=0 w=1u l=1u
R0 VSS.n89 VSS.t32 188.541
R1 VSS.t0 VSS.n88 177.45
R2 VSS.n144 VSS.t29 177.45
R3 VSS.t2 VSS.n86 166.359
R4 VSS.n142 VSS.t28 166.359
R5 VSS.t4 VSS.n85 155.268
R6 VSS.n128 VSS.t26 155.268
R7 VSS.t5 VSS.n83 144.178
R8 VSS.n127 VSS.t25 144.178
R9 VSS.t7 VSS.n82 133.088
R10 VSS.n124 VSS.t23 133.088
R11 VSS.t8 VSS.n81 121.996
R12 VSS.n122 VSS.t22 121.996
R13 VSS.t10 VSS.n79 110.906
R14 VSS.n111 VSS.t14 110.906
R15 VSS.t16 VSS.n73 110.906
R16 VSS.n118 VSS.t20 110.906
R17 VSS.t11 VSS.n78 99.8157
R18 VSS.n109 VSS.t13 99.8157
R19 VSS.t17 VSS.n71 99.8157
R20 VSS.n116 VSS.t19 99.8157
R21 VSS.n106 VSS.t11 88.7251
R22 VSS.t13 VSS.n76 88.7251
R23 VSS.n114 VSS.t17 88.7251
R24 VSS.t19 VSS.n69 88.7251
R25 VSS.n104 VSS.t10 77.6345
R26 VSS.t14 VSS.n75 77.6345
R27 VSS.n113 VSS.t16 77.6345
R28 VSS.t20 VSS.n68 77.6345
R29 VSS.n101 VSS.t8 66.5439
R30 VSS.t22 VSS.n67 66.5439
R31 VSS.n99 VSS.t7 55.4534
R32 VSS.t23 VSS.n66 55.4534
R33 VSS.n95 VSS.t5 44.3628
R34 VSS.t25 VSS.n65 44.3628
R35 VSS.n94 VSS.t4 33.2722
R36 VSS.t26 VSS.n63 33.2722
R37 VSS.n74 VSS.n39 29.2386
R38 VSS.n74 VSS.n40 29.2386
R39 VSS.n64 VSS.n53 28.8069
R40 VSS.n70 VSS.n43 28.8069
R41 VSS.n72 VSS.n41 28.8069
R42 VSS.n77 VSS.n35 28.8069
R43 VSS.n80 VSS.n31 28.8069
R44 VSS.n84 VSS.n25 28.8069
R45 VSS.n87 VSS.n21 28.8069
R46 VSS.n1 VSS.n0 0.00501646
R47 VSS.n4 VSS.n3 3.37363
R48 VSS.t32 VSS.n4 6.4633
R49 VSS.n90 VSS.n19 28.8069
R50 VSS.n90 VSS.n20 28.8069
R51 VSS.n87 VSS.n22 28.8069
R52 VSS.n93 VSS.n23 28.8069
R53 VSS.n93 VSS.n24 28.8069
R54 VSS.n84 VSS.n26 28.8069
R55 VSS.n98 VSS.n27 28.8069
R56 VSS.n98 VSS.n28 28.8069
R57 VSS.n100 VSS.n29 28.8069
R58 VSS.n100 VSS.n30 28.8069
R59 VSS.n80 VSS.n32 28.8069
R60 VSS.n105 VSS.n33 28.8069
R61 VSS.n105 VSS.n34 28.8069
R62 VSS.n77 VSS.n36 28.8069
R63 VSS.n110 VSS.n37 28.8069
R64 VSS.n110 VSS.n38 28.8069
R65 VSS.n72 VSS.n42 28.8069
R66 VSS.n70 VSS.n44 28.8069
R67 VSS.n117 VSS.n45 28.8069
R68 VSS.n117 VSS.n46 28.8069
R69 VSS.n121 VSS.n47 28.8069
R70 VSS.n121 VSS.n48 28.8069
R71 VSS.n123 VSS.n49 28.8069
R72 VSS.n123 VSS.n50 28.8069
R73 VSS.n126 VSS.n51 28.8069
R74 VSS.n126 VSS.n52 28.8069
R75 VSS.n64 VSS.n54 28.8069
R76 VSS.n141 VSS.n55 28.8069
R77 VSS.n141 VSS.n56 28.8069
R78 VSS.n143 VSS.n57 28.8069
R79 VSS.n143 VSS.n58 28.8069
R80 VSS.n146 VSS.n60 28.8069
R81 VSS.n145 VSS.n60 28.8069
R82 VSS.n145 VSS.n61 28.8069
R83 VSS.n92 VSS.t2 22.1816
R84 VSS.t28 VSS.n62 22.1816
R85 VSS.n3 VSS.n144 17.0005
R86 VSS.n3 VSS.n62 17.0005
R87 VSS.n3 VSS.n142 17.0005
R88 VSS.n3 VSS.n63 17.0005
R89 VSS.n3 VSS.n128 17.0005
R90 VSS.n3 VSS.n65 17.0005
R91 VSS.n3 VSS.n127 17.0005
R92 VSS.n3 VSS.n66 17.0005
R93 VSS.n3 VSS.n124 17.0005
R94 VSS.n3 VSS.n67 17.0005
R95 VSS.n3 VSS.n122 17.0005
R96 VSS.n3 VSS.n68 17.0005
R97 VSS.n3 VSS.n118 17.0005
R98 VSS.n3 VSS.n69 17.0005
R99 VSS.n3 VSS.n116 17.0005
R100 VSS.n3 VSS.n71 17.0005
R101 VSS.n3 VSS.n114 17.0005
R102 VSS.n3 VSS.n73 17.0005
R103 VSS.n3 VSS.n113 17.0005
R104 VSS.n3 VSS.n75 17.0005
R105 VSS.n3 VSS.n111 17.0005
R106 VSS.n3 VSS.n76 17.0005
R107 VSS.n3 VSS.n109 17.0005
R108 VSS.n3 VSS.n78 17.0005
R109 VSS.n3 VSS.n106 17.0005
R110 VSS.n3 VSS.n79 17.0005
R111 VSS.n3 VSS.n104 17.0005
R112 VSS.n3 VSS.n81 17.0005
R113 VSS.n3 VSS.n101 17.0005
R114 VSS.n3 VSS.n82 17.0005
R115 VSS.n3 VSS.n99 17.0005
R116 VSS.n3 VSS.n83 17.0005
R117 VSS.n3 VSS.n95 17.0005
R118 VSS.n3 VSS.n85 17.0005
R119 VSS.n3 VSS.n94 17.0005
R120 VSS.n3 VSS.n86 17.0005
R121 VSS.n3 VSS.n92 17.0005
R122 VSS.n3 VSS.n88 17.0005
R123 VSS.n3 VSS.n91 17.0005
R124 VSS.n7 VSS.n3 0.910052
R125 VSS.n3 VSS.n8 17.0005
R126 VSS.n1 VSS.n9 17.0005
R127 VSS.n131 VSS.n1 17.0005
R128 VSS.n133 VSS.t30 17.0005
R129 VSS.t30 VSS.n130 17.0005
R130 VSS.t30 VSS.n132 17.0005
R131 VSS.n133 VSS.t36 17.0005
R132 VSS.t36 VSS.n130 17.0005
R133 VSS.n132 VSS.t36 17.0005
R134 VSS.n1 VSS.n4 3.37278
R135 VSS.n1 VSS.n59 17.0005
R136 VSS.n3 VSS.n89 17.0005
R137 VSS.n1 VSS.n16 17.0005
R138 VSS.n1 VSS.n15 17.0005
R139 VSS.n1 VSS.n6 17.0005
R140 VSS.t33 VSS.n17 17.0005
R141 VSS.t33 VSS.n14 17.0005
R142 VSS.n18 VSS.t33 17.0005
R143 VSS.n17 VSS.t1 17.0005
R144 VSS.t1 VSS.n14 17.0005
R145 VSS.n18 VSS.t1 17.0005
R146 VSS.n146 VSS.n59 14.4037
R147 VSS.n91 VSS.n20 14.4037
R148 VSS.n92 VSS.n22 14.4037
R149 VSS.n94 VSS.n24 14.4037
R150 VSS.n95 VSS.n26 14.4037
R151 VSS.n99 VSS.n28 14.4037
R152 VSS.n101 VSS.n30 14.4037
R153 VSS.n104 VSS.n32 14.4037
R154 VSS.n106 VSS.n34 14.4037
R155 VSS.n109 VSS.n36 14.4037
R156 VSS.n111 VSS.n38 14.4037
R157 VSS.n113 VSS.n40 14.4037
R158 VSS.n114 VSS.n42 14.4037
R159 VSS.n116 VSS.n44 14.4037
R160 VSS.n118 VSS.n46 14.4037
R161 VSS.n122 VSS.n48 14.4037
R162 VSS.n124 VSS.n50 14.4037
R163 VSS.n127 VSS.n52 14.4037
R164 VSS.n128 VSS.n54 14.4037
R165 VSS.n142 VSS.n56 14.4037
R166 VSS.n144 VSS.n58 14.4037
R167 VSS.t35 VSS.n61 14.4037
R168 VSS.n89 VSS.n19 14.4037
R169 VSS.n88 VSS.n21 14.4037
R170 VSS.n86 VSS.n23 14.4037
R171 VSS.n85 VSS.n25 14.4037
R172 VSS.n83 VSS.n27 14.4037
R173 VSS.n82 VSS.n29 14.4037
R174 VSS.n81 VSS.n31 14.4037
R175 VSS.n79 VSS.n33 14.4037
R176 VSS.n78 VSS.n35 14.4037
R177 VSS.n76 VSS.n37 14.4037
R178 VSS.n75 VSS.n39 14.4037
R179 VSS.n73 VSS.n41 14.4037
R180 VSS.n71 VSS.n43 14.4037
R181 VSS.n69 VSS.n45 14.4037
R182 VSS.n68 VSS.n47 14.4037
R183 VSS.n67 VSS.n49 14.4037
R184 VSS.n66 VSS.n51 14.4037
R185 VSS.n65 VSS.n53 14.4037
R186 VSS.n63 VSS.n55 14.4037
R187 VSS.n62 VSS.n57 14.4037
R188 VSS.n91 VSS.t0 11.0911
R189 VSS.t29 VSS.n59 11.0911
R190 VSS.n132 VSS.n2 1.43719
R191 VSS.n3 VSS.n5 0.909128
R192 VSS.n1 VSS.n2 0.00580599
R193 VSS.n134 VSS.t34 3.0005
R194 VSS.n147 VSS.t31 3.0005
R195 VSS.n148 VSS.t3 2.48177
R196 VSS.n149 VSS.t6 2.48177
R197 VSS.n150 VSS.t9 2.48177
R198 VSS.n13 VSS.t12 2.48177
R199 VSS.t18 VSS.n12 2.48177
R200 VSS.n136 VSS.t21 2.48177
R201 VSS.n137 VSS.t24 2.48177
R202 VSS.t27 VSS.n138 2.48177
R203 VSS.n3 VSS.n140 2.09947
R204 VSS.n3 VSS.n125 2.09947
R205 VSS.n3 VSS.n120 2.09947
R206 VSS.n3 VSS.n115 2.09947
R207 VSS.n3 VSS.n10 2.09947
R208 VSS.n3 VSS.n108 2.09947
R209 VSS.n3 VSS.n103 2.09947
R210 VSS.n3 VSS.n97 2.09947
R211 VSS.n147 VSS.n14 1.52811
R212 VSS.n134 VSS.n130 1.52811
R213 VSS.n3 VSS.n146 1.29964
R214 VSS.n3 VSS.n143 1.29964
R215 VSS.n3 VSS.n141 1.29964
R216 VSS.n3 VSS.n64 1.29964
R217 VSS.n3 VSS.n126 1.29964
R218 VSS.n3 VSS.n123 1.29964
R219 VSS.n3 VSS.n121 1.29964
R220 VSS.n3 VSS.n117 1.29964
R221 VSS.n3 VSS.n70 1.29964
R222 VSS.n3 VSS.n72 1.29964
R223 VSS.n3 VSS.n110 1.29964
R224 VSS.n3 VSS.n77 1.29964
R225 VSS.n3 VSS.n105 1.29964
R226 VSS.n3 VSS.n80 1.29964
R227 VSS.n3 VSS.n100 1.29964
R228 VSS.n3 VSS.n98 1.29964
R229 VSS.n3 VSS.n84 1.29964
R230 VSS.n3 VSS.n93 1.29964
R231 VSS.n3 VSS.n87 1.29964
R232 VSS.n3 VSS.n145 1.29964
R233 VSS.n1 VSS.n19 1.29964
R234 VSS.n1 VSS.n20 1.29964
R235 VSS.n1 VSS.n21 1.29964
R236 VSS.n1 VSS.n22 1.29964
R237 VSS.n1 VSS.n23 1.29964
R238 VSS.n1 VSS.n24 1.29964
R239 VSS.n1 VSS.n25 1.29964
R240 VSS.n1 VSS.n26 1.29964
R241 VSS.n1 VSS.n27 1.29964
R242 VSS.n1 VSS.n28 1.29964
R243 VSS.n1 VSS.n29 1.29964
R244 VSS.n1 VSS.n30 1.29964
R245 VSS.n1 VSS.n31 1.29964
R246 VSS.n1 VSS.n32 1.29964
R247 VSS.n1 VSS.n33 1.29964
R248 VSS.n1 VSS.n34 1.29964
R249 VSS.n1 VSS.n35 1.29964
R250 VSS.n1 VSS.n36 1.29964
R251 VSS.n1 VSS.n37 1.29964
R252 VSS.n1 VSS.n38 1.29964
R253 VSS.n1 VSS.n39 1.29964
R254 VSS.n1 VSS.n40 1.29964
R255 VSS.n1 VSS.n41 1.29964
R256 VSS.n1 VSS.n42 1.29964
R257 VSS.n1 VSS.n43 1.29964
R258 VSS.n1 VSS.n44 1.29964
R259 VSS.n1 VSS.n45 1.29964
R260 VSS.n1 VSS.n46 1.29964
R261 VSS.n1 VSS.n47 1.29964
R262 VSS.n1 VSS.n48 1.29964
R263 VSS.n1 VSS.n49 1.29964
R264 VSS.n1 VSS.n50 1.29964
R265 VSS.n1 VSS.n51 1.29964
R266 VSS.n1 VSS.n52 1.29964
R267 VSS.n1 VSS.n53 1.29964
R268 VSS.n1 VSS.n54 1.29964
R269 VSS.n1 VSS.n55 1.29964
R270 VSS.n1 VSS.n56 1.29964
R271 VSS.n1 VSS.n57 1.29964
R272 VSS.n1 VSS.n58 1.29964
R273 VSS.n1 VSS.n60 1.29964
R274 VSS.n1 VSS.n61 1.29964
R275 VSS.n3 VSS.n90 1.29964
R276 VSS.n3 VSS.n74 1.08379
R277 VSS.n7 VSS.n139 0.147554
R278 VSS.n148 VSS.n147 0.209825
R279 VSS.n138 VSS.n134 0.209825
R280 VSS.n96 VSS.t3 0.200997
R281 VSS.n102 VSS.t6 0.200997
R282 VSS.n107 VSS.t9 0.200997
R283 VSS.n112 VSS.t12 0.200997
R284 VSS.n119 VSS.t18 0.200997
R285 VSS.t21 VSS.n135 0.200997
R286 VSS.t24 VSS.n129 0.200997
R287 VSS.n139 VSS.t27 0.200997
R288 VSS.n149 VSS.n148 0.16242
R289 VSS.n150 VSS.n149 0.16242
R290 VSS.n13 VSS.n150 0.16242
R291 VSS.n11 VSS.n13 0.16242
R292 VSS.n11 VSS.n12 0.16242
R293 VSS.n136 VSS.n12 0.16242
R294 VSS.n137 VSS.n136 0.16242
R295 VSS.n138 VSS.n137 0.16242
R296 VSS.n2 VSS.n18 1.37756
R297 VSS.n96 VSS.n5 0.146746
R298 VSS.n97 VSS.n96 0.0952183
R299 VSS.n103 VSS.n102 0.0927738
R300 VSS.n140 VSS.n139 0.0925656
R301 VSS.n108 VSS.n107 0.0903294
R302 VSS.n115 VSS.t15 0.0903294
R303 VSS.n129 VSS.n125 0.0901212
R304 VSS.n10 VSS.n112 0.0878849
R305 VSS.n120 VSS.n119 0.0878849
R306 VSS.t15 VSS.n10 0.0876767
R307 VSS.n135 VSS.n120 0.0876767
R308 VSS.n135 VSS.n125 0.0854405
R309 VSS.n112 VSS.n108 0.0852323
R310 VSS.n119 VSS.n115 0.0852323
R311 VSS.n140 VSS.n129 0.082996
R312 VSS.n107 VSS.n103 0.0827878
R313 VSS.n102 VSS.n97 0.0803434
R314 VSS VSS.n11 0.0682949
R315 VSS.t15 VSS.n11 0.0394177
R316 VSS.t31 VSS.n5 0.082967
R317 VSS.t34 VSS.n8 0.0133922
R318 VSS.t31 VSS.n6 0.0133922
R319 VSS.n9 VSS.n130 0.00798582
R320 VSS.n131 VSS.n130 0.00798582
R321 VSS.n15 VSS.n14 0.00798582
R322 VSS.n16 VSS.n14 0.00798582
R323 VSS.n8 VSS.n133 0.00756994
R324 VSS.n133 VSS.n9 0.00756994
R325 VSS.n132 VSS.n131 0.00756994
R326 VSS.n17 VSS.n6 0.00756994
R327 VSS.n17 VSS.n15 0.00756994
R328 VSS.n18 VSS.n16 0.00756994
R329 VSS.t34 VSS.n7 0.0813231
R330 VSS.n0 VSS.n3 0.00294683
R331 VSS.n0 VSS.t35 15.6517
C0 vin vout 18.6541f
C1 vin VDD 29.702f
C2 vout VDD 19.3894f
C3 vout VSS 13.72425f
.ends
