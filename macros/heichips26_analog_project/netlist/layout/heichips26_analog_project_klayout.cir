* Extracted by KLayout with SG13CMOS5L LVS runset on : 02/08/2026 23:50

.SUBCKT heichips26_analog_project VAPWR VGND VPWR analog_0 analog_1 analog_2
+ ui_in[0]
X$14 VGND VAPWR analog_2 ui_in[0] inverter
X$15 VGND VAPWR analog_1 analog_0 inverter
M$1 VGND VAPWR VGND VGND sg13_lv_pmos L=10u W=10u AS=3.4p AD=3.4p PS=20.68u
+ PD=20.68u rfmode=0
M$2 VGND VPWR VGND VGND sg13_lv_pmos L=10u W=10u AS=3.4p AD=3.4p PS=20.68u
+ PD=20.68u rfmode=0
.ENDS heichips26_analog_project

.SUBCKT inverter VSS VDD vout vin
M$1 VSS VSS VSS VSS sg13_lv_nmos L=1u W=2u AS=0.53p AD=0.53p PS=4.06u PD=4.06u
+ rfmode=0
M$2 VSS vin vout VSS sg13_lv_nmos L=1u W=20u AS=3.8p AD=3.8p PS=27.6u PD=27.6u
+ rfmode=0
M$23 VDD VDD VDD VDD sg13_lv_pmos L=1u W=12u AS=3.18p AD=3.18p PS=19.06u
+ PD=19.06u rfmode=0
M$24 VDD vin vout VDD sg13_lv_pmos L=1u W=120u AS=22.8p AD=22.8p PS=127.6u
+ PD=127.6u rfmode=0
.ENDS inverter
