* PEX produced on Sun Aug  2 02:55:16 PM CEST 2026 using scripts/sak-pex.sh with m=3 and s=1 (extresist threshold=10000 mOhm, minres=1000 mOhm, mindelay=1 ps)
* NGSPICE file created from heichips26_analog_project_pex.ext - technology: ihp-sg13cmos5l

.subckt heichips26_analog_project_pex VPWR VAPWR VGND rst_n clk ena uio_in[7]
+ uio_in[6] uio_in[5] uio_in[4] uio_in[3] uio_in[2] uio_in[1] uio_in[0] ui_in[7]
+ ui_in[6] ui_in[5] ui_in[4] ui_in[3] ui_in[2] ui_in[1] ui_in[0] uio_oe[7]
+ uio_oe[6] uio_oe[5] uio_oe[4] uio_oe[3] uio_oe[2] uio_oe[1] uio_oe[0]
+ uio_out[7] uio_out[6] uio_out[5] uio_out[4] uio_out[3] uio_out[2] uio_out[1]
+ uio_out[0] uo_out[7] uo_out[6] uo_out[5] uo_out[4] uo_out[3] uo_out[2]
+ uo_out[1] uo_out[0] analog_2 analog_1 analog_0
X0 VAPWR VAPWR VAPWR VAPWR sg13_lv_pmos ad=1.14p pd=6.38u as=0.28875n ps=0.61464m w=6u l=1u
X1 VGND.t37 VGND.t34 VGND.t36 VGND.t35 sg13_lv_nmos ad=0.34p pd=2.68u as=0 ps=0 w=1u l=1u
X2 analog_1 analog_0 VGND.t4 VGND.t3 sg13_lv_nmos ad=0.19p pd=1.38u as=0.19p ps=1.38u w=1u l=1u
X3 analog_1 analog_0 VAPWR VAPWR sg13_lv_pmos ad=1.14p pd=6.38u as=1.14p ps=6.38u w=6u l=1u
X4 VAPWR ui_in[0].t1 analog_2 VAPWR sg13_lv_pmos ad=1.14p pd=6.38u as=1.14p ps=6.38u w=6u l=1u
X5 VAPWR analog_0 analog_1 VAPWR sg13_lv_pmos ad=1.14p pd=6.38u as=1.14p ps=6.38u w=6u l=1u
X6 analog_1 analog_0 VGND.t6 VGND.t7 sg13_lv_nmos ad=0.19p pd=1.38u as=0.19p ps=1.38u w=1u l=1u
X7 VAPWR analog_0 analog_1 VAPWR sg13_lv_pmos ad=1.14p pd=6.38u as=1.14p ps=6.38u w=6u l=1u
X8 VAPWR analog_0 analog_1 VAPWR sg13_lv_pmos ad=1.14p pd=6.38u as=1.14p ps=6.38u w=6u l=1u
X9 VGND.t12 analog_0 analog_1 VGND.t11 sg13_lv_nmos ad=0.19p pd=1.38u as=0.19p ps=1.38u w=1u l=1u
X10 VAPWR analog_0 analog_1 VAPWR sg13_lv_pmos ad=1.14p pd=6.38u as=1.14p ps=6.38u w=6u l=1u
X11 analog_1 analog_0 VAPWR VAPWR sg13_lv_pmos ad=1.14p pd=6.38u as=1.14p ps=6.38u w=6u l=1u
X12 analog_2 ui_in[0].t1 VAPWR VAPWR sg13_lv_pmos ad=1.14p pd=6.38u as=1.14p ps=6.38u w=6u l=1u
X13 VGND.t9 analog_0 analog_1 VGND.t8 sg13_lv_nmos ad=0.19p pd=1.38u as=0.19p ps=1.38u w=1u l=1u
X14 VGND.t15 analog_0 analog_1 VGND.t14 sg13_lv_nmos ad=0.19p pd=1.38u as=0.19p ps=1.38u w=1u l=1u
X15 analog_1 analog_0 VAPWR VAPWR sg13_lv_pmos ad=1.14p pd=6.38u as=1.14p ps=6.38u w=6u l=1u
X16 analog_2 ui_in[0].t1 VAPWR VAPWR sg13_lv_pmos ad=1.14p pd=6.38u as=1.14p ps=6.38u w=6u l=1u
X17 VAPWR analog_0 analog_1 VAPWR sg13_lv_pmos ad=1.14p pd=6.38u as=1.14p ps=6.38u w=6u l=1u
X18 VAPWR ui_in[0].t1 analog_2 VAPWR sg13_lv_pmos ad=1.14p pd=6.38u as=1.14p ps=6.38u w=6u l=1u
X19 VGND.t18 analog_0 analog_1 VGND.t17 sg13_lv_nmos ad=0.19p pd=1.38u as=0.19p ps=1.38u w=1u l=1u
X20 analog_1 analog_0 VGND.t24 VGND.t25 sg13_lv_nmos ad=0.19p pd=1.38u as=0.19p ps=1.38u w=1u l=1u
X21 analog_2 ui_in[0].t1 VAPWR VAPWR sg13_lv_pmos ad=1.14p pd=6.38u as=1.14p ps=6.38u w=6u l=1u
X22 VGND.t41 ui_in[0].t0 analog_2 VGND.t32 sg13_lv_nmos ad=0.19p pd=1.38u as=0.19p ps=1.38u w=1u l=1u
X23 analog_1 analog_0 VGND.t21 VGND.t22 sg13_lv_nmos ad=0.19p pd=1.38u as=0.19p ps=1.38u w=1u l=1u
X24 VAPWR analog_0 analog_1 VAPWR sg13_lv_pmos ad=1.14p pd=6.38u as=1.14p ps=6.38u w=6u l=1u
X25 VAPWR ui_in[0].t1 analog_2 VAPWR sg13_lv_pmos ad=1.14p pd=6.38u as=1.14p ps=6.38u w=6u l=1u
X26 analog_2 ui_in[0].t1 VAPWR VAPWR sg13_lv_pmos ad=1.14p pd=6.38u as=1.14p ps=6.38u w=6u l=1u
X27 analog_2 ui_in[0].t0 VGND.t36 VGND.t3 sg13_lv_nmos ad=0.19p pd=1.38u as=0.19p ps=1.38u w=1u l=1u
X28 VGND.t27 analog_0 analog_1 VGND.t26 sg13_lv_nmos ad=0.19p pd=1.38u as=0.19p ps=1.38u w=1u l=1u
X29 VAPWR VAPWR VAPWR VAPWR sg13_lv_pmos ad=1.14p pd=6.38u as=0 ps=0 w=6u l=1u
X30 analog_2 ui_in[0].t1 VAPWR VAPWR sg13_lv_pmos ad=1.14p pd=6.38u as=1.14p ps=6.38u w=6u l=1u
X31 analog_2 ui_in[0].t1 VAPWR VAPWR sg13_lv_pmos ad=1.14p pd=6.38u as=1.14p ps=6.38u w=6u l=1u
X32 VAPWR VAPWR VAPWR VAPWR sg13_lv_pmos ad=2.04p pd=12.68u as=0 ps=0 w=6u l=1u
X33 VGND.t30 analog_0 analog_1 VGND.t29 sg13_lv_nmos ad=0.19p pd=1.38u as=0.19p ps=1.38u w=1u l=1u
X34 VAPWR analog_0 analog_1 VAPWR sg13_lv_pmos ad=1.14p pd=6.38u as=1.14p ps=6.38u w=6u l=1u
X35 analog_2 ui_in[0].t0 VGND.t48 VGND.t7 sg13_lv_nmos ad=0.19p pd=1.38u as=0.19p ps=1.38u w=1u l=1u
X36 VGND.t33 VGND.t45 VGND.t46 VGND.t39 sg13_lv_nmos ad=0.19p pd=1.38u as=0 ps=0 w=1u l=1u
X37 VGND.t1 VPWR VGND.t1 VGND.t0 sg13_lv_pmos ad=3.4p pd=20.68u as=0 ps=0 w=10u l=10u
X38 VGND.t52 ui_in[0].t0 analog_2 VGND.t11 sg13_lv_nmos ad=0.19p pd=1.38u as=0.19p ps=1.38u w=1u l=1u
X39 VGND.t6 analog_0 analog_1 VGND.t5 sg13_lv_nmos ad=0.19p pd=1.38u as=0.19p ps=1.38u w=1u l=1u
X40 VGND.t50 ui_in[0].t0 analog_2 VGND.t8 sg13_lv_nmos ad=0.19p pd=1.38u as=0.19p ps=1.38u w=1u l=1u
X41 VGND.t54 ui_in[0].t0 analog_2 VGND.t14 sg13_lv_nmos ad=0.19p pd=1.38u as=0.19p ps=1.38u w=1u l=1u
X42 analog_1 analog_0 VAPWR VAPWR sg13_lv_pmos ad=1.14p pd=6.38u as=1.14p ps=6.38u w=6u l=1u
X43 analog_1 analog_0 VAPWR VAPWR sg13_lv_pmos ad=1.14p pd=6.38u as=1.14p ps=6.38u w=6u l=1u
X44 VGND.t56 ui_in[0].t0 analog_2 VGND.t17 sg13_lv_nmos ad=0.19p pd=1.38u as=0.19p ps=1.38u w=1u l=1u
X45 analog_2 ui_in[0].t0 VGND.t60 VGND.t25 sg13_lv_nmos ad=0.19p pd=1.38u as=0.19p ps=1.38u w=1u l=1u
X46 analog_1 analog_0 VGND.t12 VGND.t13 sg13_lv_nmos ad=0.19p pd=1.38u as=0.19p ps=1.38u w=1u l=1u
X47 VAPWR analog_0 analog_1 VAPWR sg13_lv_pmos ad=1.14p pd=6.38u as=1.14p ps=6.38u w=6u l=1u
X48 analog_2 ui_in[0].t0 VGND.t58 VGND.t22 sg13_lv_nmos ad=0.19p pd=1.38u as=0.19p ps=1.38u w=1u l=1u
X49 analog_1 analog_0 VAPWR VAPWR sg13_lv_pmos ad=1.14p pd=6.38u as=1.14p ps=6.38u w=6u l=1u
X50 VGND.t62 ui_in[0].t0 analog_2 VGND.t26 sg13_lv_nmos ad=0.19p pd=1.38u as=0.19p ps=1.38u w=1u l=1u
X51 analog_1 analog_0 VGND.t15 VGND.t16 sg13_lv_nmos ad=0.19p pd=1.38u as=0.19p ps=1.38u w=1u l=1u
X52 VAPWR analog_0 analog_1 VAPWR sg13_lv_pmos ad=1.14p pd=6.38u as=1.14p ps=6.38u w=6u l=1u
X53 analog_1 analog_0 VAPWR VAPWR sg13_lv_pmos ad=1.14p pd=6.38u as=1.14p ps=6.38u w=6u l=1u
X54 VAPWR ui_in[0].t1 analog_2 VAPWR sg13_lv_pmos ad=1.14p pd=6.38u as=1.14p ps=6.38u w=6u l=1u
X55 VGND.t21 analog_0 analog_1 VGND.t20 sg13_lv_nmos ad=0.19p pd=1.38u as=0.19p ps=1.38u w=1u l=1u
X56 analog_1 analog_0 VAPWR VAPWR sg13_lv_pmos ad=1.14p pd=6.38u as=1.14p ps=6.38u w=6u l=1u
X57 analog_1 analog_0 VAPWR VAPWR sg13_lv_pmos ad=1.14p pd=6.38u as=1.14p ps=6.38u w=6u l=1u
X58 analog_2 ui_in[0].t1 VAPWR VAPWR sg13_lv_pmos ad=1.14p pd=6.38u as=1.14p ps=6.38u w=6u l=1u
X59 VGND.t64 ui_in[0].t0 analog_2 VGND.t29 sg13_lv_nmos ad=0.19p pd=1.38u as=0.19p ps=1.38u w=1u l=1u
X60 analog_1 analog_0 VGND.t18 VGND.t19 sg13_lv_nmos ad=0.19p pd=1.38u as=0.19p ps=1.38u w=1u l=1u
X61 VAPWR VAPWR VAPWR VAPWR sg13_lv_pmos ad=2.04p pd=12.68u as=0 ps=0 w=6u l=1u
X62 VGND.t41 VGND.t38 VGND.t40 VGND.t39 sg13_lv_nmos ad=0.19p pd=1.38u as=0 ps=0 w=1u l=1u
X63 VGND.t24 analog_0 analog_1 VGND.t23 sg13_lv_nmos ad=0.19p pd=1.38u as=0.19p ps=1.38u w=1u l=1u
X64 analog_1 analog_0 VGND.t30 VGND.t31 sg13_lv_nmos ad=0.19p pd=1.38u as=0.19p ps=1.38u w=1u l=1u
X65 VGND.t44 VGND.t42 VGND.t4 VGND.t35 sg13_lv_nmos ad=0.34p pd=2.68u as=0 ps=0 w=1u l=1u
X66 analog_1 analog_0 VGND.t9 VGND.t10 sg13_lv_nmos ad=0.19p pd=1.38u as=0.19p ps=1.38u w=1u l=1u
X67 analog_1 analog_0 VGND.t27 VGND.t28 sg13_lv_nmos ad=0.19p pd=1.38u as=0.19p ps=1.38u w=1u l=1u
X68 analog_2 ui_in[0].t1 VAPWR VAPWR sg13_lv_pmos ad=1.14p pd=6.38u as=1.14p ps=6.38u w=6u l=1u
X69 VAPWR ui_in[0].t1 analog_2 VAPWR sg13_lv_pmos ad=1.14p pd=6.38u as=1.14p ps=6.38u w=6u l=1u
X70 VGND.t48 ui_in[0].t0 analog_2 VGND.t5 sg13_lv_nmos ad=0.19p pd=1.38u as=0.19p ps=1.38u w=1u l=1u
X71 VAPWR ui_in[0].t1 analog_2 VAPWR sg13_lv_pmos ad=1.14p pd=6.38u as=1.14p ps=6.38u w=6u l=1u
X72 VAPWR ui_in[0].t1 analog_2 VAPWR sg13_lv_pmos ad=1.14p pd=6.38u as=1.14p ps=6.38u w=6u l=1u
X73 analog_2 ui_in[0].t0 VGND.t52 VGND.t13 sg13_lv_nmos ad=0.19p pd=1.38u as=0.19p ps=1.38u w=1u l=1u
X74 VAPWR ui_in[0].t1 analog_2 VAPWR sg13_lv_pmos ad=1.14p pd=6.38u as=1.14p ps=6.38u w=6u l=1u
X75 analog_2 ui_in[0].t1 VAPWR VAPWR sg13_lv_pmos ad=1.14p pd=6.38u as=1.14p ps=6.38u w=6u l=1u
X76 analog_2 ui_in[0].t0 VGND.t54 VGND.t16 sg13_lv_nmos ad=0.19p pd=1.38u as=0.19p ps=1.38u w=1u l=1u
X77 analog_2 ui_in[0].t1 VAPWR VAPWR sg13_lv_pmos ad=1.14p pd=6.38u as=1.14p ps=6.38u w=6u l=1u
X78 VGND.t58 ui_in[0].t0 analog_2 VGND.t20 sg13_lv_nmos ad=0.19p pd=1.38u as=0.19p ps=1.38u w=1u l=1u
X79 VAPWR analog_0 analog_1 VAPWR sg13_lv_pmos ad=1.14p pd=6.38u as=1.14p ps=6.38u w=6u l=1u
X80 VAPWR ui_in[0].t1 analog_2 VAPWR sg13_lv_pmos ad=1.14p pd=6.38u as=1.14p ps=6.38u w=6u l=1u
X81 analog_2 ui_in[0].t0 VGND.t56 VGND.t19 sg13_lv_nmos ad=0.19p pd=1.38u as=0.19p ps=1.38u w=1u l=1u
X82 analog_1 analog_0 VAPWR VAPWR sg13_lv_pmos ad=1.14p pd=6.38u as=1.14p ps=6.38u w=6u l=1u
X83 VGND.t60 ui_in[0].t0 analog_2 VGND.t23 sg13_lv_nmos ad=0.19p pd=1.38u as=0.19p ps=1.38u w=1u l=1u
X84 analog_2 ui_in[0].t0 VGND.t64 VGND.t31 sg13_lv_nmos ad=0.19p pd=1.38u as=0.19p ps=1.38u w=1u l=1u
X85 VGND.t2 VAPWR VGND.t2 VGND.t2 sg13_lv_pmos ad=3.4p pd=20.68u as=0 ps=0 w=10u l=10u
X86 VAPWR ui_in[0].t1 analog_2 VAPWR sg13_lv_pmos ad=1.14p pd=6.38u as=1.14p ps=6.38u w=6u l=1u
X87 analog_2 ui_in[0].t0 VGND.t50 VGND.t10 sg13_lv_nmos ad=0.19p pd=1.38u as=0.19p ps=1.38u w=1u l=1u
X88 analog_2 ui_in[0].t0 VGND.t62 VGND.t28 sg13_lv_nmos ad=0.19p pd=1.38u as=0.19p ps=1.38u w=1u l=1u
X89 VGND.t33 analog_0 analog_1 VGND.t32 sg13_lv_nmos ad=0.19p pd=1.38u as=0.19p ps=1.38u w=1u l=1u
R0 ui_in[0].n15 ui_in[0].t1 0.994683
R1 ui_in[0].n17 ui_in[0].t0 0.994013
R2 ui_in[0].n9 ui_in[0].n1 0.748572
R3 ui_in[0].n10 ui_in[0].n9 0.578786
R4 ui_in[0].n11 ui_in[0].n10 0.578786
R5 ui_in[0].n12 ui_in[0].n11 0.578786
R6 ui_in[0].n13 ui_in[0].n12 0.578786
R7 ui_in[0].n14 ui_in[0].n13 0.578786
R8 ui_in[0].n15 ui_in[0].n14 0.578786
R9 ui_in[0].n0 ui_in[0].n24 0.755676
R10 ui_in[0].n24 ui_in[0].n23 0.578786
R11 ui_in[0].n23 ui_in[0].n22 0.578786
R12 ui_in[0].n22 ui_in[0].n21 0.578786
R13 ui_in[0].n21 ui_in[0].n20 0.578786
R14 ui_in[0].n20 ui_in[0].n19 0.578786
R15 ui_in[0].n19 ui_in[0].n18 0.578786
R16 ui_in[0].n18 ui_in[0].n17 0.578786
R17 ui_in[0].n14 ui_in[0].n8 0.254024
R18 ui_in[0].n13 ui_in[0].n7 0.254024
R19 ui_in[0].n12 ui_in[0].n6 0.254024
R20 ui_in[0].n11 ui_in[0].n5 0.254024
R21 ui_in[0].n10 ui_in[0].n4 0.254024
R22 ui_in[0].n9 ui_in[0].n3 0.254024
R23 ui_in[0].n1 ui_in[0].n2 0.0282822
R24 ui_in[0].n24 ui_in[0].n2 0.254024
R25 ui_in[0].n23 ui_in[0].n3 0.254024
R26 ui_in[0].n22 ui_in[0].n4 0.254024
R27 ui_in[0].n21 ui_in[0].n5 0.254024
R28 ui_in[0].n20 ui_in[0].n6 0.254024
R29 ui_in[0].n19 ui_in[0].n7 0.254024
R30 ui_in[0].n18 ui_in[0].n8 0.254024
R31 ui_in[0].n17 ui_in[0].n16 0.192615
R32 ui_in[0].n16 ui_in[0].n15 0.191641
R33 ui_in[0].n16 ui_in[0].n8 0.128842
R34 ui_in[0].n1 ui_in[0].n0 0.105962
R35 ui_in[0].n3 ui_in[0].n2 0.12194
R36 ui_in[0].n4 ui_in[0].n3 0.12194
R37 ui_in[0].n5 ui_in[0].n4 0.12194
R38 ui_in[0].n6 ui_in[0].n5 0.12194
R39 ui_in[0].n7 ui_in[0].n6 0.12194
R40 ui_in[0].n8 ui_in[0].n7 0.12194
R41 ui_in[0] ui_in[0].n0 40.295
R42 VGND.n55 VGND.n8 3.11617
R43 VGND.n161 VGND.t3 86.957
R44 VGND.t32 VGND.n87 86.957
R45 VGND.n165 VGND.t5 81.5222
R46 VGND.t31 VGND.n91 81.5222
R47 VGND.n169 VGND.t7 76.0875
R48 VGND.t29 VGND.n93 76.0875
R49 VGND.n172 VGND.t8 70.6527
R50 VGND.t28 VGND.n96 70.6527
R51 VGND.n175 VGND.t10 65.2179
R52 VGND.t26 VGND.n98 65.2179
R53 VGND.n178 VGND.t11 59.7831
R54 VGND.t25 VGND.n100 59.7831
R55 VGND.n182 VGND.t13 54.3483
R56 VGND.t17 VGND.n116 54.3483
R57 VGND.n196 VGND.t19 54.3483
R58 VGND.t23 VGND.n102 54.3483
R59 VGND.n186 VGND.t14 48.9135
R60 VGND.t16 VGND.n120 48.9135
R61 VGND.n199 VGND.t20 48.9135
R62 VGND.t22 VGND.n105 48.9135
R63 VGND.t14 VGND.n124 43.4788
R64 VGND.n189 VGND.t16 43.4788
R65 VGND.t20 VGND.n109 43.4788
R66 VGND.n202 VGND.t22 43.4788
R67 VGND.t13 VGND.n128 38.044
R68 VGND.n192 VGND.t17 38.044
R69 VGND.t19 VGND.n113 38.044
R70 VGND.n205 VGND.t23 38.044
R71 VGND.t11 VGND.n130 32.6092
R72 VGND.n208 VGND.t25 32.6092
R73 VGND.t10 VGND.n134 27.1744
R74 VGND.n213 VGND.t26 27.1744
R75 VGND.t8 VGND.n137 21.7396
R76 VGND.n216 VGND.t28 21.7396
R77 VGND.n69 VGND.n82 17.0005
R78 VGND.n69 VGND.n236 17.0005
R79 VGND.n69 VGND.n83 17.0005
R80 VGND.n69 VGND.n84 17.0005
R81 VGND.n69 VGND.t39 17.0005
R82 VGND.n69 VGND.n85 17.0005
R83 VGND.n69 VGND.n232 17.0005
R84 VGND.n69 VGND.n86 17.0005
R85 VGND.n69 VGND.n229 17.0005
R86 VGND.n69 VGND.n228 17.0005
R87 VGND.n69 VGND.n87 17.0005
R88 VGND.n69 VGND.n227 17.0005
R89 VGND.n69 VGND.n89 17.0005
R90 VGND.n69 VGND.n90 17.0005
R91 VGND.n69 VGND.n225 17.0005
R92 VGND.n69 VGND.n91 17.0005
R93 VGND.n69 VGND.n223 17.0005
R94 VGND.n69 VGND.n67 8.49879
R95 VGND.n69 VGND.n92 17.0005
R96 VGND.n69 VGND.n221 17.0005
R97 VGND.n69 VGND.n93 17.0005
R98 VGND.n69 VGND.n219 17.0005
R99 VGND.n69 VGND.n217 17.0005
R100 VGND.n69 VGND.n94 17.0005
R101 VGND.n6 VGND.n216 8.50025
R102 VGND.n7 VGND.n96 8.50233
R103 VGND.n69 VGND.n215 17.0005
R104 VGND.n69 VGND.n97 17.0005
R105 VGND.n69 VGND.n60 17.0005
R106 VGND.n69 VGND.n213 17.0005
R107 VGND.n69 VGND.n98 17.0005
R108 VGND.n69 VGND.n211 17.0005
R109 VGND.n69 VGND.n99 17.0005
R110 VGND.n69 VGND.n208 17.0005
R111 VGND.n69 VGND.n100 17.0005
R112 VGND.n69 VGND.n207 17.0005
R113 VGND.n69 VGND.n101 17.0005
R114 VGND.n69 VGND.n205 17.0005
R115 VGND.n69 VGND.n102 17.0005
R116 VGND.n69 VGND.n204 17.0005
R117 VGND.n69 VGND.n103 17.0005
R118 VGND.n69 VGND.n202 17.0005
R119 VGND.n69 VGND.n105 17.0005
R120 VGND.n69 VGND.n201 17.0005
R121 VGND.n69 VGND.n107 17.0005
R122 VGND.n69 VGND.n199 17.0005
R123 VGND.n69 VGND.n109 17.0005
R124 VGND.n69 VGND.n198 17.0005
R125 VGND.n69 VGND.n111 17.0005
R126 VGND.n69 VGND.n112 17.0005
R127 VGND.n69 VGND.n196 17.0005
R128 VGND.n69 VGND.n113 17.0005
R129 VGND.n69 VGND.n194 17.0005
R130 VGND.n69 VGND.n64 17.0005
R131 VGND.n69 VGND.n114 17.0005
R132 VGND.n69 VGND.n192 17.0005
R133 VGND.n69 VGND.n116 17.0005
R134 VGND.n69 VGND.n191 17.0005
R135 VGND.n69 VGND.n118 17.0005
R136 VGND.n69 VGND.n189 17.0005
R137 VGND.n69 VGND.n120 17.0005
R138 VGND.n69 VGND.n188 17.0005
R139 VGND.n69 VGND.n122 17.0005
R140 VGND.n69 VGND.n123 17.0005
R141 VGND.n69 VGND.n186 17.0005
R142 VGND.n69 VGND.n185 17.0005
R143 VGND.n69 VGND.n124 17.0005
R144 VGND.n69 VGND.n184 17.0005
R145 VGND.n69 VGND.n126 17.0005
R146 VGND.n69 VGND.n127 17.0005
R147 VGND.n6 VGND.n182 8.49977
R148 VGND.n69 VGND.n128 17.0005
R149 VGND.n69 VGND.n180 17.0005
R150 VGND.n69 VGND.n5 5.66316
R151 VGND.n69 VGND.n129 17.0005
R152 VGND.n69 VGND.n178 17.0005
R153 VGND.n69 VGND.n130 17.0005
R154 VGND.n69 VGND.n177 17.0005
R155 VGND.n69 VGND.n132 17.0005
R156 VGND.n69 VGND.n175 17.0005
R157 VGND.n69 VGND.n134 17.0005
R158 VGND.n69 VGND.n174 17.0005
R159 VGND.n69 VGND.n136 17.0005
R160 VGND.n69 VGND.n172 17.0005
R161 VGND.n69 VGND.n137 17.0005
R162 VGND.n69 VGND.n171 17.0005
R163 VGND.n69 VGND.n139 17.0005
R164 VGND.n69 VGND.n140 17.0005
R165 VGND.n69 VGND.n169 17.0005
R166 VGND.n7 VGND.n6 0.00258087
R167 VGND.n69 VGND.n167 17.0005
R168 VGND.n69 VGND.n142 17.0005
R169 VGND.n69 VGND.n66 8.49879
R170 VGND.n69 VGND.n165 17.0005
R171 VGND.n69 VGND.n164 17.0005
R172 VGND.n69 VGND.n143 17.0005
R173 VGND.n69 VGND.n163 17.0005
R174 VGND.n69 VGND.n145 17.0005
R175 VGND.n69 VGND.n161 17.0005
R176 VGND.n69 VGND.n73 17.0005
R177 VGND.n69 VGND.n160 17.0005
R178 VGND.n69 VGND.n148 17.0005
R179 VGND.n69 VGND.n158 17.0005
R180 VGND.n69 VGND.t35 17.0005
R181 VGND.n69 VGND.n156 17.0005
R182 VGND.n69 VGND.n151 17.0005
R183 VGND.n69 VGND.n154 17.0005
R184 VGND.n8 VGND.n152 14.1401
R185 VGND.n55 VGND.n238 17.0005
R186 VGND.n55 VGND.n279 17.0005
R187 VGND.n55 VGND.n241 17.0005
R188 VGND.n55 VGND.n62 17.0005
R189 VGND.n55 VGND.n1 2.4234
R190 VGND.n55 VGND.n274 17.0005
R191 VGND.n55 VGND.n245 17.0005
R192 VGND.n55 VGND.n271 17.0005
R193 VGND.n55 VGND.n247 17.0005
R194 VGND.n55 VGND.n267 17.0005
R195 VGND.n55 VGND.n250 17.0005
R196 VGND.n55 VGND.n265 17.0005
R197 VGND.n55 VGND.n4 5.66421
R198 VGND.n59 VGND.n135 0.0105114
R199 VGND.n55 VGND.n59 8.49909
R200 VGND.n55 VGND.n263 17.0005
R201 VGND.n55 VGND.n256 17.0005
R202 VGND.n55 VGND.n74 17.0005
R203 VGND.n229 VGND.n6 17.0005
R204 VGND.n87 VGND.n6 17.0005
R205 VGND.n225 VGND.n6 17.0005
R206 VGND.n91 VGND.n6 17.0005
R207 VGND.n221 VGND.n6 17.0005
R208 VGND.n93 VGND.n6 17.0005
R209 VGND.n213 VGND.n6 17.0005
R210 VGND.n98 VGND.n6 17.0005
R211 VGND.n208 VGND.n6 17.0005
R212 VGND.n100 VGND.n6 17.0005
R213 VGND.n205 VGND.n6 17.0005
R214 VGND.n102 VGND.n6 17.0005
R215 VGND.n202 VGND.n6 17.0005
R216 VGND.n105 VGND.n6 17.0005
R217 VGND.n199 VGND.n6 17.0005
R218 VGND.n109 VGND.n6 17.0005
R219 VGND.n196 VGND.n6 17.0005
R220 VGND.n113 VGND.n6 17.0005
R221 VGND.n192 VGND.n6 17.0005
R222 VGND.n116 VGND.n6 17.0005
R223 VGND.n189 VGND.n6 17.0005
R224 VGND.n120 VGND.n6 17.0005
R225 VGND.n186 VGND.n6 17.0005
R226 VGND.n124 VGND.n6 17.0005
R227 VGND.n128 VGND.n6 17.0005
R228 VGND.n178 VGND.n6 17.0005
R229 VGND.n130 VGND.n6 17.0005
R230 VGND.n175 VGND.n6 17.0005
R231 VGND.n134 VGND.n6 17.0005
R232 VGND.n172 VGND.n6 17.0005
R233 VGND.n137 VGND.n6 17.0005
R234 VGND.n169 VGND.n6 17.0005
R235 VGND.n141 VGND.n6 8.49975
R236 VGND.n165 VGND.n6 17.0005
R237 VGND.n143 VGND.n6 17.0005
R238 VGND.n161 VGND.n6 17.0005
R239 VGND.n152 VGND.n6 17.0005
R240 VGND.n55 VGND.n72 1.70057
R241 VGND.t7 VGND.n141 16.3048
R242 VGND.n221 VGND.t29 16.3048
R243 VGND.t34 VGND.n81 15.0005
R244 VGND.n295 VGND.t45 15.0005
R245 VGND.n285 VGND.t38 15.0005
R246 VGND.n305 VGND.t42 15.0005
R247 VGND.n194 VGND.n193 13.099
R248 VGND.n193 VGND.n114 13.099
R249 VGND.n299 VGND.n72 12.4279
R250 VGND.n298 VGND.n297 12.4279
R251 VGND.n236 VGND.n235 12.4279
R252 VGND.t39 VGND.n234 12.4279
R253 VGND.n232 VGND.n231 12.4279
R254 VGND.n227 VGND.n226 12.4279
R255 VGND.n223 VGND.n222 12.4279
R256 VGND.n219 VGND.n218 12.4279
R257 VGND.n215 VGND.n214 12.4279
R258 VGND.n211 VGND.n210 12.4279
R259 VGND.n207 VGND.n206 12.4279
R260 VGND.n204 VGND.n203 12.4279
R261 VGND.n201 VGND.n200 12.4279
R262 VGND.n198 VGND.n197 12.4279
R263 VGND.n191 VGND.n190 12.4279
R264 VGND.n188 VGND.n187 12.4279
R265 VGND.n184 VGND.n183 12.4279
R266 VGND.n180 VGND.n179 12.4279
R267 VGND.n177 VGND.n176 12.4279
R268 VGND.n174 VGND.n173 12.4279
R269 VGND.n171 VGND.n170 12.4279
R270 VGND.n167 VGND.n166 12.4279
R271 VGND.n163 VGND.n162 12.4279
R272 VGND.n159 VGND.n73 12.4279
R273 VGND.n157 VGND.n148 12.4279
R274 VGND.n155 VGND.t35 12.4279
R275 VGND.n153 VGND.n151 12.4279
R276 VGND.n154 VGND.n153 12.4279
R277 VGND.n156 VGND.n155 12.4279
R278 VGND.n158 VGND.n157 12.4279
R279 VGND.n160 VGND.n159 12.4279
R280 VGND.n162 VGND.n145 12.4279
R281 VGND.n166 VGND.n142 12.4279
R282 VGND.n170 VGND.n139 12.4279
R283 VGND.n173 VGND.n136 12.4279
R284 VGND.n176 VGND.n132 12.4279
R285 VGND.n179 VGND.n129 12.4279
R286 VGND.n183 VGND.n126 12.4279
R287 VGND.n187 VGND.n122 12.4279
R288 VGND.n190 VGND.n118 12.4279
R289 VGND.n197 VGND.n111 12.4279
R290 VGND.n200 VGND.n107 12.4279
R291 VGND.n203 VGND.n103 12.4279
R292 VGND.n206 VGND.n101 12.4279
R293 VGND.n210 VGND.n99 12.4279
R294 VGND.n214 VGND.n97 12.4279
R295 VGND.n218 VGND.n94 12.4279
R296 VGND.n222 VGND.n92 12.4279
R297 VGND.n226 VGND.n89 12.4279
R298 VGND.n231 VGND.n86 12.4279
R299 VGND.n234 VGND.n85 12.4279
R300 VGND.n235 VGND.n83 12.4279
R301 VGND.n297 VGND.n82 12.4279
R302 VGND.n299 VGND.n298 12.4279
R303 VGND.t5 VGND.n143 10.8701
R304 VGND.n225 VGND.t31 10.8701
R305 VGND.n8 VGND.n69 0.261362
R306 VGND.n70 VGND.n69 2.08775
R307 VGND.n298 VGND.n55 8.5005
R308 VGND.n55 VGND.t46 1.0382
R309 VGND.n300 VGND.n69 8.5005
R310 VGND.n300 VGND.n56 1.10392
R311 VGND.n55 VGND.n73 8.5005
R312 VGND.n69 VGND.n233 8.4984
R313 VGND.n69 VGND.n230 8.4984
R314 VGND.n69 VGND.n88 8.4984
R315 VGND.n69 VGND.n224 8.4984
R316 VGND.n69 VGND.n220 8.4984
R317 VGND.n69 VGND.n95 8.4984
R318 VGND.n69 VGND.n61 8.4984
R319 VGND.n69 VGND.n212 8.4984
R320 VGND.n69 VGND.n209 8.4984
R321 VGND.n0 VGND.n1 0.00653337
R322 VGND.n2 VGND.n0 0.0157515
R323 VGND.n69 VGND.n2 2.41741
R324 VGND.n69 VGND.n104 8.4984
R325 VGND.n69 VGND.n106 8.4984
R326 VGND.n69 VGND.n108 8.4984
R327 VGND.n69 VGND.n110 8.4984
R328 VGND.n69 VGND.n195 8.4984
R329 VGND.n69 VGND.n115 8.4984
R330 VGND.n69 VGND.n117 8.4984
R331 VGND.n69 VGND.n119 8.4984
R332 VGND.n69 VGND.n121 8.4984
R333 VGND.n69 VGND.n125 8.4984
R334 VGND.n69 VGND.n181 8.4984
R335 VGND.n5 VGND.n3 0.00635632
R336 VGND.n69 VGND.n131 8.4984
R337 VGND.n69 VGND.n133 8.4984
R338 VGND.n69 VGND.n135 8.4984
R339 VGND.n69 VGND.n57 8.4984
R340 VGND.n69 VGND.n138 8.4984
R341 VGND.n69 VGND.n168 8.4984
R342 VGND.n69 VGND.n144 8.4984
R343 VGND.n69 VGND.n146 8.4984
R344 VGND.n69 VGND.n147 8.4984
R345 VGND.n69 VGND.n149 8.4984
R346 VGND.n69 VGND.n150 8.4984
R347 VGND.n55 VGND.n237 8.4984
R348 VGND.n55 VGND.n281 8.4984
R349 VGND.n55 VGND.n280 8.4984
R350 VGND.n55 VGND.n239 8.4984
R351 VGND.n55 VGND.n278 8.4984
R352 VGND.n55 VGND.n240 8.4984
R353 VGND.n55 VGND.n277 8.4984
R354 VGND.n55 VGND.n242 8.4984
R355 VGND.n55 VGND.n243 8.4984
R356 VGND.n55 VGND.n244 8.4984
R357 VGND.n55 VGND.n276 8.4984
R358 VGND.n55 VGND.n275 8.4984
R359 VGND.n55 VGND.n246 8.4984
R360 VGND.n55 VGND.n272 8.4984
R361 VGND.n55 VGND.n270 8.4984
R362 VGND.n55 VGND.n248 8.4984
R363 VGND.n55 VGND.n269 8.4984
R364 VGND.n55 VGND.n268 8.4984
R365 VGND.n55 VGND.n249 8.4984
R366 VGND.n55 VGND.n251 8.4984
R367 VGND.n55 VGND.n264 8.4984
R368 VGND.n55 VGND.n252 8.4984
R369 VGND.n55 VGND.n253 8.4984
R370 VGND.n55 VGND.n254 8.4984
R371 VGND.n55 VGND.n255 8.4984
R372 VGND.n55 VGND.n262 8.4984
R373 VGND.n55 VGND.n261 8.4984
R374 VGND.n55 VGND.n257 8.4984
R375 VGND.n55 VGND.n258 8.4984
R376 VGND.n55 VGND.n259 8.4984
R377 VGND.n55 VGND.n260 8.4984
R378 VGND.n302 VGND.t34 7.49606
R379 VGND.t45 VGND.n294 7.49606
R380 VGND.t38 VGND.n284 7.49606
R381 VGND.t42 VGND.n80 7.49606
R382 VGND.n37 VGND.n82 7.18094
R383 VGND.n9 VGND.n83 7.18094
R384 VGND.n38 VGND.n85 7.18094
R385 VGND.n10 VGND.n86 7.18094
R386 VGND.n12 VGND.n89 7.18094
R387 VGND.n39 VGND.n91 7.18094
R388 VGND.n40 VGND.n92 7.18094
R389 VGND.n41 VGND.n93 7.18094
R390 VGND.n42 VGND.n94 7.18094
R391 VGND.n13 VGND.n96 7.18094
R392 VGND.n14 VGND.n97 7.18094
R393 VGND.n43 VGND.n99 7.18094
R394 VGND.n16 VGND.n100 7.18094
R395 VGND.n17 VGND.n101 7.18094
R396 VGND.n44 VGND.n103 7.18094
R397 VGND.n45 VGND.n105 7.18094
R398 VGND.n46 VGND.n111 7.18094
R399 VGND.n47 VGND.n113 7.18094
R400 VGND.n48 VGND.n116 7.18094
R401 VGND.n22 VGND.n118 7.18094
R402 VGND.n24 VGND.n122 7.18094
R403 VGND.n49 VGND.n129 7.18094
R404 VGND.n28 VGND.n130 7.18094
R405 VGND.n29 VGND.n132 7.18094
R406 VGND.n31 VGND.n136 7.18094
R407 VGND.n50 VGND.n137 7.18094
R408 VGND.n33 VGND.n141 7.18094
R409 VGND.n34 VGND.n142 7.18094
R410 VGND.n35 VGND.n143 7.18094
R411 VGND.n36 VGND.n145 7.18094
R412 VGND.n51 VGND.n158 7.18094
R413 VGND.n52 VGND.n156 7.18094
R414 VGND.n53 VGND.n154 7.18094
R415 VGND.n54 VGND.n148 7.18094
R416 VGND.n32 VGND.n169 7.18094
R417 VGND.n30 VGND.n174 7.18094
R418 VGND.n27 VGND.n180 7.18094
R419 VGND.n26 VGND.n182 7.18094
R420 VGND.n25 VGND.n184 7.18094
R421 VGND.n23 VGND.n188 7.18094
R422 VGND.n21 VGND.n192 7.18094
R423 VGND.n20 VGND.n198 7.18094
R424 VGND.n19 VGND.n199 7.18094
R425 VGND.n18 VGND.n204 7.18094
R426 VGND.n15 VGND.n211 7.18094
R427 VGND.n11 VGND.n227 7.18094
R428 VGND.n37 VGND.n236 7.18026
R429 VGND.n9 VGND.t39 7.18026
R430 VGND.n38 VGND.n232 7.18026
R431 VGND.n10 VGND.n229 7.18026
R432 VGND.n12 VGND.n225 7.18026
R433 VGND.n39 VGND.n223 7.18026
R434 VGND.n40 VGND.n221 7.18026
R435 VGND.n41 VGND.n219 7.18026
R436 VGND.n42 VGND.n216 7.18026
R437 VGND.n13 VGND.n215 7.18026
R438 VGND.n14 VGND.n213 7.18026
R439 VGND.n43 VGND.n208 7.18026
R440 VGND.n16 VGND.n207 7.18026
R441 VGND.n17 VGND.n205 7.18026
R442 VGND.n44 VGND.n202 7.18026
R443 VGND.n45 VGND.n201 7.18026
R444 VGND.n46 VGND.n196 7.18026
R445 VGND.n47 VGND.n194 7.18026
R446 VGND.n48 VGND.n191 7.18026
R447 VGND.n22 VGND.n189 7.18026
R448 VGND.n24 VGND.n186 7.18026
R449 VGND.n49 VGND.n178 7.18026
R450 VGND.n28 VGND.n177 7.18026
R451 VGND.n29 VGND.n175 7.18026
R452 VGND.n31 VGND.n172 7.18026
R453 VGND.n50 VGND.n171 7.18026
R454 VGND.n33 VGND.n167 7.18026
R455 VGND.n34 VGND.n165 7.18026
R456 VGND.n35 VGND.n163 7.18026
R457 VGND.n36 VGND.n161 7.18026
R458 VGND.n51 VGND.t35 7.18026
R459 VGND.n52 VGND.n151 7.18026
R460 VGND.n53 VGND.n152 7.18026
R461 VGND.n11 VGND.n87 7.18026
R462 VGND.n15 VGND.n98 7.18026
R463 VGND.n18 VGND.n102 7.18026
R464 VGND.n19 VGND.n107 7.18026
R465 VGND.n20 VGND.n109 7.18026
R466 VGND.n21 VGND.n114 7.18026
R467 VGND.n23 VGND.n120 7.18026
R468 VGND.n25 VGND.n124 7.18026
R469 VGND.n26 VGND.n126 7.18026
R470 VGND.n27 VGND.n128 7.18026
R471 VGND.n30 VGND.n134 7.18026
R472 VGND.n32 VGND.n139 7.18026
R473 VGND.n54 VGND.n160 7.18026
R474 VGND.n72 VGND.n6 1.88945
R475 VGND.t3 VGND.n73 5.43528
R476 VGND.n229 VGND.t32 5.43528
R477 VGND.t4 VGND.n79 4.5005
R478 VGND.n303 VGND.t36 4.5005
R479 VGND.n296 VGND.t33 4.5005
R480 VGND.t41 VGND.n283 4.5005
R481 VGND.n55 VGND.n71 4.25219
R482 VGND.n55 VGND.n75 4.25206
R483 VGND.n69 VGND.n75 4.25175
R484 VGND.n69 VGND.n71 4.25169
R485 VGND.n56 VGND.n70 1.75799
R486 VGND.n307 VGND.n306 3.0005
R487 VGND.n301 VGND.n78 3.0005
R488 VGND.n293 VGND.n292 3.0005
R489 VGND.n287 VGND.n286 3.0005
R490 VGND.n309 VGND.t6 2.48177
R491 VGND.n310 VGND.t9 2.48177
R492 VGND.n311 VGND.t12 2.48177
R493 VGND.n77 VGND.t15 2.48177
R494 VGND.t21 VGND.n76 2.48177
R495 VGND.n288 VGND.t24 2.48177
R496 VGND.n289 VGND.t27 2.48177
R497 VGND.n290 VGND.t30 2.48177
R498 VGND.n309 VGND.t48 2.48177
R499 VGND.n310 VGND.t50 2.48177
R500 VGND.n311 VGND.t52 2.48177
R501 VGND.n77 VGND.t54 2.48177
R502 VGND.t58 VGND.n76 2.48177
R503 VGND.n288 VGND.t60 2.48177
R504 VGND.n289 VGND.t62 2.48177
R505 VGND.n290 VGND.t64 2.48177
R506 VGND.n69 VGND.n299 2.28755
R507 VGND.n297 VGND.n6 2.28755
R508 VGND.n235 VGND.n6 2.28755
R509 VGND.n234 VGND.n6 2.28755
R510 VGND.n231 VGND.n6 2.28755
R511 VGND.n226 VGND.n6 2.28755
R512 VGND.n222 VGND.n6 2.28755
R513 VGND.n218 VGND.n6 2.28755
R514 VGND.n214 VGND.n6 2.28755
R515 VGND.n210 VGND.n6 2.28755
R516 VGND.n206 VGND.n6 2.28755
R517 VGND.n203 VGND.n6 2.28755
R518 VGND.n200 VGND.n6 2.28755
R519 VGND.n197 VGND.n6 2.28755
R520 VGND.n190 VGND.n6 2.28755
R521 VGND.n187 VGND.n6 2.28755
R522 VGND.n183 VGND.n6 2.28755
R523 VGND.n179 VGND.n6 2.28755
R524 VGND.n176 VGND.n6 2.28755
R525 VGND.n173 VGND.n6 2.28755
R526 VGND.n170 VGND.n6 2.28755
R527 VGND.n166 VGND.n6 2.28755
R528 VGND.n162 VGND.n6 2.28755
R529 VGND.n159 VGND.n6 2.28755
R530 VGND.n157 VGND.n6 2.28755
R531 VGND.n155 VGND.n6 2.28755
R532 VGND.n153 VGND.n6 2.28755
R533 VGND.t44 VGND.n79 2.2505
R534 VGND.t37 VGND.n303 2.2505
R535 VGND.t46 VGND.n296 2.2505
R536 VGND.n283 VGND.t40 2.2505
R537 VGND.n193 VGND.n6 1.95198
R538 VGND VGND.n312 1.88203
R539 VGND.n312 VGND.n63 1.49725
R540 VGND.n55 VGND.t44 1.08079
R541 VGND.n55 VGND.n10 0.661826
R542 VGND.n55 VGND.n11 0.661826
R543 VGND.n55 VGND.n12 0.661826
R544 VGND.n55 VGND.n13 0.661826
R545 VGND.n55 VGND.n14 0.661826
R546 VGND.n55 VGND.n15 0.661826
R547 VGND.n55 VGND.n16 0.661826
R548 VGND.n55 VGND.n17 0.661826
R549 VGND.n55 VGND.n18 0.661826
R550 VGND.n55 VGND.n19 0.661826
R551 VGND.n55 VGND.n20 0.661826
R552 VGND.n55 VGND.n21 0.661826
R553 VGND.n55 VGND.n22 0.661826
R554 VGND.n55 VGND.n23 0.661826
R555 VGND.n55 VGND.n24 0.661826
R556 VGND.n55 VGND.n25 0.661826
R557 VGND.n55 VGND.n26 0.661826
R558 VGND.n55 VGND.n27 0.661826
R559 VGND.n55 VGND.n28 0.661826
R560 VGND.n55 VGND.n29 0.661826
R561 VGND.n55 VGND.n30 0.661826
R562 VGND.n55 VGND.n31 0.661826
R563 VGND.n55 VGND.n32 0.661826
R564 VGND.n55 VGND.n33 0.661826
R565 VGND.n55 VGND.n34 0.661826
R566 VGND.n55 VGND.n35 0.661826
R567 VGND.n55 VGND.n36 0.661826
R568 VGND.n55 VGND.n54 0.661826
R569 VGND.n55 VGND.n37 0.661826
R570 VGND.n55 VGND.n38 0.661826
R571 VGND.n55 VGND.n39 0.661826
R572 VGND.n55 VGND.n40 0.661826
R573 VGND.n55 VGND.n41 0.661826
R574 VGND.n55 VGND.n42 0.661826
R575 VGND.n55 VGND.n43 0.661826
R576 VGND.n55 VGND.n44 0.661826
R577 VGND.n55 VGND.n45 0.661826
R578 VGND.n55 VGND.n46 0.661826
R579 VGND.n55 VGND.n47 0.661826
R580 VGND.n55 VGND.n48 0.661826
R581 VGND.n55 VGND.n49 0.661826
R582 VGND.n55 VGND.n50 0.661826
R583 VGND.n55 VGND.n51 0.661826
R584 VGND.n55 VGND.n52 0.661826
R585 VGND.n55 VGND.n53 0.661826
R586 VGND.n65 VGND.t48 0.200997
R587 VGND.n58 VGND.t50 0.200997
R588 VGND.n3 VGND.t52 0.200997
R589 VGND.n266 VGND.t54 0.200997
R590 VGND.n273 VGND.t58 0.200997
R591 VGND.t60 VGND.n0 0.200997
R592 VGND.t62 VGND.n62 0.200997
R593 VGND.t64 VGND.n68 0.200997
R594 VGND.n65 VGND.t6 0.200995
R595 VGND.n58 VGND.t9 0.200995
R596 VGND.n3 VGND.t12 0.200995
R597 VGND.n266 VGND.t15 0.200995
R598 VGND.n273 VGND.t21 0.200995
R599 VGND.n0 VGND.t24 0.200995
R600 VGND.n62 VGND.t27 0.200995
R601 VGND.n68 VGND.t30 0.200995
R602 VGND.n55 VGND.n9 0.666164
R603 VGND.t56 VGND.t18 0.185126
R604 VGND.n309 VGND.n308 0.117247
R605 VGND.n291 VGND.n290 0.1171
R606 VGND.n310 VGND.n309 0.08146
R607 VGND.n311 VGND.n310 0.08146
R608 VGND.n77 VGND.n311 0.08146
R609 VGND.n63 VGND.n77 0.08146
R610 VGND.n63 VGND.n76 0.08146
R611 VGND.n288 VGND.n76 0.08146
R612 VGND.n289 VGND.n288 0.08146
R613 VGND.n290 VGND.n289 0.08146
R614 VGND.t37 VGND.n70 0.109202
R615 VGND.n300 VGND.t40 0.0592831
R616 VGND.t1 VGND.t0 0.668709
R617 VGND.t36 VGND.n302 0.031258
R618 VGND.n80 VGND.t4 0.031258
R619 VGND.n308 VGND.n307 0.0291125
R620 VGND.n308 VGND.n78 0.0291125
R621 VGND.n291 VGND.n287 0.0291125
R622 VGND.n292 VGND.n291 0.0291125
R623 VGND.n307 VGND.n79 0.0281144
R624 VGND.n303 VGND.n78 0.0281144
R625 VGND.n287 VGND.n283 0.0281144
R626 VGND.n296 VGND.n292 0.0281144
R627 VGND.n294 VGND.n282 0.0216549
R628 VGND.n284 VGND.n282 0.0216549
R629 VGND.t33 VGND.n295 0.0208704
R630 VGND.n285 VGND.t41 0.0208704
R631 VGND.n301 VGND.n81 0.0202884
R632 VGND.n295 VGND.n293 0.0202884
R633 VGND.n286 VGND.n285 0.0202884
R634 VGND.n306 VGND.n305 0.0202884
R635 VGND.t56 VGND.n63 0.0194533
R636 VGND.n282 VGND.n75 0.0162424
R637 VGND.n304 VGND.n71 0.0159649
R638 VGND.n237 VGND.n233 0.0118857
R639 VGND.n281 VGND.n233 0.0118857
R640 VGND.n280 VGND.n230 0.0118857
R641 VGND.n239 VGND.n88 0.0118857
R642 VGND.n278 VGND.n224 0.0118857
R643 VGND.n240 VGND.n220 0.0118857
R644 VGND.n277 VGND.n220 0.0118857
R645 VGND.n242 VGND.n95 0.0118857
R646 VGND.n243 VGND.n212 0.0118857
R647 VGND.n244 VGND.n209 0.0118857
R648 VGND.n276 VGND.n104 0.0118857
R649 VGND.n275 VGND.n106 0.0118857
R650 VGND.n246 VGND.n108 0.0118857
R651 VGND.n270 VGND.n195 0.0118857
R652 VGND.n248 VGND.n115 0.0118857
R653 VGND.n269 VGND.n119 0.0118857
R654 VGND.n268 VGND.n121 0.0118857
R655 VGND.n251 VGND.n125 0.0118857
R656 VGND.n264 VGND.n181 0.0118857
R657 VGND.n4 VGND.n3 0.00858771
R658 VGND.n252 VGND.n131 0.0118857
R659 VGND.n253 VGND.n133 0.0118857
R660 VGND.n254 VGND.n57 0.0118857
R661 VGND.n255 VGND.n138 0.0118857
R662 VGND.n262 VGND.n168 0.0118857
R663 VGND.n257 VGND.n144 0.0118857
R664 VGND.n258 VGND.n146 0.0118857
R665 VGND.n259 VGND.n147 0.0118857
R666 VGND.n260 VGND.n149 0.0118857
R667 VGND.n260 VGND.n150 0.0118857
R668 VGND.n259 VGND.n149 0.0118857
R669 VGND.n258 VGND.n147 0.0118857
R670 VGND.n257 VGND.n146 0.0118857
R671 VGND.n254 VGND.n138 0.0118857
R672 VGND.n253 VGND.n135 0.0118857
R673 VGND.n252 VGND.n133 0.0118857
R674 VGND.n4 VGND.n131 0.0161786
R675 VGND.n268 VGND.n119 0.0118857
R676 VGND.n269 VGND.n117 0.0118857
R677 VGND.n248 VGND.n117 0.0118857
R678 VGND.n272 VGND.n110 0.0118857
R679 VGND.n246 VGND.n110 0.0118857
R680 VGND.n275 VGND.n104 0.0118857
R681 VGND.n276 VGND.n2 0.0492861
R682 VGND.n1 VGND.n209 0.0262321
R683 VGND.n244 VGND.n212 0.0118857
R684 VGND.n242 VGND.n61 0.0118857
R685 VGND.n281 VGND.n230 0.0118857
R686 VGND.n304 VGND.n81 0.0115582
R687 VGND.n305 VGND.n304 0.0115582
R688 VGND.n256 VGND.n164 0.0108889
R689 VGND.n263 VGND.n140 0.0108889
R690 VGND.n265 VGND.n127 0.0108889
R691 VGND.n250 VGND.n185 0.0108889
R692 VGND.n271 VGND.n112 0.0108889
R693 VGND.n241 VGND.n217 0.0108889
R694 VGND.n279 VGND.n90 0.0108889
R695 VGND.n238 VGND.n228 0.0108889
R696 VGND.n302 VGND.n301 0.0108877
R697 VGND.n294 VGND.n293 0.0108877
R698 VGND.n286 VGND.n284 0.0108877
R699 VGND.n306 VGND.n80 0.0108877
R700 VGND.t46 VGND.n282 0.0101032
R701 VGND.n282 VGND.t40 0.0101032
R702 VGND.n304 VGND.t37 0.00981217
R703 VGND.n304 VGND.t44 0.00981217
R704 VGND.n66 VGND.n65 0.0054294
R705 VGND.n68 VGND.n67 0.0054294
R706 VGND.n59 VGND.n58 0.00481859
R707 VGND.n62 VGND.n60 0.00813889
R708 VGND.n56 VGND.n6 0.00561434
R709 VGND.n247 VGND.t56 0.00691667
R710 VGND.n278 VGND.n68 0.00772064
R711 VGND.t1 VGND.t2 0.434684
R712 VGND.n304 VGND.n74 0.00630556
R713 VGND.n274 VGND.n106 0.00619286
R714 VGND.n267 VGND.n121 0.00619286
R715 VGND.n150 VGND.n74 0.00619286
R716 VGND.n272 VGND.n112 0.00619286
R717 VGND.n249 VGND.n185 0.00619286
R718 VGND.n256 VGND.n144 0.00619286
R719 VGND.n261 VGND.n164 0.00619286
R720 VGND.n262 VGND.n66 0.0111223
R721 VGND.n263 VGND.n168 0.00619286
R722 VGND.n255 VGND.n140 0.00619286
R723 VGND.n264 VGND.n5 0.0174081
R724 VGND.n265 VGND.n181 0.00619286
R725 VGND.n251 VGND.n127 0.00619286
R726 VGND.n250 VGND.n125 0.00619286
R727 VGND.n249 VGND.n123 0.00619286
R728 VGND.n247 VGND.n115 0.00619286
R729 VGND.n270 VGND.n64 0.00619286
R730 VGND.n271 VGND.n195 0.00619286
R731 VGND.n245 VGND.n108 0.00619286
R732 VGND.n243 VGND.n60 0.00619286
R733 VGND.n241 VGND.n95 0.00619286
R734 VGND.n277 VGND.n217 0.00619286
R735 VGND.n240 VGND.n67 0.0111223
R736 VGND.n62 VGND.n61 0.00894286
R737 VGND.n58 VGND.n57 0.00894286
R738 VGND.t56 VGND.n64 0.00890776
R739 VGND.n261 VGND.n65 0.00772064
R740 VGND.n279 VGND.n224 0.00619286
R741 VGND.n239 VGND.n90 0.00619286
R742 VGND.n238 VGND.n88 0.00619286
R743 VGND.n280 VGND.n228 0.00619286
R744 VGND.n237 VGND.n84 0.00619286
R745 VGND.n282 VGND.n84 0.00615278
R746 VGND.n266 VGND.n123 0.00569444
R747 VGND.n267 VGND.n266 0.00569444
R748 VGND.n273 VGND.n245 0.00569444
R749 VGND.n274 VGND.n273 0.00569444
R750 VGND.n7 VGND.n69 0.0012083
R751 VGND.n312 VGND.t2 1.56957
C0 VAPWR analog_1 19.588f
C1 analog_2 VAPWR 19.494f
C2 analog_2 ui_in[0] 18.7529f
C3 analog_0 VAPWR 30.2344f
C4 ui_in[0] analog_0 0.25462f
C5 VPWR ui_in[0] 0.54099f
C6 analog_2 analog_1 1.44271f
C7 ui_in[0] VAPWR 30.2796f
C8 analog_0 analog_1 19.9607f
C9 uo_out[0] VGND 0.04448f
C10 uo_out[1] VGND 0.03799f
C11 uo_out[2] VGND 0.03799f
C12 uo_out[3] VGND 0.03799f
C13 uo_out[4] VGND 0.03799f
C14 uo_out[5] VGND 0.03799f
C15 uo_out[6] VGND 0.03799f
C16 uo_out[7] VGND 0.03799f
C17 uio_out[0] VGND 0.03799f
C18 uio_out[1] VGND 0.03799f
C19 uio_out[2] VGND 0.03799f
C20 uio_out[3] VGND 0.03799f
C21 uio_out[4] VGND 0.03799f
C22 uio_out[5] VGND 0.03799f
C23 uio_out[6] VGND 0.03799f
C24 uio_out[7] VGND 0.03799f
C25 uio_oe[0] VGND 0.03799f
C26 uio_oe[1] VGND 0.03799f
C27 uio_oe[2] VGND 0.03799f
C28 uio_oe[3] VGND 0.03799f
C29 uio_oe[4] VGND 0.03799f
C30 uio_oe[5] VGND 0.03799f
C31 uio_oe[6] VGND 0.03799f
C32 uio_oe[7] VGND 0.03799f
C33 ui_in[1] VGND 0.03799f
C34 ui_in[2] VGND 0.03799f
C35 ui_in[3] VGND 0.03799f
C36 ui_in[4] VGND 0.03799f
C37 ui_in[5] VGND 0.03799f
C38 ui_in[6] VGND 0.03799f
C39 ui_in[7] VGND 0.03799f
C40 uio_in[0] VGND 0.03799f
C41 uio_in[1] VGND 0.03799f
C42 uio_in[2] VGND 0.03799f
C43 uio_in[3] VGND 0.03799f
C44 uio_in[4] VGND 0.03799f
C45 uio_in[5] VGND 0.03799f
C46 uio_in[6] VGND 0.03799f
C47 uio_in[7] VGND 0.03799f
C48 ena VGND 0.03799f
C49 clk VGND 0.03799f
C50 rst_n VGND 0.04448f
C51 analog_1 VGND 27.9707f
C52 analog_2 VGND 33.2753f
C53 ui_in[0] VGND 32.20408f
C54 VGND.t1 VGND 50.5974f
C55 VGND.t4 VGND 13.1891f
C56 VGND.t41 VGND 3.54405f
C57 ui_in[0].n0 VGND 4.60807f
C58 ui_in[0].n1 VGND 0.13896f
C59 ui_in[0].n2 VGND 0.26857f
C60 ui_in[0].n3 VGND 0.26857f
C61 ui_in[0].n4 VGND 0.26857f
C62 ui_in[0].n5 VGND 0.26857f
C63 ui_in[0].n6 VGND 0.26857f
C64 ui_in[0].n7 VGND 0.26857f
C65 ui_in[0].n8 VGND 0.28384f
C66 ui_in[0].n9 VGND 0.08166f
C67 ui_in[0].n10 VGND 0.06297f
C68 ui_in[0].n11 VGND 0.06297f
C69 ui_in[0].n12 VGND 0.06297f
C70 ui_in[0].n13 VGND 0.06297f
C71 ui_in[0].n14 VGND 0.06297f
C72 ui_in[0].n15 VGND 0.70263f
C73 ui_in[0].n16 VGND 2.82525f
C74 ui_in[0].n17 VGND 0.71398f
C75 ui_in[0].n18 VGND 0.06297f
C76 ui_in[0].n19 VGND 0.06297f
C77 ui_in[0].n20 VGND 0.06297f
C78 ui_in[0].n21 VGND 0.06297f
C79 ui_in[0].n22 VGND 0.06297f
C80 ui_in[0].n23 VGND 0.06297f
C81 ui_in[0].n24 VGND 0.08251f
.ends
