* PEX produced on Sun Aug  2 23:50:24 CEST 2026 using scripts/sak-pex.sh with m=3 and s=1 (extresist threshold=10000 mOhm, minres=1000 mOhm, mindelay=1 ps)
* NGSPICE file created from heichips26_analog_project_pex.ext - technology: ihp-sg13cmos5l

.subckt heichips26_analog_project_pex VPWR VAPWR VGND rst_n clk ena uio_in[7]
+ uio_in[6] uio_in[5] uio_in[4] uio_in[3] uio_in[2] uio_in[1] uio_in[0] ui_in[7]
+ ui_in[6] ui_in[5] ui_in[4] ui_in[3] ui_in[2] ui_in[1] ui_in[0] uio_oe[7]
+ uio_oe[6] uio_oe[5] uio_oe[4] uio_oe[3] uio_oe[2] uio_oe[1] uio_oe[0]
+ uio_out[7] uio_out[6] uio_out[5] uio_out[4] uio_out[3] uio_out[2] uio_out[1]
+ uio_out[0] uo_out[7] uo_out[6] uo_out[5] uo_out[4] uo_out[3] uo_out[2]
+ uo_out[1] uo_out[0] analog_2 analog_1 analog_0
X0 VAPWR VAPWR VAPWR VAPWR sg13_lv_pmos ad=1.14p pd=6.38u as=0.28875n ps=0.61464m w=6u l=1u
X1 VGND.t55 VGND.t53 VGND.t31 VGND.t54 sg13_lv_nmos ad=0.34p pd=2.68u as=0 ps=0 w=1u l=1u
X2 analog_1 analog_0 VGND.t1 VGND.t0 sg13_lv_nmos ad=0.19p pd=1.38u as=0.19p ps=1.38u w=1u l=1u
X3 analog_1 analog_0 VAPWR VAPWR sg13_lv_pmos ad=1.14p pd=6.38u as=1.14p ps=6.38u w=6u l=1u
X4 VAPWR ui_in[0].t1 analog_2 VAPWR sg13_lv_pmos ad=1.14p pd=6.38u as=1.14p ps=6.38u w=6u l=1u
X5 VAPWR analog_0 analog_1 VAPWR sg13_lv_pmos ad=1.14p pd=6.38u as=1.14p ps=6.38u w=6u l=1u
X6 analog_1 analog_0 VGND.t3 VGND.t4 sg13_lv_nmos ad=0.19p pd=1.38u as=0.19p ps=1.38u w=1u l=1u
X7 VAPWR analog_0 analog_1 VAPWR sg13_lv_pmos ad=1.14p pd=6.38u as=1.14p ps=6.38u w=6u l=1u
X8 VAPWR analog_0 analog_1 VAPWR sg13_lv_pmos ad=1.14p pd=6.38u as=1.14p ps=6.38u w=6u l=1u
X9 VGND.t9 analog_0 analog_1 VGND.t8 sg13_lv_nmos ad=0.19p pd=1.38u as=0.19p ps=1.38u w=1u l=1u
X10 VAPWR analog_0 analog_1 VAPWR sg13_lv_pmos ad=1.14p pd=6.38u as=1.14p ps=6.38u w=6u l=1u
X11 analog_1 analog_0 VAPWR VAPWR sg13_lv_pmos ad=1.14p pd=6.38u as=1.14p ps=6.38u w=6u l=1u
X12 analog_2 ui_in[0].t1 VAPWR VAPWR sg13_lv_pmos ad=1.14p pd=6.38u as=1.14p ps=6.38u w=6u l=1u
X13 VGND.t6 analog_0 analog_1 VGND.t5 sg13_lv_nmos ad=0.19p pd=1.38u as=0.19p ps=1.38u w=1u l=1u
X14 VGND.t12 analog_0 analog_1 VGND.t11 sg13_lv_nmos ad=0.19p pd=1.38u as=0.19p ps=1.38u w=1u l=1u
X15 analog_1 analog_0 VAPWR VAPWR sg13_lv_pmos ad=1.14p pd=6.38u as=1.14p ps=6.38u w=6u l=1u
X16 analog_2 ui_in[0].t1 VAPWR VAPWR sg13_lv_pmos ad=1.14p pd=6.38u as=1.14p ps=6.38u w=6u l=1u
X17 VAPWR analog_0 analog_1 VAPWR sg13_lv_pmos ad=1.14p pd=6.38u as=1.14p ps=6.38u w=6u l=1u
X18 VAPWR ui_in[0].t1 analog_2 VAPWR sg13_lv_pmos ad=1.14p pd=6.38u as=1.14p ps=6.38u w=6u l=1u
X19 VGND.t15 analog_0 analog_1 VGND.t14 sg13_lv_nmos ad=0.19p pd=1.38u as=0.19p ps=1.38u w=1u l=1u
X20 analog_1 analog_0 VGND.t21 VGND.t22 sg13_lv_nmos ad=0.19p pd=1.38u as=0.19p ps=1.38u w=1u l=1u
X21 analog_2 ui_in[0].t1 VAPWR VAPWR sg13_lv_pmos ad=1.14p pd=6.38u as=1.14p ps=6.38u w=6u l=1u
X22 VGND.t50 ui_in[0].t0 analog_2 VGND.t29 sg13_lv_nmos ad=0.19p pd=1.38u as=0.19p ps=1.38u w=1u l=1u
X23 analog_1 analog_0 VGND.t18 VGND.t19 sg13_lv_nmos ad=0.19p pd=1.38u as=0.19p ps=1.38u w=1u l=1u
X24 VAPWR analog_0 analog_1 VAPWR sg13_lv_pmos ad=1.14p pd=6.38u as=1.14p ps=6.38u w=6u l=1u
X25 VAPWR ui_in[0].t1 analog_2 VAPWR sg13_lv_pmos ad=1.14p pd=6.38u as=1.14p ps=6.38u w=6u l=1u
X26 analog_2 ui_in[0].t1 VAPWR VAPWR sg13_lv_pmos ad=1.14p pd=6.38u as=1.14p ps=6.38u w=6u l=1u
X27 analog_2 ui_in[0].t0 VGND.t31 VGND.t0 sg13_lv_nmos ad=0.19p pd=1.38u as=0.19p ps=1.38u w=1u l=1u
X28 VGND.t24 analog_0 analog_1 VGND.t23 sg13_lv_nmos ad=0.19p pd=1.38u as=0.19p ps=1.38u w=1u l=1u
X29 VAPWR VAPWR VAPWR VAPWR sg13_lv_pmos ad=1.14p pd=6.38u as=0 ps=0 w=6u l=1u
X30 analog_2 ui_in[0].t1 VAPWR VAPWR sg13_lv_pmos ad=1.14p pd=6.38u as=1.14p ps=6.38u w=6u l=1u
X31 analog_2 ui_in[0].t1 VAPWR VAPWR sg13_lv_pmos ad=1.14p pd=6.38u as=1.14p ps=6.38u w=6u l=1u
X32 VAPWR VAPWR VAPWR VAPWR sg13_lv_pmos ad=2.04p pd=12.68u as=0 ps=0 w=6u l=1u
X33 VGND.t27 analog_0 analog_1 VGND.t26 sg13_lv_nmos ad=0.19p pd=1.38u as=0.19p ps=1.38u w=1u l=1u
X34 VAPWR analog_0 analog_1 VAPWR sg13_lv_pmos ad=1.14p pd=6.38u as=1.14p ps=6.38u w=6u l=1u
X35 analog_2 ui_in[0].t0 VGND.t32 VGND.t4 sg13_lv_nmos ad=0.19p pd=1.38u as=0.19p ps=1.38u w=1u l=1u
X36 VGND.t30 VGND.t62 VGND.t63 VGND.t57 sg13_lv_nmos ad=0.19p pd=1.38u as=0 ps=0 w=1u l=1u
X37 VGND.t52 VPWR VGND.t52 VGND.t51 sg13_lv_pmos ad=3.4p pd=20.68u as=0 ps=0 w=10u l=10u
X38 VGND.t36 ui_in[0].t0 analog_2 VGND.t8 sg13_lv_nmos ad=0.19p pd=1.38u as=0.19p ps=1.38u w=1u l=1u
X39 VGND.t3 analog_0 analog_1 VGND.t2 sg13_lv_nmos ad=0.19p pd=1.38u as=0.19p ps=1.38u w=1u l=1u
X40 VGND.t34 ui_in[0].t0 analog_2 VGND.t5 sg13_lv_nmos ad=0.19p pd=1.38u as=0.19p ps=1.38u w=1u l=1u
X41 VGND.t38 ui_in[0].t0 analog_2 VGND.t11 sg13_lv_nmos ad=0.19p pd=1.38u as=0.19p ps=1.38u w=1u l=1u
X42 analog_1 analog_0 VAPWR VAPWR sg13_lv_pmos ad=1.14p pd=6.38u as=1.14p ps=6.38u w=6u l=1u
X43 analog_1 analog_0 VAPWR VAPWR sg13_lv_pmos ad=1.14p pd=6.38u as=1.14p ps=6.38u w=6u l=1u
X44 VGND.t40 ui_in[0].t0 analog_2 VGND.t14 sg13_lv_nmos ad=0.19p pd=1.38u as=0.19p ps=1.38u w=1u l=1u
X45 analog_2 ui_in[0].t0 VGND.t44 VGND.t22 sg13_lv_nmos ad=0.19p pd=1.38u as=0.19p ps=1.38u w=1u l=1u
X46 analog_1 analog_0 VGND.t9 VGND.t10 sg13_lv_nmos ad=0.19p pd=1.38u as=0.19p ps=1.38u w=1u l=1u
X47 VAPWR analog_0 analog_1 VAPWR sg13_lv_pmos ad=1.14p pd=6.38u as=1.14p ps=6.38u w=6u l=1u
X48 analog_2 ui_in[0].t0 VGND.t42 VGND.t19 sg13_lv_nmos ad=0.19p pd=1.38u as=0.19p ps=1.38u w=1u l=1u
X49 analog_1 analog_0 VAPWR VAPWR sg13_lv_pmos ad=1.14p pd=6.38u as=1.14p ps=6.38u w=6u l=1u
X50 VGND.t46 ui_in[0].t0 analog_2 VGND.t23 sg13_lv_nmos ad=0.19p pd=1.38u as=0.19p ps=1.38u w=1u l=1u
X51 analog_1 analog_0 VGND.t12 VGND.t13 sg13_lv_nmos ad=0.19p pd=1.38u as=0.19p ps=1.38u w=1u l=1u
X52 VAPWR analog_0 analog_1 VAPWR sg13_lv_pmos ad=1.14p pd=6.38u as=1.14p ps=6.38u w=6u l=1u
X53 analog_1 analog_0 VAPWR VAPWR sg13_lv_pmos ad=1.14p pd=6.38u as=1.14p ps=6.38u w=6u l=1u
X54 VAPWR ui_in[0].t1 analog_2 VAPWR sg13_lv_pmos ad=1.14p pd=6.38u as=1.14p ps=6.38u w=6u l=1u
X55 VGND.t18 analog_0 analog_1 VGND.t17 sg13_lv_nmos ad=0.19p pd=1.38u as=0.19p ps=1.38u w=1u l=1u
X56 analog_1 analog_0 VAPWR VAPWR sg13_lv_pmos ad=1.14p pd=6.38u as=1.14p ps=6.38u w=6u l=1u
X57 analog_1 analog_0 VAPWR VAPWR sg13_lv_pmos ad=1.14p pd=6.38u as=1.14p ps=6.38u w=6u l=1u
X58 analog_2 ui_in[0].t1 VAPWR VAPWR sg13_lv_pmos ad=1.14p pd=6.38u as=1.14p ps=6.38u w=6u l=1u
X59 VGND.t48 ui_in[0].t0 analog_2 VGND.t26 sg13_lv_nmos ad=0.19p pd=1.38u as=0.19p ps=1.38u w=1u l=1u
X60 analog_1 analog_0 VGND.t15 VGND.t16 sg13_lv_nmos ad=0.19p pd=1.38u as=0.19p ps=1.38u w=1u l=1u
X61 VAPWR VAPWR VAPWR VAPWR sg13_lv_pmos ad=2.04p pd=12.68u as=0 ps=0 w=6u l=1u
X62 VGND.t50 VGND.t56 VGND.t58 VGND.t57 sg13_lv_nmos ad=0.19p pd=1.38u as=0 ps=0 w=1u l=1u
X63 VGND.t21 analog_0 analog_1 VGND.t20 sg13_lv_nmos ad=0.19p pd=1.38u as=0.19p ps=1.38u w=1u l=1u
X64 analog_1 analog_0 VGND.t27 VGND.t28 sg13_lv_nmos ad=0.19p pd=1.38u as=0.19p ps=1.38u w=1u l=1u
X65 VGND.t61 VGND.t59 VGND.t1 VGND.t54 sg13_lv_nmos ad=0.34p pd=2.68u as=0 ps=0 w=1u l=1u
X66 analog_1 analog_0 VGND.t6 VGND.t7 sg13_lv_nmos ad=0.19p pd=1.38u as=0.19p ps=1.38u w=1u l=1u
X67 analog_1 analog_0 VGND.t24 VGND.t25 sg13_lv_nmos ad=0.19p pd=1.38u as=0.19p ps=1.38u w=1u l=1u
X68 analog_2 ui_in[0].t1 VAPWR VAPWR sg13_lv_pmos ad=1.14p pd=6.38u as=1.14p ps=6.38u w=6u l=1u
X69 VAPWR ui_in[0].t1 analog_2 VAPWR sg13_lv_pmos ad=1.14p pd=6.38u as=1.14p ps=6.38u w=6u l=1u
X70 VGND.t32 ui_in[0].t0 analog_2 VGND.t2 sg13_lv_nmos ad=0.19p pd=1.38u as=0.19p ps=1.38u w=1u l=1u
X71 VAPWR ui_in[0].t1 analog_2 VAPWR sg13_lv_pmos ad=1.14p pd=6.38u as=1.14p ps=6.38u w=6u l=1u
X72 VAPWR ui_in[0].t1 analog_2 VAPWR sg13_lv_pmos ad=1.14p pd=6.38u as=1.14p ps=6.38u w=6u l=1u
X73 analog_2 ui_in[0].t0 VGND.t36 VGND.t10 sg13_lv_nmos ad=0.19p pd=1.38u as=0.19p ps=1.38u w=1u l=1u
X74 VAPWR ui_in[0].t1 analog_2 VAPWR sg13_lv_pmos ad=1.14p pd=6.38u as=1.14p ps=6.38u w=6u l=1u
X75 analog_2 ui_in[0].t1 VAPWR VAPWR sg13_lv_pmos ad=1.14p pd=6.38u as=1.14p ps=6.38u w=6u l=1u
X76 analog_2 ui_in[0].t0 VGND.t38 VGND.t13 sg13_lv_nmos ad=0.19p pd=1.38u as=0.19p ps=1.38u w=1u l=1u
X77 analog_2 ui_in[0].t1 VAPWR VAPWR sg13_lv_pmos ad=1.14p pd=6.38u as=1.14p ps=6.38u w=6u l=1u
X78 VGND.t42 ui_in[0].t0 analog_2 VGND.t17 sg13_lv_nmos ad=0.19p pd=1.38u as=0.19p ps=1.38u w=1u l=1u
X79 VAPWR analog_0 analog_1 VAPWR sg13_lv_pmos ad=1.14p pd=6.38u as=1.14p ps=6.38u w=6u l=1u
X80 VAPWR ui_in[0].t1 analog_2 VAPWR sg13_lv_pmos ad=1.14p pd=6.38u as=1.14p ps=6.38u w=6u l=1u
X81 analog_2 ui_in[0].t0 VGND.t40 VGND.t16 sg13_lv_nmos ad=0.19p pd=1.38u as=0.19p ps=1.38u w=1u l=1u
X82 analog_1 analog_0 VAPWR VAPWR sg13_lv_pmos ad=1.14p pd=6.38u as=1.14p ps=6.38u w=6u l=1u
X83 VGND.t44 ui_in[0].t0 analog_2 VGND.t20 sg13_lv_nmos ad=0.19p pd=1.38u as=0.19p ps=1.38u w=1u l=1u
X84 analog_2 ui_in[0].t0 VGND.t48 VGND.t28 sg13_lv_nmos ad=0.19p pd=1.38u as=0.19p ps=1.38u w=1u l=1u
X85 VGND.t65 VAPWR VGND.t65 VGND.t64 sg13_lv_pmos ad=3.4p pd=20.68u as=0 ps=0 w=10u l=10u
X86 VAPWR ui_in[0].t1 analog_2 VAPWR sg13_lv_pmos ad=1.14p pd=6.38u as=1.14p ps=6.38u w=6u l=1u
X87 analog_2 ui_in[0].t0 VGND.t34 VGND.t7 sg13_lv_nmos ad=0.19p pd=1.38u as=0.19p ps=1.38u w=1u l=1u
X88 analog_2 ui_in[0].t0 VGND.t46 VGND.t25 sg13_lv_nmos ad=0.19p pd=1.38u as=0.19p ps=1.38u w=1u l=1u
X89 VGND.t30 analog_0 analog_1 VGND.t29 sg13_lv_nmos ad=0.19p pd=1.38u as=0.19p ps=1.38u w=1u l=1u
R0 ui_in[0].n15 ui_in[0].t1 0.994683
R1 ui_in[0].n17 ui_in[0].t0 0.994013
R2 ui_in[0].n9 ui_in[0].n1 0.748572
R3 ui_in[0].n10 ui_in[0].n9 0.578786
R4 ui_in[0].n11 ui_in[0].n10 0.578786
R5 ui_in[0].n12 ui_in[0].n11 0.578786
R6 ui_in[0].n13 ui_in[0].n12 0.578786
R7 ui_in[0].n14 ui_in[0].n13 0.578786
R8 ui_in[0].n15 ui_in[0].n14 0.578786
R9 ui_in[0].n0 ui_in[0].n24 0.755676
R10 ui_in[0].n24 ui_in[0].n23 0.578786
R11 ui_in[0].n23 ui_in[0].n22 0.578786
R12 ui_in[0].n22 ui_in[0].n21 0.578786
R13 ui_in[0].n21 ui_in[0].n20 0.578786
R14 ui_in[0].n20 ui_in[0].n19 0.578786
R15 ui_in[0].n19 ui_in[0].n18 0.578786
R16 ui_in[0].n18 ui_in[0].n17 0.578786
R17 ui_in[0].n14 ui_in[0].n8 0.254024
R18 ui_in[0].n13 ui_in[0].n7 0.254024
R19 ui_in[0].n12 ui_in[0].n6 0.254024
R20 ui_in[0].n11 ui_in[0].n5 0.254024
R21 ui_in[0].n10 ui_in[0].n4 0.254024
R22 ui_in[0].n9 ui_in[0].n3 0.254024
R23 ui_in[0].n1 ui_in[0].n2 0.0282822
R24 ui_in[0].n24 ui_in[0].n2 0.254024
R25 ui_in[0].n23 ui_in[0].n3 0.254024
R26 ui_in[0].n22 ui_in[0].n4 0.254024
R27 ui_in[0].n21 ui_in[0].n5 0.254024
R28 ui_in[0].n20 ui_in[0].n6 0.254024
R29 ui_in[0].n19 ui_in[0].n7 0.254024
R30 ui_in[0].n18 ui_in[0].n8 0.254024
R31 ui_in[0].n17 ui_in[0].n16 0.192615
R32 ui_in[0].n16 ui_in[0].n15 0.191641
R33 ui_in[0].n16 ui_in[0].n8 0.128842
R34 ui_in[0].n1 ui_in[0].n0 0.105962
R35 ui_in[0].n3 ui_in[0].n2 0.12194
R36 ui_in[0].n4 ui_in[0].n3 0.12194
R37 ui_in[0].n5 ui_in[0].n4 0.12194
R38 ui_in[0].n6 ui_in[0].n5 0.12194
R39 ui_in[0].n7 ui_in[0].n6 0.12194
R40 ui_in[0].n8 ui_in[0].n7 0.12194
R41 ui_in[0] ui_in[0].n0 40.295
R42 VGND.n292 VGND.n75 4688.03
R43 VGND.n162 VGND.t0 86.957
R44 VGND.t29 VGND.n85 86.957
R45 VGND.n165 VGND.t2 81.5222
R46 VGND.t28 VGND.n87 81.5222
R47 VGND.n168 VGND.t4 76.0875
R48 VGND.t26 VGND.n93 76.0875
R49 VGND.n174 VGND.t5 70.6527
R50 VGND.t25 VGND.n97 70.6527
R51 VGND.n181 VGND.t7 65.2179
R52 VGND.t23 VGND.n103 65.2179
R53 VGND.n189 VGND.t8 59.7831
R54 VGND.t22 VGND.n104 59.7831
R55 VGND.n196 VGND.t10 54.3483
R56 VGND.t14 VGND.n116 54.3483
R57 VGND.n220 VGND.t16 54.3483
R58 VGND.t20 VGND.n105 54.3483
R59 VGND.n204 VGND.t11 48.9135
R60 VGND.t13 VGND.n120 48.9135
R61 VGND.n226 VGND.t17 48.9135
R62 VGND.t19 VGND.n109 48.9135
R63 VGND.t11 VGND.n126 43.4788
R64 VGND.n207 VGND.t13 43.4788
R65 VGND.t17 VGND.n111 43.4788
R66 VGND.n234 VGND.t19 43.4788
R67 VGND.t10 VGND.n127 38.044
R68 VGND.n213 VGND.t14 38.044
R69 VGND.t16 VGND.n115 38.044
R70 VGND.n239 VGND.t20 38.044
R71 VGND.t8 VGND.n129 32.6092
R72 VGND.n244 VGND.t22 32.6092
R73 VGND.t7 VGND.n130 27.1744
R74 VGND.n252 VGND.t23 27.1744
R75 VGND.t5 VGND.n132 21.7396
R76 VGND.n255 VGND.t25 21.7396
R77 VGND.n27 VGND.n280 13.8429
R78 VGND.n16 VGND.n278 14.36
R79 VGND.n0 VGND.n84 17.0005
R80 VGND.n10 VGND.n274 14.3607
R81 VGND.n22 VGND.n274 14.36
R82 VGND.n0 VGND.n22 0.661826
R83 VGND.n0 VGND.n85 8.48934
R84 VGND.n0 VGND.n266 17.0005
R85 VGND.n0 VGND.n5 0.661826
R86 VGND.n0 VGND.n87 8.48958
R87 VGND.n11 VGND.n260 14.3607
R88 VGND.n0 VGND.n92 17.0005
R89 VGND.n0 VGND.n259 17.0005
R90 VGND.n0 VGND.n93 8.48981
R91 VGND.n0 VGND.n8 0.661826
R92 VGND.n17 VGND.n251 14.3607
R93 VGND.n0 VGND.n102 17.0005
R94 VGND.n0 VGND.n103 8.49004
R95 VGND.n0 VGND.n6 0.661826
R96 VGND.n6 VGND.n243 14.3607
R97 VGND.n0 VGND.n104 8.49028
R98 VGND.n0 VGND.n35 17.0005
R99 VGND.n13 VGND.n238 14.3607
R100 VGND.n281 VGND.n0 17.0005
R101 VGND.n0 VGND.n237 17.0005
R102 VGND.n0 VGND.n105 8.49052
R103 VGND.n0 VGND.n18 0.661826
R104 VGND.n18 VGND.n233 14.3607
R105 VGND.n0 VGND.n108 17.0005
R106 VGND.n0 VGND.n234 8.49609
R107 VGND.n0 VGND.n109 8.49076
R108 VGND.n0 VGND.n228 17.0005
R109 VGND.n7 VGND.n225 14.3607
R110 VGND.n0 VGND.n110 17.0005
R111 VGND.n0 VGND.n226 8.49585
R112 VGND.n0 VGND.n224 17.0005
R113 VGND.n0 VGND.n111 8.49099
R114 VGND.n0 VGND.n15 0.661826
R115 VGND.n15 VGND.n219 14.3607
R116 VGND.n0 VGND.n114 17.0005
R117 VGND.n0 VGND.n220 8.4956
R118 VGND.n0 VGND.n115 8.49634
R119 VGND.n2 VGND.n215 14.579
R120 VGND.n0 VGND.n214 17.0005
R121 VGND.n0 VGND.n2 0.552335
R122 VGND.n0 VGND.n68 17.0005
R123 VGND.n0 VGND.n213 8.49536
R124 VGND.n0 VGND.n211 17.0005
R125 VGND.n0 VGND.n116 8.49123
R126 VGND.n0 VGND.n9 0.661826
R127 VGND.n9 VGND.n206 14.3607
R128 VGND.n0 VGND.n207 8.49511
R129 VGND.n0 VGND.n120 8.49147
R130 VGND.n0 VGND.n24 0.661826
R131 VGND.n24 VGND.n203 14.3607
R132 VGND.n0 VGND.n125 17.0005
R133 VGND.n0 VGND.n204 8.49486
R134 VGND.n0 VGND.n126 8.49171
R135 VGND.n0 VGND.n19 0.661826
R136 VGND.n19 VGND.n195 14.36
R137 VGND.n0 VGND.n196 8.49462
R138 VGND.n0 VGND.n127 8.49925
R139 VGND.n0 VGND.n191 17.0005
R140 VGND.n12 VGND.n188 14.36
R141 VGND.n0 VGND.n128 17.0005
R142 VGND.n0 VGND.n129 8.49195
R143 VGND.n14 VGND.n180 14.3607
R144 VGND.n0 VGND.n181 8.49437
R145 VGND.n0 VGND.n130 8.49219
R146 VGND.n25 VGND.n177 14.36
R147 VGND.n0 VGND.n176 17.0005
R148 VGND.n0 VGND.n25 0.661826
R149 VGND.n0 VGND.n131 17.0005
R150 VGND.n0 VGND.n174 8.49413
R151 VGND.n0 VGND.n172 17.0005
R152 VGND.n0 VGND.n132 8.49243
R153 VGND.n0 VGND.n3 0.661826
R154 VGND.n3 VGND.n167 14.3607
R155 VGND.n0 VGND.n168 8.49388
R156 VGND.n0 VGND.n136 8.49267
R157 VGND.n26 VGND.n166 14.36
R158 VGND.n0 VGND.n26 0.661826
R159 VGND.n0 VGND.n165 8.49364
R160 VGND.n0 VGND.n143 8.49291
R161 VGND.n0 VGND.n21 0.661826
R162 VGND.n21 VGND.n161 14.36
R163 VGND.n0 VGND.n147 17.0005
R164 VGND.n0 VGND.n162 8.4934
R165 VGND.n0 VGND.n148 8.49316
R166 VGND.n0 VGND.n20 0.661826
R167 VGND.n20 VGND.n154 14.3607
R168 VGND.n1 VGND.n154 14.36
R169 VGND.n0 VGND.n1 0.661826
R170 VGND.n0 VGND.n23 0.661826
R171 VGND.n0 VGND.n36 17.0005
R172 VGND.n23 VGND.n150 14.36
R173 VGND.n0 VGND.n4 0.661826
R174 VGND.n265 VGND.n33 17.0005
R175 VGND.n90 VGND.n33 17.0005
R176 VGND.n258 VGND.n33 17.0005
R177 VGND.n100 VGND.n33 17.0005
R178 VGND.n236 VGND.n33 17.0005
R179 VGND.n231 VGND.n33 17.0005
R180 VGND.n223 VGND.n33 17.0005
R181 VGND.n217 VGND.n33 17.0005
R182 VGND.n210 VGND.n33 17.0005
R183 VGND.n123 VGND.n33 17.0005
R184 VGND.n171 VGND.n33 17.0005
R185 VGND.n139 VGND.n33 17.0005
R186 VGND.n141 VGND.n33 17.0005
R187 VGND.n159 VGND.n33 17.0005
R188 VGND.n271 VGND.n0 8.50055
R189 VGND.n264 VGND.n0 8.49955
R190 VGND.n261 VGND.n0 8.4993
R191 VGND.n255 VGND.n0 8.49905
R192 VGND.n97 VGND.n0 8.5
R193 VGND.n252 VGND.n0 8.4988
R194 VGND.n244 VGND.n0 8.49855
R195 VGND.n239 VGND.n0 8.49965
R196 VGND.n189 VGND.n0 8.49975
R197 VGND.t4 VGND.n136 16.3048
R198 VGND.n261 VGND.t26 16.3048
R199 VGND.t53 VGND.n74 15.0005
R200 VGND.n290 VGND.t62 15.0005
R201 VGND.n79 VGND.t56 15.0005
R202 VGND.n297 VGND.t59 15.0005
R203 VGND.n2 VGND.n212 14.5804
R204 VGND.n28 VGND.n83 14.1402
R205 VGND.n27 VGND.n83 13.3246
R206 VGND.n280 VGND.n16 14.3607
R207 VGND.t57 VGND.n10 7.18094
R208 VGND.n262 VGND.n11 14.3607
R209 VGND.n253 VGND.n17 14.3607
R210 VGND.n240 VGND.n13 14.3607
R211 VGND.n229 VGND.n7 14.3607
R212 VGND.n192 VGND.n12 14.3607
R213 VGND.n184 VGND.n14 14.3607
R214 VGND.n4 VGND.n149 14.8364
R215 VGND.n1 VGND.t54 7.18094
R216 VGND.n26 VGND.n164 14.3614
R217 VGND.n25 VGND.n173 14.3614
R218 VGND.n8 VGND.n254 14.3614
R219 VGND.n5 VGND.n263 14.3614
R220 VGND.n22 VGND.n270 14.3614
R221 VGND.t2 VGND.n143 10.8701
R222 VGND.n264 VGND.t28 10.8701
R223 VGND.n75 VGND.n0 1.7006
R224 VGND.n292 VGND.n28 1.41491
R225 VGND.n30 VGND.n29 0.00986364
R226 VGND.n83 VGND.n33 8.5005
R227 VGND.n38 VGND.n29 1.87907
R228 VGND.n0 VGND.n277 8.4984
R229 VGND.n0 VGND.n273 8.4984
R230 VGND.n0 VGND.n269 8.4984
R231 VGND.n0 VGND.n86 8.4984
R232 VGND.n0 VGND.n89 8.4984
R233 VGND.n0 VGND.n94 8.4984
R234 VGND.n0 VGND.n96 8.4984
R235 VGND.n0 VGND.n99 8.4984
R236 VGND.n0 VGND.n250 8.4984
R237 VGND.n0 VGND.n246 8.4984
R238 VGND.n0 VGND.n242 8.4984
R239 VGND.n0 VGND.n106 8.4984
R240 VGND.n0 VGND.n232 8.4984
R241 VGND.n0 VGND.n112 8.4984
R242 VGND.n0 VGND.n218 8.4984
R243 VGND.n0 VGND.n117 8.4984
R244 VGND.n0 VGND.n119 8.4984
R245 VGND.n0 VGND.n122 8.4984
R246 VGND.n0 VGND.n202 8.4984
R247 VGND.n0 VGND.n198 8.4984
R248 VGND.n0 VGND.n194 8.4984
R249 VGND.n0 VGND.n187 8.4984
R250 VGND.n0 VGND.n183 8.4984
R251 VGND.n0 VGND.n179 8.4984
R252 VGND.n0 VGND.n133 8.4984
R253 VGND.n0 VGND.n135 8.4984
R254 VGND.n0 VGND.n138 8.4984
R255 VGND.n0 VGND.n142 8.4984
R256 VGND.n0 VGND.n145 8.4984
R257 VGND.n0 VGND.n160 8.4984
R258 VGND.n0 VGND.n156 8.4984
R259 VGND.n0 VGND.n153 8.4984
R260 VGND.n276 VGND.n33 8.4984
R261 VGND.n275 VGND.n33 8.4984
R262 VGND.n272 VGND.n33 8.4984
R263 VGND.n268 VGND.n33 8.4984
R264 VGND.n88 VGND.n33 8.4984
R265 VGND.n257 VGND.n33 8.4984
R266 VGND.n95 VGND.n33 8.4984
R267 VGND.n98 VGND.n33 8.4984
R268 VGND.n249 VGND.n33 8.4984
R269 VGND.n248 VGND.n33 8.4984
R270 VGND.n245 VGND.n33 8.4984
R271 VGND.n241 VGND.n33 8.4984
R272 VGND.n82 VGND.n33 8.4984
R273 VGND.n107 VGND.n33 8.4984
R274 VGND.n230 VGND.n33 8.4984
R275 VGND.n222 VGND.n33 8.4984
R276 VGND.n113 VGND.n33 8.4984
R277 VGND.n216 VGND.n33 8.4984
R278 VGND.n209 VGND.n33 8.4984
R279 VGND.n118 VGND.n33 8.4984
R280 VGND.n121 VGND.n33 8.4984
R281 VGND.n201 VGND.n33 8.4984
R282 VGND.n200 VGND.n33 8.4984
R283 VGND.n197 VGND.n33 8.4984
R284 VGND.n193 VGND.n33 8.4984
R285 VGND.n186 VGND.n33 8.4984
R286 VGND.n185 VGND.n33 8.4984
R287 VGND.n182 VGND.n33 8.4984
R288 VGND.n178 VGND.n33 8.4984
R289 VGND.n170 VGND.n33 8.4984
R290 VGND.n134 VGND.n33 8.4984
R291 VGND.n137 VGND.n33 8.4984
R292 VGND.n144 VGND.n33 8.4984
R293 VGND.n146 VGND.n33 8.4984
R294 VGND.n158 VGND.n33 8.4984
R295 VGND.n155 VGND.n33 8.4984
R296 VGND.n152 VGND.n33 8.4984
R297 VGND.n31 VGND.n29 0.00257912
R298 VGND.n294 VGND.t53 7.49606
R299 VGND.t62 VGND.n289 7.49606
R300 VGND.t56 VGND.n78 7.49606
R301 VGND.t59 VGND.n73 7.49606
R302 VGND.n262 VGND.n87 7.18094
R303 VGND.n253 VGND.n97 7.18094
R304 VGND.n240 VGND.n104 7.18094
R305 VGND.n229 VGND.n109 7.18094
R306 VGND.n215 VGND.n115 7.18094
R307 VGND.n192 VGND.n127 7.18094
R308 VGND.n184 VGND.n129 7.18094
R309 VGND.n177 VGND.n130 7.18094
R310 VGND.n166 VGND.n136 7.18094
R311 VGND.n163 VGND.n143 7.18094
R312 VGND.n157 VGND.n148 7.18094
R313 VGND.n151 VGND.t54 7.18094
R314 VGND.n4 VGND.n150 14.3607
R315 VGND.n162 VGND.n161 7.18094
R316 VGND.n3 VGND.n169 14.3614
R317 VGND.n189 VGND.n188 7.18094
R318 VGND.n196 VGND.n195 7.18094
R319 VGND.n19 VGND.n199 14.3614
R320 VGND.n24 VGND.n205 14.3614
R321 VGND.n9 VGND.n208 14.3614
R322 VGND.n15 VGND.n221 14.3614
R323 VGND.n18 VGND.n235 14.3614
R324 VGND.n6 VGND.n247 14.3614
R325 VGND.n8 VGND.n256 14.3607
R326 VGND.n5 VGND.n267 14.3607
R327 VGND.t57 VGND.n278 7.18094
R328 VGND.n271 VGND.n270 7.18026
R329 VGND.n264 VGND.n263 7.18026
R330 VGND.n261 VGND.n260 7.18026
R331 VGND.n255 VGND.n254 7.18026
R332 VGND.n252 VGND.n251 7.18026
R333 VGND.n244 VGND.n243 7.18026
R334 VGND.n239 VGND.n238 7.18026
R335 VGND.n234 VGND.n233 7.18026
R336 VGND.n226 VGND.n225 7.18026
R337 VGND.n220 VGND.n219 7.18026
R338 VGND.n213 VGND.n212 7.18026
R339 VGND.n207 VGND.n206 7.18026
R340 VGND.n204 VGND.n203 7.18026
R341 VGND.n181 VGND.n180 7.18026
R342 VGND.n174 VGND.n173 7.18026
R343 VGND.n168 VGND.n167 7.18026
R344 VGND.n165 VGND.n164 7.18026
R345 VGND.n21 VGND.n163 14.3607
R346 VGND.n20 VGND.n157 14.3607
R347 VGND.n23 VGND.n151 14.3607
R348 VGND.n267 VGND.n85 7.18026
R349 VGND.n256 VGND.n93 7.18026
R350 VGND.n247 VGND.n103 7.18026
R351 VGND.n235 VGND.n105 7.18026
R352 VGND.n221 VGND.n111 7.18026
R353 VGND.n208 VGND.n116 7.18026
R354 VGND.n205 VGND.n120 7.18026
R355 VGND.n199 VGND.n126 7.18026
R356 VGND.n169 VGND.n132 7.18026
R357 VGND.n292 VGND.n33 1.70196
R358 VGND.n30 VGND.n32 0.137674
R359 VGND.n33 VGND.n34 0.00333805
R360 VGND.n38 VGND.n32 1.50079
R361 VGND.n31 VGND.t52 1.36922
R362 VGND.t0 VGND.n148 5.43528
R363 VGND.n271 VGND.t29 5.43528
R364 VGND.t1 VGND.n72 4.5005
R365 VGND.n295 VGND.t31 4.5005
R366 VGND.n291 VGND.t30 4.5005
R367 VGND.t50 VGND.n77 4.5005
R368 VGND.n33 VGND.n37 4.25219
R369 VGND.n279 VGND.n33 4.25206
R370 VGND.n0 VGND.n279 4.25175
R371 VGND.n0 VGND.n37 4.25169
R372 VGND.t51 VGND.n30 0.113454
R373 VGND.n299 VGND.n298 3.0005
R374 VGND.n293 VGND.n71 3.0005
R375 VGND.n288 VGND.n287 3.0005
R376 VGND.n81 VGND.n80 3.0005
R377 VGND.n301 VGND.t3 2.48177
R378 VGND.n302 VGND.t6 2.48177
R379 VGND.n303 VGND.t9 2.48177
R380 VGND.n70 VGND.t12 2.48177
R381 VGND.t18 VGND.n69 2.48177
R382 VGND.n283 VGND.t21 2.48177
R383 VGND.n284 VGND.t24 2.48177
R384 VGND.n285 VGND.t27 2.48177
R385 VGND.n301 VGND.t32 2.48177
R386 VGND.n302 VGND.t34 2.48177
R387 VGND.n303 VGND.t36 2.48177
R388 VGND.n70 VGND.t38 2.48177
R389 VGND.t42 VGND.n69 2.48177
R390 VGND.n283 VGND.t44 2.48177
R391 VGND.n284 VGND.t46 2.48177
R392 VGND.n285 VGND.t48 2.48177
R393 VGND.n0 VGND.n28 0.261206
R394 VGND.n27 VGND.n0 1.22693
R395 VGND.n16 VGND.n0 0.661826
R396 VGND.n10 VGND.n0 0.661826
R397 VGND.n11 VGND.n0 0.661826
R398 VGND.n17 VGND.n0 0.661826
R399 VGND.n13 VGND.n0 0.661826
R400 VGND.n7 VGND.n0 0.661826
R401 VGND.n12 VGND.n0 0.661826
R402 VGND.n14 VGND.n0 0.661826
R403 VGND.t61 VGND.n72 2.2505
R404 VGND.t55 VGND.n295 2.2505
R405 VGND.t63 VGND.n291 2.2505
R406 VGND.n77 VGND.t58 2.2505
R407 VGND VGND.n304 1.88203
R408 VGND.n149 VGND.n75 1.53271
R409 VGND.n304 VGND.n66 1.49725
R410 VGND.n304 VGND.n65 1.41932
R411 VGND.n278 VGND.n33 0.661826
R412 VGND.n274 VGND.n33 0.661826
R413 VGND.n267 VGND.n33 0.661826
R414 VGND.n263 VGND.n33 0.661826
R415 VGND.n256 VGND.n33 0.661826
R416 VGND.n254 VGND.n33 0.661826
R417 VGND.n253 VGND.n33 0.661826
R418 VGND.n251 VGND.n33 0.661826
R419 VGND.n247 VGND.n33 0.661826
R420 VGND.n240 VGND.n33 0.661826
R421 VGND.n238 VGND.n33 0.661826
R422 VGND.n235 VGND.n33 0.661826
R423 VGND.n229 VGND.n33 0.661826
R424 VGND.n225 VGND.n33 0.661826
R425 VGND.n221 VGND.n33 0.661826
R426 VGND.n215 VGND.n33 0.661826
R427 VGND.n212 VGND.n33 0.661826
R428 VGND.n208 VGND.n33 0.661826
R429 VGND.n205 VGND.n33 0.661826
R430 VGND.n203 VGND.n33 0.661826
R431 VGND.n199 VGND.n33 0.661826
R432 VGND.n195 VGND.n33 0.661826
R433 VGND.n188 VGND.n33 0.661826
R434 VGND.n184 VGND.n33 0.661826
R435 VGND.n180 VGND.n33 0.661826
R436 VGND.n169 VGND.n33 0.661826
R437 VGND.n161 VGND.n33 0.661826
R438 VGND.n151 VGND.n33 0.661826
R439 VGND.n150 VGND.n33 0.661826
R440 VGND.n280 VGND.n33 0.661826
R441 VGND.n270 VGND.n33 0.661826
R442 VGND.n262 VGND.n33 0.661826
R443 VGND.n260 VGND.n33 0.661826
R444 VGND.n243 VGND.n33 0.661826
R445 VGND.n233 VGND.n33 0.661826
R446 VGND.n219 VGND.n33 0.661826
R447 VGND.n206 VGND.n33 0.661826
R448 VGND.n192 VGND.n33 0.661826
R449 VGND.n177 VGND.n33 0.661826
R450 VGND.n173 VGND.n33 0.661826
R451 VGND.n167 VGND.n33 0.661826
R452 VGND.n166 VGND.n33 0.661826
R453 VGND.n164 VGND.n33 0.661826
R454 VGND.n163 VGND.n33 0.661826
R455 VGND.n157 VGND.n33 0.661826
R456 VGND.n154 VGND.n33 0.661826
R457 VGND.n50 VGND.t52 0.412831
R458 VGND.n43 VGND.t65 0.412464
R459 VGND.n51 VGND.n39 0.41245
R460 VGND.n64 VGND.n63 0.41245
R461 VGND.n53 VGND.n52 0.409591
R462 VGND.n55 VGND.n54 0.409591
R463 VGND.n57 VGND.n56 0.409591
R464 VGND.n59 VGND.n58 0.409591
R465 VGND.n61 VGND.n60 0.409591
R466 VGND.n62 VGND.n42 0.409591
R467 VGND.n51 VGND.n50 0.409591
R468 VGND.n52 VGND.n49 0.409591
R469 VGND.n55 VGND.n48 0.409591
R470 VGND.n56 VGND.n47 0.409591
R471 VGND.n59 VGND.n46 0.409591
R472 VGND.n61 VGND.n45 0.409591
R473 VGND.n62 VGND.n44 0.409591
R474 VGND.n63 VGND.n43 0.409591
R475 VGND.t65 VGND.t64 0.652987
R476 VGND.n65 VGND.n39 0.204366
R477 VGND.n65 VGND.n40 0.204366
R478 VGND.n65 VGND.n41 0.204366
R479 VGND.n65 VGND.n64 0.204366
R480 VGND.n140 VGND.t32 0.200997
R481 VGND.n175 VGND.t34 0.200997
R482 VGND.n190 VGND.t36 0.200997
R483 VGND.n124 VGND.t38 0.200997
R484 VGND.n227 VGND.t42 0.200997
R485 VGND.t44 VGND.n282 0.200997
R486 VGND.n101 VGND.t46 0.200997
R487 VGND.n91 VGND.t48 0.200997
R488 VGND.n140 VGND.t3 0.200995
R489 VGND.n175 VGND.t6 0.200995
R490 VGND.n190 VGND.t9 0.200995
R491 VGND.n124 VGND.t12 0.200995
R492 VGND.n227 VGND.t18 0.200995
R493 VGND.n282 VGND.t21 0.200995
R494 VGND.n101 VGND.t24 0.200995
R495 VGND.n91 VGND.t27 0.200995
R496 VGND.n31 VGND.n32 2.81593
R497 VGND.t58 VGND.n0 1.08363
R498 VGND.n67 VGND.t15 0.185126
R499 VGND.n149 VGND.n33 0.142116
R500 VGND.n301 VGND.n300 0.117247
R501 VGND.n286 VGND.n285 0.1171
R502 VGND.n302 VGND.n301 0.08146
R503 VGND.n303 VGND.n302 0.08146
R504 VGND.n70 VGND.n303 0.08146
R505 VGND.n66 VGND.n70 0.08146
R506 VGND.n66 VGND.n69 0.08146
R507 VGND.n283 VGND.n69 0.08146
R508 VGND.n284 VGND.n283 0.08146
R509 VGND.n285 VGND.n284 0.08146
R510 VGND.t63 VGND.n34 1.0384
R511 VGND.t55 VGND.n0 1.05949
R512 VGND.t52 VGND.n38 0.0134277
R513 VGND.t31 VGND.n294 0.031258
R514 VGND.n73 VGND.t1 0.031258
R515 VGND.n300 VGND.n299 0.0291125
R516 VGND.n300 VGND.n71 0.0291125
R517 VGND.n286 VGND.n81 0.0291125
R518 VGND.n287 VGND.n286 0.0291125
R519 VGND.n299 VGND.n72 0.0281144
R520 VGND.n295 VGND.n71 0.0281144
R521 VGND.n81 VGND.n77 0.0281144
R522 VGND.n291 VGND.n287 0.0281144
R523 VGND.n289 VGND.n76 0.0216549
R524 VGND.n78 VGND.n76 0.0216549
R525 VGND.t30 VGND.n290 0.0208704
R526 VGND.n79 VGND.t50 0.0208704
R527 VGND.n293 VGND.n74 0.0202884
R528 VGND.n290 VGND.n288 0.0202884
R529 VGND.n80 VGND.n79 0.0202884
R530 VGND.n298 VGND.n297 0.0202884
R531 VGND.n67 VGND.n66 0.0194533
R532 VGND.n279 VGND.n76 0.0162424
R533 VGND.n296 VGND.n37 0.0159649
R534 VGND.n277 VGND.n276 0.0118857
R535 VGND.n277 VGND.n275 0.0118857
R536 VGND.n272 VGND.n269 0.0118857
R537 VGND.n269 VGND.n268 0.0118857
R538 VGND.n88 VGND.n86 0.0118857
R539 VGND.n95 VGND.n94 0.0118857
R540 VGND.n98 VGND.n96 0.0118857
R541 VGND.n248 VGND.n246 0.0118857
R542 VGND.n245 VGND.n242 0.0118857
R543 VGND.n242 VGND.n241 0.0118857
R544 VGND.n107 VGND.n106 0.0118857
R545 VGND.n232 VGND.n230 0.0118857
R546 VGND.n113 VGND.n112 0.0118857
R547 VGND.n218 VGND.n216 0.0118857
R548 VGND.n118 VGND.n117 0.0118857
R549 VGND.n121 VGND.n119 0.0118857
R550 VGND.n202 VGND.n201 0.0118857
R551 VGND.n200 VGND.n198 0.0118857
R552 VGND.n198 VGND.n197 0.0118857
R553 VGND.n194 VGND.n193 0.0118857
R554 VGND.n187 VGND.n185 0.0118857
R555 VGND.n183 VGND.n182 0.0118857
R556 VGND.n179 VGND.n178 0.0118857
R557 VGND.n134 VGND.n133 0.0118857
R558 VGND.n137 VGND.n135 0.0118857
R559 VGND.n144 VGND.n142 0.0118857
R560 VGND.n146 VGND.n145 0.0118857
R561 VGND.n160 VGND.n158 0.0118857
R562 VGND.n155 VGND.n153 0.0118857
R563 VGND.n153 VGND.n152 0.0118857
R564 VGND.n156 VGND.n155 0.0118857
R565 VGND.n158 VGND.n156 0.0118857
R566 VGND.n145 VGND.n144 0.0118857
R567 VGND.n138 VGND.n137 0.0118857
R568 VGND.n135 VGND.n134 0.0118857
R569 VGND.n182 VGND.n179 0.0118857
R570 VGND.n185 VGND.n183 0.0118857
R571 VGND.n187 VGND.n186 0.0118857
R572 VGND.n197 VGND.n194 0.0118857
R573 VGND.n202 VGND.n200 0.0118857
R574 VGND.n122 VGND.n121 0.0118857
R575 VGND.n119 VGND.n118 0.0118857
R576 VGND.n246 VGND.n245 0.0118857
R577 VGND.n250 VGND.n248 0.0118857
R578 VGND.n250 VGND.n249 0.0118857
R579 VGND.n99 VGND.n98 0.0118857
R580 VGND.n96 VGND.n95 0.0118857
R581 VGND.n89 VGND.n88 0.0118857
R582 VGND.n273 VGND.n272 0.0118857
R583 VGND.n275 VGND.n273 0.0118857
R584 VGND.n296 VGND.n74 0.0115582
R585 VGND.n297 VGND.n296 0.0115582
R586 VGND.n159 VGND.n147 0.0108889
R587 VGND.n172 VGND.n171 0.0108889
R588 VGND.n211 VGND.n210 0.0108889
R589 VGND.n217 VGND.n114 0.0108889
R590 VGND.n224 VGND.n223 0.0108889
R591 VGND.n231 VGND.n108 0.0108889
R592 VGND.n237 VGND.n236 0.0108889
R593 VGND.n259 VGND.n258 0.0108889
R594 VGND.n266 VGND.n265 0.0108889
R595 VGND.n294 VGND.n293 0.0108877
R596 VGND.n289 VGND.n288 0.0108877
R597 VGND.n80 VGND.n78 0.0108877
R598 VGND.n298 VGND.n73 0.0108877
R599 VGND.t63 VGND.n76 0.0101032
R600 VGND.t58 VGND.n76 0.0101032
R601 VGND.n296 VGND.t55 0.00981217
R602 VGND.n296 VGND.t61 0.00981217
R603 VGND.n140 VGND.n139 0.00936111
R604 VGND.n92 VGND.n91 0.00936111
R605 VGND.n176 VGND.n175 0.00813889
R606 VGND.n102 VGND.n101 0.00813889
R607 VGND.n191 VGND.n190 0.00691667
R608 VGND.t40 VGND.n68 0.00691667
R609 VGND.n214 VGND.t40 0.00691667
R610 VGND.n282 VGND.n281 0.00691667
R611 VGND.n50 VGND.n49 0.00643258
R612 VGND.n49 VGND.n48 0.00643258
R613 VGND.n48 VGND.n47 0.00643258
R614 VGND.n47 VGND.n46 0.00643258
R615 VGND.n46 VGND.n45 0.00643258
R616 VGND.n45 VGND.n44 0.00643258
R617 VGND.n44 VGND.n43 0.00643258
R618 VGND.n296 VGND.n36 0.00630556
R619 VGND.n90 VGND.n89 0.00619286
R620 VGND.n100 VGND.n99 0.00619286
R621 VGND.n123 VGND.n122 0.00619286
R622 VGND.n139 VGND.n138 0.00619286
R623 VGND.n257 VGND.n92 0.00619286
R624 VGND.n249 VGND.n102 0.00619286
R625 VGND.n281 VGND.n82 0.00619286
R626 VGND.n224 VGND.n222 0.00619286
R627 VGND.n209 VGND.n68 0.00619286
R628 VGND.n186 VGND.n128 0.00619286
R629 VGND.n170 VGND.n131 0.00619286
R630 VGND.n152 VGND.n36 0.00619286
R631 VGND.n160 VGND.n159 0.00619286
R632 VGND.n147 VGND.n146 0.00619286
R633 VGND.n142 VGND.n141 0.00619286
R634 VGND.n171 VGND.n133 0.00619286
R635 VGND.n172 VGND.n170 0.00619286
R636 VGND.n178 VGND.n176 0.00619286
R637 VGND.n193 VGND.n191 0.00619286
R638 VGND.n201 VGND.n125 0.00619286
R639 VGND.n210 VGND.n117 0.00619286
R640 VGND.n211 VGND.n209 0.00619286
R641 VGND.n216 VGND.n214 0.00619286
R642 VGND.n218 VGND.n217 0.00619286
R643 VGND.n114 VGND.n113 0.00619286
R644 VGND.n223 VGND.n112 0.00619286
R645 VGND.n222 VGND.n110 0.00619286
R646 VGND.n230 VGND.n228 0.00619286
R647 VGND.n232 VGND.n231 0.00619286
R648 VGND.n108 VGND.n107 0.00619286
R649 VGND.n236 VGND.n106 0.00619286
R650 VGND.n237 VGND.n82 0.00619286
R651 VGND.n241 VGND.n35 0.00619286
R652 VGND.n258 VGND.n94 0.00619286
R653 VGND.n259 VGND.n257 0.00619286
R654 VGND.n265 VGND.n86 0.00619286
R655 VGND.n268 VGND.n266 0.00619286
R656 VGND.n276 VGND.n84 0.00619286
R657 VGND.n84 VGND.n76 0.00615278
R658 VGND.n125 VGND.n124 0.00569444
R659 VGND.n124 VGND.n123 0.00569444
R660 VGND.n227 VGND.n110 0.00569444
R661 VGND.n228 VGND.n227 0.00569444
R662 VGND.n54 VGND.n53 0.00524607
R663 VGND.n58 VGND.n57 0.00524607
R664 VGND.n60 VGND.n42 0.00524607
R665 VGND.n52 VGND.n51 0.00524607
R666 VGND.n55 VGND.n52 0.00524607
R667 VGND.n56 VGND.n55 0.00524607
R668 VGND.n59 VGND.n56 0.00524607
R669 VGND.n61 VGND.n59 0.00524607
R670 VGND.n62 VGND.n61 0.00524607
R671 VGND.n63 VGND.n62 0.00524607
R672 VGND.n190 VGND.n128 0.00447222
R673 VGND.n282 VGND.n35 0.00447222
R674 VGND.n54 VGND.n40 0.00335935
R675 VGND.n58 VGND.n41 0.00335935
R676 VGND.n64 VGND.n42 0.00335935
R677 VGND.n53 VGND.n39 0.00335935
R678 VGND.n57 VGND.n40 0.00335935
R679 VGND.n60 VGND.n41 0.00335935
R680 VGND.n175 VGND.n131 0.00325
R681 VGND.n101 VGND.n100 0.00325
R682 VGND.t40 VGND.n67 0.00249109
R683 VGND.n141 VGND.n140 0.00202778
R684 VGND.n91 VGND.n90 0.00202778
R685 VGND.t61 VGND.n34 1.08184
C0 ui_in[0] VPWR 0.54099f
C1 analog_2 analog_1 1.44271f
C2 ui_in[0] analog_0 0.25462f
C3 VAPWR analog_1 19.588f
C4 ui_in[0] analog_2 18.7529f
C5 ui_in[0] VAPWR 30.2796f
C6 analog_0 VAPWR 30.2344f
C7 analog_0 analog_1 19.9607f
C8 analog_2 VAPWR 19.494f
C9 uo_out[0] VGND 0.04448f
C10 uo_out[1] VGND 0.03799f
C11 uo_out[2] VGND 0.03799f
C12 uo_out[3] VGND 0.03799f
C13 uo_out[4] VGND 0.03799f
C14 uo_out[5] VGND 0.03799f
C15 uo_out[6] VGND 0.03799f
C16 uo_out[7] VGND 0.03799f
C17 uio_out[0] VGND 0.03799f
C18 uio_out[1] VGND 0.03799f
C19 uio_out[2] VGND 0.03799f
C20 uio_out[3] VGND 0.03799f
C21 uio_out[4] VGND 0.03799f
C22 uio_out[5] VGND 0.03799f
C23 uio_out[6] VGND 0.03799f
C24 uio_out[7] VGND 0.03799f
C25 uio_oe[0] VGND 0.03799f
C26 uio_oe[1] VGND 0.03799f
C27 uio_oe[2] VGND 0.03799f
C28 uio_oe[3] VGND 0.03799f
C29 uio_oe[4] VGND 0.03799f
C30 uio_oe[5] VGND 0.03799f
C31 uio_oe[6] VGND 0.03799f
C32 uio_oe[7] VGND 0.03799f
C33 ui_in[1] VGND 0.03799f
C34 ui_in[2] VGND 0.03799f
C35 ui_in[3] VGND 0.03799f
C36 ui_in[4] VGND 0.03799f
C37 ui_in[5] VGND 0.03799f
C38 ui_in[6] VGND 0.03799f
C39 ui_in[7] VGND 0.03799f
C40 uio_in[0] VGND 0.03799f
C41 uio_in[1] VGND 0.03799f
C42 uio_in[2] VGND 0.03799f
C43 uio_in[3] VGND 0.03799f
C44 uio_in[4] VGND 0.03799f
C45 uio_in[5] VGND 0.03799f
C46 uio_in[6] VGND 0.03799f
C47 uio_in[7] VGND 0.03799f
C48 ena VGND 0.03799f
C49 clk VGND 0.03799f
C50 rst_n VGND 0.04448f
C51 analog_1 VGND 27.9707f
C52 analog_2 VGND 33.2753f
C53 ui_in[0] VGND 32.20408f
C54 VGND.t52 VGND 50.5974f
C55 VGND.t1 VGND 13.1891f
C56 VGND.t50 VGND 3.54405f
C57 ui_in[0].n0 VGND 4.60807f
C58 ui_in[0].n1 VGND 0.13896f
C59 ui_in[0].n2 VGND 0.26857f
C60 ui_in[0].n3 VGND 0.26857f
C61 ui_in[0].n4 VGND 0.26857f
C62 ui_in[0].n5 VGND 0.26857f
C63 ui_in[0].n6 VGND 0.26857f
C64 ui_in[0].n7 VGND 0.26857f
C65 ui_in[0].n8 VGND 0.28384f
C66 ui_in[0].n9 VGND 0.08166f
C67 ui_in[0].n10 VGND 0.06297f
C68 ui_in[0].n11 VGND 0.06297f
C69 ui_in[0].n12 VGND 0.06297f
C70 ui_in[0].n13 VGND 0.06297f
C71 ui_in[0].n14 VGND 0.06297f
C72 ui_in[0].n15 VGND 0.70263f
C73 ui_in[0].n16 VGND 2.82525f
C74 ui_in[0].n17 VGND 0.71398f
C75 ui_in[0].n18 VGND 0.06297f
C76 ui_in[0].n19 VGND 0.06297f
C77 ui_in[0].n20 VGND 0.06297f
C78 ui_in[0].n21 VGND 0.06297f
C79 ui_in[0].n22 VGND 0.06297f
C80 ui_in[0].n23 VGND 0.06297f
C81 ui_in[0].n24 VGND 0.08251f
.ends
