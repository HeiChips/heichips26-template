* NGSPICE file created from heichips26_dna_sequencer.ext - technology: ihp-sg13cmos5l

* Black-box entry subcircuit for sg13cmos5l_decap_8 abstract view
.subckt sg13cmos5l_decap_8 VDD VSS
.ends

* Black-box entry subcircuit for sg13cmos5l_mux2_1 abstract view
.subckt sg13cmos5l_mux2_1 X A0 A1 S VDD VSS
.ends

* Black-box entry subcircuit for sg13cmos5l_xnor2_1 abstract view
.subckt sg13cmos5l_xnor2_1 Y A B VDD VSS
.ends

* Black-box entry subcircuit for sg13cmos5l_a21oi_1 abstract view
.subckt sg13cmos5l_a21oi_1 Y A1 A2 B1 VDD VSS
.ends

* Black-box entry subcircuit for sg13cmos5l_inv_1 abstract view
.subckt sg13cmos5l_inv_1 Y A VDD VSS
.ends

* Black-box entry subcircuit for sg13cmos5l_a221oi_1 abstract view
.subckt sg13cmos5l_a221oi_1 Y A1 A2 B1 B2 C1 VDD VSS
.ends

* Black-box entry subcircuit for sg13cmos5l_fill_2 abstract view
.subckt sg13cmos5l_fill_2 VDD VSS
.ends

* Black-box entry subcircuit for sg13cmos5l_nor2_1 abstract view
.subckt sg13cmos5l_nor2_1 Y A B VDD VSS
.ends

* Black-box entry subcircuit for sg13cmos5l_nand2b_1 abstract view
.subckt sg13cmos5l_nand2b_1 Y A_N B VDD VSS
.ends

* Black-box entry subcircuit for sg13cmos5l_dfrbpq_1 abstract view
.subckt sg13cmos5l_dfrbpq_1 Q CLK D RESET_B VDD VSS
.ends

* Black-box entry subcircuit for sg13cmos5l_tiehi abstract view
.subckt sg13cmos5l_tiehi L_HI VDD VSS
.ends

* Black-box entry subcircuit for sg13cmos5l_dlygate4sd3_1 abstract view
.subckt sg13cmos5l_dlygate4sd3_1 X A VDD VSS
.ends

* Black-box entry subcircuit for sg13cmos5l_fill_1 abstract view
.subckt sg13cmos5l_fill_1 VDD VSS
.ends

* Black-box entry subcircuit for sg13cmos5l_decap_4 abstract view
.subckt sg13cmos5l_decap_4 VDD VSS
.ends

* Black-box entry subcircuit for sg13cmos5l_o21ai_1 abstract view
.subckt sg13cmos5l_o21ai_1 Y A1 A2 B1 VDD VSS
.ends

* Black-box entry subcircuit for sg13cmos5l_nand2_1 abstract view
.subckt sg13cmos5l_nand2_1 Y A B VDD VSS
.ends

* Black-box entry subcircuit for sg13cmos5l_and2_1 abstract view
.subckt sg13cmos5l_and2_1 X A B VDD VSS
.ends

* Black-box entry subcircuit for sg13cmos5l_buf_1 abstract view
.subckt sg13cmos5l_buf_1 X A VDD VSS
.ends

* Black-box entry subcircuit for sg13cmos5l_nand3_1 abstract view
.subckt sg13cmos5l_nand3_1 Y A B C VDD VSS
.ends

* Black-box entry subcircuit for sg13cmos5l_a21o_1 abstract view
.subckt sg13cmos5l_a21o_1 X A1 A2 B1 VDD VSS
.ends

* Black-box entry subcircuit for sg13cmos5l_a22oi_1 abstract view
.subckt sg13cmos5l_a22oi_1 Y A1 A2 B1 B2 VDD VSS
.ends

* Black-box entry subcircuit for sg13cmos5l_nor2b_1 abstract view
.subckt sg13cmos5l_nor2b_1 Y A B_N VDD VSS
.ends

* Black-box entry subcircuit for sg13cmos5l_xor2_1 abstract view
.subckt sg13cmos5l_xor2_1 X A B VDD VSS
.ends

* Black-box entry subcircuit for sg13cmos5l_nor3_1 abstract view
.subckt sg13cmos5l_nor3_1 Y A B C VDD VSS
.ends

* Black-box entry subcircuit for sg13cmos5l_or2_1 abstract view
.subckt sg13cmos5l_or2_1 X A B VDD VSS
.ends

* Black-box entry subcircuit for sg13cmos5l_tielo abstract view
.subckt sg13cmos5l_tielo L_LO VDD VSS
.ends

* Black-box entry subcircuit for sg13cmos5l_buf_8 abstract view
.subckt sg13cmos5l_buf_8 X A VDD VSS
.ends

* Black-box entry subcircuit for sg13cmos5l_nor4_1 abstract view
.subckt sg13cmos5l_nor4_1 Y A B C D VDD VSS
.ends

* Black-box entry subcircuit for sg13cmos5l_and3_1 abstract view
.subckt sg13cmos5l_and3_1 X A B C VDD VSS
.ends

* Black-box entry subcircuit for sg13cmos5l_and4_1 abstract view
.subckt sg13cmos5l_and4_1 X A B C D VDD VSS
.ends

* Black-box entry subcircuit for sg13cmos5l_or3_1 abstract view
.subckt sg13cmos5l_or3_1 X A B C VDD VSS
.ends

* Black-box entry subcircuit for sg13cmos5l_nand4_1 abstract view
.subckt sg13cmos5l_nand4_1 Y A B C D VDD VSS
.ends

* Black-box entry subcircuit for sg13cmos5l_or4_1 abstract view
.subckt sg13cmos5l_or4_1 X A B C D VDD VSS
.ends

* Black-box entry subcircuit for sg13cmos5l_nand3b_1 abstract view
.subckt sg13cmos5l_nand3b_1 Y A_N B C VDD VSS
.ends

* Black-box entry subcircuit for sg13cmos5l_inv_2 abstract view
.subckt sg13cmos5l_inv_2 Y A VDD VSS
.ends

* Black-box entry subcircuit for sg13cmos5l_inv_8 abstract view
.subckt sg13cmos5l_inv_8 Y A VDD VSS
.ends

* Black-box entry subcircuit for sg13cmos5l_inv_4 abstract view
.subckt sg13cmos5l_inv_4 Y A VDD VSS
.ends

.subckt heichips26_dna_sequencer VGND VPWR clk ena rst_n ui_in[0] ui_in[1] ui_in[2]
+ ui_in[3] ui_in[4] ui_in[5] ui_in[6] ui_in[7] uio_in[0] uio_in[1] uio_in[2] uio_in[3]
+ uio_in[4] uio_in[5] uio_in[6] uio_in[7] uio_oe[0] uio_oe[1] uio_oe[2] uio_oe[3]
+ uio_oe[4] uio_oe[5] uio_oe[6] uio_oe[7] uio_out[0] uio_out[1] uio_out[2] uio_out[3]
+ uio_out[4] uio_out[5] uio_out[6] uio_out[7] uo_out[0] uo_out[1] uo_out[2] uo_out[3]
+ uo_out[4] uo_out[5] uo_out[6] uo_out[7]
XFILLER_39_211 VPWR VGND sg13cmos5l_decap_8
X_6914_ _7008_/A _6899_/X _4145_/Y _6916_/S VPWR VGND sg13cmos5l_mux2_1
X_6845_ _6845_/Y _7446_/Q _7418_/Q VPWR VGND sg13cmos5l_xnor2_1
X_6776_ _7436_/D _6836_/B _6836_/C _6889_/A VPWR VGND sg13cmos5l_a21oi_1
X_3988_ _5731_/B _3988_/A VPWR VGND sg13cmos5l_inv_1
X_5727_ _5727_/Y _5993_/A _7220_/Q _7219_/Q _5992_/A _5726_/Y VPWR VGND sg13cmos5l_a221oi_1
XFILLER_22_177 VPWR VGND sg13cmos5l_fill_2
X_5658_ _5660_/B _5915_/A _5662_/B VPWR VGND sg13cmos5l_nor2_1
X_5589_ _5620_/C _5616_/A VPWR VGND sg13cmos5l_inv_1
X_4609_ _4613_/A _4625_/B _4609_/B VPWR VGND sg13cmos5l_nand2b_1
X_7328_ _7328_/Q _7344_/CLK _7328_/D _7328_/RESET_B VPWR VGND sg13cmos5l_dfrbpq_1
XFILLER_2_527 VPWR VGND sg13cmos5l_decap_8
X_7259_ _7259_/Q _7332_/CLK _7259_/D _7259_/RESET_B VPWR VGND sg13cmos5l_dfrbpq_1
X_7459__643 _7459_/RESET_B VPWR VGND sg13cmos5l_tiehi
Xhold1051 _7410_/D _6646_/Y VPWR VGND sg13cmos5l_dlygate4sd3_1
Xhold1040 _3952_/A _7633_/Q VPWR VGND sg13cmos5l_dlygate4sd3_1
Xhold1062 hold1062/X _7236_/Q VPWR VGND sg13cmos5l_dlygate4sd3_1
Xhold1073 _3999_/A _7142_/Q VPWR VGND sg13cmos5l_dlygate4sd3_1
Xhold1084 _6987_/A2 _7081_/A VPWR VGND sg13cmos5l_dlygate4sd3_1
Xhold1095 _6353_/A0 _7346_/Q VPWR VGND sg13cmos5l_dlygate4sd3_1
XFILLER_42_932 VPWR VGND sg13cmos5l_decap_8
XFILLER_27_995 VPWR VGND sg13cmos5l_decap_8
XFILLER_41_431 VPWR VGND sg13cmos5l_fill_2
X_7466__625 _7466_/RESET_B VPWR VGND sg13cmos5l_tiehi
XFILLER_42_987 VPWR VGND sg13cmos5l_fill_1
XFILLER_9_115 VPWR VGND sg13cmos5l_decap_4
XFILLER_5_321 VPWR VGND sg13cmos5l_fill_1
XFILLER_6_899 VPWR VGND sg13cmos5l_decap_8
XFILLER_49_575 VPWR VGND sg13cmos5l_fill_1
XFILLER_3_1007 VPWR VGND sg13cmos5l_decap_8
X_7588__705 _7588_/RESET_B VPWR VGND sg13cmos5l_tiehi
X_7217__523 _7217_/RESET_B VPWR VGND sg13cmos5l_tiehi
XFILLER_18_951 VPWR VGND sg13cmos5l_decap_4
XFILLER_24_409 VPWR VGND sg13cmos5l_fill_2
XFILLER_36_236 VPWR VGND sg13cmos5l_decap_4
X_4960_ _4994_/A _4960_/A _4960_/B VPWR VGND sg13cmos5l_xnor2_1
X_3911_ _6976_/B _3911_/A VPWR VGND sg13cmos5l_inv_1
X_4891_ _7640_/D _6107_/A _4891_/B VPWR VGND sg13cmos5l_nor2_1
X_6630_ _6632_/B _6630_/A1 _6633_/C _6629_/Y VPWR VGND sg13cmos5l_o21ai_1
X_6561_ _6561_/Y _7400_/Q _7399_/Q VPWR VGND sg13cmos5l_xnor2_1
X_5512_ _5512_/Y _5777_/A _7183_/Q _5511_/Y VPWR VGND sg13cmos5l_o21ai_1
X_6492_ _6492_/X _6486_/B _6626_/B _6494_/S VPWR VGND sg13cmos5l_mux2_1
X_5443_ _5443_/Y _5450_/B _5452_/B VPWR VGND sg13cmos5l_nand2_1
X_5374_ _5374_/Y _5376_/B _5376_/C VPWR VGND sg13cmos5l_nand2_1
X_7113_ _7513_/D _7113_/A _7113_/B VPWR VGND sg13cmos5l_and2_1
X_4325_ _4325_/Y _4540_/B _4324_/X _4321_/Y VPWR VGND sg13cmos5l_a21oi_1
Xfanout105 _7083_/B hold1317/X VPWR VGND sg13cmos5l_buf_1
Xfanout116 _6107_/A _6427_/A VPWR VGND sg13cmos5l_buf_1
Xfanout127 _6827_/A _6829_/A VPWR VGND sg13cmos5l_buf_1
Xfanout138 _4560_/A fanout142/X VPWR VGND sg13cmos5l_buf_1
X_4256_ _7526_/D _4256_/A _4337_/A VPWR VGND sg13cmos5l_nor2_1
X_7044_ _7046_/B _7041_/Y _7053_/A VPWR VGND sg13cmos5l_nand2b_1
X_4187_ _4213_/A _4194_/B _4187_/B VPWR VGND sg13cmos5l_nor2_1
XFILLER_43_718 VPWR VGND sg13cmos5l_decap_8
XFILLER_23_464 VPWR VGND sg13cmos5l_decap_4
X_6828_ _7450_/D _6829_/A _6828_/B VPWR VGND sg13cmos5l_and2_1
X_6759_ _6759_/Y _6761_/A _6761_/B _6758_/Y VPWR VGND sg13cmos5l_a21oi_1
XFILLER_6_107 VPWR VGND sg13cmos5l_fill_2
XFILLER_3_803 VPWR VGND sg13cmos5l_decap_8
XFILLER_18_214 VPWR VGND sg13cmos5l_fill_2
XFILLER_18_225 VPWR VGND sg13cmos5l_fill_2
XFILLER_19_737 VPWR VGND sg13cmos5l_fill_2
XFILLER_46_589 VPWR VGND sg13cmos5l_decap_4
XFILLER_14_442 VPWR VGND sg13cmos5l_fill_2
XFILLER_30_913 VPWR VGND sg13cmos5l_fill_1
XFILLER_6_652 VPWR VGND sg13cmos5l_fill_1
XFILLER_10_692 VPWR VGND sg13cmos5l_fill_2
XFILLER_6_696 VPWR VGND sg13cmos5l_fill_2
XFILLER_6_685 VPWR VGND sg13cmos5l_decap_8
XFILLER_5_184 VPWR VGND sg13cmos5l_decap_8
XFILLER_38_4 VPWR VGND sg13cmos5l_decap_4
X_4110_ _4120_/B _4110_/A _4110_/B VPWR VGND sg13cmos5l_nor2_1
XFILLER_2_880 VPWR VGND sg13cmos5l_fill_2
X_5090_ _5090_/Y _7619_/Q _5550_/A2 _5096_/A VPWR VGND sg13cmos5l_o21ai_1
XFILLER_25_1019 VPWR VGND sg13cmos5l_decap_8
XFILLER_49_350 VPWR VGND sg13cmos5l_fill_1
X_4041_ _4041_/Y input8/X _4041_/B _4041_/C VPWR VGND sg13cmos5l_nand3_1
XFILLER_37_534 VPWR VGND sg13cmos5l_decap_8
XFILLER_37_512 VPWR VGND sg13cmos5l_decap_4
Xheichips26_dna_sequencer_758 uio_oe[5] VPWR VGND sg13cmos5l_tiehi
XFILLER_37_556 VPWR VGND sg13cmos5l_fill_1
X_5992_ _7306_/D _5992_/A _5993_/B VPWR VGND sg13cmos5l_nor2_1
X_7510__309 _7510_/RESET_B VPWR VGND sg13cmos5l_tiehi
X_4943_ _7128_/D _4904_/Y _4941_/Y _7115_/D VPWR VGND sg13cmos5l_a21o_1
X_6613_ _6613_/Y _6613_/A _6613_/B VPWR VGND sg13cmos5l_nor2_1
X_4874_ _4874_/Y hold834/X _4873_/Y _6427_/A VPWR VGND sg13cmos5l_a21oi_1
X_7593_ _7593_/Q _7597_/CLK _7593_/D _7593_/RESET_B VPWR VGND sg13cmos5l_dfrbpq_1
XFILLER_20_434 VPWR VGND sg13cmos5l_decap_8
XFILLER_20_445 VPWR VGND sg13cmos5l_fill_1
X_6544_ _6547_/A _6532_/Y _6534_/X _6540_/Y _6542_/Y _6543_/Y VPWR VGND sg13cmos5l_a221oi_1
XFILLER_20_489 VPWR VGND sg13cmos5l_fill_1
X_6475_ _6475_/Y _7396_/Q _6483_/B _6481_/B _7395_/Q VPWR VGND sg13cmos5l_a22oi_1
X_5426_ _5461_/A _7207_/Q _5426_/B VPWR VGND sg13cmos5l_xnor2_1
X_5357_ _5369_/A _7194_/Q _5382_/B VPWR VGND sg13cmos5l_xnor2_1
X_4308_ _4324_/S _4575_/A _4307_/Y _4306_/Y VPWR VGND sg13cmos5l_o21ai_1
X_5288_ _5288_/Y _7203_/Q _7198_/Q VPWR VGND sg13cmos5l_nor2b_1
XFILLER_47_309 VPWR VGND sg13cmos5l_decap_4
X_4239_ _4239_/Y _4228_/X _4232_/Y _4235_/Y _4266_/A _4233_/X VPWR VGND sg13cmos5l_a221oi_1
X_7027_ _7055_/C _7487_/Q _7037_/B _7050_/A VPWR VGND sg13cmos5l_o21ai_1
XFILLER_28_556 VPWR VGND sg13cmos5l_decap_8
XFILLER_43_526 VPWR VGND sg13cmos5l_decap_4
XFILLER_11_412 VPWR VGND sg13cmos5l_decap_8
XFILLER_12_968 VPWR VGND sg13cmos5l_decap_4
XFILLER_23_53 VPWR VGND sg13cmos5l_fill_1
XFILLER_23_75 VPWR VGND sg13cmos5l_fill_2
X_7207__533 _7207_/RESET_B VPWR VGND sg13cmos5l_tiehi
XFILLER_3_677 VPWR VGND sg13cmos5l_fill_2
XFILLER_3_699 VPWR VGND sg13cmos5l_fill_1
XFILLER_46_364 VPWR VGND sg13cmos5l_decap_8
XFILLER_46_386 VPWR VGND sg13cmos5l_decap_8
X_7214__526 _7214_/RESET_B VPWR VGND sg13cmos5l_tiehi
X_7585__708 _7585_/RESET_B VPWR VGND sg13cmos5l_tiehi
XFILLER_15_773 VPWR VGND sg13cmos5l_fill_2
XFILLER_14_272 VPWR VGND sg13cmos5l_fill_2
X_4590_ _4590_/Y _4600_/A _4611_/B VPWR VGND sg13cmos5l_nand2_1
Xhold906 _3975_/A _7354_/Q VPWR VGND sg13cmos5l_dlygate4sd3_1
Xhold917 _4901_/B _4029_/B VPWR VGND sg13cmos5l_dlygate4sd3_1
Xhold928 _7003_/A _7457_/Q VPWR VGND sg13cmos5l_dlygate4sd3_1
X_6260_ _6260_/Y _6269_/B _6260_/B VPWR VGND sg13cmos5l_nand2_1
Xhold939 _3939_/A _7238_/Q VPWR VGND sg13cmos5l_dlygate4sd3_1
X_5211_ _5229_/S _5208_/A _5208_/B _5210_/Y VPWR VGND sg13cmos5l_o21ai_1
X_7221__519 _7221_/RESET_B VPWR VGND sg13cmos5l_tiehi
X_6191_ _7334_/D _6191_/A _6325_/A VPWR VGND sg13cmos5l_nor2_1
X_5142_ _5142_/X _5142_/A _5142_/B VPWR VGND sg13cmos5l_xor2_1
XFILLER_29_0 VPWR VGND sg13cmos5l_fill_2
X_5073_ _5073_/Y _5334_/A _3948_/A _4771_/A _7615_/Q VPWR VGND sg13cmos5l_a22oi_1
XFILLER_49_180 VPWR VGND sg13cmos5l_decap_4
X_4024_ _6511_/A _4024_/A VPWR VGND sg13cmos5l_inv_1
X_5975_ _5975_/X _5963_/B _6156_/B _5975_/S VPWR VGND sg13cmos5l_mux2_1
XFILLER_40_529 VPWR VGND sg13cmos5l_fill_2
X_4926_ _4926_/Y _4938_/A _6500_/A2 _6108_/B VPWR VGND sg13cmos5l_o21ai_1
XFILLER_33_581 VPWR VGND sg13cmos5l_decap_8
X_7645_ _7645_/Q clkload6/A _7645_/D _7645_/RESET_B VPWR VGND sg13cmos5l_dfrbpq_1
XFILLER_21_743 VPWR VGND sg13cmos5l_fill_1
X_4857_ _4858_/B _4823_/Y _4850_/Y _4784_/B VPWR VGND sg13cmos5l_o21ai_1
XFILLER_20_264 VPWR VGND sg13cmos5l_decap_4
X_7576_ _7576_/Q _7630_/CLK _7576_/D _7576_/RESET_B VPWR VGND sg13cmos5l_dfrbpq_1
X_4788_ _7629_/D _4788_/A _4788_/B VPWR VGND sg13cmos5l_nor2_1
X_6527_ _6545_/A _6531_/A _6531_/B _6531_/C VPWR VGND sg13cmos5l_a21oi_1
X_6458_ _6458_/Y _6458_/A VPWR VGND sg13cmos5l_inv_1
X_5409_ _7200_/D _5375_/X _5401_/Y _5408_/Y VPWR VGND sg13cmos5l_a21oi_1
X_6389_ _6389_/Y _4939_/A _6653_/A2 _6391_/B1 VPWR VGND sg13cmos5l_o21ai_1
XFILLER_0_625 VPWR VGND sg13cmos5l_fill_1
XFILLER_16_515 VPWR VGND sg13cmos5l_fill_1
XFILLER_28_397 VPWR VGND sg13cmos5l_fill_1
XFILLER_12_721 VPWR VGND sg13cmos5l_fill_1
XFILLER_8_725 VPWR VGND sg13cmos5l_fill_1
XFILLER_11_242 VPWR VGND sg13cmos5l_fill_2
XFILLER_12_776 VPWR VGND sg13cmos5l_decap_8
XFILLER_4_975 VPWR VGND sg13cmos5l_decap_8
XFILLER_15_6 VPWR VGND sg13cmos5l_fill_1
X_5760_ _7256_/D _5847_/A _5760_/B VPWR VGND sg13cmos5l_nor2_1
XFILLER_34_378 VPWR VGND sg13cmos5l_decap_8
X_5691_ _5698_/C _7210_/Q _7211_/Q _7212_/Q VPWR VGND sg13cmos5l_o21ai_1
X_7288__446 _7288_/RESET_B VPWR VGND sg13cmos5l_tiehi
X_4711_ _4711_/Y _4433_/B _4701_/X _4714_/B _4714_/A VPWR VGND sg13cmos5l_a22oi_1
X_7430_ _7430_/Q _7490_/CLK _7430_/D _7430_/RESET_B VPWR VGND sg13cmos5l_dfrbpq_1
X_4642_ _4657_/B _7632_/Q _5098_/A VPWR VGND sg13cmos5l_nor2_1
X_4573_ _7590_/D _4573_/A _4573_/B VPWR VGND sg13cmos5l_nor2_1
X_7361_ _7361_/Q _7394_/CLK _7361_/D _7361_/RESET_B VPWR VGND sg13cmos5l_dfrbpq_1
X_7292_ _7292_/Q _7314_/CLK _7292_/D _7292_/RESET_B VPWR VGND sg13cmos5l_dfrbpq_1
X_6312_ _6312_/Y _6307_/Y _6310_/A _6311_/Y VPWR VGND sg13cmos5l_a21oi_1
X_7149__597 _7149_/RESET_B VPWR VGND sg13cmos5l_tiehi
X_6243_ _6256_/B _6240_/B _6240_/C _6240_/A VPWR VGND sg13cmos5l_a21oi_1
X_7479__443 _7479_/RESET_B VPWR VGND sg13cmos5l_tiehi
Xhold769 _6394_/B _7125_/Q VPWR VGND sg13cmos5l_dlygate4sd3_1
X_6174_ _6174_/Y _6180_/A _6174_/B _6174_/C VPWR VGND sg13cmos5l_nor3_1
X_5125_ _5136_/B _7158_/Q _5146_/B VPWR VGND sg13cmos5l_nand2_1
X_5056_ _5056_/Y _7166_/Q _7161_/Q VPWR VGND sg13cmos5l_nor2b_1
X_4007_ _4749_/B _4007_/A VPWR VGND sg13cmos5l_inv_1
XFILLER_40_315 VPWR VGND sg13cmos5l_fill_1
X_5958_ _5958_/Y _5958_/A VPWR VGND sg13cmos5l_inv_1
XFILLER_13_518 VPWR VGND sg13cmos5l_decap_8
X_4909_ _4912_/B _4911_/A _4909_/B VPWR VGND sg13cmos5l_nand2_1
X_5889_ _7280_/D _5993_/B _5889_/B VPWR VGND sg13cmos5l_nor2_1
X_7628_ _7628_/Q _7630_/CLK _7628_/D _7628_/RESET_B VPWR VGND sg13cmos5l_dfrbpq_1
X_7559_ _7559_/Q _7560_/CLK _7559_/D _7559_/RESET_B VPWR VGND sg13cmos5l_dfrbpq_1
XFILLER_5_706 VPWR VGND sg13cmos5l_fill_2
X_7204__536 _7204_/RESET_B VPWR VGND sg13cmos5l_tiehi
XFILLER_0_477 VPWR VGND sg13cmos5l_decap_8
XFILLER_1_989 VPWR VGND sg13cmos5l_decap_8
X_7211__529 _7211_/RESET_B VPWR VGND sg13cmos5l_tiehi
XFILLER_31_337 VPWR VGND sg13cmos5l_fill_1
XFILLER_12_595 VPWR VGND sg13cmos5l_fill_2
XFILLER_4_794 VPWR VGND sg13cmos5l_decap_8
XFILLER_6_1005 VPWR VGND sg13cmos5l_decap_8
XFILLER_20_4 VPWR VGND sg13cmos5l_decap_4
XFILLER_39_437 VPWR VGND sg13cmos5l_decap_8
XFILLER_48_982 VPWR VGND sg13cmos5l_decap_8
X_6930_ _6930_/Y _7458_/Q _6930_/B VPWR VGND sg13cmos5l_nand2_1
X_6861_ _6861_/X _6868_/B _6861_/B VPWR VGND sg13cmos5l_or2_1
X_5812_ _5813_/B _5818_/A _5818_/B _5790_/Y VPWR VGND sg13cmos5l_a21oi_1
X_6792_ _6793_/A _6816_/A _6792_/B VPWR VGND sg13cmos5l_nor2_1
X_5743_ _5743_/Y _5741_/C _5742_/Y _5741_/Y VPWR VGND sg13cmos5l_a21oi_1
X_5674_ _5675_/B _5664_/X _5672_/Y _5673_/X _5677_/C VPWR VGND sg13cmos5l_a22oi_1
X_4625_ _4628_/B _4625_/A _4625_/B _4625_/C VPWR VGND sg13cmos5l_nor3_1
X_7413_ _7413_/Q _7513_/CLK _7413_/D _7413_/RESET_B VPWR VGND sg13cmos5l_dfrbpq_1
X_7344_ _7344_/Q _7344_/CLK _7344_/D _7344_/RESET_B VPWR VGND sg13cmos5l_dfrbpq_1
X_4556_ _4556_/Y _4542_/X _4554_/S _4640_/B1 VPWR VGND sg13cmos5l_o21ai_1
X_4487_ _4487_/Y _4261_/B _4507_/A _4486_/Y VPWR VGND sg13cmos5l_o21ai_1
X_7275_ _7275_/Q _7277_/CLK _7275_/D _7275_/RESET_B VPWR VGND sg13cmos5l_dfrbpq_1
X_6226_ _6227_/A _6309_/A _6222_/Y _6309_/B VPWR VGND sg13cmos5l_a21oi_1
Xhold1200 _6582_/A1 _7399_/Q VPWR VGND sg13cmos5l_dlygate4sd3_1
X_6157_ _6157_/Y _6142_/Y _6155_/Y _6156_/Y VPWR VGND sg13cmos5l_a21oi_1
Xhold1233 _4207_/A _7520_/Q VPWR VGND sg13cmos5l_dlygate4sd3_1
X_5108_ _5108_/Y _5105_/Y _5106_/Y _5107_/Y VPWR VGND sg13cmos5l_o21ai_1
Xhold1222 _5607_/A _7232_/Q VPWR VGND sg13cmos5l_dlygate4sd3_1
Xhold1211 _5843_/A1 _5809_/Y VPWR VGND sg13cmos5l_dlygate4sd3_1
Xhold1244 _6944_/A _7435_/Q VPWR VGND sg13cmos5l_dlygate4sd3_1
Xhold1266 _4427_/A _7565_/Q VPWR VGND sg13cmos5l_dlygate4sd3_1
X_6088_ _6088_/Y _6081_/Y _6082_/Y _6086_/Y _6122_/A _6083_/Y VPWR VGND sg13cmos5l_a221oi_1
Xhold1255 hold1255/X _7199_/Q VPWR VGND sg13cmos5l_dlygate4sd3_1
X_7371__168 _7371_/D VPWR VGND sg13cmos5l_tielo
Xhold1288 _4128_/A _7470_/Q VPWR VGND sg13cmos5l_dlygate4sd3_1
X_5039_ _5039_/Y _5039_/A _5039_/B VPWR VGND sg13cmos5l_nor2_1
Xhold1277 _4676_/A _7599_/Q VPWR VGND sg13cmos5l_dlygate4sd3_1
Xhold1299 _3930_/A _7310_/Q VPWR VGND sg13cmos5l_dlygate4sd3_1
XFILLER_41_624 VPWR VGND sg13cmos5l_fill_1
XFILLER_13_326 VPWR VGND sg13cmos5l_decap_8
XFILLER_13_337 VPWR VGND sg13cmos5l_decap_8
XFILLER_15_54 VPWR VGND sg13cmos5l_decap_8
XFILLER_15_65 VPWR VGND sg13cmos5l_fill_2
XFILLER_25_197 VPWR VGND sg13cmos5l_fill_2
XFILLER_15_98 VPWR VGND sg13cmos5l_fill_1
XFILLER_0_230 VPWR VGND sg13cmos5l_fill_2
XFILLER_49_724 VPWR VGND sg13cmos5l_fill_1
XFILLER_49_713 VPWR VGND sg13cmos5l_decap_8
XFILLER_49_746 VPWR VGND sg13cmos5l_fill_1
XFILLER_48_234 VPWR VGND sg13cmos5l_decap_4
X_7278__456 _7278_/RESET_B VPWR VGND sg13cmos5l_tiehi
XFILLER_49_779 VPWR VGND sg13cmos5l_fill_2
XFILLER_32_613 VPWR VGND sg13cmos5l_fill_1
X_7627__663 _7627_/RESET_B VPWR VGND sg13cmos5l_tiehi
X_7285__449 _7285_/RESET_B VPWR VGND sg13cmos5l_tiehi
XFILLER_9_864 VPWR VGND sg13cmos5l_decap_4
XFILLER_9_897 VPWR VGND sg13cmos5l_fill_2
X_4410_ _4410_/Y _4410_/A1 _4409_/Y _4357_/B VPWR VGND sg13cmos5l_o21ai_1
X_5390_ _5390_/Y _5390_/A VPWR VGND sg13cmos5l_inv_1
X_4341_ _4341_/Y _4327_/Y hold986/X _4337_/A VPWR VGND sg13cmos5l_a21oi_1
X_4272_ _7530_/D _4337_/A _4272_/B VPWR VGND sg13cmos5l_nor2_1
X_7060_ _7062_/A _7060_/A _7056_/Y VPWR VGND sg13cmos5l_nor2b_1
XFILLER_28_1028 VPWR VGND sg13cmos5l_fill_1
X_6011_ _6047_/A _7307_/Q _6039_/B VPWR VGND sg13cmos5l_xnor2_1
X_7634__656 _7634_/RESET_B VPWR VGND sg13cmos5l_tiehi
XFILLER_39_278 VPWR VGND sg13cmos5l_fill_2
X_6913_ _7462_/D _7007_/B _7009_/B VPWR VGND sg13cmos5l_nor2_1
X_6844_ _6844_/Y _7448_/Q _6844_/B VPWR VGND sg13cmos5l_nand2_1
X_6775_ _6839_/B _6836_/B _6836_/C VPWR VGND sg13cmos5l_nand2_1
X_3987_ _5737_/B _3987_/A VPWR VGND sg13cmos5l_inv_1
XFILLER_10_307 VPWR VGND sg13cmos5l_decap_8
X_5726_ _5726_/Y _7275_/Q _5741_/B _5737_/B _7274_/Q _5725_/Y VPWR VGND sg13cmos5l_a221oi_1
XFILLER_10_318 VPWR VGND sg13cmos5l_fill_2
X_5657_ _5657_/Y _5662_/B VPWR VGND sg13cmos5l_inv_1
X_7407__289 _7407_/RESET_B VPWR VGND sg13cmos5l_tiehi
X_5588_ _5616_/A _5615_/B _5615_/C _5615_/A VPWR VGND sg13cmos5l_a21oi_1
X_4608_ _4608_/X _4608_/A _4608_/B VPWR VGND sg13cmos5l_xor2_1
X_7327_ _7327_/Q clkload9/A _7327_/D _7327_/RESET_B VPWR VGND sg13cmos5l_dfrbpq_1
X_4539_ _4539_/Y _7575_/Q _4531_/B _4543_/B _7576_/Q VPWR VGND sg13cmos5l_a22oi_1
X_7258_ _7258_/Q _7314_/CLK _7258_/D _7258_/RESET_B VPWR VGND sg13cmos5l_dfrbpq_1
X_6209_ _6213_/C _7336_/Q _6224_/B _6216_/A VPWR VGND sg13cmos5l_o21ai_1
X_7201__539 _7201_/RESET_B VPWR VGND sg13cmos5l_tiehi
X_7189_ _7189_/Q _7611_/CLK _7189_/D _7189_/RESET_B VPWR VGND sg13cmos5l_dfrbpq_1
Xhold1041 _6192_/A _7311_/Q VPWR VGND sg13cmos5l_dlygate4sd3_1
Xhold1030 _3959_/A _7595_/Q VPWR VGND sg13cmos5l_dlygate4sd3_1
Xhold1063 _3885_/A _7290_/Q VPWR VGND sg13cmos5l_dlygate4sd3_1
Xhold1074 _5078_/B _5077_/X VPWR VGND sg13cmos5l_dlygate4sd3_1
Xhold1085 _7473_/D _6988_/Y VPWR VGND sg13cmos5l_dlygate4sd3_1
Xhold1052 _6647_/A1 _7411_/Q VPWR VGND sg13cmos5l_dlygate4sd3_1
Xhold1096 _6354_/B _6412_/A VPWR VGND sg13cmos5l_dlygate4sd3_1
Xclkbuf_3_6__f_clk clkload4/A clkbuf_0_clk/X VPWR VGND sg13cmos5l_buf_8
XFILLER_10_830 VPWR VGND sg13cmos5l_fill_2
XFILLER_13_178 VPWR VGND sg13cmos5l_fill_2
X_7384__315 _7384_/RESET_B VPWR VGND sg13cmos5l_tiehi
XFILLER_5_344 VPWR VGND sg13cmos5l_decap_4
XFILLER_1_572 VPWR VGND sg13cmos5l_fill_2
XFILLER_49_554 VPWR VGND sg13cmos5l_fill_1
X_7291__442 _7291_/RESET_B VPWR VGND sg13cmos5l_tiehi
X_3910_ _4144_/A _6971_/B VPWR VGND sg13cmos5l_inv_1
X_4890_ _4891_/B _3892_/A _4885_/X _4892_/B VPWR VGND sg13cmos5l_a21oi_1
XFILLER_32_465 VPWR VGND sg13cmos5l_fill_1
X_6560_ _6571_/B _6570_/B _6560_/B VPWR VGND sg13cmos5l_and2_1
X_5511_ _5511_/Y _5509_/Y _5511_/B VPWR VGND sg13cmos5l_nand2b_1
XFILLER_8_171 VPWR VGND sg13cmos5l_fill_2
X_6491_ _6494_/S _7383_/Q _6491_/B VPWR VGND sg13cmos5l_nor2_1
X_5442_ _5708_/A _5773_/A _5709_/A VPWR VGND sg13cmos5l_and2_1
X_5373_ _5376_/C _5391_/B _5391_/C _5340_/A VPWR VGND sg13cmos5l_a21o_1
X_7112_ _7512_/D _3861_/Y _7112_/A2 _7111_/Y VPWR VGND sg13cmos5l_a21oi_1
X_4324_ _4324_/X _4323_/Y _4322_/Y _4324_/S VPWR VGND sg13cmos5l_mux2_1
X_7043_ _7053_/A _7012_/A _7042_/B _7042_/Y VPWR VGND sg13cmos5l_a21oi_1
Xfanout106 _6971_/B hold1242/X VPWR VGND sg13cmos5l_buf_1
Xfanout117 _6427_/A _6554_/A VPWR VGND sg13cmos5l_buf_1
Xfanout128 _6829_/A input1/X VPWR VGND sg13cmos5l_buf_1
Xfanout139 _5096_/A _4569_/A VPWR VGND sg13cmos5l_buf_1
X_4255_ _4291_/A _4560_/B _7106_/A VPWR VGND sg13cmos5l_nand2b_1
X_4186_ _4187_/B _4186_/A _4186_/B VPWR VGND sg13cmos5l_xnor2_1
X_6827_ _7449_/D _6827_/A _6827_/B VPWR VGND sg13cmos5l_and2_1
XFILLER_10_115 VPWR VGND sg13cmos5l_fill_1
X_6758_ _6758_/Y _6751_/B _6751_/C _6751_/A VPWR VGND sg13cmos5l_a21oi_1
XFILLER_10_159 VPWR VGND sg13cmos5l_decap_8
X_7268__466 _7268_/RESET_B VPWR VGND sg13cmos5l_tiehi
X_5709_ _5709_/Y _5709_/A _5709_/B VPWR VGND sg13cmos5l_nor2_1
X_6689_ _6690_/B _6689_/A _6689_/B VPWR VGND sg13cmos5l_xnor2_1
XFILLER_2_314 VPWR VGND sg13cmos5l_decap_4
XFILLER_3_859 VPWR VGND sg13cmos5l_decap_4
XFILLER_2_336 VPWR VGND sg13cmos5l_decap_8
X_7275__459 _7275_/RESET_B VPWR VGND sg13cmos5l_tiehi
XFILLER_46_568 VPWR VGND sg13cmos5l_decap_8
XFILLER_37_63 VPWR VGND sg13cmos5l_fill_1
XFILLER_46_579 VPWR VGND sg13cmos5l_fill_1
XFILLER_14_410 VPWR VGND sg13cmos5l_fill_1
XFILLER_27_782 VPWR VGND sg13cmos5l_decap_8
XFILLER_15_966 VPWR VGND sg13cmos5l_decap_8
XFILLER_41_295 VPWR VGND sg13cmos5l_fill_2
X_7624__666 _7624_/RESET_B VPWR VGND sg13cmos5l_tiehi
XFILLER_6_664 VPWR VGND sg13cmos5l_decap_8
XFILLER_49_340 VPWR VGND sg13cmos5l_decap_4
X_4040_ _4040_/Y input8/X _4041_/C VPWR VGND sg13cmos5l_nand2_1
XFILLER_49_362 VPWR VGND sg13cmos5l_decap_4
Xheichips26_dna_sequencer_759 uio_oe[6] VPWR VGND sg13cmos5l_tiehi
XFILLER_49_395 VPWR VGND sg13cmos5l_fill_2
X_7631__659 _7631_/RESET_B VPWR VGND sg13cmos5l_tiehi
X_5991_ _7305_/D _5991_/A _5994_/B VPWR VGND sg13cmos5l_nor2_1
X_4942_ _4942_/Y _4912_/Y hold889/X _4917_/B _4941_/Y _4917_/A VPWR VGND sg13cmos5l_a221oi_1
X_6612_ _7404_/D _6661_/B _6681_/B VPWR VGND sg13cmos5l_and2_1
X_4873_ _4873_/Y _4875_/B _4880_/A VPWR VGND sg13cmos5l_nor2_1
X_7592_ _7592_/Q _7597_/CLK _7592_/D _7592_/RESET_B VPWR VGND sg13cmos5l_dfrbpq_1
X_6543_ _6543_/Y _6543_/A _6543_/B VPWR VGND sg13cmos5l_nor2_1
X_6474_ _6474_/Y _6663_/A _7356_/Q VPWR VGND sg13cmos5l_nand2_1
X_5425_ _5429_/B _7207_/Q _7206_/Q _7204_/Q _7205_/Q VPWR VGND sg13cmos5l_nor4_1
X_5356_ _5367_/B _7195_/Q _5382_/B VPWR VGND sg13cmos5l_nand2_1
X_4307_ _4307_/Y _7508_/Q _7560_/Q VPWR VGND sg13cmos5l_nor2_1
X_5287_ _5297_/C _7203_/Q _5284_/B _5285_/Y VPWR VGND sg13cmos5l_o21ai_1
X_4238_ _4238_/Y _4266_/A VPWR VGND sg13cmos5l_inv_1
X_7026_ _7050_/A _7486_/Q _7037_/B _7041_/A VPWR VGND sg13cmos5l_a21o_1
X_4169_ _4196_/B _4120_/X _7074_/B _4168_/Y VPWR VGND sg13cmos5l_o21ai_1
XFILLER_28_546 VPWR VGND sg13cmos5l_decap_4
XFILLER_43_505 VPWR VGND sg13cmos5l_decap_8
XFILLER_16_719 VPWR VGND sg13cmos5l_decap_8
X_7561__208 _7561_/D VPWR VGND sg13cmos5l_tielo
XFILLER_23_98 VPWR VGND sg13cmos5l_fill_2
XFILLER_3_689 VPWR VGND sg13cmos5l_fill_1
XFILLER_2_155 VPWR VGND sg13cmos5l_fill_2
XFILLER_48_84 VPWR VGND sg13cmos5l_fill_1
XFILLER_15_752 VPWR VGND sg13cmos5l_fill_1
XFILLER_9_56 VPWR VGND sg13cmos5l_fill_2
XFILLER_31_1024 VPWR VGND sg13cmos5l_decap_4
Xhold907 _7354_/D _6381_/Y VPWR VGND sg13cmos5l_dlygate4sd3_1
XFILLER_7_995 VPWR VGND sg13cmos5l_decap_8
Xhold918 hold918/X _4901_/Y VPWR VGND sg13cmos5l_dlygate4sd3_1
X_7327__393 _7327_/RESET_B VPWR VGND sg13cmos5l_tiehi
X_5210_ _5210_/Y _5489_/B _5228_/B VPWR VGND sg13cmos5l_nand2_1
XFILLER_6_483 VPWR VGND sg13cmos5l_decap_4
Xhold929 _6661_/A _7395_/Q VPWR VGND sg13cmos5l_dlygate4sd3_1
X_6190_ _7333_/D _6190_/A _6325_/A VPWR VGND sg13cmos5l_nor2_1
X_5141_ _5142_/B _7155_/Q _5151_/B _5119_/Y VPWR VGND sg13cmos5l_a21oi_1
X_5072_ _5072_/Y _7145_/Q _5067_/Y _5071_/Y VPWR VGND sg13cmos5l_o21ai_1
X_4023_ _4023_/Y _7409_/Q VPWR VGND sg13cmos5l_inv_1
X_5974_ _5974_/Y _6143_/B _5975_/S _5973_/Y VPWR VGND sg13cmos5l_a21oi_1
X_4925_ _7120_/D _6108_/B _4925_/B VPWR VGND sg13cmos5l_and2_1
XFILLER_20_210 VPWR VGND sg13cmos5l_fill_2
X_7644_ _7644_/Q clkload6/A _7644_/D _7644_/RESET_B VPWR VGND sg13cmos5l_dfrbpq_1
X_4856_ _4858_/A _4856_/A _4850_/Y VPWR VGND sg13cmos5l_nor2b_1
X_7575_ _7575_/Q _7630_/CLK _7575_/D _7575_/RESET_B VPWR VGND sg13cmos5l_dfrbpq_1
X_4787_ _7628_/D _4787_/A _4788_/B VPWR VGND sg13cmos5l_nor2_1
X_6526_ _6531_/C _7393_/Q _6541_/B VPWR VGND sg13cmos5l_xnor2_1
X_7265__469 _7265_/RESET_B VPWR VGND sg13cmos5l_tiehi
X_6457_ _6458_/A _6463_/B _6456_/Y VPWR VGND sg13cmos5l_nor2b_1
X_5408_ _5408_/Y _5376_/A _5401_/Y _5332_/B VPWR VGND sg13cmos5l_o21ai_1
X_6388_ _6388_/Y _3873_/Y _6653_/A2 _6387_/Y VPWR VGND sg13cmos5l_a21oi_1
X_5339_ _5339_/Y _5336_/Y _5337_/Y _5338_/Y VPWR VGND sg13cmos5l_o21ai_1
X_7009_ _7009_/Y _6946_/B _7009_/B VPWR VGND sg13cmos5l_nand2b_1
XFILLER_44_825 VPWR VGND sg13cmos5l_fill_1
XFILLER_44_814 VPWR VGND sg13cmos5l_fill_1
XFILLER_43_335 VPWR VGND sg13cmos5l_fill_2
XFILLER_43_379 VPWR VGND sg13cmos5l_decap_4
XFILLER_34_42 VPWR VGND sg13cmos5l_fill_2
XFILLER_4_954 VPWR VGND sg13cmos5l_decap_8
X_7621__669 _7621_/RESET_B VPWR VGND sg13cmos5l_tiehi
X_7537__210 _7537_/D VPWR VGND sg13cmos5l_tielo
X_7591__702 _7591_/RESET_B VPWR VGND sg13cmos5l_tiehi
X_7220__520 _7220_/RESET_B VPWR VGND sg13cmos5l_tiehi
XFILLER_46_151 VPWR VGND sg13cmos5l_fill_1
XFILLER_35_836 VPWR VGND sg13cmos5l_decap_4
X_5690_ _5703_/B _5690_/A _5698_/B VPWR VGND sg13cmos5l_xor2_1
XFILLER_15_582 VPWR VGND sg13cmos5l_fill_2
X_4710_ _4710_/Y _4714_/B VPWR VGND sg13cmos5l_inv_1
X_4641_ _7597_/D _4628_/A _4631_/Y _4640_/Y VPWR VGND sg13cmos5l_a21oi_1
X_7360_ _7360_/Q _7651_/CLK _7360_/D _7360_/RESET_B VPWR VGND sg13cmos5l_dfrbpq_1
X_4572_ _7589_/D _4572_/A _4573_/B VPWR VGND sg13cmos5l_nor2_1
X_7291_ _7291_/Q _7314_/CLK _7291_/D _7291_/RESET_B VPWR VGND sg13cmos5l_dfrbpq_1
X_6311_ _6311_/Y _6311_/A _6326_/B VPWR VGND sg13cmos5l_nor2_1
X_6242_ _6242_/Y _6242_/A VPWR VGND sg13cmos5l_inv_1
XFILLER_41_0 VPWR VGND sg13cmos5l_decap_8
X_6173_ _6174_/C _6181_/B _6144_/Y VPWR VGND sg13cmos5l_nor2b_1
X_5124_ _5136_/A _7159_/Q _5146_/B VPWR VGND sg13cmos5l_xnor2_1
X_5055_ _5065_/C _7166_/Q _4771_/A _5054_/B VPWR VGND sg13cmos5l_o21ai_1
X_4006_ _4753_/B _4006_/A VPWR VGND sg13cmos5l_inv_1
XFILLER_38_696 VPWR VGND sg13cmos5l_fill_1
X_5957_ _5958_/A _5961_/C _5956_/Y _5955_/Y VPWR VGND sg13cmos5l_o21ai_1
X_4908_ _4908_/Y _4908_/A _7115_/Q VPWR VGND sg13cmos5l_nor2b_1
X_5888_ _5889_/B _5861_/B _5887_/Y _5888_/S VPWR VGND sg13cmos5l_mux2_1
X_7627_ _7627_/Q _7630_/CLK _7627_/D _7627_/RESET_B VPWR VGND sg13cmos5l_dfrbpq_1
X_4839_ _4842_/B _4839_/A VPWR VGND sg13cmos5l_inv_1
X_7558_ _7558_/Q _7560_/CLK _7558_/D _7558_/RESET_B VPWR VGND sg13cmos5l_dfrbpq_1
XFILLER_5_718 VPWR VGND sg13cmos5l_decap_8
X_7489_ _7489_/Q _7489_/CLK _7489_/D _7489_/RESET_B VPWR VGND sg13cmos5l_dfrbpq_1
XFILLER_4_239 VPWR VGND sg13cmos5l_fill_1
X_6509_ _7392_/D _6509_/A _6511_/B VPWR VGND sg13cmos5l_nor2_1
XFILLER_20_88 VPWR VGND sg13cmos5l_fill_2
XFILLER_1_968 VPWR VGND sg13cmos5l_decap_8
XFILLER_49_939 VPWR VGND sg13cmos5l_decap_8
XFILLER_0_456 VPWR VGND sg13cmos5l_decap_8
XFILLER_29_641 VPWR VGND sg13cmos5l_fill_1
XFILLER_45_74 VPWR VGND sg13cmos5l_decap_4
XFILLER_17_858 VPWR VGND sg13cmos5l_fill_1
XFILLER_16_368 VPWR VGND sg13cmos5l_decap_8
XFILLER_32_839 VPWR VGND sg13cmos5l_fill_2
XFILLER_8_512 VPWR VGND sg13cmos5l_decap_8
XFILLER_6_46 VPWR VGND sg13cmos5l_fill_2
XFILLER_4_762 VPWR VGND sg13cmos5l_fill_2
XFILLER_6_1028 VPWR VGND sg13cmos5l_fill_1
XFILLER_48_961 VPWR VGND sg13cmos5l_decap_8
X_7452__672 _7452_/RESET_B VPWR VGND sg13cmos5l_tiehi
X_7511__246 _7511_/RESET_B VPWR VGND sg13cmos5l_tiehi
X_6860_ _6861_/B _6860_/A _6860_/B VPWR VGND sg13cmos5l_xnor2_1
X_5811_ _5811_/Y _5679_/B _5827_/S _5810_/Y VPWR VGND sg13cmos5l_a21oi_1
XFILLER_34_143 VPWR VGND sg13cmos5l_fill_1
X_6791_ _6809_/B _7007_/A _7003_/A _6802_/C VPWR VGND sg13cmos5l_nand3_1
X_5742_ _5742_/Y _7277_/Q _5992_/A VPWR VGND sg13cmos5l_nor2_1
XFILLER_22_349 VPWR VGND sg13cmos5l_fill_1
X_5673_ _5673_/X _5673_/A _5677_/B VPWR VGND sg13cmos5l_and2_1
X_4624_ _4625_/C _4624_/A _4624_/B _4624_/C VPWR VGND sg13cmos5l_and3_1
X_7412_ _7412_/Q _7490_/CLK _7412_/D _7412_/RESET_B VPWR VGND sg13cmos5l_dfrbpq_1
X_7343_ _7343_/Q clkload6/A _7343_/D _7343_/RESET_B VPWR VGND sg13cmos5l_dfrbpq_1
X_4555_ _7576_/D _4573_/B _4555_/B VPWR VGND sg13cmos5l_nor2_1
X_4486_ _4486_/Y _4483_/Y _4484_/Y _4503_/A _7557_/Q VPWR VGND sg13cmos5l_a22oi_1
X_7274_ _7274_/Q _7307_/CLK _7274_/D _7274_/RESET_B VPWR VGND sg13cmos5l_dfrbpq_1
X_6225_ _6309_/B _6230_/B _6223_/X _6224_/Y VPWR VGND sg13cmos5l_o21ai_1
X_6156_ _6156_/Y _7295_/Q _6156_/B _6159_/B VPWR VGND sg13cmos5l_nor3_1
Xhold1201 _6613_/A _7396_/Q VPWR VGND sg13cmos5l_dlygate4sd3_1
Xhold1212 _4283_/B _7525_/Q VPWR VGND sg13cmos5l_dlygate4sd3_1
Xhold1234 _4218_/A2 _4205_/A VPWR VGND sg13cmos5l_dlygate4sd3_1
X_5107_ _5107_/Y _5105_/A _5105_/B _5109_/B _5109_/A VPWR VGND sg13cmos5l_a22oi_1
Xhold1223 _5609_/B _5608_/Y VPWR VGND sg13cmos5l_dlygate4sd3_1
Xhold1267 _4474_/B _4473_/A VPWR VGND sg13cmos5l_dlygate4sd3_1
X_6087_ _6122_/A _7319_/Q _6087_/B VPWR VGND sg13cmos5l_xnor2_1
Xhold1245 _5667_/A _7241_/Q VPWR VGND sg13cmos5l_dlygate4sd3_1
Xhold1256 _4825_/A _7625_/Q VPWR VGND sg13cmos5l_dlygate4sd3_1
Xhold1278 _6910_/A _7466_/Q VPWR VGND sg13cmos5l_dlygate4sd3_1
XFILLER_45_419 VPWR VGND sg13cmos5l_fill_1
X_5038_ _7138_/D _5038_/A _5038_/B VPWR VGND sg13cmos5l_nor2_1
Xhold1289 _5863_/B _7279_/Q VPWR VGND sg13cmos5l_dlygate4sd3_1
XFILLER_26_600 VPWR VGND sg13cmos5l_fill_1
XFILLER_25_132 VPWR VGND sg13cmos5l_fill_2
X_6989_ _6989_/Y _6989_/A _6989_/B VPWR VGND sg13cmos5l_nor2_1
XFILLER_41_669 VPWR VGND sg13cmos5l_fill_1
XFILLER_40_146 VPWR VGND sg13cmos5l_fill_2
X_7210__530 _7210_/RESET_B VPWR VGND sg13cmos5l_tiehi
XFILLER_40_179 VPWR VGND sg13cmos5l_decap_4
Xoutput10 uio_out[0] _8272_/X VPWR VGND sg13cmos5l_buf_1
XFILLER_1_765 VPWR VGND sg13cmos5l_fill_1
XFILLER_29_471 VPWR VGND sg13cmos5l_fill_1
XFILLER_45_997 VPWR VGND sg13cmos5l_decap_8
XFILLER_44_463 VPWR VGND sg13cmos5l_fill_1
XFILLER_16_143 VPWR VGND sg13cmos5l_decap_4
X_4340_ _4340_/Y _4527_/A _4340_/B VPWR VGND sg13cmos5l_nand2_1
X_4271_ _4380_/A _4247_/B _4258_/B _4518_/A VPWR VGND sg13cmos5l_a21o_1
X_6010_ _6010_/Y _6020_/A _6039_/B VPWR VGND sg13cmos5l_nand2_1
X_6912_ _7009_/B _6899_/B _4154_/Y _6916_/S VPWR VGND sg13cmos5l_mux2_1
X_6843_ _6843_/X _6837_/C _6771_/B _6870_/B VPWR VGND sg13cmos5l_mux2_1
XFILLER_36_986 VPWR VGND sg13cmos5l_fill_2
X_6774_ _6836_/C _6777_/B _6768_/B _6773_/Y VPWR VGND sg13cmos5l_o21ai_1
X_3986_ _5741_/B _3986_/A VPWR VGND sg13cmos5l_inv_1
XFILLER_22_135 VPWR VGND sg13cmos5l_fill_2
X_5725_ _5725_/Y _5991_/A _7218_/Q _7217_/Q _3936_/Y _5724_/Y VPWR VGND sg13cmos5l_a221oi_1
X_5656_ _5662_/B _7245_/Q _5656_/B VPWR VGND sg13cmos5l_xnor2_1
X_4607_ _4608_/B _7587_/Q _4611_/B _4586_/Y VPWR VGND sg13cmos5l_a21oi_1
X_5587_ _5615_/C _7232_/Q _5620_/B _5608_/A VPWR VGND sg13cmos5l_o21ai_1
X_7326_ _7326_/Q clkload9/A _7326_/D _7326_/RESET_B VPWR VGND sg13cmos5l_dfrbpq_1
X_4538_ _4543_/B _4532_/B _4536_/Y _4537_/Y _4540_/C VPWR VGND sg13cmos5l_a22oi_1
X_4469_ _7564_/D _4519_/A _4580_/A VPWR VGND sg13cmos5l_nor2_1
X_7257_ _7257_/Q _7314_/CLK _7257_/D _7257_/RESET_B VPWR VGND sg13cmos5l_dfrbpq_1
X_6208_ _6216_/A _6217_/A _6217_/B _6205_/Y VPWR VGND sg13cmos5l_o21ai_1
X_7188_ _7188_/Q _7611_/CLK _7188_/D _7188_/RESET_B VPWR VGND sg13cmos5l_dfrbpq_1
Xhold1031 _6434_/A _7398_/Q VPWR VGND sg13cmos5l_dlygate4sd3_1
X_6139_ _6139_/Y _6139_/A _6139_/B _6139_/C VPWR VGND sg13cmos5l_nor3_1
Xhold1042 _7335_/D _6192_/X VPWR VGND sg13cmos5l_dlygate4sd3_1
Xhold1020 _4021_/A _7413_/Q VPWR VGND sg13cmos5l_dlygate4sd3_1
Xhold1053 _4106_/B _7494_/Q VPWR VGND sg13cmos5l_dlygate4sd3_1
Xhold1064 _5970_/B _5969_/X VPWR VGND sg13cmos5l_dlygate4sd3_1
Xhold1075 _3935_/A _7274_/Q VPWR VGND sg13cmos5l_dlygate4sd3_1
Xhold1086 _4309_/B _7504_/Q VPWR VGND sg13cmos5l_dlygate4sd3_1
Xhold1097 _4017_/A _7443_/Q VPWR VGND sg13cmos5l_dlygate4sd3_1
XFILLER_42_912 VPWR VGND sg13cmos5l_decap_4
XFILLER_42_956 VPWR VGND sg13cmos5l_decap_8
XFILLER_41_433 VPWR VGND sg13cmos5l_fill_1
XFILLER_13_102 VPWR VGND sg13cmos5l_fill_2
XFILLER_13_124 VPWR VGND sg13cmos5l_decap_4
XFILLER_14_636 VPWR VGND sg13cmos5l_fill_2
XFILLER_26_76 VPWR VGND sg13cmos5l_fill_2
XFILLER_13_135 VPWR VGND sg13cmos5l_fill_2
XFILLER_13_157 VPWR VGND sg13cmos5l_decap_8
XFILLER_14_658 VPWR VGND sg13cmos5l_fill_1
XFILLER_6_824 VPWR VGND sg13cmos5l_fill_2
X_7284__450 _7284_/RESET_B VPWR VGND sg13cmos5l_tiehi
XFILLER_49_566 VPWR VGND sg13cmos5l_decap_8
X_7651__278 _7651_/RESET_B VPWR VGND sg13cmos5l_tiehi
X_5510_ _5511_/B _5777_/A _7183_/Q _7182_/Q _5776_/A VPWR VGND sg13cmos5l_a22oi_1
X_6490_ _6491_/B _6496_/B _6487_/X _6489_/Y VPWR VGND sg13cmos5l_o21ai_1
X_5441_ _5441_/X _5441_/A _5441_/B VPWR VGND sg13cmos5l_or2_1
X_5372_ _5376_/B _5372_/A _5391_/B _5391_/C VPWR VGND sg13cmos5l_nand3_1
X_7406__290 _7406_/RESET_B VPWR VGND sg13cmos5l_tiehi
X_4323_ _4323_/Y _7508_/Q hold1103/X VPWR VGND sg13cmos5l_nor2b_1
X_7111_ _7111_/Y _3860_/A _7112_/A2 _7111_/B1 VPWR VGND sg13cmos5l_o21ai_1
X_7042_ _7042_/Y _7042_/A _7042_/B VPWR VGND sg13cmos5l_nor2_1
Xfanout118 _6554_/A _6711_/A VPWR VGND sg13cmos5l_buf_1
Xfanout129 _5987_/A _7111_/B1 VPWR VGND sg13cmos5l_buf_1
Xfanout107 _7004_/A hold1227/X VPWR VGND sg13cmos5l_buf_1
X_4254_ _4357_/B _6711_/A _4560_/B VPWR VGND sg13cmos5l_nor2_1
XFILLER_41_1026 VPWR VGND sg13cmos5l_fill_2
X_7200__540 _7200_/RESET_B VPWR VGND sg13cmos5l_tiehi
X_4185_ _4186_/B _4190_/A _4190_/B _4171_/Y VPWR VGND sg13cmos5l_a21oi_1
XFILLER_42_219 VPWR VGND sg13cmos5l_decap_8
XFILLER_24_901 VPWR VGND sg13cmos5l_fill_1
X_7413__283 _7413_/RESET_B VPWR VGND sg13cmos5l_tiehi
X_6826_ _7448_/D _3868_/Y _6826_/A2 _6825_/Y VPWR VGND sg13cmos5l_a21oi_1
X_6757_ _6757_/Y _6757_/A _6757_/B _6757_/C VPWR VGND sg13cmos5l_nand3_1
XFILLER_11_617 VPWR VGND sg13cmos5l_decap_8
XFILLER_23_477 VPWR VGND sg13cmos5l_decap_4
X_3969_ _5960_/B _3969_/A VPWR VGND sg13cmos5l_inv_1
XFILLER_10_138 VPWR VGND sg13cmos5l_decap_8
X_5708_ _5712_/A _5708_/A _5708_/B VPWR VGND sg13cmos5l_nand2_1
X_6688_ _6689_/B _7421_/Q _6677_/B _6665_/Y VPWR VGND sg13cmos5l_a21oi_1
X_5639_ _5907_/A _7274_/Q _5672_/A VPWR VGND sg13cmos5l_xnor2_1
XFILLER_12_89 VPWR VGND sg13cmos5l_decap_8
XFILLER_2_348 VPWR VGND sg13cmos5l_decap_4
X_7309_ _7309_/Q clkload7/A _7309_/D _7309_/RESET_B VPWR VGND sg13cmos5l_dfrbpq_1
XFILLER_18_216 VPWR VGND sg13cmos5l_fill_1
XFILLER_19_739 VPWR VGND sg13cmos5l_fill_1
XFILLER_33_208 VPWR VGND sg13cmos5l_fill_2
XFILLER_18_1028 VPWR VGND sg13cmos5l_fill_1
XFILLER_41_263 VPWR VGND sg13cmos5l_decap_4
XFILLER_14_466 VPWR VGND sg13cmos5l_decap_8
XFILLER_14_488 VPWR VGND sg13cmos5l_fill_2
XFILLER_10_694 VPWR VGND sg13cmos5l_fill_1
XFILLER_2_882 VPWR VGND sg13cmos5l_fill_1
X_5990_ _7304_/D _5990_/A _5990_/B VPWR VGND sg13cmos5l_and2_1
X_4941_ _4941_/Y _4941_/A _4941_/B _4941_/C _4941_/D VPWR VGND sg13cmos5l_nor4_1
X_4872_ _4880_/A _4872_/A _4872_/B _4872_/C VPWR VGND sg13cmos5l_nor3_1
X_6611_ _6681_/B _6596_/B _6609_/Y _6610_/Y VPWR VGND sg13cmos5l_o21ai_1
X_7591_ _7591_/Q _7597_/CLK _7591_/D _7591_/RESET_B VPWR VGND sg13cmos5l_dfrbpq_1
XFILLER_9_470 VPWR VGND sg13cmos5l_fill_1
X_6542_ _6542_/Y _6537_/A _6541_/Y _6518_/Y VPWR VGND sg13cmos5l_o21ai_1
X_6473_ _7378_/D _6511_/B _6534_/B VPWR VGND sg13cmos5l_nor2_1
XFILLER_9_492 VPWR VGND sg13cmos5l_fill_2
X_5424_ _5703_/A _5431_/B _5424_/B VPWR VGND sg13cmos5l_nand2b_1
X_5355_ _5367_/A _7196_/Q _5382_/B VPWR VGND sg13cmos5l_xnor2_1
X_4306_ _4306_/Y _4301_/Y _4303_/Y _4305_/Y VPWR VGND sg13cmos5l_o21ai_1
X_5286_ _5286_/Y _7147_/Q _5286_/B VPWR VGND sg13cmos5l_nor2_1
X_4237_ _4266_/A _7529_/Q _4237_/B VPWR VGND sg13cmos5l_xor2_1
X_7025_ _7041_/A _7040_/B _7040_/C _7040_/A VPWR VGND sg13cmos5l_a21oi_1
X_4168_ _4168_/Y _4158_/Y _4166_/Y _4167_/Y VPWR VGND sg13cmos5l_o21ai_1
XFILLER_28_525 VPWR VGND sg13cmos5l_decap_8
X_4099_ _4099_/Y _4095_/B _4118_/B VPWR VGND sg13cmos5l_nand2b_1
X_7274__460 _7274_/RESET_B VPWR VGND sg13cmos5l_tiehi
XFILLER_36_580 VPWR VGND sg13cmos5l_fill_1
X_6809_ _6809_/Y _6809_/A _6809_/B _6809_/C VPWR VGND sg13cmos5l_nand3_1
XFILLER_12_948 VPWR VGND sg13cmos5l_fill_2
X_7281__453 _7281_/RESET_B VPWR VGND sg13cmos5l_tiehi
XFILLER_46_333 VPWR VGND sg13cmos5l_decap_8
XFILLER_46_322 VPWR VGND sg13cmos5l_fill_1
X_7630__660 _7630_/RESET_B VPWR VGND sg13cmos5l_tiehi
XFILLER_14_241 VPWR VGND sg13cmos5l_fill_1
XFILLER_9_68 VPWR VGND sg13cmos5l_decap_4
XFILLER_7_930 VPWR VGND sg13cmos5l_fill_2
XFILLER_7_974 VPWR VGND sg13cmos5l_decap_8
Xhold919 _7643_/D _4903_/Y VPWR VGND sg13cmos5l_dlygate4sd3_1
Xhold908 hold908/X _7123_/Q VPWR VGND sg13cmos5l_dlygate4sd3_1
X_7403__293 _7403_/RESET_B VPWR VGND sg13cmos5l_tiehi
XFILLER_9_1026 VPWR VGND sg13cmos5l_fill_2
X_5140_ _5173_/B _5038_/B _5109_/A _5145_/S VPWR VGND sg13cmos5l_mux2_1
XFILLER_2_690 VPWR VGND sg13cmos5l_decap_4
X_5071_ _5071_/Y _5069_/Y _5070_/Y _5064_/Y VPWR VGND sg13cmos5l_o21ai_1
X_4022_ _4022_/Y _7410_/Q VPWR VGND sg13cmos5l_inv_1
XFILLER_38_867 VPWR VGND sg13cmos5l_fill_1
XFILLER_37_344 VPWR VGND sg13cmos5l_fill_2
X_5973_ _5973_/Y _5958_/A _5975_/S _5990_/B VPWR VGND sg13cmos5l_o21ai_1
X_4924_ _7118_/D _6363_/A _4924_/A2 _4917_/A VPWR VGND sg13cmos5l_a21oi_1
XFILLER_33_550 VPWR VGND sg13cmos5l_fill_1
X_7410__286 _7410_/RESET_B VPWR VGND sg13cmos5l_tiehi
X_7643_ _7643_/Q clkload6/A _7643_/D _7643_/RESET_B VPWR VGND sg13cmos5l_dfrbpq_1
X_4855_ _7631_/D _4855_/A _4855_/B VPWR VGND sg13cmos5l_nor2_1
X_7574_ _7574_/Q _7635_/CLK _7574_/D _7574_/RESET_B VPWR VGND sg13cmos5l_dfrbpq_1
X_4786_ _7627_/D _4786_/A _4788_/B VPWR VGND sg13cmos5l_nor2_1
XFILLER_20_299 VPWR VGND sg13cmos5l_fill_2
X_6525_ _6531_/B _7387_/Q _6525_/B _6536_/A VPWR VGND sg13cmos5l_nand3_1
X_6456_ _6456_/Y _7351_/Q _7350_/Q _7352_/Q VPWR VGND sg13cmos5l_o21ai_1
X_5407_ _7199_/D _5407_/A _5407_/B _5407_/C VPWR VGND sg13cmos5l_nor3_1
X_6387_ _6387_/Y _7121_/Q _6653_/A2 _6391_/B1 VPWR VGND sg13cmos5l_o21ai_1
X_5338_ _5338_/Y _5336_/A _5336_/B _5372_/A _5340_/A VPWR VGND sg13cmos5l_a22oi_1
X_7008_ _7008_/Y _7008_/A _7034_/A VPWR VGND sg13cmos5l_nor2_1
X_5269_ _7174_/D _5332_/B _5336_/B VPWR VGND sg13cmos5l_and2_1
XFILLER_18_11 VPWR VGND sg13cmos5l_fill_2
XFILLER_18_22 VPWR VGND sg13cmos5l_fill_1
XFILLER_43_347 VPWR VGND sg13cmos5l_fill_2
XFILLER_31_509 VPWR VGND sg13cmos5l_fill_1
XFILLER_11_200 VPWR VGND sg13cmos5l_fill_2
XFILLER_7_248 VPWR VGND sg13cmos5l_fill_1
XFILLER_7_215 VPWR VGND sg13cmos5l_decap_4
XFILLER_7_259 VPWR VGND sg13cmos5l_decap_8
XFILLER_1_0 VPWR VGND sg13cmos5l_fill_2
XFILLER_38_108 VPWR VGND sg13cmos5l_fill_1
XFILLER_43_881 VPWR VGND sg13cmos5l_fill_2
XFILLER_43_870 VPWR VGND sg13cmos5l_decap_8
XFILLER_15_594 VPWR VGND sg13cmos5l_fill_2
X_4640_ _4640_/Y _4628_/B _4631_/Y _4640_/B1 VPWR VGND sg13cmos5l_o21ai_1
X_6310_ _6310_/Y _6310_/A VPWR VGND sg13cmos5l_inv_1
X_4571_ _7588_/D _4571_/A _4575_/B VPWR VGND sg13cmos5l_and2_1
X_7290_ _7290_/Q clkload9/A _7290_/D _7290_/RESET_B VPWR VGND sg13cmos5l_dfrbpq_1
X_7264__470 _7264_/RESET_B VPWR VGND sg13cmos5l_tiehi
X_6241_ _6242_/A _7287_/Q _6249_/A VPWR VGND sg13cmos5l_xor2_1
X_6172_ _6174_/B _6172_/A _6181_/B VPWR VGND sg13cmos5l_nor2b_1
X_5123_ _5123_/Y _5123_/A _5146_/B VPWR VGND sg13cmos5l_nand2_1
XFILLER_34_0 VPWR VGND sg13cmos5l_fill_1
X_5054_ _5054_/X _7611_/Q _5054_/B VPWR VGND sg13cmos5l_and2_1
X_4005_ _4739_/A _7579_/Q VPWR VGND sg13cmos5l_inv_1
X_7271__463 _7271_/RESET_B VPWR VGND sg13cmos5l_tiehi
X_5956_ _5956_/Y _6195_/A _7311_/Q VPWR VGND sg13cmos5l_nand2_1
XFILLER_25_369 VPWR VGND sg13cmos5l_fill_1
XFILLER_40_339 VPWR VGND sg13cmos5l_decap_8
X_5887_ _5887_/Y _5887_/A _5887_/B VPWR VGND sg13cmos5l_nand2_1
X_4907_ _4911_/A _6411_/A _6396_/A VPWR VGND sg13cmos5l_nand2b_1
X_4838_ _4839_/A _4728_/B _4693_/B _4838_/S VPWR VGND sg13cmos5l_mux2_1
X_7626_ _7626_/Q _7630_/CLK _7626_/D _7626_/RESET_B VPWR VGND sg13cmos5l_dfrbpq_1
X_7557_ _7557_/Q _7560_/CLK _7557_/D _7557_/RESET_B VPWR VGND sg13cmos5l_dfrbpq_1
X_4769_ _4769_/Y _4755_/X _4767_/S _4784_/B VPWR VGND sg13cmos5l_o21ai_1
X_6508_ _7391_/D _6508_/A _6511_/B VPWR VGND sg13cmos5l_nor2_1
X_7488_ _7488_/Q _7490_/CLK _7488_/D _7488_/RESET_B VPWR VGND sg13cmos5l_dfrbpq_1
X_6439_ _6439_/Y _7395_/Q _7372_/Q VPWR VGND sg13cmos5l_nand2_1
XFILLER_0_413 VPWR VGND sg13cmos5l_fill_2
XFILLER_49_907 VPWR VGND sg13cmos5l_decap_4
XFILLER_1_947 VPWR VGND sg13cmos5l_decap_8
XFILLER_49_918 VPWR VGND sg13cmos5l_decap_8
XFILLER_29_675 VPWR VGND sg13cmos5l_fill_1
XFILLER_45_64 VPWR VGND sg13cmos5l_decap_4
XFILLER_44_645 VPWR VGND sg13cmos5l_decap_8
XFILLER_48_940 VPWR VGND sg13cmos5l_decap_8
X_7400__296 _7400_/RESET_B VPWR VGND sg13cmos5l_tiehi
XFILLER_0_991 VPWR VGND sg13cmos5l_decap_8
XFILLER_47_483 VPWR VGND sg13cmos5l_fill_1
X_5810_ _5810_/Y _5810_/A _5827_/S VPWR VGND sg13cmos5l_nor2_1
XFILLER_23_807 VPWR VGND sg13cmos5l_decap_4
XFILLER_23_818 VPWR VGND sg13cmos5l_decap_8
X_6790_ _6802_/C _7461_/Q _6789_/A _6801_/B VPWR VGND sg13cmos5l_o21ai_1
X_5741_ _5741_/Y _7221_/Q _5741_/B _5741_/C VPWR VGND sg13cmos5l_nor3_1
X_5672_ _5672_/Y _5672_/A _5918_/B VPWR VGND sg13cmos5l_nor2_1
X_7411_ _7411_/Q _7490_/CLK _7411_/D _7411_/RESET_B VPWR VGND sg13cmos5l_dfrbpq_1
X_4623_ _4628_/A _4623_/A _4623_/B VPWR VGND sg13cmos5l_and2_1
X_7342_ _7342_/Q _7344_/CLK _7342_/D _7342_/RESET_B VPWR VGND sg13cmos5l_dfrbpq_1
X_4554_ _4554_/X _4543_/B _4749_/B _4554_/S VPWR VGND sg13cmos5l_mux2_1
X_7273_ _7273_/Q _7332_/CLK _7273_/D _7273_/RESET_B VPWR VGND sg13cmos5l_dfrbpq_1
X_4485_ _4503_/A _7532_/Q _7533_/Q VPWR VGND sg13cmos5l_xnor2_1
X_6224_ _6224_/Y _6224_/A _6224_/B VPWR VGND sg13cmos5l_nand2_1
X_6155_ _6155_/Y _6155_/A _7345_/Q VPWR VGND sg13cmos5l_nor2_1
X_6086_ _6086_/Y _6160_/A _6086_/B VPWR VGND sg13cmos5l_xnor2_1
X_5106_ _5106_/Y _5117_/A _5106_/B VPWR VGND sg13cmos5l_nand2b_1
Xhold1224 _5632_/A1 _5618_/A VPWR VGND sg13cmos5l_dlygate4sd3_1
Xhold1213 _6224_/A _7338_/Q VPWR VGND sg13cmos5l_dlygate4sd3_1
Xhold1202 _6020_/A _7308_/Q VPWR VGND sg13cmos5l_dlygate4sd3_1
Xhold1235 _3966_/A _7499_/Q VPWR VGND sg13cmos5l_dlygate4sd3_1
X_5037_ _5109_/B _5035_/A _5035_/B _5033_/Y VPWR VGND sg13cmos5l_o21ai_1
Xhold1257 _4826_/B _4825_/Y VPWR VGND sg13cmos5l_dlygate4sd3_1
Xhold1246 _6848_/A _7456_/Q VPWR VGND sg13cmos5l_dlygate4sd3_1
Xhold1279 _6918_/A2 _6911_/B VPWR VGND sg13cmos5l_dlygate4sd3_1
XFILLER_39_984 VPWR VGND sg13cmos5l_fill_2
Xhold1268 _4663_/A _7603_/Q VPWR VGND sg13cmos5l_dlygate4sd3_1
XFILLER_26_623 VPWR VGND sg13cmos5l_fill_2
X_6988_ _6988_/Y _6973_/Y _6982_/Y _6987_/Y VPWR VGND sg13cmos5l_a21oi_1
X_5939_ _5939_/Y _7311_/Q _7255_/Q VPWR VGND sg13cmos5l_nand2b_1
XFILLER_15_67 VPWR VGND sg13cmos5l_fill_1
XFILLER_15_78 VPWR VGND sg13cmos5l_fill_2
X_7609_ _7609_/Q _7634_/CLK _7609_/D _7609_/RESET_B VPWR VGND sg13cmos5l_dfrbpq_1
XFILLER_31_66 VPWR VGND sg13cmos5l_fill_1
Xoutput11 uio_out[1] _8273_/X VPWR VGND sg13cmos5l_buf_1
X_7497__353 _7497_/RESET_B VPWR VGND sg13cmos5l_tiehi
XFILLER_49_704 VPWR VGND sg13cmos5l_fill_1
XFILLER_0_232 VPWR VGND sg13cmos5l_fill_1
XFILLER_45_943 VPWR VGND sg13cmos5l_fill_1
XFILLER_45_976 VPWR VGND sg13cmos5l_decap_8
XFILLER_8_354 VPWR VGND sg13cmos5l_fill_2
X_4270_ _4272_/B _4247_/B _4258_/B _4518_/A VPWR VGND sg13cmos5l_a21oi_1
XFILLER_28_1019 VPWR VGND sg13cmos5l_decap_8
XFILLER_39_269 VPWR VGND sg13cmos5l_decap_4
X_6911_ _6916_/S _6909_/Y _6911_/B VPWR VGND sg13cmos5l_nand2b_1
XFILLER_35_431 VPWR VGND sg13cmos5l_decap_4
X_6842_ _6870_/B _6840_/Y _6841_/Y _6835_/Y VPWR VGND sg13cmos5l_a21o_1
XFILLER_36_998 VPWR VGND sg13cmos5l_fill_1
X_6773_ _6773_/Y _6773_/A _6773_/B VPWR VGND sg13cmos5l_nor2_1
X_3985_ _5728_/B _7221_/Q VPWR VGND sg13cmos5l_inv_1
X_5724_ _5724_/Y _5672_/A _5731_/B _5734_/B _7272_/Q VPWR VGND sg13cmos5l_a22oi_1
X_5655_ _5661_/B _7245_/Q _5656_/B VPWR VGND sg13cmos5l_nor2b_1
X_4606_ _4615_/A _4606_/A _4606_/B VPWR VGND sg13cmos5l_and2_1
XFILLER_11_1001 VPWR VGND sg13cmos5l_fill_1
X_7325_ _7325_/Q clkload9/A _7325_/D _7325_/RESET_B VPWR VGND sg13cmos5l_dfrbpq_1
X_5586_ _5608_/A _7231_/Q _5602_/B _5593_/A VPWR VGND sg13cmos5l_a21o_1
X_4537_ _4537_/Y _7598_/Q _4785_/A VPWR VGND sg13cmos5l_nor2_1
X_4468_ _4580_/A _4433_/A _4457_/S _4467_/Y VPWR VGND sg13cmos5l_o21ai_1
X_7256_ _7256_/Q _7314_/CLK _7256_/D _7256_/RESET_B VPWR VGND sg13cmos5l_dfrbpq_1
X_6207_ _6217_/B _6207_/A _6224_/B VPWR VGND sg13cmos5l_xnor2_1
X_7187_ _7187_/Q _7611_/CLK _7187_/D _7187_/RESET_B VPWR VGND sg13cmos5l_dfrbpq_1
X_4399_ _4405_/A _4403_/A _4399_/B VPWR VGND sg13cmos5l_nor2_1
X_6138_ _6139_/C _7294_/Q _6160_/A _6137_/Y VPWR VGND sg13cmos5l_o21ai_1
Xhold1032 _6384_/B _7356_/Q VPWR VGND sg13cmos5l_dlygate4sd3_1
Xhold1010 _4921_/B _7118_/Q VPWR VGND sg13cmos5l_dlygate4sd3_1
Xhold1021 _6804_/A _6803_/Y VPWR VGND sg13cmos5l_dlygate4sd3_1
XFILLER_46_729 VPWR VGND sg13cmos5l_fill_1
Xhold1065 _4288_/B _7500_/Q VPWR VGND sg13cmos5l_dlygate4sd3_1
Xhold1054 _7067_/A1 _4117_/A VPWR VGND sg13cmos5l_dlygate4sd3_1
X_6069_ _6083_/A _6086_/B _6068_/Y VPWR VGND sg13cmos5l_nor2b_1
Xhold1076 _3994_/A _7179_/Q VPWR VGND sg13cmos5l_dlygate4sd3_1
Xhold1043 _3941_/A _7237_/Q VPWR VGND sg13cmos5l_dlygate4sd3_1
Xhold1098 _3947_/A _7166_/Q VPWR VGND sg13cmos5l_dlygate4sd3_1
XFILLER_26_11 VPWR VGND sg13cmos5l_fill_2
Xhold1087 _7098_/A1 _4309_/Y VPWR VGND sg13cmos5l_dlygate4sd3_1
X_7470__592 _7470_/RESET_B VPWR VGND sg13cmos5l_tiehi
XFILLER_42_946 VPWR VGND sg13cmos5l_fill_2
XFILLER_41_478 VPWR VGND sg13cmos5l_decap_8
XFILLER_22_681 VPWR VGND sg13cmos5l_fill_2
XFILLER_1_574 VPWR VGND sg13cmos5l_fill_1
XFILLER_36_228 VPWR VGND sg13cmos5l_fill_1
XFILLER_44_261 VPWR VGND sg13cmos5l_fill_2
XFILLER_32_423 VPWR VGND sg13cmos5l_fill_2
XFILLER_33_957 VPWR VGND sg13cmos5l_decap_8
X_5440_ _5441_/B _5450_/B _5452_/B _5439_/Y VPWR VGND sg13cmos5l_o21ai_1
XFILLER_9_663 VPWR VGND sg13cmos5l_fill_1
X_5371_ _5371_/Y _5376_/A VPWR VGND sg13cmos5l_inv_1
X_4322_ _4322_/Y _4575_/A _4573_/A VPWR VGND sg13cmos5l_nor2_1
X_7110_ _7110_/Y _3863_/Y _7112_/A2 _7109_/Y VPWR VGND sg13cmos5l_a21oi_1
X_4253_ _4256_/A _4224_/Y _4252_/Y _4263_/S VPWR VGND sg13cmos5l_mux2_1
Xfanout108 _6160_/B _7345_/Q VPWR VGND sg13cmos5l_buf_1
Xfanout119 _6711_/A _6893_/A VPWR VGND sg13cmos5l_buf_1
X_7041_ _7041_/Y _7041_/A _7041_/B _7041_/C VPWR VGND sg13cmos5l_nor3_1
X_4184_ _4194_/B _4184_/A _4184_/B VPWR VGND sg13cmos5l_nor2_1
XFILLER_36_773 VPWR VGND sg13cmos5l_fill_2
XFILLER_35_250 VPWR VGND sg13cmos5l_fill_1
XFILLER_24_979 VPWR VGND sg13cmos5l_decap_8
X_6825_ _6825_/Y hold881/X _6826_/A2 _6660_/A VPWR VGND sg13cmos5l_o21ai_1
X_6756_ _6756_/X _6757_/A _6757_/B _6757_/C VPWR VGND sg13cmos5l_and3_1
X_3968_ _5955_/A _7258_/Q VPWR VGND sg13cmos5l_inv_1
XFILLER_10_106 VPWR VGND sg13cmos5l_decap_8
XFILLER_11_607 VPWR VGND sg13cmos5l_fill_1
X_5707_ _5708_/B _5707_/A _5707_/B VPWR VGND sg13cmos5l_nand2_1
XFILLER_32_990 VPWR VGND sg13cmos5l_decap_4
X_3899_ _3899_/Y _6440_/B VPWR VGND sg13cmos5l_inv_1
X_6687_ _6687_/Y _6697_/B _6677_/Y _6686_/X VPWR VGND sg13cmos5l_o21ai_1
X_5638_ _5638_/X _7272_/Q _5684_/A VPWR VGND sg13cmos5l_and2_1
X_5569_ _5569_/Y _5463_/B _5503_/Y _5614_/B _5467_/B VPWR VGND sg13cmos5l_a22oi_1
X_7308_ _7308_/Q clkload7/A _7308_/D _7308_/RESET_B VPWR VGND sg13cmos5l_dfrbpq_1
X_7239_ _7239_/Q _7239_/CLK _7239_/D _7239_/RESET_B VPWR VGND sg13cmos5l_dfrbpq_1
XFILLER_42_765 VPWR VGND sg13cmos5l_fill_2
X_7646__348 _7646_/RESET_B VPWR VGND sg13cmos5l_tiehi
XFILLER_23_990 VPWR VGND sg13cmos5l_fill_1
XFILLER_6_611 VPWR VGND sg13cmos5l_decap_4
XFILLER_6_622 VPWR VGND sg13cmos5l_fill_2
X_7471__153 _7471_/D VPWR VGND sg13cmos5l_tielo
XFILLER_37_548 VPWR VGND sg13cmos5l_fill_1
XFILLER_45_581 VPWR VGND sg13cmos5l_decap_8
X_4940_ _4941_/D _4938_/A _4938_/B hold908/X VPWR VGND sg13cmos5l_o21ai_1
X_4871_ _4875_/B _4871_/A _4871_/B _4871_/C _4872_/C VPWR VGND sg13cmos5l_nor4_1
X_6610_ _6610_/Y _6661_/A _6610_/B _6610_/C VPWR VGND sg13cmos5l_nand3_1
X_7590_ _7590_/Q _7597_/CLK _7590_/D _7590_/RESET_B VPWR VGND sg13cmos5l_dfrbpq_1
XFILLER_32_242 VPWR VGND sg13cmos5l_fill_1
X_6541_ _6541_/Y _6541_/A _6541_/B VPWR VGND sg13cmos5l_xnor2_1
X_6472_ _6512_/B _6534_/B VPWR VGND sg13cmos5l_inv_1
XFILLER_9_482 VPWR VGND sg13cmos5l_fill_1
X_5423_ _5424_/B _5450_/A _7237_/Q _7238_/Q VPWR VGND sg13cmos5l_o21ai_1
X_5354_ _5354_/Y _5364_/A _5382_/B VPWR VGND sg13cmos5l_nand2_1
X_4305_ _4305_/Y _7507_/Q _4573_/A _4304_/Y _4575_/A VPWR VGND sg13cmos5l_a22oi_1
X_5285_ _5285_/Y _5279_/Y _5283_/Y _5284_/Y VPWR VGND sg13cmos5l_o21ai_1
X_4236_ _4243_/B _7529_/Q _7528_/Q _7526_/Q _7527_/Q VPWR VGND sg13cmos5l_nor4_1
X_7456__649 _7456_/RESET_B VPWR VGND sg13cmos5l_tiehi
X_7024_ _7040_/C _7024_/A _7451_/Q _7032_/A VPWR VGND sg13cmos5l_nand3_1
X_4167_ _4167_/Y _4120_/X _7074_/B _7073_/B _7069_/B VPWR VGND sg13cmos5l_a22oi_1
X_4098_ _4118_/B _7523_/Q _7083_/B _7524_/Q VPWR VGND sg13cmos5l_o21ai_1
XFILLER_24_787 VPWR VGND sg13cmos5l_fill_2
X_6808_ _6809_/C _6793_/A _6794_/Y _6807_/Y VPWR VGND sg13cmos5l_a21oi_1
X_6739_ _7431_/D _6891_/A _6836_/A VPWR VGND sg13cmos5l_and2_1
XFILLER_3_603 VPWR VGND sg13cmos5l_decap_8
X_7578__718 _7578_/RESET_B VPWR VGND sg13cmos5l_tiehi
XFILLER_3_636 VPWR VGND sg13cmos5l_decap_4
XFILLER_3_625 VPWR VGND sg13cmos5l_fill_2
XFILLER_47_824 VPWR VGND sg13cmos5l_fill_2
X_7138__608 _7138_/RESET_B VPWR VGND sg13cmos5l_tiehi
XFILLER_0_27 VPWR VGND sg13cmos5l_fill_1
XFILLER_46_378 VPWR VGND sg13cmos5l_decap_4
XFILLER_15_743 VPWR VGND sg13cmos5l_decap_8
XFILLER_14_253 VPWR VGND sg13cmos5l_fill_1
XFILLER_42_584 VPWR VGND sg13cmos5l_decap_8
XFILLER_14_297 VPWR VGND sg13cmos5l_decap_8
XFILLER_30_724 VPWR VGND sg13cmos5l_fill_2
Xfanout90 _4519_/A _4516_/A VPWR VGND sg13cmos5l_buf_1
Xhold909 _4871_/B _7636_/Q VPWR VGND sg13cmos5l_dlygate4sd3_1
X_7503__149 _7503_/D VPWR VGND sg13cmos5l_tielo
X_5070_ _5070_/Y _7143_/Q _5060_/Y _5068_/X VPWR VGND sg13cmos5l_o21ai_1
XFILLER_38_802 VPWR VGND sg13cmos5l_fill_2
X_4021_ _6789_/A _4021_/A VPWR VGND sg13cmos5l_inv_1
XFILLER_37_323 VPWR VGND sg13cmos5l_fill_2
XFILLER_49_194 VPWR VGND sg13cmos5l_decap_8
X_5972_ _7291_/D _5976_/A _5972_/B VPWR VGND sg13cmos5l_nor2_1
X_4923_ _7117_/D _4919_/Y _4922_/Y _4917_/A VPWR VGND sg13cmos5l_a21oi_1
X_7642_ _7642_/Q clkload6/A _7642_/D _7642_/RESET_B VPWR VGND sg13cmos5l_dfrbpq_1
XFILLER_20_212 VPWR VGND sg13cmos5l_fill_1
X_4854_ _4855_/B _4828_/Y _4850_/Y _4784_/B VPWR VGND sg13cmos5l_o21ai_1
X_4785_ _7626_/D _4785_/A _4788_/B VPWR VGND sg13cmos5l_nor2_1
X_7573_ _7573_/Q _7630_/CLK _7573_/D _7573_/RESET_B VPWR VGND sg13cmos5l_dfrbpq_1
X_6524_ _6531_/A _6541_/A _6541_/B VPWR VGND sg13cmos5l_nand2_1
X_7408__161 _7408_/D VPWR VGND sg13cmos5l_tielo
X_6455_ _6463_/B _7351_/Q _7350_/Q _7352_/Q VPWR VGND sg13cmos5l_nor3_1
X_5406_ _5407_/C _5406_/A _5406_/B _5406_/C VPWR VGND sg13cmos5l_and3_1
X_6386_ _7358_/D _6505_/A _6386_/B VPWR VGND sg13cmos5l_and2_1
X_5337_ _5337_/Y _5348_/A _5337_/B VPWR VGND sg13cmos5l_nand2b_1
X_5268_ _5336_/B _5261_/Y _5267_/Y _5266_/Y VPWR VGND sg13cmos5l_o21ai_1
X_4219_ _4235_/B _7558_/Q _4571_/A VPWR VGND sg13cmos5l_nor2_1
X_7007_ _7488_/D _7007_/A _7007_/B VPWR VGND sg13cmos5l_nor2_1
X_5199_ _5201_/B _5485_/A _5232_/A VPWR VGND sg13cmos5l_nor2_1
XFILLER_43_315 VPWR VGND sg13cmos5l_decap_4
XFILLER_28_378 VPWR VGND sg13cmos5l_decap_8
XFILLER_43_337 VPWR VGND sg13cmos5l_fill_1
XFILLER_34_44 VPWR VGND sg13cmos5l_fill_1
XFILLER_3_444 VPWR VGND sg13cmos5l_fill_1
XFILLER_3_433 VPWR VGND sg13cmos5l_decap_8
XFILLER_4_989 VPWR VGND sg13cmos5l_decap_8
X_7537__223 _7537_/RESET_B VPWR VGND sg13cmos5l_tiehi
XFILLER_19_312 VPWR VGND sg13cmos5l_decap_8
XFILLER_46_175 VPWR VGND sg13cmos5l_fill_2
XFILLER_15_584 VPWR VGND sg13cmos5l_fill_1
X_7544__216 _7544_/RESET_B VPWR VGND sg13cmos5l_tiehi
X_4570_ _7587_/D _4570_/A _4575_/B VPWR VGND sg13cmos5l_and2_1
XFILLER_7_761 VPWR VGND sg13cmos5l_decap_8
X_6240_ _6240_/Y _6240_/A _6240_/B _6240_/C VPWR VGND sg13cmos5l_nand3_1
X_6171_ _6171_/Y _3880_/Y _6167_/Y _6170_/Y VPWR VGND sg13cmos5l_a21oi_1
X_5122_ _5122_/Y _5120_/Y _5121_/Y _5119_/Y VPWR VGND sg13cmos5l_a21oi_1
XFILLER_27_0 VPWR VGND sg13cmos5l_decap_4
X_5053_ _5054_/B _5049_/Y _5051_/Y _5052_/Y VPWR VGND sg13cmos5l_o21ai_1
X_4004_ _5046_/B _4004_/A VPWR VGND sg13cmos5l_inv_1
X_7568__728 _7568_/RESET_B VPWR VGND sg13cmos5l_tiehi
X_5955_ _5955_/Y _5955_/A _7255_/Q _5955_/C VPWR VGND sg13cmos5l_nand3_1
X_5886_ _7279_/D _5993_/B _5886_/B VPWR VGND sg13cmos5l_nor2_1
X_4906_ _4906_/Y _7115_/Q _4908_/A VPWR VGND sg13cmos5l_nand2b_1
XFILLER_21_554 VPWR VGND sg13cmos5l_fill_1
X_4837_ _4842_/A _4845_/B _4837_/B VPWR VGND sg13cmos5l_nand2b_1
X_7625_ _7625_/Q _7630_/CLK _7625_/D _7625_/RESET_B VPWR VGND sg13cmos5l_dfrbpq_1
X_7556_ _7556_/Q _7560_/CLK _7556_/D _7556_/RESET_B VPWR VGND sg13cmos5l_dfrbpq_1
X_4768_ _7613_/D _4768_/A _4768_/B VPWR VGND sg13cmos5l_nor2_1
X_7487_ _7487_/Q _7490_/CLK _7487_/D _7487_/RESET_B VPWR VGND sg13cmos5l_dfrbpq_1
XFILLER_20_24 VPWR VGND sg13cmos5l_decap_4
X_6507_ _7390_/D _6507_/A _6525_/B VPWR VGND sg13cmos5l_and2_1
X_4699_ _4709_/B _7570_/Q _7568_/Q _7569_/Q VPWR VGND sg13cmos5l_nor3_1
X_7128__618 _7128_/RESET_B VPWR VGND sg13cmos5l_tiehi
X_6438_ _6438_/Y _6438_/A _6437_/Y VPWR VGND sg13cmos5l_nor2b_1
X_7620__671 _7620_/RESET_B VPWR VGND sg13cmos5l_tiehi
XFILLER_1_926 VPWR VGND sg13cmos5l_decap_8
X_6369_ _6372_/C _6369_/A _6369_/B VPWR VGND sg13cmos5l_nor2_1
XFILLER_21_1025 VPWR VGND sg13cmos5l_decap_4
XFILLER_43_112 VPWR VGND sg13cmos5l_decap_4
XFILLER_40_896 VPWR VGND sg13cmos5l_fill_2
XFILLER_40_874 VPWR VGND sg13cmos5l_decap_8
XFILLER_3_274 VPWR VGND sg13cmos5l_fill_2
XFILLER_6_1019 VPWR VGND sg13cmos5l_decap_8
XFILLER_0_970 VPWR VGND sg13cmos5l_decap_8
XFILLER_48_996 VPWR VGND sg13cmos5l_decap_8
X_5740_ _5740_/Y _7255_/Q _5744_/B VPWR VGND sg13cmos5l_nand2_1
XFILLER_31_830 VPWR VGND sg13cmos5l_fill_2
X_7410_ _7410_/Q _7490_/CLK _7410_/D _7410_/RESET_B VPWR VGND sg13cmos5l_dfrbpq_1
X_5671_ _7241_/D _5671_/A _5774_/B VPWR VGND sg13cmos5l_and2_1
X_4622_ _4622_/Y _4622_/A _4622_/B VPWR VGND sg13cmos5l_nor2_1
X_7341_ _7341_/Q _7344_/CLK _7341_/D _7341_/RESET_B VPWR VGND sg13cmos5l_dfrbpq_1
X_4553_ _7575_/D _4573_/B _4553_/B VPWR VGND sg13cmos5l_nor2_1
X_4484_ _4484_/Y _7556_/Q _7532_/Q VPWR VGND sg13cmos5l_nor2_1
X_7272_ _7272_/Q _7272_/CLK _7272_/D _7272_/RESET_B VPWR VGND sg13cmos5l_dfrbpq_1
X_6223_ _6223_/X _7337_/Q _6224_/B _6230_/C VPWR VGND sg13cmos5l_a21o_1
X_6154_ _6154_/Y _7324_/Q _6144_/Y _6153_/Y VPWR VGND sg13cmos5l_o21ai_1
X_6085_ _6097_/B _7343_/Q _6086_/B VPWR VGND sg13cmos5l_xnor2_1
X_5105_ _5105_/Y _5105_/A _5105_/B VPWR VGND sg13cmos5l_nor2_1
Xhold1214 _4681_/A _7631_/Q VPWR VGND sg13cmos5l_dlygate4sd3_1
Xhold1203 _6034_/A _7303_/Q VPWR VGND sg13cmos5l_dlygate4sd3_1
Xhold1225 _4039_/A _7648_/Q VPWR VGND sg13cmos5l_dlygate4sd3_1
X_5036_ _5038_/B _4685_/X _5020_/Y _5035_/Y VPWR VGND sg13cmos5l_a21oi_1
Xhold1236 _5582_/A _7231_/Q VPWR VGND sg13cmos5l_dlygate4sd3_1
Xhold1258 _4853_/A _4829_/A VPWR VGND sg13cmos5l_dlygate4sd3_1
Xhold1247 _6892_/A2 _6881_/B VPWR VGND sg13cmos5l_dlygate4sd3_1
XFILLER_39_974 VPWR VGND sg13cmos5l_fill_1
Xhold1269 _4697_/B _4696_/A VPWR VGND sg13cmos5l_dlygate4sd3_1
XFILLER_25_101 VPWR VGND sg13cmos5l_fill_2
X_6987_ _6987_/Y _6982_/Y _6987_/A2 _6893_/Y VPWR VGND sg13cmos5l_o21ai_1
X_5938_ _5938_/Y _7311_/Q _3970_/Y _5945_/B _7310_/Q VPWR VGND sg13cmos5l_a22oi_1
XFILLER_40_148 VPWR VGND sg13cmos5l_fill_1
XFILLER_22_863 VPWR VGND sg13cmos5l_fill_1
XFILLER_34_690 VPWR VGND sg13cmos5l_decap_4
X_7527__233 _7527_/RESET_B VPWR VGND sg13cmos5l_tiehi
X_5869_ _6240_/A _6194_/A _5893_/C VPWR VGND sg13cmos5l_xnor2_1
XFILLER_22_885 VPWR VGND sg13cmos5l_fill_1
X_7608_ _7608_/Q _7634_/CLK _7608_/D _7608_/RESET_B VPWR VGND sg13cmos5l_dfrbpq_1
X_7539_ _7539_/Q _7630_/CLK _7539_/D _7539_/RESET_B VPWR VGND sg13cmos5l_dfrbpq_1
XFILLER_31_78 VPWR VGND sg13cmos5l_fill_2
Xoutput12 uio_out[2] _8274_/X VPWR VGND sg13cmos5l_buf_1
XFILLER_0_277 VPWR VGND sg13cmos5l_fill_2
X_7534__226 _7534_/RESET_B VPWR VGND sg13cmos5l_tiehi
XFILLER_45_955 VPWR VGND sg13cmos5l_decap_8
XFILLER_44_432 VPWR VGND sg13cmos5l_fill_2
XFILLER_16_123 VPWR VGND sg13cmos5l_decap_8
XFILLER_16_134 VPWR VGND sg13cmos5l_fill_2
X_7172__192 _7172_/D VPWR VGND sg13cmos5l_tielo
XFILLER_12_340 VPWR VGND sg13cmos5l_decap_8
XFILLER_12_362 VPWR VGND sg13cmos5l_decap_8
XFILLER_13_885 VPWR VGND sg13cmos5l_decap_8
XFILLER_12_373 VPWR VGND sg13cmos5l_fill_2
X_7541__219 _7541_/RESET_B VPWR VGND sg13cmos5l_tiehi
X_7558__738 _7558_/RESET_B VPWR VGND sg13cmos5l_tiehi
XFILLER_39_204 VPWR VGND sg13cmos5l_decap_8
XFILLER_39_259 VPWR VGND sg13cmos5l_decap_4
X_6910_ _6911_/B _6910_/A _6910_/B VPWR VGND sg13cmos5l_xnor2_1
X_6841_ _6841_/Y _6870_/A _6838_/B _6873_/B _6835_/A VPWR VGND sg13cmos5l_a22oi_1
XFILLER_36_988 VPWR VGND sg13cmos5l_fill_1
X_6772_ _6836_/B _6772_/A _6772_/B VPWR VGND sg13cmos5l_nand2_1
X_3984_ _6253_/B _7288_/Q VPWR VGND sg13cmos5l_inv_1
X_5723_ _5723_/Y _5993_/A _7220_/Q VPWR VGND sg13cmos5l_nor2_1
X_5654_ _5915_/A _5993_/A _5654_/B VPWR VGND sg13cmos5l_xnor2_1
X_4605_ _4606_/B _4511_/B _4580_/A _4619_/S VPWR VGND sg13cmos5l_mux2_1
X_7324_ _7324_/Q clkload9/A _7324_/D _7324_/RESET_B VPWR VGND sg13cmos5l_dfrbpq_1
X_5585_ _5593_/A _5603_/C _5592_/C _5592_/A VPWR VGND sg13cmos5l_a21oi_1
X_4536_ _4536_/Y _7543_/Q _4536_/B VPWR VGND sg13cmos5l_nor2_1
X_4467_ _4467_/Y _4451_/Y _4454_/X _4723_/A VPWR VGND sg13cmos5l_o21ai_1
X_7255_ _7255_/Q _7314_/CLK _7255_/D _7255_/RESET_B VPWR VGND sg13cmos5l_dfrbpq_1
X_6206_ _6217_/A _7334_/Q _6196_/X _6215_/B _7333_/Q VPWR VGND sg13cmos5l_a22oi_1
X_7186_ _7186_/Q _7611_/CLK _7186_/D _7186_/RESET_B VPWR VGND sg13cmos5l_dfrbpq_1
X_4398_ _4398_/Y _4398_/A _4398_/B VPWR VGND sg13cmos5l_xnor2_1
X_6137_ _6137_/Y _6160_/B _7344_/Q VPWR VGND sg13cmos5l_nand2b_1
Xhold1000 _4001_/A _7614_/Q VPWR VGND sg13cmos5l_dlygate4sd3_1
Xhold1011 _4924_/A2 _4921_/Y VPWR VGND sg13cmos5l_dlygate4sd3_1
Xhold1033 _6385_/A2 _6487_/A VPWR VGND sg13cmos5l_dlygate4sd3_1
Xhold1022 _7442_/D _6818_/Y VPWR VGND sg13cmos5l_dlygate4sd3_1
Xhold1066 _4289_/B2 _4288_/Y VPWR VGND sg13cmos5l_dlygate4sd3_1
XFILLER_39_771 VPWR VGND sg13cmos5l_fill_1
Xhold1044 hold1044/X _7117_/Q VPWR VGND sg13cmos5l_dlygate4sd3_1
X_6068_ _6068_/Y _7341_/Q _7340_/Q _7342_/Q VPWR VGND sg13cmos5l_o21ai_1
Xhold1055 _3955_/A _7630_/Q VPWR VGND sg13cmos5l_dlygate4sd3_1
Xhold1099 _4296_/A _7503_/Q VPWR VGND sg13cmos5l_dlygate4sd3_1
XFILLER_39_782 VPWR VGND sg13cmos5l_fill_1
Xhold1077 _5310_/B _5309_/X VPWR VGND sg13cmos5l_dlygate4sd3_1
X_5019_ _5019_/Y _5021_/A _5028_/B _5017_/Y VPWR VGND sg13cmos5l_o21ai_1
XFILLER_26_421 VPWR VGND sg13cmos5l_fill_1
Xhold1088 _7099_/B _7098_/X VPWR VGND sg13cmos5l_dlygate4sd3_1
XFILLER_26_432 VPWR VGND sg13cmos5l_fill_1
XFILLER_41_413 VPWR VGND sg13cmos5l_fill_1
XFILLER_14_627 VPWR VGND sg13cmos5l_fill_1
XFILLER_26_78 VPWR VGND sg13cmos5l_fill_1
XFILLER_9_108 VPWR VGND sg13cmos5l_decap_8
XFILLER_6_826 VPWR VGND sg13cmos5l_fill_1
XFILLER_6_804 VPWR VGND sg13cmos5l_fill_2
XFILLER_5_314 VPWR VGND sg13cmos5l_decap_8
XFILLER_18_944 VPWR VGND sg13cmos5l_decap_8
XFILLER_18_955 VPWR VGND sg13cmos5l_fill_2
XFILLER_18_966 VPWR VGND sg13cmos5l_fill_2
XFILLER_34_1013 VPWR VGND sg13cmos5l_fill_1
XFILLER_9_631 VPWR VGND sg13cmos5l_decap_8
XFILLER_12_170 VPWR VGND sg13cmos5l_fill_2
XFILLER_8_141 VPWR VGND sg13cmos5l_decap_8
X_5370_ _5376_/A _5370_/A _5383_/A _5370_/C VPWR VGND sg13cmos5l_nor3_1
X_4321_ _4321_/Y _7539_/Q _4315_/B _4320_/Y _7540_/Q _4316_/Y VPWR VGND sg13cmos5l_a221oi_1
X_4252_ _4252_/Y hold1310/X _4258_/B VPWR VGND sg13cmos5l_nand2b_1
Xfanout109 _5961_/A hold1302/X VPWR VGND sg13cmos5l_buf_1
X_7040_ _7041_/C _7040_/A _7040_/B _7040_/C VPWR VGND sg13cmos5l_and3_1
XFILLER_41_1028 VPWR VGND sg13cmos5l_fill_1
X_4183_ _4184_/B _4207_/A _4207_/B _4207_/C _4182_/Y VPWR VGND sg13cmos5l_a22oi_1
X_7517__243 _7517_/RESET_B VPWR VGND sg13cmos5l_tiehi
XFILLER_36_763 VPWR VGND sg13cmos5l_fill_1
X_6824_ _7447_/D _3869_/Y _6824_/A2 _6823_/Y VPWR VGND sg13cmos5l_a21oi_1
X_6755_ _6757_/C _7425_/Q _7404_/Q _6773_/A VPWR VGND sg13cmos5l_o21ai_1
X_3967_ _5251_/A _7140_/Q VPWR VGND sg13cmos5l_inv_1
X_5706_ _5707_/B _5702_/A _5702_/B _5709_/B VPWR VGND sg13cmos5l_a21oi_1
X_6686_ _6686_/X _6583_/B _6681_/B _6691_/B VPWR VGND sg13cmos5l_mux2_1
X_7524__236 _7524_/RESET_B VPWR VGND sg13cmos5l_tiehi
X_3898_ _6663_/A _6451_/A VPWR VGND sg13cmos5l_inv_1
Xclkbuf_leaf_30_clk _7307_/CLK clkload0/A VPWR VGND sg13cmos5l_buf_8
X_5637_ _5918_/B _5994_/A _5637_/B VPWR VGND sg13cmos5l_xnor2_1
X_5568_ _5568_/Y _5463_/B _5503_/Y _5567_/Y VPWR VGND sg13cmos5l_o21ai_1
X_4519_ _7572_/D _4519_/A _4623_/B VPWR VGND sg13cmos5l_nor2_1
X_7307_ _7307_/Q _7307_/CLK _7307_/D _7307_/RESET_B VPWR VGND sg13cmos5l_dfrbpq_1
X_5499_ _5499_/Y _5567_/B VPWR VGND sg13cmos5l_inv_1
X_7238_ _7238_/Q _7272_/CLK _7238_/D _7238_/RESET_B VPWR VGND sg13cmos5l_dfrbpq_1
X_7169_ _7169_/Q _7214_/CLK _7169_/D _7169_/RESET_B VPWR VGND sg13cmos5l_dfrbpq_1
X_7617__676 _7617_/RESET_B VPWR VGND sg13cmos5l_tiehi
X_7531__229 _7531_/RESET_B VPWR VGND sg13cmos5l_tiehi
XFILLER_46_527 VPWR VGND sg13cmos5l_fill_2
XFILLER_2_1011 VPWR VGND sg13cmos5l_decap_8
X_7548__748 _7548_/RESET_B VPWR VGND sg13cmos5l_tiehi
Xclkbuf_leaf_21_clk _7622_/CLK clkload4/A VPWR VGND sg13cmos5l_buf_8
XFILLER_6_678 VPWR VGND sg13cmos5l_decap_8
XFILLER_5_133 VPWR VGND sg13cmos5l_fill_2
XFILLER_38_8 VPWR VGND sg13cmos5l_fill_2
XFILLER_2_873 VPWR VGND sg13cmos5l_fill_2
X_7321__176 _7321_/D VPWR VGND sg13cmos5l_tielo
XFILLER_37_505 VPWR VGND sg13cmos5l_decap_8
XFILLER_37_527 VPWR VGND sg13cmos5l_decap_8
XFILLER_45_560 VPWR VGND sg13cmos5l_fill_1
XFILLER_17_295 VPWR VGND sg13cmos5l_decap_8
X_4870_ _4870_/Y _4867_/Y _4871_/A VPWR VGND sg13cmos5l_nand2b_1
X_6540_ _6540_/Y _6543_/A _6543_/B VPWR VGND sg13cmos5l_nand2_1
XFILLER_20_427 VPWR VGND sg13cmos5l_fill_2
XFILLER_32_276 VPWR VGND sg13cmos5l_fill_2
Xclkbuf_leaf_12_clk _7490_/CLK clkload2/A VPWR VGND sg13cmos5l_buf_8
X_6471_ _6534_/B _6458_/Y _6471_/A2 _6348_/X VPWR VGND sg13cmos5l_a21oi_1
XFILLER_9_494 VPWR VGND sg13cmos5l_fill_1
X_5422_ _5431_/B _7238_/Q _5450_/A _7237_/Q VPWR VGND sg13cmos5l_nor3_1
X_5353_ _5353_/Y _5351_/Y _5352_/Y _5350_/Y VPWR VGND sg13cmos5l_a21oi_1
X_4304_ _4304_/Y _7508_/Q _7560_/Q VPWR VGND sg13cmos5l_nand2_1
X_7298__429 _7298_/RESET_B VPWR VGND sg13cmos5l_tiehi
X_5284_ _5284_/Y _7203_/Q _5284_/B VPWR VGND sg13cmos5l_nand2_1
X_4235_ _4235_/Y _4573_/A _4235_/B VPWR VGND sg13cmos5l_xnor2_1
X_7023_ _7040_/B _7037_/A _7037_/B VPWR VGND sg13cmos5l_nand2_1
X_4166_ _4166_/Y _7073_/B _7069_/B _4165_/Y VPWR VGND sg13cmos5l_o21ai_1
X_4097_ _4110_/B _4097_/A _4102_/A VPWR VGND sg13cmos5l_xor2_1
XFILLER_43_519 VPWR VGND sg13cmos5l_fill_2
XFILLER_12_928 VPWR VGND sg13cmos5l_fill_1
X_6807_ _6807_/Y _6816_/B _6803_/Y _6805_/Y _6800_/Y _6806_/Y VPWR VGND sg13cmos5l_a221oi_1
X_4999_ _5039_/A _7608_/Q _5007_/B VPWR VGND sg13cmos5l_xor2_1
X_6738_ _6836_/A _6721_/Y _6737_/X _6738_/S VPWR VGND sg13cmos5l_mux2_1
X_6669_ _6669_/Y _6674_/A _6677_/B VPWR VGND sg13cmos5l_nand2_1
XFILLER_2_103 VPWR VGND sg13cmos5l_decap_4
XFILLER_3_648 VPWR VGND sg13cmos5l_decap_8
X_7240__185 _7240_/D VPWR VGND sg13cmos5l_tielo
XFILLER_46_357 VPWR VGND sg13cmos5l_decap_8
XFILLER_14_210 VPWR VGND sg13cmos5l_fill_1
XFILLER_27_582 VPWR VGND sg13cmos5l_fill_2
XFILLER_42_563 VPWR VGND sg13cmos5l_fill_2
XFILLER_14_232 VPWR VGND sg13cmos5l_decap_8
XFILLER_14_265 VPWR VGND sg13cmos5l_decap_8
Xfanout80 _5560_/B _5562_/B VPWR VGND sg13cmos5l_buf_1
Xfanout91 _4516_/A _4573_/B VPWR VGND sg13cmos5l_buf_1
XFILLER_7_932 VPWR VGND sg13cmos5l_fill_1
XFILLER_6_453 VPWR VGND sg13cmos5l_fill_2
XFILLER_6_442 VPWR VGND sg13cmos5l_decap_8
XFILLER_9_1028 VPWR VGND sg13cmos5l_fill_1
Xclkbuf_leaf_1_clk clkload6/A clkbuf_leaf_5_clk/A VPWR VGND sg13cmos5l_buf_8
X_4020_ _6810_/B _4020_/A VPWR VGND sg13cmos5l_inv_1
XFILLER_49_184 VPWR VGND sg13cmos5l_fill_1
XFILLER_37_313 VPWR VGND sg13cmos5l_fill_2
X_7258__479 _7258_/RESET_B VPWR VGND sg13cmos5l_tiehi
XFILLER_37_346 VPWR VGND sg13cmos5l_fill_1
X_5971_ _5971_/X _5950_/B _6146_/B _5975_/S VPWR VGND sg13cmos5l_mux2_1
X_4922_ _4922_/Y _6411_/A _4924_/A2 _6411_/B VPWR VGND sg13cmos5l_o21ai_1
X_7641_ _7641_/Q clkload6/A _7641_/D _7641_/RESET_B VPWR VGND sg13cmos5l_dfrbpq_1
X_4853_ _4855_/A _4853_/A _4850_/Y VPWR VGND sg13cmos5l_nor2b_1
X_7572_ _7572_/Q _7597_/CLK _7572_/D _7572_/RESET_B VPWR VGND sg13cmos5l_dfrbpq_1
XFILLER_20_257 VPWR VGND sg13cmos5l_decap_8
XFILLER_21_758 VPWR VGND sg13cmos5l_decap_4
X_4784_ _7625_/D _4784_/A _4784_/B VPWR VGND sg13cmos5l_and2_1
X_6523_ _6523_/Y _6523_/A _6541_/B VPWR VGND sg13cmos5l_nand2_1
X_7607__686 _7607_/RESET_B VPWR VGND sg13cmos5l_tiehi
X_6454_ _7374_/D _6511_/B _6534_/A VPWR VGND sg13cmos5l_nor2_1
X_7521__239 _7521_/RESET_B VPWR VGND sg13cmos5l_tiehi
X_5405_ _5407_/B _5406_/B _5406_/C _5381_/X VPWR VGND sg13cmos5l_a21oi_1
XFILLER_47_1012 VPWR VGND sg13cmos5l_decap_8
X_6385_ _7356_/D _6378_/B _6385_/A2 _6425_/A VPWR VGND sg13cmos5l_a21oi_1
X_5336_ _5336_/Y _5336_/A _5336_/B VPWR VGND sg13cmos5l_nor2_1
X_5267_ _5267_/Y _5267_/A _5267_/B VPWR VGND sg13cmos5l_nand2_1
X_4218_ _7524_/D _4208_/A _4218_/A2 _7071_/A VPWR VGND sg13cmos5l_a21oi_1
X_7006_ _7487_/D _7006_/A _7006_/B VPWR VGND sg13cmos5l_and2_1
X_5198_ _5232_/A _5198_/A _5198_/B VPWR VGND sg13cmos5l_xnor2_1
XFILLER_18_13 VPWR VGND sg13cmos5l_fill_1
X_4149_ _7072_/B _4147_/Y _4148_/Y _4146_/X VPWR VGND sg13cmos5l_a21o_1
X_7614__679 _7614_/RESET_B VPWR VGND sg13cmos5l_tiehi
XFILLER_37_880 VPWR VGND sg13cmos5l_fill_2
XFILLER_18_79 VPWR VGND sg13cmos5l_fill_2
XFILLER_12_714 VPWR VGND sg13cmos5l_decap_8
XFILLER_7_228 VPWR VGND sg13cmos5l_decap_4
XFILLER_7_206 VPWR VGND sg13cmos5l_fill_1
Xclkload0 clkload0/X clkload0/A VPWR VGND sg13cmos5l_buf_8
XFILLER_20_791 VPWR VGND sg13cmos5l_fill_1
XFILLER_4_935 VPWR VGND sg13cmos5l_fill_1
X_7144__602 _7144_/RESET_B VPWR VGND sg13cmos5l_tiehi
XFILLER_4_968 VPWR VGND sg13cmos5l_decap_8
XFILLER_35_828 VPWR VGND sg13cmos5l_decap_4
XFILLER_46_198 VPWR VGND sg13cmos5l_fill_1
XFILLER_30_522 VPWR VGND sg13cmos5l_decap_4
X_6170_ _6170_/Y _6148_/A _6167_/Y _6192_/B VPWR VGND sg13cmos5l_o21ai_1
X_5121_ _5121_/Y _7150_/Q _7622_/Q VPWR VGND sg13cmos5l_xnor2_1
X_5052_ _5052_/Y _7166_/Q _4771_/A _7615_/Q _5333_/A VPWR VGND sg13cmos5l_a22oi_1
X_4003_ _5058_/B _4003_/A VPWR VGND sg13cmos5l_inv_1
XFILLER_38_677 VPWR VGND sg13cmos5l_fill_2
XFILLER_40_308 VPWR VGND sg13cmos5l_decap_8
X_5954_ _5954_/Y _7290_/Q _5954_/B _5954_/C VPWR VGND sg13cmos5l_nand3_1
X_5885_ _5886_/B _5863_/X _5884_/Y _5888_/S VPWR VGND sg13cmos5l_mux2_1
X_4905_ _4917_/A _6386_/B _6108_/B VPWR VGND sg13cmos5l_nand2b_1
X_7624_ _7624_/Q _7630_/CLK _7624_/D _7624_/RESET_B VPWR VGND sg13cmos5l_dfrbpq_1
X_4836_ _4836_/Y _4836_/A _4836_/B VPWR VGND sg13cmos5l_xnor2_1
X_7555_ _7555_/Q _7555_/CLK _7555_/D _7555_/RESET_B VPWR VGND sg13cmos5l_dfrbpq_1
X_4767_ _4767_/X _4756_/B _5061_/B _4767_/S VPWR VGND sg13cmos5l_mux2_1
X_6506_ _7389_/D _6506_/A _6506_/B VPWR VGND sg13cmos5l_and2_1
X_7486_ _7486_/Q _7513_/CLK _7486_/D _7486_/RESET_B VPWR VGND sg13cmos5l_dfrbpq_1
X_4698_ _4701_/B _7568_/Q _7569_/Q VPWR VGND sg13cmos5l_nor2_1
X_6437_ _6437_/Y _7373_/Q _7372_/Q _7374_/Q VPWR VGND sg13cmos5l_o21ai_1
X_6368_ _6369_/B _7119_/Q _7370_/Q _6511_/A VPWR VGND sg13cmos5l_a21oi_1
XFILLER_0_426 VPWR VGND sg13cmos5l_fill_2
X_5319_ _7185_/D _6827_/A _5319_/B VPWR VGND sg13cmos5l_and2_1
X_6299_ _6299_/X _6299_/A _6299_/B _6299_/C _6299_/D VPWR VGND sg13cmos5l_and4_1
XFILLER_29_34 VPWR VGND sg13cmos5l_fill_1
XFILLER_29_78 VPWR VGND sg13cmos5l_fill_1
XFILLER_43_157 VPWR VGND sg13cmos5l_fill_1
X_7248__489 _7248_/RESET_B VPWR VGND sg13cmos5l_tiehi
XFILLER_4_732 VPWR VGND sg13cmos5l_fill_2
X_7324__399 _7324_/RESET_B VPWR VGND sg13cmos5l_tiehi
XFILLER_4_787 VPWR VGND sg13cmos5l_decap_8
XFILLER_20_8 VPWR VGND sg13cmos5l_fill_2
XFILLER_48_975 VPWR VGND sg13cmos5l_decap_8
XFILLER_16_861 VPWR VGND sg13cmos5l_fill_1
X_5670_ _5778_/B _5979_/B _6827_/A VPWR VGND sg13cmos5l_nand2b_1
X_4621_ _4621_/Y _4606_/A _4606_/B _4620_/Y VPWR VGND sg13cmos5l_o21ai_1
X_7340_ _7340_/Q _7344_/CLK _7340_/D _7340_/RESET_B VPWR VGND sg13cmos5l_dfrbpq_1
X_4552_ _4552_/X _4531_/B _4008_/Y _4554_/S VPWR VGND sg13cmos5l_mux2_1
X_4483_ _4483_/Y _7557_/Q _7533_/Q VPWR VGND sg13cmos5l_nand2b_1
X_7604__689 _7604_/RESET_B VPWR VGND sg13cmos5l_tiehi
X_7271_ _7271_/Q _7307_/CLK _7271_/D _7271_/RESET_B VPWR VGND sg13cmos5l_dfrbpq_1
X_6222_ _6222_/Y _6222_/A _6302_/A _6222_/C _6222_/D VPWR VGND sg13cmos5l_nor4_1
X_7574__722 _7574_/RESET_B VPWR VGND sg13cmos5l_tiehi
X_6153_ _6153_/Y _3880_/Y _6148_/A _6152_/Y VPWR VGND sg13cmos5l_a21oi_1
X_6084_ _6095_/C _7342_/Q _7343_/Q _7341_/Q _7340_/Q VPWR VGND sg13cmos5l_nor4_1
X_5104_ _5116_/A _5161_/A _5161_/B VPWR VGND sg13cmos5l_nand2b_1
Xhold1215 _5032_/B _5030_/Y VPWR VGND sg13cmos5l_dlygate4sd3_1
Xhold1204 _5378_/A _7193_/Q VPWR VGND sg13cmos5l_dlygate4sd3_1
Xhold1248 _6350_/A _7349_/Q VPWR VGND sg13cmos5l_dlygate4sd3_1
X_5035_ _5035_/Y _5035_/A _5035_/B VPWR VGND sg13cmos5l_nor2_1
Xhold1237 _5628_/A _5612_/A VPWR VGND sg13cmos5l_dlygate4sd3_1
Xhold1226 _4041_/C _4862_/C VPWR VGND sg13cmos5l_dlygate4sd3_1
XFILLER_39_986 VPWR VGND sg13cmos5l_fill_1
XFILLER_38_441 VPWR VGND sg13cmos5l_fill_1
Xhold1259 _7055_/A _7488_/Q VPWR VGND sg13cmos5l_dlygate4sd3_1
X_7134__612 _7134_/RESET_B VPWR VGND sg13cmos5l_tiehi
X_6986_ _7081_/A _6989_/A _6986_/B VPWR VGND sg13cmos5l_nor2_1
X_5937_ _5937_/Y _7309_/Q _5951_/B _5937_/C VPWR VGND sg13cmos5l_nand3_1
XFILLER_15_47 VPWR VGND sg13cmos5l_decap_8
XFILLER_22_842 VPWR VGND sg13cmos5l_decap_8
XFILLER_22_853 VPWR VGND sg13cmos5l_fill_2
X_7581__715 _7581_/RESET_B VPWR VGND sg13cmos5l_tiehi
X_5868_ _5877_/B _7313_/Q _7312_/Q _7310_/Q _7311_/Q VPWR VGND sg13cmos5l_nor4_1
X_7607_ _7607_/Q _7634_/CLK _7607_/D _7607_/RESET_B VPWR VGND sg13cmos5l_dfrbpq_1
X_5799_ _5819_/C _5818_/A _5818_/B VPWR VGND sg13cmos5l_nand2_1
XFILLER_21_396 VPWR VGND sg13cmos5l_fill_1
X_4819_ _4845_/B _4845_/A _4818_/Y _4806_/Y VPWR VGND sg13cmos5l_o21ai_1
XFILLER_31_35 VPWR VGND sg13cmos5l_fill_1
X_7538_ _7538_/Q _7630_/CLK _7538_/D _7538_/RESET_B VPWR VGND sg13cmos5l_dfrbpq_1
X_7469_ _7469_/Q _7489_/CLK _7469_/D _7469_/RESET_B VPWR VGND sg13cmos5l_dfrbpq_1
Xoutput13 uo_out[0] _7322_/Q VPWR VGND sg13cmos5l_buf_1
X_7141__605 _7141_/RESET_B VPWR VGND sg13cmos5l_tiehi
XFILLER_1_735 VPWR VGND sg13cmos5l_fill_1
XFILLER_45_901 VPWR VGND sg13cmos5l_fill_1
XFILLER_45_923 VPWR VGND sg13cmos5l_decap_4
XFILLER_44_422 VPWR VGND sg13cmos5l_fill_2
XFILLER_17_658 VPWR VGND sg13cmos5l_fill_1
XFILLER_44_488 VPWR VGND sg13cmos5l_fill_1
XFILLER_9_857 VPWR VGND sg13cmos5l_decap_8
XFILLER_9_868 VPWR VGND sg13cmos5l_fill_2
XFILLER_8_356 VPWR VGND sg13cmos5l_fill_1
Xclkbuf_3_1__f_clk clkload0/A clkbuf_0_clk/X VPWR VGND sg13cmos5l_buf_8
XFILLER_4_551 VPWR VGND sg13cmos5l_fill_2
X_7261__475 _7261_/RESET_B VPWR VGND sg13cmos5l_tiehi
XFILLER_47_260 VPWR VGND sg13cmos5l_fill_2
X_6840_ _6840_/Y _6840_/A _6840_/B _6840_/C VPWR VGND sg13cmos5l_nand3_1
X_6771_ _7435_/D _6889_/A _6771_/B VPWR VGND sg13cmos5l_nor2_1
XFILLER_22_105 VPWR VGND sg13cmos5l_fill_2
X_5722_ _7251_/D _5774_/B _5831_/B VPWR VGND sg13cmos5l_and2_1
X_3983_ _3983_/Y input4/X VPWR VGND sg13cmos5l_inv_1
X_5653_ _5660_/A _5643_/X _5647_/Y _5681_/A _5912_/A _5648_/X VPWR VGND sg13cmos5l_a221oi_1
XFILLER_30_182 VPWR VGND sg13cmos5l_decap_4
X_4604_ _4606_/A _4604_/A _4625_/B _4604_/C VPWR VGND sg13cmos5l_nor3_1
X_5584_ _5592_/C _5584_/A _7191_/Q _7230_/Q VPWR VGND sg13cmos5l_nand3_1
X_7323_ _7323_/Q clkload9/A _7323_/D _7323_/RESET_B VPWR VGND sg13cmos5l_dfrbpq_1
X_4535_ _4535_/X _4535_/A _4535_/B _4535_/C VPWR VGND sg13cmos5l_or3_1
X_7254_ _7254_/Q _7314_/CLK _7254_/D _7254_/RESET_B VPWR VGND sg13cmos5l_dfrbpq_1
X_4466_ _4723_/A _4466_/A _4470_/B VPWR VGND sg13cmos5l_nand2_1
X_7377__326 _7377_/RESET_B VPWR VGND sg13cmos5l_tiehi
X_6205_ _6205_/Y _7335_/Q _6224_/B VPWR VGND sg13cmos5l_nand2_1
X_7185_ _7185_/Q _7332_/CLK _7185_/D _7185_/RESET_B VPWR VGND sg13cmos5l_dfrbpq_1
X_4397_ _4398_/B _7551_/Q _4386_/B _4368_/Y VPWR VGND sg13cmos5l_a21oi_1
X_6136_ _6139_/B _6160_/B _7295_/Q VPWR VGND sg13cmos5l_nor2b_1
Xhold1023 _3961_/A _7559_/Q VPWR VGND sg13cmos5l_dlygate4sd3_1
Xhold1001 _7614_/D _4770_/Y VPWR VGND sg13cmos5l_dlygate4sd3_1
Xhold1012 _6816_/A _7444_/Q VPWR VGND sg13cmos5l_dlygate4sd3_1
Xhold1056 _6923_/A _7438_/Q VPWR VGND sg13cmos5l_dlygate4sd3_1
Xhold1067 _4291_/B _4290_/A VPWR VGND sg13cmos5l_dlygate4sd3_1
Xhold1045 _4919_/B1 _4918_/Y VPWR VGND sg13cmos5l_dlygate4sd3_1
X_6067_ _6086_/B _7342_/Q _7341_/Q _7340_/Q VPWR VGND sg13cmos5l_nor3_1
Xhold1034 _5977_/B _7294_/Q VPWR VGND sg13cmos5l_dlygate4sd3_1
Xhold1078 _3989_/A _7216_/Q VPWR VGND sg13cmos5l_dlygate4sd3_1
X_5018_ _5020_/B _5017_/A _5017_/B _5039_/B _4685_/B VPWR VGND sg13cmos5l_a22oi_1
Xhold1089 _3980_/A _7472_/Q VPWR VGND sg13cmos5l_dlygate4sd3_1
X_7238__499 _7238_/RESET_B VPWR VGND sg13cmos5l_tiehi
XFILLER_42_948 VPWR VGND sg13cmos5l_fill_1
X_6969_ _6969_/Y _6969_/A _6969_/B VPWR VGND sg13cmos5l_nand2_1
XFILLER_10_801 VPWR VGND sg13cmos5l_fill_2
XFILLER_42_56 VPWR VGND sg13cmos5l_fill_1
XFILLER_10_823 VPWR VGND sg13cmos5l_decap_8
XFILLER_21_171 VPWR VGND sg13cmos5l_decap_4
X_7540__220 _7540_/RESET_B VPWR VGND sg13cmos5l_tiehi
XFILLER_5_348 VPWR VGND sg13cmos5l_fill_1
Xhold890 _7114_/D _4914_/Y VPWR VGND sg13cmos5l_dlygate4sd3_1
XFILLER_49_503 VPWR VGND sg13cmos5l_decap_8
XFILLER_37_709 VPWR VGND sg13cmos5l_decap_4
XFILLER_45_731 VPWR VGND sg13cmos5l_fill_1
X_7564__732 _7564_/RESET_B VPWR VGND sg13cmos5l_tiehi
XFILLER_13_650 VPWR VGND sg13cmos5l_fill_1
XFILLER_9_621 VPWR VGND sg13cmos5l_fill_1
XFILLER_8_186 VPWR VGND sg13cmos5l_fill_2
X_4320_ _4320_/Y _4320_/A _4320_/B VPWR VGND sg13cmos5l_nand2_1
X_4251_ _4263_/S _4249_/A _4249_/B _4250_/Y VPWR VGND sg13cmos5l_o21ai_1
XFILLER_4_381 VPWR VGND sg13cmos5l_fill_2
X_7124__622 _7124_/RESET_B VPWR VGND sg13cmos5l_tiehi
X_7571__725 _7571_/RESET_B VPWR VGND sg13cmos5l_tiehi
X_4182_ _4182_/Y _7519_/Q _4190_/B VPWR VGND sg13cmos5l_nand2_1
XFILLER_35_230 VPWR VGND sg13cmos5l_fill_1
X_7131__615 _7131_/RESET_B VPWR VGND sg13cmos5l_tiehi
XFILLER_24_948 VPWR VGND sg13cmos5l_fill_2
X_6823_ _6823_/Y hold859/X _6824_/A2 _6660_/A VPWR VGND sg13cmos5l_o21ai_1
X_6754_ _6773_/A _7405_/Q _7404_/Q VPWR VGND sg13cmos5l_xor2_1
X_3966_ _3966_/Y _3966_/A VPWR VGND sg13cmos5l_inv_1
X_6685_ _6691_/B _6681_/Y _6683_/Y _6684_/Y VPWR VGND sg13cmos5l_a21oi_1
X_5705_ _5709_/B _7215_/Q _5705_/B VPWR VGND sg13cmos5l_xnor2_1
X_3897_ _6662_/A _6613_/A VPWR VGND sg13cmos5l_inv_1
X_5636_ _5684_/A _7277_/Q _5637_/B VPWR VGND sg13cmos5l_xnor2_1
X_5567_ _5567_/Y _5458_/B _5567_/B VPWR VGND sg13cmos5l_nand2b_1
X_4518_ _4623_/B _4518_/A _4518_/B VPWR VGND sg13cmos5l_nor2_1
X_5498_ _5567_/B _5222_/A _5488_/X _5490_/Y _5497_/Y VPWR VGND sg13cmos5l_a22oi_1
XFILLER_2_307 VPWR VGND sg13cmos5l_decap_8
XFILLER_2_318 VPWR VGND sg13cmos5l_fill_1
X_7306_ _7306_/Q _7307_/CLK _7306_/D _7306_/RESET_B VPWR VGND sg13cmos5l_dfrbpq_1
X_7237_ _7237_/Q _7272_/CLK _7237_/D _7237_/RESET_B VPWR VGND sg13cmos5l_dfrbpq_1
X_4449_ _4449_/X _4449_/A _4470_/B VPWR VGND sg13cmos5l_and2_1
X_7168_ _7168_/Q _7214_/CLK _7168_/D _7168_/RESET_B VPWR VGND sg13cmos5l_dfrbpq_1
X_6119_ _6119_/Y _6122_/B _6119_/B VPWR VGND sg13cmos5l_nand2b_1
X_7099_ _7504_/D _7105_/A _7099_/B VPWR VGND sg13cmos5l_nor2_1
XFILLER_41_233 VPWR VGND sg13cmos5l_fill_1
XFILLER_41_222 VPWR VGND sg13cmos5l_decap_8
XFILLER_42_767 VPWR VGND sg13cmos5l_fill_1
XFILLER_30_918 VPWR VGND sg13cmos5l_fill_2
XFILLER_6_657 VPWR VGND sg13cmos5l_decap_8
XFILLER_5_156 VPWR VGND sg13cmos5l_fill_1
XFILLER_49_311 VPWR VGND sg13cmos5l_decap_4
XFILLER_49_300 VPWR VGND sg13cmos5l_fill_2
XFILLER_49_366 VPWR VGND sg13cmos5l_fill_2
XFILLER_49_355 VPWR VGND sg13cmos5l_decap_8
XFILLER_49_344 VPWR VGND sg13cmos5l_fill_2
XFILLER_18_742 VPWR VGND sg13cmos5l_fill_2
X_7367__336 _7367_/RESET_B VPWR VGND sg13cmos5l_tiehi
X_6470_ _7377_/D _6510_/B _6538_/A VPWR VGND sg13cmos5l_and2_1
X_5421_ _5421_/Y _5698_/A _5456_/A _5420_/Y VPWR VGND sg13cmos5l_o21ai_1
X_5352_ _5352_/Y _7187_/Q _7153_/Q VPWR VGND sg13cmos5l_xnor2_1
X_4303_ _4303_/Y _7506_/Q _4572_/A _4302_/Y VPWR VGND sg13cmos5l_o21ai_1
X_5283_ _5283_/Y _5561_/A _7146_/Q _7145_/Q _5560_/A _5282_/Y VPWR VGND sg13cmos5l_a221oi_1
X_7022_ _7040_/A _7022_/A _7037_/B VPWR VGND sg13cmos5l_xnor2_1
X_4234_ _4265_/B _7559_/Q _4235_/B VPWR VGND sg13cmos5l_xnor2_1
XFILLER_4_71 VPWR VGND sg13cmos5l_fill_1
X_7198__542 _7198_/RESET_B VPWR VGND sg13cmos5l_tiehi
X_7374__329 _7374_/RESET_B VPWR VGND sg13cmos5l_tiehi
X_4165_ _4165_/Y _7072_/B _7068_/B VPWR VGND sg13cmos5l_nand2_1
X_4096_ _4113_/A _4120_/A _4281_/A VPWR VGND sg13cmos5l_or2_1
X_7530__230 _7530_/RESET_B VPWR VGND sg13cmos5l_tiehi
XFILLER_24_789 VPWR VGND sg13cmos5l_fill_1
X_6806_ _6806_/Y _4017_/A _6794_/Y _4016_/Y VPWR VGND sg13cmos5l_o21ai_1
X_4998_ _5011_/B _7608_/Q _7607_/Q _7605_/Q _7606_/Q VPWR VGND sg13cmos5l_nor4_1
XFILLER_23_36 VPWR VGND sg13cmos5l_decap_4
X_6737_ _6737_/X _6737_/A _6941_/A VPWR VGND sg13cmos5l_and2_1
X_3949_ _5331_/A _3949_/A VPWR VGND sg13cmos5l_inv_1
X_6668_ _6677_/B _6666_/Y _6667_/Y _6665_/Y VPWR VGND sg13cmos5l_a21oi_1
X_6599_ _6600_/B _7377_/Q _7376_/Q _7378_/Q VPWR VGND sg13cmos5l_o21ai_1
X_5619_ _5622_/A _5606_/Y _5613_/Y _5621_/A _5621_/B _5618_/Y VPWR VGND sg13cmos5l_a221oi_1
XFILLER_3_627 VPWR VGND sg13cmos5l_fill_1
XFILLER_48_22 VPWR VGND sg13cmos5l_decap_8
X_7554__742 _7554_/RESET_B VPWR VGND sg13cmos5l_tiehi
XFILLER_15_701 VPWR VGND sg13cmos5l_fill_2
XFILLER_42_542 VPWR VGND sg13cmos5l_fill_1
XFILLER_9_38 VPWR VGND sg13cmos5l_fill_2
XFILLER_9_49 VPWR VGND sg13cmos5l_fill_2
XFILLER_30_726 VPWR VGND sg13cmos5l_fill_1
Xfanout70 _6511_/B _6495_/A VPWR VGND sg13cmos5l_buf_1
Xfanout81 _5542_/A _5562_/B VPWR VGND sg13cmos5l_buf_1
Xfanout92 _4573_/B _4421_/Y VPWR VGND sg13cmos5l_buf_1
XFILLER_31_1028 VPWR VGND sg13cmos5l_fill_1
X_7561__735 _7561_/RESET_B VPWR VGND sg13cmos5l_tiehi
XFILLER_7_988 VPWR VGND sg13cmos5l_decap_8
XFILLER_6_487 VPWR VGND sg13cmos5l_fill_1
XFILLER_6_476 VPWR VGND sg13cmos5l_decap_8
XFILLER_49_141 VPWR VGND sg13cmos5l_decap_8
XFILLER_49_174 VPWR VGND sg13cmos5l_fill_2
X_7455__651 _7455_/RESET_B VPWR VGND sg13cmos5l_tiehi
X_5970_ _7290_/D _5976_/A _5970_/B VPWR VGND sg13cmos5l_nor2_1
XFILLER_18_561 VPWR VGND sg13cmos5l_decap_8
X_4921_ _4921_/Y _7119_/Q _4921_/B VPWR VGND sg13cmos5l_nand2b_1
XFILLER_33_520 VPWR VGND sg13cmos5l_fill_2
X_7640_ _7640_/Q clkload6/A _7640_/D _7640_/RESET_B VPWR VGND sg13cmos5l_dfrbpq_1
X_4852_ _7630_/D _4852_/A1 _4850_/Y _4851_/Y VPWR VGND sg13cmos5l_a21oi_1
XFILLER_21_715 VPWR VGND sg13cmos5l_fill_1
X_7571_ _7571_/Q _7571_/CLK _7571_/D _7571_/RESET_B VPWR VGND sg13cmos5l_dfrbpq_1
X_4783_ _7624_/D _4783_/A _4784_/B VPWR VGND sg13cmos5l_and2_1
X_6522_ _6541_/B _6520_/Y _6521_/Y _6519_/Y VPWR VGND sg13cmos5l_a21oi_1
X_6453_ _6534_/A _6434_/A _6435_/B _6452_/Y VPWR VGND sg13cmos5l_a21oi_1
X_5404_ _7198_/D _5407_/A _5404_/B _5404_/C VPWR VGND sg13cmos5l_nor3_1
X_6384_ _6487_/A _7357_/Q _6384_/B VPWR VGND sg13cmos5l_nand2b_1
X_5335_ _5391_/B _5335_/A _5396_/B VPWR VGND sg13cmos5l_or2_1
X_5266_ _5266_/Y _5255_/Y _5259_/Y _4981_/Y VPWR VGND sg13cmos5l_o21ai_1
X_4217_ _7523_/D _4195_/Y _4209_/Y _4216_/Y VPWR VGND sg13cmos5l_a21oi_1
X_7005_ _7486_/D _7005_/A _7007_/B VPWR VGND sg13cmos5l_nor2_1
X_5197_ _5205_/B _7171_/Q _5198_/B VPWR VGND sg13cmos5l_nor2b_1
X_4148_ _4148_/Y _4155_/B _4138_/Y VPWR VGND sg13cmos5l_nor2b_1
XFILLER_28_325 VPWR VGND sg13cmos5l_fill_2
X_4079_ _4080_/C _4079_/A _4079_/B _4079_/C VPWR VGND sg13cmos5l_nand3_1
XFILLER_43_328 VPWR VGND sg13cmos5l_decap_8
Xclkload1 clkload1/X clkload1/A VPWR VGND sg13cmos5l_buf_8
XFILLER_4_947 VPWR VGND sg13cmos5l_decap_8
X_7257__480 _7257_/RESET_B VPWR VGND sg13cmos5l_tiehi
XFILLER_19_369 VPWR VGND sg13cmos5l_decap_8
XFILLER_46_177 VPWR VGND sg13cmos5l_fill_1
XFILLER_27_380 VPWR VGND sg13cmos5l_decap_4
XFILLER_42_383 VPWR VGND sg13cmos5l_fill_1
X_7364__339 _7364_/RESET_B VPWR VGND sg13cmos5l_tiehi
X_7520__240 _7520_/RESET_B VPWR VGND sg13cmos5l_tiehi
X_5120_ _5120_/Y _7149_/Q _7621_/Q VPWR VGND sg13cmos5l_xnor2_1
X_5051_ _5051_/Y _5333_/A _7615_/Q _5050_/Y VPWR VGND sg13cmos5l_o21ai_1
X_4002_ _5061_/B _4002_/A VPWR VGND sg13cmos5l_inv_1
X_7195__545 _7195_/RESET_B VPWR VGND sg13cmos5l_tiehi
X_7490__394 _7490_/RESET_B VPWR VGND sg13cmos5l_tiehi
XFILLER_19_892 VPWR VGND sg13cmos5l_fill_1
X_7613__680 _7613_/RESET_B VPWR VGND sg13cmos5l_tiehi
X_5953_ _5954_/C _5955_/C _5951_/Y _5952_/Y VPWR VGND sg13cmos5l_a21oi_1
XFILLER_34_840 VPWR VGND sg13cmos5l_fill_2
X_5884_ _5884_/Y _6191_/A _5887_/B VPWR VGND sg13cmos5l_nand2_1
X_4904_ _4904_/Y _6107_/A _6386_/B VPWR VGND sg13cmos5l_nor2_1
X_7623_ _7623_/Q _7635_/CLK _7623_/D _7623_/RESET_B VPWR VGND sg13cmos5l_dfrbpq_1
X_4835_ _4836_/B _4835_/A _4835_/B VPWR VGND sg13cmos5l_xnor2_1
X_7554_ _7554_/Q _7560_/CLK _7554_/D _7554_/RESET_B VPWR VGND sg13cmos5l_dfrbpq_1
X_4766_ _7612_/D _4768_/A _4766_/B VPWR VGND sg13cmos5l_nor2_1
X_6505_ _7388_/D _6505_/A _6505_/B VPWR VGND sg13cmos5l_and2_1
X_4697_ _7603_/D _4728_/A _4697_/B VPWR VGND sg13cmos5l_nor2_1
X_7485_ _7485_/Q _7513_/CLK _7485_/D _7485_/RESET_B VPWR VGND sg13cmos5l_dfrbpq_1
X_6436_ _6604_/A _7396_/Q _7397_/Q VPWR VGND sg13cmos5l_xnor2_1
XFILLER_20_37 VPWR VGND sg13cmos5l_decap_4
X_6367_ _6369_/A _7119_/Q _6511_/A _6364_/Y _6365_/Y _6366_/Y VPWR VGND sg13cmos5l_a221oi_1
X_5318_ _7183_/D _5305_/Y hold995/X _5334_/B VPWR VGND sg13cmos5l_a21oi_1
X_6298_ _6298_/Y _6229_/B _6228_/B _6298_/B1 VPWR VGND sg13cmos5l_a21oi_1
X_5249_ _5256_/C _5249_/A _5274_/A VPWR VGND sg13cmos5l_nor2_1
X_7551__745 _7551_/RESET_B VPWR VGND sg13cmos5l_tiehi
XFILLER_29_689 VPWR VGND sg13cmos5l_fill_2
XFILLER_45_78 VPWR VGND sg13cmos5l_fill_1
X_7567__207 _7567_/D VPWR VGND sg13cmos5l_tielo
XFILLER_24_350 VPWR VGND sg13cmos5l_fill_1
XFILLER_31_309 VPWR VGND sg13cmos5l_fill_1
XFILLER_8_505 VPWR VGND sg13cmos5l_decap_8
XFILLER_10_70 VPWR VGND sg13cmos5l_fill_1
XFILLER_48_954 VPWR VGND sg13cmos5l_decap_8
XFILLER_47_453 VPWR VGND sg13cmos5l_fill_2
XFILLER_19_133 VPWR VGND sg13cmos5l_decap_8
XFILLER_35_615 VPWR VGND sg13cmos5l_fill_2
XFILLER_15_361 VPWR VGND sg13cmos5l_fill_1
XFILLER_43_692 VPWR VGND sg13cmos5l_fill_2
XFILLER_42_180 VPWR VGND sg13cmos5l_decap_8
XFILLER_15_394 VPWR VGND sg13cmos5l_fill_2
XFILLER_30_320 VPWR VGND sg13cmos5l_fill_1
X_4620_ _4620_/Y _4622_/A _4622_/B VPWR VGND sg13cmos5l_nand2_1
X_4551_ _4551_/Y _4535_/A _4554_/S _4550_/Y VPWR VGND sg13cmos5l_a21oi_1
X_4482_ _4507_/A _4482_/A _4481_/Y VPWR VGND sg13cmos5l_nor2b_1
X_7270_ _7270_/Q _7277_/CLK _7270_/D _7270_/RESET_B VPWR VGND sg13cmos5l_dfrbpq_1
X_6221_ _6222_/D _6221_/A VPWR VGND sg13cmos5l_inv_1
X_6152_ _6152_/Y _7323_/Q _6148_/Y _6151_/Y _7322_/Q VPWR VGND sg13cmos5l_a22oi_1
XFILLER_44_1027 VPWR VGND sg13cmos5l_fill_2
X_5103_ _5155_/B _5161_/A _5103_/B VPWR VGND sg13cmos5l_nor2_1
XFILLER_32_0 VPWR VGND sg13cmos5l_fill_2
X_6083_ _6083_/Y _6083_/A _6119_/B VPWR VGND sg13cmos5l_nor2_1
Xhold1205 _6039_/A _7306_/Q VPWR VGND sg13cmos5l_dlygate4sd3_1
Xhold1216 _6029_/A _7304_/Q VPWR VGND sg13cmos5l_dlygate4sd3_1
Xhold1249 _6359_/A2 _6350_/Y VPWR VGND sg13cmos5l_dlygate4sd3_1
Xheichips26_dna_sequencer_143 uio_out[4] VPWR VGND sg13cmos5l_tielo
X_5034_ _5035_/B _5007_/B _5007_/C _5039_/B VPWR VGND sg13cmos5l_a21o_1
Xhold1227 hold1227/X _7458_/Q VPWR VGND sg13cmos5l_dlygate4sd3_1
Xhold1238 hold1238/X _7561_/Q VPWR VGND sg13cmos5l_dlygate4sd3_1
XFILLER_38_453 VPWR VGND sg13cmos5l_decap_4
XFILLER_25_158 VPWR VGND sg13cmos5l_fill_1
XFILLER_26_659 VPWR VGND sg13cmos5l_fill_2
X_6985_ _6985_/Y _6974_/B _6982_/Y _6984_/Y VPWR VGND sg13cmos5l_a21oi_1
X_5936_ _5937_/C _6191_/A _7254_/Q VPWR VGND sg13cmos5l_nand2_1
X_5867_ _5867_/Y _5867_/A _5867_/B VPWR VGND sg13cmos5l_nor2_1
X_7606_ _7606_/Q _7634_/CLK _7606_/D _7606_/RESET_B VPWR VGND sg13cmos5l_dfrbpq_1
X_5798_ _5808_/A _7268_/Q _5818_/B VPWR VGND sg13cmos5l_xnor2_1
X_4818_ _4818_/Y _7629_/Q _4835_/B _4807_/Y VPWR VGND sg13cmos5l_o21ai_1
X_7537_ _7537_/Q _7571_/CLK _7537_/D _7537_/RESET_B VPWR VGND sg13cmos5l_dfrbpq_1
X_4749_ _4749_/Y _7579_/Q _4749_/B VPWR VGND sg13cmos5l_nor2_1
X_7468_ _7468_/Q _7489_/CLK _7468_/D _7468_/RESET_B VPWR VGND sg13cmos5l_dfrbpq_1
X_6419_ _6423_/A _6411_/D _6410_/B _6418_/Y VPWR VGND sg13cmos5l_a21o_1
Xoutput14 uo_out[1] _7323_/Q VPWR VGND sg13cmos5l_buf_1
X_7247__490 _7247_/RESET_B VPWR VGND sg13cmos5l_tiehi
X_7399_ _7399_/Q _7428_/CLK _7399_/D _7399_/RESET_B VPWR VGND sg13cmos5l_dfrbpq_1
XFILLER_17_626 VPWR VGND sg13cmos5l_fill_1
XFILLER_44_456 VPWR VGND sg13cmos5l_decap_8
X_7254__483 _7254_/RESET_B VPWR VGND sg13cmos5l_tiehi
XFILLER_16_147 VPWR VGND sg13cmos5l_fill_2
XFILLER_44_478 VPWR VGND sg13cmos5l_fill_2
XFILLER_13_821 VPWR VGND sg13cmos5l_fill_2
XFILLER_25_681 VPWR VGND sg13cmos5l_fill_1
XFILLER_9_836 VPWR VGND sg13cmos5l_decap_4
XFILLER_24_191 VPWR VGND sg13cmos5l_fill_2
X_7603__690 _7603_/RESET_B VPWR VGND sg13cmos5l_tiehi
XFILLER_4_585 VPWR VGND sg13cmos5l_decap_4
XFILLER_4_563 VPWR VGND sg13cmos5l_fill_2
X_7398__298 _7398_/RESET_B VPWR VGND sg13cmos5l_tiehi
X_7192__548 _7192_/RESET_B VPWR VGND sg13cmos5l_tiehi
X_6770_ _6771_/B _6581_/B _6772_/B _6768_/X _6769_/Y VPWR VGND sg13cmos5l_a22oi_1
X_7610__683 _7610_/RESET_B VPWR VGND sg13cmos5l_tiehi
X_3982_ _3982_/Y input3/X VPWR VGND sg13cmos5l_inv_1
XFILLER_35_467 VPWR VGND sg13cmos5l_fill_2
X_5721_ _5831_/B _5702_/B _5709_/B _5464_/Y VPWR VGND sg13cmos5l_o21ai_1
X_5652_ _5912_/A _5654_/B _5652_/B VPWR VGND sg13cmos5l_nand2b_1
X_4603_ _4604_/C _4603_/A _4612_/C _4603_/C VPWR VGND sg13cmos5l_and3_1
X_5583_ _5603_/C _5602_/A _5602_/B VPWR VGND sg13cmos5l_nand2_1
X_7322_ _7322_/Q clkload9/A _7322_/D _7322_/RESET_B VPWR VGND sg13cmos5l_dfrbpq_1
X_4534_ _4535_/C _7543_/Q _4532_/Y _4533_/Y VPWR VGND sg13cmos5l_o21ai_1
X_4465_ _7563_/D _4519_/A _4465_/B VPWR VGND sg13cmos5l_nor2_1
X_7253_ _7253_/Q _7314_/CLK _7253_/D _7253_/RESET_B VPWR VGND sg13cmos5l_dfrbpq_1
X_4396_ _4407_/A _4396_/A _4414_/B VPWR VGND sg13cmos5l_nor2_1
X_7184_ _7184_/Q _7239_/CLK _7184_/D _7184_/RESET_B VPWR VGND sg13cmos5l_dfrbpq_1
X_6204_ _6213_/B _6204_/A _6224_/B VPWR VGND sg13cmos5l_nand2_1
X_6135_ _6139_/A _7293_/Q _6155_/A _6160_/A _7294_/Q _6134_/Y VPWR VGND sg13cmos5l_a221oi_1
X_6066_ _7313_/D _6046_/Y _6049_/Y _5993_/B VPWR VGND sg13cmos5l_a21oi_1
Xhold1024 _5319_/B _7148_/Q VPWR VGND sg13cmos5l_dlygate4sd3_1
Xhold1002 _4938_/A _7121_/Q VPWR VGND sg13cmos5l_dlygate4sd3_1
Xhold1013 _6970_/A _6813_/Y VPWR VGND sg13cmos5l_dlygate4sd3_1
XFILLER_45_209 VPWR VGND sg13cmos5l_decap_4
XFILLER_39_762 VPWR VGND sg13cmos5l_decap_4
XFILLER_39_751 VPWR VGND sg13cmos5l_fill_1
Xhold1035 _5978_/A2 _6159_/A VPWR VGND sg13cmos5l_dlygate4sd3_1
Xhold1057 _3928_/A _7313_/Q VPWR VGND sg13cmos5l_dlygate4sd3_1
X_5017_ _5017_/Y _5017_/A _5017_/B VPWR VGND sg13cmos5l_nand2_1
Xhold1046 _4872_/A _7646_/Q VPWR VGND sg13cmos5l_dlygate4sd3_1
Xhold1079 _3903_/A _7426_/Q VPWR VGND sg13cmos5l_dlygate4sd3_1
Xhold1068 _5881_/A _7309_/Q VPWR VGND sg13cmos5l_dlygate4sd3_1
XFILLER_42_905 VPWR VGND sg13cmos5l_decap_8
XFILLER_42_916 VPWR VGND sg13cmos5l_fill_2
XFILLER_26_69 VPWR VGND sg13cmos5l_decap_8
X_6968_ _6968_/Y _6989_/A _6968_/B VPWR VGND sg13cmos5l_nor2_1
XFILLER_13_117 VPWR VGND sg13cmos5l_decap_8
XFILLER_13_128 VPWR VGND sg13cmos5l_fill_1
X_6899_ _6899_/X _6899_/A _6899_/B VPWR VGND sg13cmos5l_xor2_1
XFILLER_41_459 VPWR VGND sg13cmos5l_decap_4
X_5919_ _5919_/Y _5917_/A _5917_/B _5918_/Y VPWR VGND sg13cmos5l_o21ai_1
Xhold880 _7325_/D _6177_/Y VPWR VGND sg13cmos5l_dlygate4sd3_1
Xhold891 _3876_/A _7299_/Q VPWR VGND sg13cmos5l_dlygate4sd3_1
XFILLER_49_559 VPWR VGND sg13cmos5l_decap_8
XFILLER_17_423 VPWR VGND sg13cmos5l_fill_2
XFILLER_17_445 VPWR VGND sg13cmos5l_decap_4
XFILLER_18_968 VPWR VGND sg13cmos5l_fill_1
XFILLER_26_990 VPWR VGND sg13cmos5l_fill_2
XFILLER_32_437 VPWR VGND sg13cmos5l_fill_1
XFILLER_13_695 VPWR VGND sg13cmos5l_fill_2
X_7482__433 _7482_/RESET_B VPWR VGND sg13cmos5l_tiehi
XFILLER_8_154 VPWR VGND sg13cmos5l_fill_1
XFILLER_5_872 VPWR VGND sg13cmos5l_decap_8
X_4250_ _4250_/Y _4498_/A _4258_/B VPWR VGND sg13cmos5l_nand2_1
X_4181_ _4207_/C _7519_/Q _4190_/B _4203_/A VPWR VGND sg13cmos5l_o21ai_1
X_6822_ _6822_/Y _3870_/Y _6826_/A2 _6821_/Y VPWR VGND sg13cmos5l_a21oi_1
X_6753_ _6757_/B _7426_/Q _6753_/B VPWR VGND sg13cmos5l_or2_1
X_3965_ _3965_/Y _7501_/Q VPWR VGND sg13cmos5l_inv_1
X_3896_ _6664_/A _6434_/A VPWR VGND sg13cmos5l_inv_1
X_6684_ _6684_/Y _6590_/B _6616_/Y _6699_/A VPWR VGND sg13cmos5l_o21ai_1
X_5704_ _5707_/A _5704_/A _5704_/B _5704_/C VPWR VGND sg13cmos5l_or3_1
X_5635_ _5637_/B _5993_/A _5654_/B VPWR VGND sg13cmos5l_and2_1
XFILLER_12_38 VPWR VGND sg13cmos5l_fill_1
X_5566_ _5566_/Y _5458_/B _5499_/Y _5563_/Y _5564_/Y _5565_/Y VPWR VGND sg13cmos5l_a221oi_1
X_4517_ _4518_/B _4517_/A _4513_/B VPWR VGND sg13cmos5l_nor2b_1
X_5497_ _5497_/Y _5497_/A _5501_/B VPWR VGND sg13cmos5l_nor2_1
X_7305_ _7305_/Q _7332_/CLK _7305_/D _7305_/RESET_B VPWR VGND sg13cmos5l_dfrbpq_1
X_7244__493 _7244_/RESET_B VPWR VGND sg13cmos5l_tiehi
X_7236_ _7236_/Q _7272_/CLK _7236_/D _7236_/RESET_B VPWR VGND sg13cmos5l_dfrbpq_1
X_4448_ _4470_/B _7598_/Q _4448_/B VPWR VGND sg13cmos5l_xnor2_1
X_4379_ _4379_/Y _4379_/A _7554_/Q _4379_/C _4392_/A VPWR VGND sg13cmos5l_nand4_1
X_7167_ _7167_/Q _7214_/CLK _7167_/D _7167_/RESET_B VPWR VGND sg13cmos5l_dfrbpq_1
X_6118_ _7317_/D _6180_/A _6268_/B VPWR VGND sg13cmos5l_nor2_1
X_7098_ _7098_/X _7088_/B _7098_/A1 _7098_/S VPWR VGND sg13cmos5l_mux2_1
XFILLER_46_529 VPWR VGND sg13cmos5l_fill_1
XFILLER_46_518 VPWR VGND sg13cmos5l_fill_1
X_6049_ _6049_/Y _6049_/A VPWR VGND sg13cmos5l_inv_1
XFILLER_15_927 VPWR VGND sg13cmos5l_decap_4
XFILLER_26_264 VPWR VGND sg13cmos5l_fill_2
XFILLER_41_256 VPWR VGND sg13cmos5l_decap_8
XFILLER_14_448 VPWR VGND sg13cmos5l_fill_2
X_7251__486 _7251_/RESET_B VPWR VGND sg13cmos5l_tiehi
XFILLER_41_267 VPWR VGND sg13cmos5l_fill_1
XFILLER_22_492 VPWR VGND sg13cmos5l_fill_2
XFILLER_5_102 VPWR VGND sg13cmos5l_fill_2
XFILLER_5_124 VPWR VGND sg13cmos5l_fill_1
XFILLER_2_820 VPWR VGND sg13cmos5l_fill_2
XFILLER_2_875 VPWR VGND sg13cmos5l_fill_1
X_7600__693 _7600_/RESET_B VPWR VGND sg13cmos5l_tiehi
XFILLER_17_220 VPWR VGND sg13cmos5l_fill_1
XFILLER_32_256 VPWR VGND sg13cmos5l_fill_2
XFILLER_13_470 VPWR VGND sg13cmos5l_decap_8
XFILLER_14_971 VPWR VGND sg13cmos5l_fill_2
XFILLER_14_993 VPWR VGND sg13cmos5l_decap_4
X_5420_ _5420_/Y _5452_/A _5418_/Y _5419_/Y _5450_/A VPWR VGND sg13cmos5l_a22oi_1
X_5351_ _5351_/Y _7186_/Q _7152_/Q VPWR VGND sg13cmos5l_xnor2_1
X_4302_ _4302_/Y _7507_/Q _7559_/Q VPWR VGND sg13cmos5l_nand2b_1
X_5282_ _5282_/Y _7201_/Q _5297_/B _5293_/B _7200_/Q _5281_/Y VPWR VGND sg13cmos5l_a221oi_1
X_4233_ _4233_/X _4261_/B _4237_/B _4233_/C VPWR VGND sg13cmos5l_and3_1
X_7021_ _7030_/A _7055_/A _7037_/B VPWR VGND sg13cmos5l_nor2_1
XFILLER_4_94 VPWR VGND sg13cmos5l_fill_2
X_4164_ _7069_/B _4102_/C _4116_/B _4163_/Y VPWR VGND sg13cmos5l_a21o_1
X_4095_ _4281_/A _7090_/A _4095_/B VPWR VGND sg13cmos5l_nor2_1
XFILLER_36_562 VPWR VGND sg13cmos5l_decap_8
X_6805_ _6805_/Y _7441_/Q _6798_/Y _6804_/Y _7442_/Q VPWR VGND sg13cmos5l_a22oi_1
X_6736_ _7430_/D _6889_/A _6837_/C VPWR VGND sg13cmos5l_nor2_1
X_4997_ _5007_/B _7607_/Q _7605_/Q _7606_/Q VPWR VGND sg13cmos5l_or3_1
X_7547__750 _7547_/RESET_B VPWR VGND sg13cmos5l_tiehi
X_3948_ _5333_/A _3948_/A VPWR VGND sg13cmos5l_inv_1
XFILLER_20_930 VPWR VGND sg13cmos5l_fill_1
XFILLER_23_59 VPWR VGND sg13cmos5l_fill_1
X_3879_ _3879_/Y _7328_/Q VPWR VGND sg13cmos5l_inv_1
X_6667_ _6667_/Y _7416_/Q _7389_/Q VPWR VGND sg13cmos5l_xnor2_1
X_6598_ _6598_/Y _7396_/Q _6596_/Y _6597_/Y VPWR VGND sg13cmos5l_a21oi_1
X_5618_ _5618_/Y _5618_/A _5618_/B VPWR VGND sg13cmos5l_nor2_1
X_5549_ _7223_/D _3888_/Y _5551_/A2 _5548_/Y VPWR VGND sg13cmos5l_a21oi_1
X_7219_ _7219_/Q _7277_/CLK _7219_/D _7219_/RESET_B VPWR VGND sg13cmos5l_dfrbpq_1
XFILLER_27_584 VPWR VGND sg13cmos5l_fill_1
XFILLER_42_565 VPWR VGND sg13cmos5l_fill_1
Xfanout60 _4402_/B _4386_/B VPWR VGND sg13cmos5l_buf_1
XFILLER_11_952 VPWR VGND sg13cmos5l_fill_2
Xfanout82 _5314_/A _5334_/B VPWR VGND sg13cmos5l_buf_1
Xfanout71 _6180_/A _6328_/A VPWR VGND sg13cmos5l_buf_1
XFILLER_7_923 VPWR VGND sg13cmos5l_fill_2
XFILLER_11_963 VPWR VGND sg13cmos5l_fill_1
Xfanout93 _4575_/B _4640_/B1 VPWR VGND sg13cmos5l_buf_1
XFILLER_7_967 VPWR VGND sg13cmos5l_decap_8
XFILLER_9_1019 VPWR VGND sg13cmos5l_decap_8
XFILLER_2_694 VPWR VGND sg13cmos5l_fill_1
X_7297__431 _7297_/RESET_B VPWR VGND sg13cmos5l_tiehi
X_7373__330 _7373_/RESET_B VPWR VGND sg13cmos5l_tiehi
XFILLER_46_871 VPWR VGND sg13cmos5l_fill_2
X_4920_ _6411_/B _6396_/A _6362_/A VPWR VGND sg13cmos5l_nor2b_1
X_4851_ _4851_/Y _4801_/Y _4850_/Y _4784_/B VPWR VGND sg13cmos5l_o21ai_1
XFILLER_21_749 VPWR VGND sg13cmos5l_decap_4
X_4782_ _7623_/D _5087_/A _4782_/B VPWR VGND sg13cmos5l_and2_1
X_7570_ _7570_/Q _7597_/CLK _7570_/D _7570_/RESET_B VPWR VGND sg13cmos5l_dfrbpq_1
X_6521_ _6521_/Y _7386_/Q _7363_/Q VPWR VGND sg13cmos5l_xnor2_1
X_7462__634 _7462_/RESET_B VPWR VGND sg13cmos5l_tiehi
X_6452_ _6452_/Y _6446_/A _6438_/Y _6451_/Y VPWR VGND sg13cmos5l_o21ai_1
X_7380__323 _7380_/RESET_B VPWR VGND sg13cmos5l_tiehi
X_5403_ _5404_/C _5384_/A _5403_/A2 _5401_/Y VPWR VGND sg13cmos5l_a21oi_1
X_6383_ _6383_/Y _6483_/B _6379_/Y _6382_/Y VPWR VGND sg13cmos5l_a21oi_1
X_5334_ _7197_/D _5334_/A _5334_/B VPWR VGND sg13cmos5l_nor2_1
X_5265_ _7173_/D _5334_/B _5348_/A VPWR VGND sg13cmos5l_nor2_1
X_4216_ _4216_/Y _4198_/A _4209_/Y _7072_/A VPWR VGND sg13cmos5l_o21ai_1
X_5196_ _5196_/Y _5485_/A VPWR VGND sg13cmos5l_inv_1
X_7241__496 _7241_/RESET_B VPWR VGND sg13cmos5l_tiehi
X_7004_ _7485_/D _7004_/A _7006_/B VPWR VGND sg13cmos5l_and2_1
X_4147_ _4147_/Y _4160_/A _4155_/B _4146_/A VPWR VGND sg13cmos5l_o21ai_1
X_4078_ _4079_/C _7544_/Q _7580_/Q _7617_/Q _4078_/D VPWR VGND sg13cmos5l_nor4_1
XFILLER_12_749 VPWR VGND sg13cmos5l_decap_4
X_6719_ _6719_/X _6728_/B _6724_/C _6927_/A VPWR VGND sg13cmos5l_a21o_1
XFILLER_7_219 VPWR VGND sg13cmos5l_fill_2
XFILLER_20_760 VPWR VGND sg13cmos5l_decap_4
Xclkload2 clkload2/X clkload2/A VPWR VGND sg13cmos5l_buf_8
X_7461__155 _7461_/D VPWR VGND sg13cmos5l_tielo
XFILLER_3_458 VPWR VGND sg13cmos5l_decap_4
X_7474__516 _7474_/RESET_B VPWR VGND sg13cmos5l_tiehi
X_7357__358 _7357_/RESET_B VPWR VGND sg13cmos5l_tiehi
XFILLER_19_326 VPWR VGND sg13cmos5l_fill_1
XFILLER_46_167 VPWR VGND sg13cmos5l_fill_2
XFILLER_15_510 VPWR VGND sg13cmos5l_fill_1
XFILLER_15_543 VPWR VGND sg13cmos5l_fill_2
XFILLER_42_351 VPWR VGND sg13cmos5l_fill_1
XFILLER_30_513 VPWR VGND sg13cmos5l_fill_2
XFILLER_11_760 VPWR VGND sg13cmos5l_fill_2
X_7188__553 _7188_/RESET_B VPWR VGND sg13cmos5l_tiehi
XFILLER_7_775 VPWR VGND sg13cmos5l_decap_4
XFILLER_6_252 VPWR VGND sg13cmos5l_decap_4
XFILLER_6_296 VPWR VGND sg13cmos5l_decap_8
X_5050_ _5050_/Y _7164_/Q _5065_/B VPWR VGND sg13cmos5l_nand2_1
X_4001_ _5065_/B _4001_/A VPWR VGND sg13cmos5l_inv_1
X_5952_ _5952_/Y _5961_/A _6190_/A _5961_/C VPWR VGND sg13cmos5l_nor3_1
X_4903_ _4903_/Y _4888_/X _4902_/Y _6107_/A VPWR VGND sg13cmos5l_a21oi_1
X_5883_ _7278_/D _5993_/B _5883_/B VPWR VGND sg13cmos5l_nor2_1
X_7622_ _7622_/Q _7622_/CLK _7622_/D _7622_/RESET_B VPWR VGND sg13cmos5l_dfrbpq_1
X_4834_ _4834_/Y _4829_/Y _4832_/Y _4833_/Y VPWR VGND sg13cmos5l_o21ai_1
X_7553_ _7553_/Q _7553_/CLK _7553_/D _7553_/RESET_B VPWR VGND sg13cmos5l_dfrbpq_1
X_4765_ _4765_/X _4744_/B _5058_/B _4767_/S VPWR VGND sg13cmos5l_mux2_1
X_6504_ _6504_/Y _3871_/Y _6504_/A2 _6503_/Y VPWR VGND sg13cmos5l_a21oi_1
X_4696_ _4843_/A _4696_/A VPWR VGND sg13cmos5l_inv_1
X_7484_ _7484_/Q _7513_/CLK _7484_/D _7484_/RESET_B VPWR VGND sg13cmos5l_dfrbpq_1
X_6435_ _6603_/A _6664_/A _6435_/B VPWR VGND sg13cmos5l_xnor2_1
X_6366_ _6366_/Y _7118_/Q _6509_/A _6378_/B VPWR VGND sg13cmos5l_o21ai_1
XFILLER_0_428 VPWR VGND sg13cmos5l_fill_1
XFILLER_0_406 VPWR VGND sg13cmos5l_decap_8
X_5317_ _5317_/Y _5317_/A _5317_/B VPWR VGND sg13cmos5l_nand2_1
X_6297_ _6297_/X _6297_/A _6297_/B VPWR VGND sg13cmos5l_or2_1
X_5248_ _5256_/B _5257_/A _5257_/B VPWR VGND sg13cmos5l_nor2_1
X_5179_ _5221_/A _5558_/A _7200_/Q VPWR VGND sg13cmos5l_xnor2_1
XFILLER_44_638 VPWR VGND sg13cmos5l_decap_8
XFILLER_44_616 VPWR VGND sg13cmos5l_decap_8
XFILLER_45_68 VPWR VGND sg13cmos5l_fill_1
XFILLER_12_502 VPWR VGND sg13cmos5l_fill_2
XFILLER_12_535 VPWR VGND sg13cmos5l_fill_2
XFILLER_12_557 VPWR VGND sg13cmos5l_decap_8
X_7363__340 _7363_/RESET_B VPWR VGND sg13cmos5l_tiehi
XFILLER_0_984 VPWR VGND sg13cmos5l_decap_8
XFILLER_48_933 VPWR VGND sg13cmos5l_decap_8
XFILLER_19_112 VPWR VGND sg13cmos5l_fill_2
X_7370__333 _7370_/RESET_B VPWR VGND sg13cmos5l_tiehi
XFILLER_43_660 VPWR VGND sg13cmos5l_fill_1
X_4550_ _4550_/Y _4535_/C _4554_/S _4640_/B1 VPWR VGND sg13cmos5l_o21ai_1
X_4481_ _4481_/Y _7532_/Q _7533_/Q _7534_/Q VPWR VGND sg13cmos5l_o21ai_1
X_6220_ _6221_/A _6220_/A _6220_/B VPWR VGND sg13cmos5l_xnor2_1
X_6151_ _6151_/Y _6159_/B _6149_/Y _6150_/Y VPWR VGND sg13cmos5l_a21oi_1
X_5102_ _7160_/D _5102_/A _5102_/B VPWR VGND sg13cmos5l_nor2_1
X_6082_ _6082_/Y _6083_/A _6119_/B _6080_/Y VPWR VGND sg13cmos5l_a21oi_1
Xhold1206 _6041_/B _6040_/Y VPWR VGND sg13cmos5l_dlygate4sd3_1
Xhold1239 _6899_/B _7462_/Q VPWR VGND sg13cmos5l_dlygate4sd3_1
X_5033_ _5033_/Y _5013_/Y _5019_/Y _4685_/X VPWR VGND sg13cmos5l_o21ai_1
Xheichips26_dna_sequencer_144 uio_out[5] VPWR VGND sg13cmos5l_tielo
Xhold1217 _6030_/B _6029_/Y VPWR VGND sg13cmos5l_dlygate4sd3_1
Xhold1228 _4398_/A _7552_/Q VPWR VGND sg13cmos5l_dlygate4sd3_1
XFILLER_38_498 VPWR VGND sg13cmos5l_decap_8
X_6984_ _6984_/Y _6982_/Y _6983_/Y _6893_/Y VPWR VGND sg13cmos5l_o21ai_1
X_5935_ _7288_/D _5990_/B _6046_/B VPWR VGND sg13cmos5l_and2_1
X_5866_ _5866_/Y _5867_/A _5867_/B _5860_/Y _5865_/Y VPWR VGND sg13cmos5l_a22oi_1
XFILLER_33_181 VPWR VGND sg13cmos5l_fill_1
XFILLER_21_343 VPWR VGND sg13cmos5l_fill_2
X_7605_ _7605_/Q _7634_/CLK _7605_/D _7605_/RESET_B VPWR VGND sg13cmos5l_dfrbpq_1
X_4817_ _4848_/C _4845_/A VPWR VGND sg13cmos5l_inv_1
X_5797_ _5802_/A _7268_/Q _5823_/B VPWR VGND sg13cmos5l_nand2_1
X_7536_ _7536_/Q _7571_/CLK _7536_/D _7536_/RESET_B VPWR VGND sg13cmos5l_dfrbpq_1
X_7347__368 _7347_/RESET_B VPWR VGND sg13cmos5l_tiehi
X_4748_ _4748_/Y _7611_/Q _4748_/B _4748_/C VPWR VGND sg13cmos5l_nand3_1
XFILLER_31_59 VPWR VGND sg13cmos5l_decap_8
X_7467_ _7467_/Q _7489_/CLK _7467_/D _7467_/RESET_B VPWR VGND sg13cmos5l_dfrbpq_1
X_4679_ _4679_/Y _5087_/B _5096_/A VPWR VGND sg13cmos5l_nand2b_1
X_6418_ _6418_/Y _6412_/Y _6416_/Y _6417_/Y VPWR VGND sg13cmos5l_a21oi_1
Xoutput15 uo_out[2] _7324_/Q VPWR VGND sg13cmos5l_buf_1
X_7398_ _7398_/Q _7428_/CLK _7398_/D _7398_/RESET_B VPWR VGND sg13cmos5l_dfrbpq_1
X_6349_ _6349_/Y _6348_/A _6340_/A _6355_/B VPWR VGND sg13cmos5l_o21ai_1
XFILLER_5_1022 VPWR VGND sg13cmos5l_decap_8
XFILLER_45_936 VPWR VGND sg13cmos5l_decap_8
XFILLER_45_969 VPWR VGND sg13cmos5l_decap_8
XFILLER_40_641 VPWR VGND sg13cmos5l_decap_4
XFILLER_8_336 VPWR VGND sg13cmos5l_fill_2
XFILLER_8_325 VPWR VGND sg13cmos5l_fill_1
XFILLER_13_899 VPWR VGND sg13cmos5l_decap_8
XFILLER_39_218 VPWR VGND sg13cmos5l_fill_2
XFILLER_0_781 VPWR VGND sg13cmos5l_decap_8
XFILLER_47_273 VPWR VGND sg13cmos5l_fill_2
XFILLER_36_914 VPWR VGND sg13cmos5l_fill_2
XFILLER_35_424 VPWR VGND sg13cmos5l_fill_1
XFILLER_35_435 VPWR VGND sg13cmos5l_fill_1
XFILLER_22_107 VPWR VGND sg13cmos5l_fill_1
X_3981_ _3981_/Y input2/X VPWR VGND sg13cmos5l_inv_1
XFILLER_44_991 VPWR VGND sg13cmos5l_decap_4
X_5720_ _7250_/D _5845_/A _5785_/A VPWR VGND sg13cmos5l_nor2_1
X_5651_ _5652_/B _7274_/Q _5672_/A _7275_/Q VPWR VGND sg13cmos5l_o21ai_1
X_4602_ _4625_/B _4625_/A _4601_/X _4590_/Y VPWR VGND sg13cmos5l_o21ai_1
X_5582_ _5592_/A _5582_/A _5602_/B VPWR VGND sg13cmos5l_xnor2_1
X_7321_ _7321_/Q _7344_/CLK _7321_/D _7321_/RESET_B VPWR VGND sg13cmos5l_dfrbpq_1
X_4533_ _4533_/Y _4788_/A _7593_/Q _4540_/C VPWR VGND sg13cmos5l_nand3_1
XFILLER_7_83 VPWR VGND sg13cmos5l_fill_1
X_7252_ _7252_/Q _7332_/CLK _7252_/D _7252_/RESET_B VPWR VGND sg13cmos5l_dfrbpq_1
X_4464_ _4464_/Y _4465_/B VPWR VGND sg13cmos5l_inv_1
X_6203_ _6213_/A _7337_/Q _6224_/B VPWR VGND sg13cmos5l_xnor2_1
X_4395_ _4414_/B _4363_/B _4400_/S _4394_/Y VPWR VGND sg13cmos5l_a21oi_1
X_7183_ _7183_/Q _7239_/CLK _7183_/D _7183_/RESET_B VPWR VGND sg13cmos5l_dfrbpq_1
X_6134_ _6134_/Y _6156_/B _7342_/Q _7341_/Q _6143_/B _6133_/Y VPWR VGND sg13cmos5l_a221oi_1
X_6065_ _7312_/D _6050_/A _6054_/Y _6064_/Y VPWR VGND sg13cmos5l_a21oi_1
Xhold1003 _6496_/B _7382_/Q VPWR VGND sg13cmos5l_dlygate4sd3_1
Xhold1014 _6815_/B1 _6814_/Y VPWR VGND sg13cmos5l_dlygate4sd3_1
Xhold1025 _3881_/A _7322_/Q VPWR VGND sg13cmos5l_dlygate4sd3_1
Xhold1036 _7294_/D _5978_/Y VPWR VGND sg13cmos5l_dlygate4sd3_1
X_5016_ _5039_/B _7610_/Q _5016_/B VPWR VGND sg13cmos5l_xor2_1
Xhold1047 _5142_/A _7156_/Q VPWR VGND sg13cmos5l_dlygate4sd3_1
Xhold1058 _6486_/A _7380_/Q VPWR VGND sg13cmos5l_dlygate4sd3_1
XFILLER_27_925 VPWR VGND sg13cmos5l_fill_1
Xhold1069 _3956_/A _7598_/Q VPWR VGND sg13cmos5l_dlygate4sd3_1
XFILLER_42_939 VPWR VGND sg13cmos5l_decap_8
XFILLER_14_608 VPWR VGND sg13cmos5l_fill_1
X_6967_ _6980_/B _6971_/A _7492_/Q _6793_/A VPWR VGND sg13cmos5l_a21oi_1
X_5918_ _5918_/Y _5930_/B _5918_/B VPWR VGND sg13cmos5l_nand2b_1
X_6898_ _6898_/Y _7489_/Q _7462_/Q VPWR VGND sg13cmos5l_nand2_1
Xclkbuf_leaf_33_clk clkload9/A clkbuf_leaf_5_clk/A VPWR VGND sg13cmos5l_buf_8
X_5849_ _5849_/Y _6183_/B _6659_/A VPWR VGND sg13cmos5l_nand2b_1
XFILLER_21_140 VPWR VGND sg13cmos5l_decap_4
XFILLER_21_162 VPWR VGND sg13cmos5l_fill_1
XFILLER_6_818 VPWR VGND sg13cmos5l_fill_2
X_7519_ _7519_/Q _7555_/CLK _7519_/D _7519_/RESET_B VPWR VGND sg13cmos5l_dfrbpq_1
X_7360__354 _7360_/RESET_B VPWR VGND sg13cmos5l_tiehi
Xhold870 _7359_/D _6388_/Y VPWR VGND sg13cmos5l_dlygate4sd3_1
Xhold881 hold881/X _7448_/Q VPWR VGND sg13cmos5l_dlygate4sd3_1
Xhold892 _7299_/D _5985_/Y VPWR VGND sg13cmos5l_dlygate4sd3_1
XFILLER_49_549 VPWR VGND sg13cmos5l_fill_1
XFILLER_17_402 VPWR VGND sg13cmos5l_fill_2
Xclkbuf_leaf_24_clk _7634_/CLK clkload3/A VPWR VGND sg13cmos5l_buf_8
XFILLER_40_460 VPWR VGND sg13cmos5l_fill_1
XFILLER_8_111 VPWR VGND sg13cmos5l_fill_2
XFILLER_34_1027 VPWR VGND sg13cmos5l_fill_2
XFILLER_40_482 VPWR VGND sg13cmos5l_decap_8
XFILLER_5_840 VPWR VGND sg13cmos5l_fill_1
XFILLER_4_361 VPWR VGND sg13cmos5l_decap_4
X_4180_ _4203_/A _7518_/Q _4190_/B _4194_/A VPWR VGND sg13cmos5l_a21o_1
XFILLER_36_711 VPWR VGND sg13cmos5l_decap_4
X_7337__378 _7337_/RESET_B VPWR VGND sg13cmos5l_tiehi
XFILLER_35_210 VPWR VGND sg13cmos5l_fill_1
X_6821_ _6821_/Y _7446_/Q _6826_/A2 _6659_/A VPWR VGND sg13cmos5l_o21ai_1
XFILLER_23_427 VPWR VGND sg13cmos5l_fill_1
X_3964_ _4296_/B _7502_/Q VPWR VGND sg13cmos5l_inv_1
X_6752_ _6753_/B _7425_/Q _7405_/Q _7404_/Q VPWR VGND sg13cmos5l_nor3_1
Xclkbuf_leaf_15_clk _7555_/CLK clkload4/A VPWR VGND sg13cmos5l_buf_8
X_6683_ _6683_/Y _6590_/B _6616_/Y _6682_/Y VPWR VGND sg13cmos5l_a21oi_1
X_5703_ _5704_/C _5703_/A _5703_/B VPWR VGND sg13cmos5l_nor2_1
X_3895_ _3895_/Y _3895_/A VPWR VGND sg13cmos5l_inv_1
XFILLER_32_994 VPWR VGND sg13cmos5l_fill_2
X_5634_ _5654_/B _7275_/Q _7274_/Q _5672_/A VPWR VGND sg13cmos5l_nor3_1
X_5565_ _5565_/Y _5565_/A _5454_/B VPWR VGND sg13cmos5l_nor2b_1
X_7304_ _7304_/Q _7332_/CLK _7304_/D _7304_/RESET_B VPWR VGND sg13cmos5l_dfrbpq_1
X_4516_ _7571_/D _4516_/A _4516_/B VPWR VGND sg13cmos5l_nor2_1
X_5496_ _7211_/D _5560_/B _5565_/A VPWR VGND sg13cmos5l_nor2_1
X_4447_ _4447_/Y _4449_/A _4445_/Y _4446_/Y VPWR VGND sg13cmos5l_a21oi_1
X_7235_ _7235_/Q _7272_/CLK _7235_/D _7235_/RESET_B VPWR VGND sg13cmos5l_dfrbpq_1
X_7166_ _7166_/Q _7200_/CLK _7166_/D _7166_/RESET_B VPWR VGND sg13cmos5l_dfrbpq_1
X_4378_ _4378_/Y _7554_/Q _4402_/B _4387_/A VPWR VGND sg13cmos5l_o21ai_1
X_6117_ _6117_/Y _6117_/A _6117_/B VPWR VGND sg13cmos5l_nand2_1
X_7097_ _7098_/S _4323_/Y _7075_/Y _7096_/Y VPWR VGND sg13cmos5l_a21o_1
XFILLER_39_560 VPWR VGND sg13cmos5l_fill_2
X_6048_ _6049_/A _6052_/A _6048_/B _6048_/C VPWR VGND sg13cmos5l_nor3_1
XFILLER_2_1025 VPWR VGND sg13cmos5l_decap_4
XFILLER_42_714 VPWR VGND sg13cmos5l_fill_2
XFILLER_42_736 VPWR VGND sg13cmos5l_fill_1
XFILLER_10_655 VPWR VGND sg13cmos5l_fill_2
XFILLER_2_865 VPWR VGND sg13cmos5l_decap_4
XFILLER_49_302 VPWR VGND sg13cmos5l_fill_1
XFILLER_18_744 VPWR VGND sg13cmos5l_fill_1
XFILLER_45_574 VPWR VGND sg13cmos5l_decap_8
XFILLER_33_714 VPWR VGND sg13cmos5l_fill_1
XFILLER_9_475 VPWR VGND sg13cmos5l_decap_4
X_5350_ _5350_/Y _7188_/Q _7154_/Q VPWR VGND sg13cmos5l_nand2_1
X_5281_ _5281_/Y _5559_/A _7144_/Q _7143_/Q _3945_/Y _5280_/Y VPWR VGND sg13cmos5l_a221oi_1
X_4301_ _4301_/Y _7506_/Q _4572_/A _3963_/Y _7505_/Q _4300_/Y VPWR VGND sg13cmos5l_a221oi_1
X_4232_ _4232_/Y _4258_/A _4230_/Y _4231_/Y _4571_/A VPWR VGND sg13cmos5l_a22oi_1
X_7020_ _7055_/B _7018_/Y _7019_/Y _7017_/Y VPWR VGND sg13cmos5l_a21oi_1
Xclkbuf_leaf_4_clk _7510_/CLK clkload2/A VPWR VGND sg13cmos5l_buf_8
X_4163_ _4163_/Y _4102_/A _4102_/B _4113_/B _4113_/A _4110_/A VPWR VGND sg13cmos5l_a221oi_1
X_4094_ _4120_/A _7090_/A _4095_/B VPWR VGND sg13cmos5l_and2_1
XFILLER_24_714 VPWR VGND sg13cmos5l_fill_2
X_4996_ _7134_/D _5038_/A _5161_/A VPWR VGND sg13cmos5l_nor2_1
XFILLER_12_909 VPWR VGND sg13cmos5l_decap_4
X_6804_ _6804_/Y _6804_/A VPWR VGND sg13cmos5l_inv_1
X_6735_ _6837_/C _6735_/A0 _6734_/Y _6738_/S VPWR VGND sg13cmos5l_mux2_1
X_3947_ _5334_/A _3947_/A VPWR VGND sg13cmos5l_inv_1
XFILLER_11_419 VPWR VGND sg13cmos5l_fill_1
XFILLER_32_791 VPWR VGND sg13cmos5l_decap_8
X_3878_ _3878_/Y _3878_/A VPWR VGND sg13cmos5l_inv_1
X_6666_ _6666_/Y _7415_/Q _7388_/Q VPWR VGND sg13cmos5l_xnor2_1
XFILLER_31_290 VPWR VGND sg13cmos5l_decap_8
X_6597_ _6597_/Y _7395_/Q _7376_/Q VPWR VGND sg13cmos5l_nor2_1
X_5617_ _5617_/Y _5617_/A VPWR VGND sg13cmos5l_inv_1
X_5548_ _5548_/Y hold915/X _5551_/A2 _5328_/A VPWR VGND sg13cmos5l_o21ai_1
X_5479_ _5479_/Y _5483_/A _5501_/A _5497_/A _5221_/A VPWR VGND sg13cmos5l_a22oi_1
X_7218_ _7218_/Q _7277_/CLK _7218_/D _7218_/RESET_B VPWR VGND sg13cmos5l_dfrbpq_1
X_7149_ _7149_/Q _7611_/CLK _7149_/D _7149_/RESET_B VPWR VGND sg13cmos5l_dfrbpq_1
XFILLER_14_224 VPWR VGND sg13cmos5l_fill_2
XFILLER_14_246 VPWR VGND sg13cmos5l_decap_8
XFILLER_11_920 VPWR VGND sg13cmos5l_fill_1
XFILLER_11_931 VPWR VGND sg13cmos5l_fill_2
Xfanout72 _6331_/A _6328_/A VPWR VGND sg13cmos5l_buf_1
Xfanout83 _5334_/B _5407_/A VPWR VGND sg13cmos5l_buf_1
Xfanout50 _5620_/B _5577_/Y VPWR VGND sg13cmos5l_buf_1
Xfanout61 _4190_/B _4207_/B VPWR VGND sg13cmos5l_buf_1
XFILLER_22_290 VPWR VGND sg13cmos5l_fill_1
Xfanout94 _4640_/B1 _4420_/Y VPWR VGND sg13cmos5l_buf_1
XFILLER_10_463 VPWR VGND sg13cmos5l_fill_2
XFILLER_18_541 VPWR VGND sg13cmos5l_fill_1
Xclkbuf_3_7__f_clk clkload5/A clkbuf_0_clk/X VPWR VGND sg13cmos5l_buf_8
XFILLER_45_371 VPWR VGND sg13cmos5l_fill_2
X_4850_ _4850_/Y _4850_/A _4850_/B _4850_/C VPWR VGND sg13cmos5l_nor3_1
XFILLER_14_791 VPWR VGND sg13cmos5l_fill_1
X_4781_ _7622_/D _5096_/A _4781_/B VPWR VGND sg13cmos5l_and2_1
X_6520_ _6520_/Y _7385_/Q _7362_/Q VPWR VGND sg13cmos5l_xnor2_1
X_6451_ _6451_/Y _6451_/A _6451_/B VPWR VGND sg13cmos5l_nand2_1
XFILLER_9_283 VPWR VGND sg13cmos5l_fill_1
XFILLER_9_272 VPWR VGND sg13cmos5l_decap_8
Xclkload20 clkload20/Y _7513_/CLK VPWR VGND sg13cmos5l_inv_1
X_6382_ _6382_/Y _6376_/B _6379_/Y _6396_/B VPWR VGND sg13cmos5l_o21ai_1
X_5402_ _5404_/B _5406_/B _5406_/C _5349_/Y VPWR VGND sg13cmos5l_a21oi_1
X_5333_ _7196_/D _5333_/A _5334_/B VPWR VGND sg13cmos5l_nor2_1
XFILLER_47_1026 VPWR VGND sg13cmos5l_fill_2
X_5264_ _5348_/A _4973_/X _5260_/Y _5262_/X _5263_/Y VPWR VGND sg13cmos5l_a22oi_1
X_4215_ _7522_/D _4215_/A _4215_/B VPWR VGND sg13cmos5l_nor2_1
X_5195_ _5485_/A _5561_/A _5195_/B VPWR VGND sg13cmos5l_xnor2_1
X_7003_ _7484_/D _7003_/A _7006_/B VPWR VGND sg13cmos5l_and2_1
X_4146_ _4146_/X _4146_/A _4146_/B VPWR VGND sg13cmos5l_and2_1
XFILLER_43_308 VPWR VGND sg13cmos5l_decap_8
X_4077_ _4078_/D _7414_/Q _7445_/Q _7477_/Q _7509_/Q VPWR VGND sg13cmos5l_or4_1
XFILLER_43_319 VPWR VGND sg13cmos5l_fill_1
X_4979_ _4979_/Y _7148_/Q _5326_/A VPWR VGND sg13cmos5l_nand2b_1
X_6718_ _6724_/C _7431_/Q _7430_/Q _6718_/B1 VPWR VGND sg13cmos5l_o21ai_1
Xclkload3 clkload3/X clkload3/A VPWR VGND sg13cmos5l_buf_8
X_6649_ _6649_/Y _6789_/A _6649_/B VPWR VGND sg13cmos5l_nand2_1
XFILLER_19_305 VPWR VGND sg13cmos5l_decap_8
XFILLER_47_625 VPWR VGND sg13cmos5l_decap_4
XFILLER_7_721 VPWR VGND sg13cmos5l_fill_1
XFILLER_11_783 VPWR VGND sg13cmos5l_fill_2
XFILLER_3_993 VPWR VGND sg13cmos5l_decap_8
X_4000_ _4771_/A _7616_/Q VPWR VGND sg13cmos5l_inv_1
XFILLER_27_4 VPWR VGND sg13cmos5l_fill_1
X_5951_ _5951_/Y _7258_/Q _5951_/B VPWR VGND sg13cmos5l_nor2_1
XFILLER_19_872 VPWR VGND sg13cmos5l_decap_8
X_4902_ _4902_/Y _4885_/X hold918/X _4031_/A VPWR VGND sg13cmos5l_o21ai_1
XFILLER_34_842 VPWR VGND sg13cmos5l_fill_1
X_5882_ _5883_/B _5863_/A _5881_/Y _5888_/S VPWR VGND sg13cmos5l_mux2_1
X_7621_ _7621_/Q _7622_/CLK _7621_/D _7621_/RESET_B VPWR VGND sg13cmos5l_dfrbpq_1
X_4833_ _4833_/Y _4840_/A _4840_/B _4829_/A _4829_/B VPWR VGND sg13cmos5l_a22oi_1
XFILLER_33_396 VPWR VGND sg13cmos5l_fill_1
X_4764_ _7611_/D _4768_/A _4764_/B VPWR VGND sg13cmos5l_nor2_1
X_7552_ _7552_/Q _7617_/CLK _7552_/D _7552_/RESET_B VPWR VGND sg13cmos5l_dfrbpq_1
XFILLER_14_1025 VPWR VGND sg13cmos5l_decap_4
X_7483_ _7483_/Q _7513_/CLK _7483_/D _7483_/RESET_B VPWR VGND sg13cmos5l_dfrbpq_1
X_6503_ _6503_/Y _7387_/Q _6504_/A2 _6506_/A VPWR VGND sg13cmos5l_o21ai_1
X_6434_ _6610_/B _6434_/A _6435_/B VPWR VGND sg13cmos5l_nor2_1
X_4695_ _4696_/A _4663_/X _4682_/B _4694_/Y VPWR VGND sg13cmos5l_a21oi_1
XFILLER_20_17 VPWR VGND sg13cmos5l_decap_8
X_6365_ _6365_/Y _7117_/Q _6508_/A VPWR VGND sg13cmos5l_nor2_1
X_5316_ _7182_/D _5334_/B _5316_/B VPWR VGND sg13cmos5l_nor2_1
X_6296_ _6297_/B _6222_/A _6302_/B _6289_/Y _6295_/A _6293_/Y VPWR VGND sg13cmos5l_a221oi_1
X_5247_ _5257_/B _7140_/Q _5251_/C VPWR VGND sg13cmos5l_xnor2_1
XFILLER_29_48 VPWR VGND sg13cmos5l_fill_2
X_5178_ _7165_/D _5163_/A _5162_/Y _5177_/A VPWR VGND sg13cmos5l_a21oi_1
XFILLER_21_1018 VPWR VGND sg13cmos5l_decap_8
X_4129_ _4155_/B _7471_/Q _4129_/B VPWR VGND sg13cmos5l_xor2_1
XFILLER_43_116 VPWR VGND sg13cmos5l_fill_1
XFILLER_4_768 VPWR VGND sg13cmos5l_fill_1
XFILLER_0_963 VPWR VGND sg13cmos5l_decap_8
XFILLER_48_989 VPWR VGND sg13cmos5l_decap_8
XFILLER_47_455 VPWR VGND sg13cmos5l_fill_1
XFILLER_15_396 VPWR VGND sg13cmos5l_fill_1
X_4480_ _4513_/A _7535_/Q _4482_/A VPWR VGND sg13cmos5l_xor2_1
X_6150_ _6150_/Y _7295_/Q _6150_/B _6159_/B VPWR VGND sg13cmos5l_nor3_1
XFILLER_3_790 VPWR VGND sg13cmos5l_fill_2
X_5101_ _7159_/D _5101_/A _5102_/B VPWR VGND sg13cmos5l_nor2_1
XFILLER_32_2 VPWR VGND sg13cmos5l_fill_1
X_6081_ _6081_/Y _6081_/A _6081_/B _6081_/C VPWR VGND sg13cmos5l_nand3_1
Xhold1207 _4830_/A _7624_/Q VPWR VGND sg13cmos5l_dlygate4sd3_1
XFILLER_39_945 VPWR VGND sg13cmos5l_fill_2
Xhold1229 _4399_/B _4398_/Y VPWR VGND sg13cmos5l_dlygate4sd3_1
X_5032_ _7137_/D _5038_/A _5032_/B VPWR VGND sg13cmos5l_nor2_1
Xheichips26_dna_sequencer_145 uio_out[6] VPWR VGND sg13cmos5l_tielo
Xhold1218 _4402_/A _7551_/Q VPWR VGND sg13cmos5l_dlygate4sd3_1
X_6983_ _6983_/Y _6989_/A _6983_/B VPWR VGND sg13cmos5l_nor2_1
XFILLER_15_28 VPWR VGND sg13cmos5l_fill_2
X_5934_ _6046_/B _5915_/B _5930_/B _5684_/Y VPWR VGND sg13cmos5l_o21ai_1
X_5865_ _5865_/Y _6191_/A _5863_/X _5864_/Y _5862_/X VPWR VGND sg13cmos5l_a22oi_1
X_7604_ _7604_/Q _7610_/CLK _7604_/D _7604_/RESET_B VPWR VGND sg13cmos5l_dfrbpq_1
X_4816_ _4845_/A _4844_/B _4844_/C _4844_/A VPWR VGND sg13cmos5l_a21oi_1
X_5796_ _5832_/B _7269_/Q _5823_/B VPWR VGND sg13cmos5l_nand2_1
X_7535_ _7535_/Q _7560_/CLK _7535_/D _7535_/RESET_B VPWR VGND sg13cmos5l_dfrbpq_1
X_4747_ _4748_/C _4739_/A _4745_/X _4746_/Y VPWR VGND sg13cmos5l_a21oi_1
X_7466_ _7466_/Q _7489_/CLK _7466_/D _7466_/RESET_B VPWR VGND sg13cmos5l_dfrbpq_1
X_4678_ _4784_/B _6711_/A _5087_/B VPWR VGND sg13cmos5l_nor2_1
X_6417_ _6417_/Y _6411_/C _6424_/A _6410_/X VPWR VGND sg13cmos5l_o21ai_1
X_7397_ _7397_/Q _7424_/CLK _7397_/D _7397_/RESET_B VPWR VGND sg13cmos5l_dfrbpq_1
X_6348_ _6348_/X _6348_/A _6355_/B VPWR VGND sg13cmos5l_and2_1
Xoutput16 uo_out[3] _7325_/Q VPWR VGND sg13cmos5l_buf_1
X_6279_ _6279_/Y _6279_/A _6279_/B VPWR VGND sg13cmos5l_nand2_1
XFILLER_48_219 VPWR VGND sg13cmos5l_fill_2
XFILLER_5_1001 VPWR VGND sg13cmos5l_decap_8
XFILLER_45_948 VPWR VGND sg13cmos5l_decap_8
XFILLER_13_823 VPWR VGND sg13cmos5l_fill_1
XFILLER_12_333 VPWR VGND sg13cmos5l_decap_8
XFILLER_24_193 VPWR VGND sg13cmos5l_fill_1
XFILLER_8_315 VPWR VGND sg13cmos5l_fill_2
XFILLER_12_399 VPWR VGND sg13cmos5l_decap_4
XFILLER_48_764 VPWR VGND sg13cmos5l_fill_1
XFILLER_48_731 VPWR VGND sg13cmos5l_fill_2
XFILLER_47_230 VPWR VGND sg13cmos5l_fill_2
XFILLER_44_970 VPWR VGND sg13cmos5l_decap_8
X_3980_ _6983_/B _3980_/A VPWR VGND sg13cmos5l_inv_1
XFILLER_35_469 VPWR VGND sg13cmos5l_fill_1
X_5650_ _5681_/A _7244_/Q _5650_/B VPWR VGND sg13cmos5l_xor2_1
Xclkbuf_0_clk clkbuf_0_clk/X clk VPWR VGND sg13cmos5l_buf_8
XFILLER_31_642 VPWR VGND sg13cmos5l_fill_1
X_4601_ _4601_/X _7591_/Q _4616_/B _4600_/Y VPWR VGND sg13cmos5l_a21o_1
X_5581_ _5615_/B _5581_/A _5620_/B VPWR VGND sg13cmos5l_nand2_1
X_7320_ _7320_/Q _7344_/CLK _7320_/D _7320_/RESET_B VPWR VGND sg13cmos5l_dfrbpq_1
X_4532_ _4532_/Y _4532_/A _4532_/B VPWR VGND sg13cmos5l_nand2_1
X_4463_ _4465_/B _4577_/A _4577_/B VPWR VGND sg13cmos5l_nand2_1
X_7251_ _7251_/Q _7307_/CLK _7251_/D _7251_/RESET_B VPWR VGND sg13cmos5l_dfrbpq_1
X_6202_ _6222_/A _6202_/A VPWR VGND sg13cmos5l_inv_1
X_4394_ _4394_/Y _4394_/A _4400_/S VPWR VGND sg13cmos5l_nor2_1
X_7182_ _7182_/Q _7239_/CLK _7182_/D _7182_/RESET_B VPWR VGND sg13cmos5l_dfrbpq_1
X_6133_ _6133_/Y _7292_/Q _6140_/A _6130_/Y _6131_/Y _6132_/Y VPWR VGND sg13cmos5l_a221oi_1
X_6064_ _6064_/Y _6050_/B _6054_/Y _5990_/B VPWR VGND sg13cmos5l_o21ai_1
Xhold1015 _7441_/D _6815_/Y VPWR VGND sg13cmos5l_dlygate4sd3_1
Xhold1004 _6630_/A1 _6496_/Y VPWR VGND sg13cmos5l_dlygate4sd3_1
Xhold1026 _6169_/B _6168_/X VPWR VGND sg13cmos5l_dlygate4sd3_1
X_5015_ _5028_/B _7610_/Q _5016_/B VPWR VGND sg13cmos5l_xnor2_1
Xhold1048 _5143_/B _5142_/X VPWR VGND sg13cmos5l_dlygate4sd3_1
Xhold1037 _5773_/A _7235_/Q VPWR VGND sg13cmos5l_dlygate4sd3_1
XFILLER_39_775 VPWR VGND sg13cmos5l_decap_8
Xhold1059 _6493_/B _6492_/X VPWR VGND sg13cmos5l_dlygate4sd3_1
XFILLER_27_904 VPWR VGND sg13cmos5l_fill_1
X_7353__362 _7353_/RESET_B VPWR VGND sg13cmos5l_tiehi
X_6966_ _6974_/B _6810_/Y _6970_/B _6971_/C _6965_/Y VPWR VGND sg13cmos5l_a22oi_1
X_5917_ _5917_/X _5917_/A _5917_/B VPWR VGND sg13cmos5l_or2_1
X_7648__350 _7648_/RESET_B VPWR VGND sg13cmos5l_tiehi
XFILLER_35_992 VPWR VGND sg13cmos5l_fill_2
X_6897_ _6897_/Y _6905_/B _6896_/Y VPWR VGND sg13cmos5l_nor2b_1
XFILLER_42_37 VPWR VGND sg13cmos5l_fill_1
X_5848_ _5990_/B _6554_/A _6183_/B VPWR VGND sg13cmos5l_nor2_1
X_5779_ _5779_/Y _5675_/B _5781_/A VPWR VGND sg13cmos5l_nand2b_1
X_7518_ _7518_/Q _7553_/CLK _7518_/D _7518_/RESET_B VPWR VGND sg13cmos5l_dfrbpq_1
X_7449_ _7449_/Q _7510_/CLK _7449_/D _7449_/RESET_B VPWR VGND sg13cmos5l_dfrbpq_1
Xhold860 _5990_/A _7273_/Q VPWR VGND sg13cmos5l_dlygate4sd3_1
Xhold871 _5979_/B _7259_/Q VPWR VGND sg13cmos5l_dlygate4sd3_1
Xhold882 _3862_/A _7511_/Q VPWR VGND sg13cmos5l_dlygate4sd3_1
Xhold893 _4088_/A _7492_/Q VPWR VGND sg13cmos5l_dlygate4sd3_1
XFILLER_49_528 VPWR VGND sg13cmos5l_fill_2
XFILLER_17_425 VPWR VGND sg13cmos5l_fill_1
XFILLER_45_778 VPWR VGND sg13cmos5l_fill_2
XFILLER_44_244 VPWR VGND sg13cmos5l_decap_8
XFILLER_44_299 VPWR VGND sg13cmos5l_fill_2
XFILLER_12_130 VPWR VGND sg13cmos5l_fill_2
XFILLER_13_675 VPWR VGND sg13cmos5l_fill_1
XFILLER_13_697 VPWR VGND sg13cmos5l_fill_1
XFILLER_8_167 VPWR VGND sg13cmos5l_decap_4
X_6820_ _7445_/D _7002_/A _6820_/B VPWR VGND sg13cmos5l_and2_1
XFILLER_35_288 VPWR VGND sg13cmos5l_fill_1
X_6751_ _6757_/A _6751_/A _6751_/B _6751_/C VPWR VGND sg13cmos5l_nand3_1
X_3963_ _3963_/Y _4571_/A VPWR VGND sg13cmos5l_inv_1
X_6682_ _6682_/Y _6682_/A _6691_/A VPWR VGND sg13cmos5l_nor2_1
X_5702_ _5704_/B _5702_/A _5702_/B VPWR VGND sg13cmos5l_nor2_1
X_3894_ _3894_/Y _3894_/A VPWR VGND sg13cmos5l_inv_1
X_5633_ _7239_/D _5621_/A _5617_/Y _5560_/B VPWR VGND sg13cmos5l_a21oi_1
X_5564_ _5564_/Y _5564_/A _5449_/A VPWR VGND sg13cmos5l_nor2b_1
X_4515_ _4515_/X _4508_/A _4513_/X _4512_/X VPWR VGND sg13cmos5l_a21o_1
X_7303_ _7303_/Q _7332_/CLK _7303_/D _7303_/RESET_B VPWR VGND sg13cmos5l_dfrbpq_1
X_5495_ _5565_/A _5217_/Y _5488_/X _5490_/Y _5494_/Y VPWR VGND sg13cmos5l_a22oi_1
X_7234_ _7234_/Q _7239_/CLK _7234_/D _7234_/RESET_B VPWR VGND sg13cmos5l_dfrbpq_1
X_4446_ _4446_/Y _4714_/A _4446_/B VPWR VGND sg13cmos5l_nor2_1
X_4377_ _4387_/A _7553_/Q _4402_/B _4392_/A VPWR VGND sg13cmos5l_a21o_1
X_7165_ _7165_/Q _7610_/CLK _7165_/D _7165_/RESET_B VPWR VGND sg13cmos5l_dfrbpq_1
X_6116_ _6268_/B _6117_/A _6117_/B VPWR VGND sg13cmos5l_and2_1
X_7096_ _7096_/Y _7508_/Q _7096_/B _7096_/C VPWR VGND sg13cmos5l_nor3_1
XFILLER_2_1004 VPWR VGND sg13cmos5l_decap_8
X_6047_ _6048_/C _6047_/A _6047_/B _6047_/C VPWR VGND sg13cmos5l_and3_1
X_7353__170 _7353_/D VPWR VGND sg13cmos5l_tielo
XFILLER_26_266 VPWR VGND sg13cmos5l_fill_1
XFILLER_27_789 VPWR VGND sg13cmos5l_fill_2
X_6949_ _7034_/A _6942_/Y _6948_/Y _6947_/Y VPWR VGND sg13cmos5l_o21ai_1
XFILLER_22_472 VPWR VGND sg13cmos5l_decap_4
XFILLER_5_104 VPWR VGND sg13cmos5l_fill_1
XFILLER_2_833 VPWR VGND sg13cmos5l_fill_2
XFILLER_2_822 VPWR VGND sg13cmos5l_fill_1
X_7178__191 _7178_/D VPWR VGND sg13cmos5l_tielo
XFILLER_17_266 VPWR VGND sg13cmos5l_fill_2
XFILLER_17_288 VPWR VGND sg13cmos5l_decap_8
XFILLER_33_737 VPWR VGND sg13cmos5l_fill_1
XFILLER_41_770 VPWR VGND sg13cmos5l_fill_2
XFILLER_14_973 VPWR VGND sg13cmos5l_fill_1
XFILLER_32_258 VPWR VGND sg13cmos5l_fill_1
XFILLER_9_454 VPWR VGND sg13cmos5l_fill_2
XFILLER_5_682 VPWR VGND sg13cmos5l_decap_8
X_5280_ _5280_/Y _7199_/Q _5290_/B _5286_/B _7198_/Q VPWR VGND sg13cmos5l_a22oi_1
X_7343__372 _7343_/RESET_B VPWR VGND sg13cmos5l_tiehi
X_4300_ _4300_/Y _3866_/Y _4571_/A _7556_/Q _3867_/Y VPWR VGND sg13cmos5l_a22oi_1
X_4231_ _4231_/Y _7527_/Q _7526_/Q _7556_/Q VPWR VGND sg13cmos5l_nand3b_1
X_4162_ _7073_/B _4146_/A _4159_/X _4161_/Y _4147_/Y VPWR VGND sg13cmos5l_a22oi_1
X_4093_ _4095_/B _7523_/Q _7083_/B _7524_/Q VPWR VGND sg13cmos5l_nor3_1
XFILLER_36_520 VPWR VGND sg13cmos5l_fill_2
XFILLER_23_203 VPWR VGND sg13cmos5l_fill_1
X_7350__365 _7350_/RESET_B VPWR VGND sg13cmos5l_tiehi
X_4995_ _5161_/A _5257_/A _4993_/B _4994_/Y VPWR VGND sg13cmos5l_a21oi_1
X_6803_ _6803_/Y _4021_/A _6801_/Y _6802_/Y VPWR VGND sg13cmos5l_o21ai_1
X_6734_ _6734_/Y _7003_/A _6941_/A VPWR VGND sg13cmos5l_nand2_1
X_3946_ _5559_/A _3946_/A VPWR VGND sg13cmos5l_inv_1
X_3877_ _3877_/Y _3877_/A VPWR VGND sg13cmos5l_inv_1
X_6665_ _6665_/Y _7417_/Q _7390_/Q VPWR VGND sg13cmos5l_nand2_1
X_6596_ _6596_/Y _6596_/A _6596_/B VPWR VGND sg13cmos5l_xnor2_1
X_5616_ _5621_/B _5616_/A _5616_/B _5616_/C VPWR VGND sg13cmos5l_nor3_1
X_5547_ _7222_/D _6827_/A _5547_/B VPWR VGND sg13cmos5l_and2_1
X_5478_ _5478_/X _5475_/X _5477_/Y _5473_/Y VPWR VGND sg13cmos5l_a21o_1
XFILLER_2_107 VPWR VGND sg13cmos5l_fill_2
X_4429_ _4430_/B _7562_/Q _7563_/Q _7564_/Q VPWR VGND sg13cmos5l_o21ai_1
X_7217_ _7217_/Q _7277_/CLK _7217_/D _7217_/RESET_B VPWR VGND sg13cmos5l_dfrbpq_1
X_7148_ _7148_/Q _7630_/CLK _7148_/D _7148_/RESET_B VPWR VGND sg13cmos5l_dfrbpq_1
X_7079_ _7079_/Y _7090_/A _6969_/A _7078_/Y VPWR VGND sg13cmos5l_a21oi_1
X_7450__710 _7450_/RESET_B VPWR VGND sg13cmos5l_tiehi
Xfanout40 _6122_/B _6102_/Y VPWR VGND sg13cmos5l_buf_1
Xfanout62 _4160_/A _4124_/Y VPWR VGND sg13cmos5l_buf_1
XFILLER_10_420 VPWR VGND sg13cmos5l_decap_8
Xfanout73 _6325_/A _6328_/A VPWR VGND sg13cmos5l_buf_1
Xfanout51 _5602_/B _5577_/Y VPWR VGND sg13cmos5l_buf_1
XFILLER_7_925 VPWR VGND sg13cmos5l_fill_1
Xfanout84 _5038_/A _5102_/B VPWR VGND sg13cmos5l_buf_1
XFILLER_11_954 VPWR VGND sg13cmos5l_fill_1
Xfanout95 _4337_/A _4358_/B VPWR VGND sg13cmos5l_buf_1
XFILLER_1_140 VPWR VGND sg13cmos5l_fill_1
X_7121__628 _7121_/RESET_B VPWR VGND sg13cmos5l_tiehi
XFILLER_38_80 VPWR VGND sg13cmos5l_fill_2
XFILLER_46_873 VPWR VGND sg13cmos5l_fill_1
X_4780_ _7621_/D _5328_/A _4780_/B VPWR VGND sg13cmos5l_and2_1
X_6450_ _7373_/D _6511_/B _6514_/A VPWR VGND sg13cmos5l_nor2_1
Xclkload10 clkload10/Y _7307_/CLK VPWR VGND sg13cmos5l_inv_1
X_6381_ _6381_/Y _6481_/B _6379_/Y _6380_/Y VPWR VGND sg13cmos5l_a21oi_1
X_5401_ _5401_/Y _5406_/B _5406_/C VPWR VGND sg13cmos5l_nand2_1
Xclkload21 clkload21/X _7553_/CLK VPWR VGND sg13cmos5l_buf_8
XFILLER_6_991 VPWR VGND sg13cmos5l_decap_8
X_5332_ _5332_/X _5332_/A _5332_/B VPWR VGND sg13cmos5l_and2_1
XFILLER_47_1005 VPWR VGND sg13cmos5l_decap_8
XFILLER_48_0 VPWR VGND sg13cmos5l_decap_8
X_5263_ _5263_/Y _5263_/A _5274_/B VPWR VGND sg13cmos5l_nor2_1
X_4214_ _4215_/B _4188_/X _4209_/Y _7072_/A VPWR VGND sg13cmos5l_o21ai_1
X_5194_ _5203_/B _5561_/A _5195_/B VPWR VGND sg13cmos5l_and2_1
X_7002_ _7483_/D _7002_/A _7017_/B VPWR VGND sg13cmos5l_and2_1
X_4145_ _4145_/Y _4146_/B VPWR VGND sg13cmos5l_inv_1
X_4076_ _4079_/B _7120_/Q _7148_/Q _7185_/Q _7222_/Q VPWR VGND sg13cmos5l_nor4_1
XFILLER_37_873 VPWR VGND sg13cmos5l_decap_8
X_4978_ _5175_/A _6711_/A _5319_/B VPWR VGND sg13cmos5l_nor2_1
X_6717_ _6927_/A _7459_/Q _7004_/A VPWR VGND sg13cmos5l_xnor2_1
X_3929_ _6193_/A _3929_/A VPWR VGND sg13cmos5l_inv_1
Xclkload4 clkload4/X clkload4/A VPWR VGND sg13cmos5l_buf_8
X_6648_ _7411_/D _6631_/Y _6642_/Y _6647_/Y VPWR VGND sg13cmos5l_a21oi_1
X_6579_ _6588_/S _6573_/Y _6577_/Y _6578_/Y VPWR VGND sg13cmos5l_o21ai_1
XFILLER_4_928 VPWR VGND sg13cmos5l_decap_8
XFILLER_8_1021 VPWR VGND sg13cmos5l_decap_8
XFILLER_46_114 VPWR VGND sg13cmos5l_decap_4
XFILLER_28_884 VPWR VGND sg13cmos5l_fill_1
XFILLER_43_843 VPWR VGND sg13cmos5l_fill_2
XFILLER_43_832 VPWR VGND sg13cmos5l_decap_8
XFILLER_42_342 VPWR VGND sg13cmos5l_decap_8
X_7333__382 _7333_/RESET_B VPWR VGND sg13cmos5l_tiehi
XFILLER_42_375 VPWR VGND sg13cmos5l_decap_4
XFILLER_30_526 VPWR VGND sg13cmos5l_fill_2
XFILLER_11_762 VPWR VGND sg13cmos5l_fill_1
XFILLER_10_272 VPWR VGND sg13cmos5l_decap_8
XFILLER_41_7 VPWR VGND sg13cmos5l_fill_2
XFILLER_3_972 VPWR VGND sg13cmos5l_decap_8
X_7340__375 _7340_/RESET_B VPWR VGND sg13cmos5l_tiehi
X_7236__501 _7236_/RESET_B VPWR VGND sg13cmos5l_tiehi
X_5950_ _5954_/B _7291_/Q _5950_/B VPWR VGND sg13cmos5l_or2_1
XFILLER_46_681 VPWR VGND sg13cmos5l_decap_8
X_4901_ _4901_/Y _4901_/A _4901_/B VPWR VGND sg13cmos5l_nor2_1
XFILLER_18_383 VPWR VGND sg13cmos5l_fill_2
X_5881_ _5881_/Y _5881_/A _5887_/B VPWR VGND sg13cmos5l_nand2_1
X_7620_ _7620_/Q _7622_/CLK _7620_/D _7620_/RESET_B VPWR VGND sg13cmos5l_dfrbpq_1
XFILLER_33_331 VPWR VGND sg13cmos5l_decap_4
X_4832_ _4832_/Y _4832_/A _4831_/Y VPWR VGND sg13cmos5l_nor2b_1
X_4763_ _4763_/X _4748_/C _5046_/B _4767_/S VPWR VGND sg13cmos5l_mux2_1
X_7551_ _7551_/Q _7617_/CLK _7551_/D _7551_/RESET_B VPWR VGND sg13cmos5l_dfrbpq_1
X_4694_ _4694_/Y _4694_/A _4694_/B VPWR VGND sg13cmos5l_nor2_1
X_7482_ _7482_/Q _7513_/CLK _7482_/D _7482_/RESET_B VPWR VGND sg13cmos5l_dfrbpq_1
X_6502_ _6502_/Y _3872_/Y _6504_/A2 _6501_/Y VPWR VGND sg13cmos5l_a21oi_1
X_6433_ _6613_/B _6664_/A _6451_/A VPWR VGND sg13cmos5l_nand2_1
X_6364_ _6364_/Y _7118_/Q _6509_/A VPWR VGND sg13cmos5l_nand2_1
XFILLER_0_419 VPWR VGND sg13cmos5l_decap_8
X_5315_ _5315_/X _5299_/Y _5527_/B _5315_/S VPWR VGND sg13cmos5l_mux2_1
X_6295_ _6318_/C _6295_/A _6303_/S VPWR VGND sg13cmos5l_nor2_1
X_5246_ _5256_/A _5249_/A _5274_/A _5240_/X _5244_/Y _5245_/X VPWR VGND sg13cmos5l_a221oi_1
X_5177_ _7164_/D _5177_/A _5177_/B VPWR VGND sg13cmos5l_nor2_1
XFILLER_29_626 VPWR VGND sg13cmos5l_fill_1
X_4128_ _4132_/B _4128_/A _4140_/A VPWR VGND sg13cmos5l_xor2_1
XFILLER_28_125 VPWR VGND sg13cmos5l_fill_2
X_4059_ _4060_/C _4059_/A _4872_/B _4059_/C VPWR VGND sg13cmos5l_nor3_1
XFILLER_25_810 VPWR VGND sg13cmos5l_fill_1
XFILLER_40_857 VPWR VGND sg13cmos5l_fill_2
XFILLER_8_519 VPWR VGND sg13cmos5l_decap_4
XFILLER_4_725 VPWR VGND sg13cmos5l_decap_8
XFILLER_4_758 VPWR VGND sg13cmos5l_decap_4
X_7246__184 _7246_/D VPWR VGND sg13cmos5l_tielo
XFILLER_0_942 VPWR VGND sg13cmos5l_decap_8
XFILLER_47_412 VPWR VGND sg13cmos5l_fill_2
X_7294__436 _7294_/RESET_B VPWR VGND sg13cmos5l_tiehi
XFILLER_19_114 VPWR VGND sg13cmos5l_fill_1
XFILLER_48_968 VPWR VGND sg13cmos5l_decap_8
XFILLER_28_681 VPWR VGND sg13cmos5l_fill_1
XFILLER_43_651 VPWR VGND sg13cmos5l_fill_1
XFILLER_27_191 VPWR VGND sg13cmos5l_decap_4
XFILLER_7_541 VPWR VGND sg13cmos5l_decap_8
X_6080_ _6080_/Y _6089_/D _6075_/C _6114_/A VPWR VGND sg13cmos5l_a21oi_1
X_5100_ _7158_/D _5100_/A _5102_/B VPWR VGND sg13cmos5l_nor2_1
X_5031_ _5105_/B _5035_/A _5029_/B _5027_/Y VPWR VGND sg13cmos5l_o21ai_1
Xhold1219 _4410_/A1 _4404_/B VPWR VGND sg13cmos5l_dlygate4sd3_1
XFILLER_39_913 VPWR VGND sg13cmos5l_decap_4
Xhold1208 _4852_/A1 _4831_/Y VPWR VGND sg13cmos5l_dlygate4sd3_1
XFILLER_38_434 VPWR VGND sg13cmos5l_decap_8
Xheichips26_dna_sequencer_146 uio_out[7] VPWR VGND sg13cmos5l_tielo
X_6982_ _6982_/Y _6980_/B _6968_/Y _6981_/Y _6969_/A VPWR VGND sg13cmos5l_a22oi_1
X_5933_ _7287_/D _5993_/B _5933_/B VPWR VGND sg13cmos5l_nor2_1
X_5864_ _5864_/Y _7310_/Q _7279_/Q VPWR VGND sg13cmos5l_nand2_1
X_7603_ _7603_/Q _7610_/CLK _7603_/D _7603_/RESET_B VPWR VGND sg13cmos5l_dfrbpq_1
X_4815_ _4844_/C _7627_/Q _4835_/B _4836_/A VPWR VGND sg13cmos5l_o21ai_1
X_7534_ _7534_/Q _7571_/CLK _7534_/D _7534_/RESET_B VPWR VGND sg13cmos5l_dfrbpq_1
X_5795_ _5832_/A _7270_/Q _5823_/B VPWR VGND sg13cmos5l_xnor2_1
X_4746_ _4746_/Y _7635_/Q _5097_/A _4754_/C VPWR VGND sg13cmos5l_nor3_1
X_7465_ _7465_/Q _7555_/CLK _7465_/D _7465_/RESET_B VPWR VGND sg13cmos5l_dfrbpq_1
X_4677_ _4680_/A _4672_/X _4673_/Y _4675_/Y _4676_/Y VPWR VGND sg13cmos5l_a22oi_1
X_6416_ _6416_/Y _6411_/C _6424_/A _6408_/Y VPWR VGND sg13cmos5l_a21oi_1
X_7396_ _7396_/Q _7424_/CLK _7396_/D _7396_/RESET_B VPWR VGND sg13cmos5l_dfrbpq_1
X_6347_ _6355_/B _7371_/Q _6347_/B VPWR VGND sg13cmos5l_xnor2_1
Xoutput17 uo_out[4] _7326_/Q VPWR VGND sg13cmos5l_buf_1
X_6278_ _6278_/Y _6279_/B VPWR VGND sg13cmos5l_inv_1
X_5229_ _5341_/A _5227_/Y _5228_/Y _5229_/S VPWR VGND sg13cmos5l_mux2_1
X_7319__406 _7319_/RESET_B VPWR VGND sg13cmos5l_tiehi
X_7178__565 _7178_/RESET_B VPWR VGND sg13cmos5l_tiehi
XFILLER_13_835 VPWR VGND sg13cmos5l_fill_1
XFILLER_8_338 VPWR VGND sg13cmos5l_fill_1
X_7226__511 _7226_/RESET_B VPWR VGND sg13cmos5l_tiehi
X_7185__558 _7185_/RESET_B VPWR VGND sg13cmos5l_tiehi
XFILLER_21_50 VPWR VGND sg13cmos5l_fill_1
XFILLER_4_544 VPWR VGND sg13cmos5l_decap_8
X_7439__254 _7439_/RESET_B VPWR VGND sg13cmos5l_tiehi
XFILLER_36_916 VPWR VGND sg13cmos5l_fill_1
XFILLER_47_275 VPWR VGND sg13cmos5l_fill_1
X_7233__504 _7233_/RESET_B VPWR VGND sg13cmos5l_tiehi
X_4600_ _4600_/Y _4600_/A _4616_/B VPWR VGND sg13cmos5l_nor2_1
XFILLER_30_153 VPWR VGND sg13cmos5l_fill_1
X_5580_ _5615_/A _7233_/Q _5620_/B VPWR VGND sg13cmos5l_xnor2_1
X_7446__247 _7446_/RESET_B VPWR VGND sg13cmos5l_tiehi
X_4531_ _4535_/B _7575_/Q _4531_/B VPWR VGND sg13cmos5l_nor2_1
X_4462_ _4577_/B _4436_/Y _4462_/B _4462_/C VPWR VGND sg13cmos5l_nand3b_1
XFILLER_7_393 VPWR VGND sg13cmos5l_decap_8
X_7250_ _7250_/Q _7307_/CLK _7250_/D _7250_/RESET_B VPWR VGND sg13cmos5l_dfrbpq_1
X_6201_ _6202_/A _6201_/A _6215_/B VPWR VGND sg13cmos5l_xnor2_1
X_4393_ _4393_/Y _4396_/A VPWR VGND sg13cmos5l_inv_1
X_7181_ _7181_/Q _7239_/CLK _7181_/D _7181_/RESET_B VPWR VGND sg13cmos5l_dfrbpq_1
X_6132_ _6132_/Y _7340_/Q _7291_/Q VPWR VGND sg13cmos5l_nor2b_1
X_6063_ _7311_/D _6063_/A _6063_/B VPWR VGND sg13cmos5l_nor2_1
Xhold1005 _7382_/D _6497_/Y VPWR VGND sg13cmos5l_dlygate4sd3_1
Xhold1027 _4015_/A _7555_/Q VPWR VGND sg13cmos5l_dlygate4sd3_1
XFILLER_39_743 VPWR VGND sg13cmos5l_fill_2
Xhold1016 _6789_/B _7409_/Q VPWR VGND sg13cmos5l_dlygate4sd3_1
Xhold1038 _5557_/A _7198_/Q VPWR VGND sg13cmos5l_dlygate4sd3_1
Xhold1049 _5172_/A1 _5144_/A VPWR VGND sg13cmos5l_dlygate4sd3_1
X_5014_ _5020_/A _5013_/A _5014_/B VPWR VGND sg13cmos5l_nand2b_1
XFILLER_39_787 VPWR VGND sg13cmos5l_fill_2
X_6965_ _6965_/Y _6976_/A _4154_/A VPWR VGND sg13cmos5l_nor2b_1
X_5916_ _5917_/B _5684_/A _5930_/B _5915_/X VPWR VGND sg13cmos5l_a21o_1
X_6896_ _6896_/Y _7463_/Q _7462_/Q _7464_/Q VPWR VGND sg13cmos5l_o21ai_1
X_5847_ _7276_/D _5847_/A _5847_/B VPWR VGND sg13cmos5l_nor2_1
XFILLER_10_816 VPWR VGND sg13cmos5l_decap_8
X_5778_ _7271_/D _5778_/A _5778_/B VPWR VGND sg13cmos5l_nor2_1
X_7517_ _7517_/Q _7553_/CLK _7517_/D _7517_/RESET_B VPWR VGND sg13cmos5l_dfrbpq_1
X_4729_ _4730_/B _4713_/Y _4729_/B VPWR VGND sg13cmos5l_nand2b_1
X_7448_ _7448_/Q clkload8/A _7448_/D _7448_/RESET_B VPWR VGND sg13cmos5l_dfrbpq_1
X_7379_ _7379_/Q _7428_/CLK _7379_/D _7379_/RESET_B VPWR VGND sg13cmos5l_dfrbpq_1
Xhold861 _3869_/A _7416_/Q VPWR VGND sg13cmos5l_dlygate4sd3_1
Xhold850 _4773_/B _7580_/Q VPWR VGND sg13cmos5l_dlygate4sd3_1
Xhold872 _3868_/A _7417_/Q VPWR VGND sg13cmos5l_dlygate4sd3_1
Xhold894 _5119_/A _7151_/Q VPWR VGND sg13cmos5l_dlygate4sd3_1
Xhold883 _4532_/A _7538_/Q VPWR VGND sg13cmos5l_dlygate4sd3_1
XFILLER_45_724 VPWR VGND sg13cmos5l_decap_8
XFILLER_16_61 VPWR VGND sg13cmos5l_fill_2
XFILLER_13_665 VPWR VGND sg13cmos5l_fill_2
XFILLER_40_495 VPWR VGND sg13cmos5l_fill_2
XFILLER_8_113 VPWR VGND sg13cmos5l_fill_1
X_7640__646 _7640_/RESET_B VPWR VGND sg13cmos5l_tiehi
XFILLER_5_853 VPWR VGND sg13cmos5l_decap_8
XFILLER_0_591 VPWR VGND sg13cmos5l_fill_2
X_6750_ _6751_/C _7405_/Q _7404_/Q _7406_/Q VPWR VGND sg13cmos5l_o21ai_1
X_3962_ _4572_/A _3962_/A VPWR VGND sg13cmos5l_inv_1
X_5701_ _5702_/B _7214_/Q _5701_/B VPWR VGND sg13cmos5l_xnor2_1
X_6681_ _6681_/Y _6583_/B _6681_/B _6681_/C VPWR VGND sg13cmos5l_nand3b_1
X_3893_ _3893_/Y _4586_/A VPWR VGND sg13cmos5l_inv_1
X_5632_ _7238_/D _5632_/A1 _5622_/Y _5631_/Y VPWR VGND sg13cmos5l_a21oi_1
X_5563_ _5563_/Y _5454_/B _5565_/A VPWR VGND sg13cmos5l_nand2b_1
X_7309__416 _7309_/RESET_B VPWR VGND sg13cmos5l_tiehi
X_4514_ _4516_/B _4508_/A _4513_/X _4512_/X VPWR VGND sg13cmos5l_a21oi_1
X_7168__575 _7168_/RESET_B VPWR VGND sg13cmos5l_tiehi
X_7302_ _7302_/Q clkload7/A _7302_/D _7302_/RESET_B VPWR VGND sg13cmos5l_dfrbpq_1
X_5494_ _5494_/Y _5494_/A _5501_/B VPWR VGND sg13cmos5l_nor2_1
X_4445_ _4445_/Y _4445_/A VPWR VGND sg13cmos5l_inv_1
X_7233_ _7233_/Q _7239_/CLK _7233_/D _7233_/RESET_B VPWR VGND sg13cmos5l_dfrbpq_1
X_4376_ _4392_/A _4391_/B _4391_/C _4391_/A VPWR VGND sg13cmos5l_a21oi_1
X_7164_ _7164_/Q _7610_/CLK _7164_/D _7164_/RESET_B VPWR VGND sg13cmos5l_dfrbpq_1
X_6115_ _6117_/B _6089_/D _6075_/C _6102_/Y VPWR VGND sg13cmos5l_a21o_1
X_7095_ _7096_/C _7507_/Q _7075_/Y _7094_/Y VPWR VGND sg13cmos5l_o21ai_1
X_6046_ _6046_/Y _6046_/A _6046_/B VPWR VGND sg13cmos5l_nor2_1
X_7316__409 _7316_/RESET_B VPWR VGND sg13cmos5l_tiehi
X_7175__568 _7175_/RESET_B VPWR VGND sg13cmos5l_tiehi
XFILLER_42_716 VPWR VGND sg13cmos5l_fill_1
XFILLER_41_215 VPWR VGND sg13cmos5l_decap_8
X_6948_ _6948_/Y _6955_/B _6948_/B VPWR VGND sg13cmos5l_nand2b_1
X_7314__177 _7314_/D VPWR VGND sg13cmos5l_tielo
XFILLER_22_462 VPWR VGND sg13cmos5l_fill_1
X_6879_ _6879_/Y _6879_/A _6879_/B VPWR VGND sg13cmos5l_nor2_1
XFILLER_10_635 VPWR VGND sg13cmos5l_decap_4
XFILLER_6_606 VPWR VGND sg13cmos5l_fill_1
X_7429__264 _7429_/RESET_B VPWR VGND sg13cmos5l_tiehi
XFILLER_49_315 VPWR VGND sg13cmos5l_fill_2
XFILLER_1_366 VPWR VGND sg13cmos5l_fill_1
X_7436__257 _7436_/RESET_B VPWR VGND sg13cmos5l_tiehi
X_7230__507 _7230_/RESET_B VPWR VGND sg13cmos5l_tiehi
XFILLER_32_226 VPWR VGND sg13cmos5l_fill_2
XFILLER_14_952 VPWR VGND sg13cmos5l_fill_2
XFILLER_43_81 VPWR VGND sg13cmos5l_fill_1
XFILLER_13_484 VPWR VGND sg13cmos5l_fill_2
X_4230_ _4230_/Y _7556_/Q _7526_/Q VPWR VGND sg13cmos5l_nand2_1
X_4161_ _4161_/Y _4140_/A _4140_/B _4155_/B VPWR VGND sg13cmos5l_a21oi_1
X_4092_ _4110_/A _7498_/Q _4092_/B VPWR VGND sg13cmos5l_xor2_1
X_6802_ _6802_/Y _7007_/A _6802_/B _6802_/C VPWR VGND sg13cmos5l_nand3_1
XFILLER_36_576 VPWR VGND sg13cmos5l_decap_4
X_4994_ _4994_/Y _4994_/A _4994_/B VPWR VGND sg13cmos5l_nor2_1
X_6733_ _6738_/S _6729_/Y _6732_/Y _6716_/A VPWR VGND sg13cmos5l_o21ai_1
X_3945_ _3945_/Y _5558_/A VPWR VGND sg13cmos5l_inv_1
X_6664_ _7424_/D _6664_/A _6707_/A VPWR VGND sg13cmos5l_nor2_1
X_5615_ _5616_/C _5615_/A _5615_/B _5615_/C VPWR VGND sg13cmos5l_and3_1
X_3876_ _3876_/Y _3876_/A VPWR VGND sg13cmos5l_inv_1
X_6595_ _6595_/Y _6610_/B _6608_/A VPWR VGND sg13cmos5l_nor2_1
X_5546_ _5546_/Y _5533_/Y hold976/X _5542_/A VPWR VGND sg13cmos5l_a21oi_1
X_5477_ _5477_/Y _7198_/Q _7173_/Q _5494_/A VPWR VGND sg13cmos5l_o21ai_1
X_4428_ _4428_/Y _4714_/A _4446_/B VPWR VGND sg13cmos5l_nand2_1
X_7216_ _7216_/Q _7277_/CLK _7216_/D _7216_/RESET_B VPWR VGND sg13cmos5l_dfrbpq_1
X_4359_ _4362_/A _4394_/A _4363_/B VPWR VGND sg13cmos5l_and2_1
X_7147_ _7147_/Q _7239_/CLK _7147_/D _7147_/RESET_B VPWR VGND sg13cmos5l_dfrbpq_1
X_7078_ _7078_/Y _7524_/Q _6968_/B _6989_/B _7523_/Q _7077_/Y VPWR VGND sg13cmos5l_a221oi_1
X_6029_ _6029_/Y _6029_/A _6029_/B VPWR VGND sg13cmos5l_xnor2_1
XFILLER_14_226 VPWR VGND sg13cmos5l_fill_1
Xfanout30 _6504_/A2 _6824_/A2 VPWR VGND sg13cmos5l_buf_1
Xfanout63 _7007_/B _6958_/A VPWR VGND sg13cmos5l_buf_1
Xfanout52 _5382_/B _5387_/B VPWR VGND sg13cmos5l_buf_1
Xfanout74 _6328_/A _6108_/Y VPWR VGND sg13cmos5l_buf_1
Xfanout41 _5021_/A _4694_/B VPWR VGND sg13cmos5l_buf_1
XFILLER_13_51 VPWR VGND sg13cmos5l_fill_1
Xfanout85 _5102_/B _5177_/A VPWR VGND sg13cmos5l_buf_1
Xfanout96 _4358_/B _4291_/A VPWR VGND sg13cmos5l_buf_1
XFILLER_6_425 VPWR VGND sg13cmos5l_fill_1
XFILLER_11_999 VPWR VGND sg13cmos5l_fill_2
XFILLER_13_95 VPWR VGND sg13cmos5l_decap_8
X_7598__695 _7598_/RESET_B VPWR VGND sg13cmos5l_tiehi
XFILLER_49_123 VPWR VGND sg13cmos5l_fill_1
XFILLER_49_189 VPWR VGND sg13cmos5l_fill_1
XFILLER_49_167 VPWR VGND sg13cmos5l_decap_8
XFILLER_45_362 VPWR VGND sg13cmos5l_fill_1
X_7158__585 _7158_/RESET_B VPWR VGND sg13cmos5l_tiehi
XFILLER_33_557 VPWR VGND sg13cmos5l_fill_2
XFILLER_13_270 VPWR VGND sg13cmos5l_fill_1
Xclkload22 clkload22/X _7555_/CLK VPWR VGND sg13cmos5l_buf_8
X_6380_ _6380_/Y _6375_/B _6379_/Y _6396_/B VPWR VGND sg13cmos5l_o21ai_1
Xclkload11 clkload11/Y _7277_/CLK VPWR VGND sg13cmos5l_inv_1
X_5400_ _5406_/C _5400_/A _5400_/B VPWR VGND sg13cmos5l_or2_1
X_7306__419 _7306_/RESET_B VPWR VGND sg13cmos5l_tiehi
XFILLER_6_970 VPWR VGND sg13cmos5l_decap_8
X_7165__578 _7165_/RESET_B VPWR VGND sg13cmos5l_tiehi
X_5331_ _7194_/D _5331_/A _5334_/B VPWR VGND sg13cmos5l_nor2_1
XFILLER_47_1028 VPWR VGND sg13cmos5l_fill_1
X_5262_ _5262_/X _5260_/A _5260_/B _5256_/D VPWR VGND sg13cmos5l_a21o_1
X_7001_ _7482_/D _7113_/A _7001_/B VPWR VGND sg13cmos5l_and2_1
X_4213_ _4215_/A _4213_/A _4209_/Y VPWR VGND sg13cmos5l_nor2b_1
X_5193_ _5201_/A _5182_/X _5186_/Y _5200_/A _5483_/A _5187_/X VPWR VGND sg13cmos5l_a221oi_1
X_4144_ _4146_/B _4144_/A _4160_/A VPWR VGND sg13cmos5l_and2_1
XFILLER_18_18 VPWR VGND sg13cmos5l_decap_4
X_7419__274 _7419_/RESET_B VPWR VGND sg13cmos5l_tiehi
X_4075_ _4079_/A _7259_/Q _7296_/Q _7358_/Q _7384_/Q VPWR VGND sg13cmos5l_nor4_1
X_6716_ _6716_/Y _6716_/A VPWR VGND sg13cmos5l_inv_1
X_4977_ _5106_/B _4972_/X _4973_/X _4975_/Y _4976_/Y VPWR VGND sg13cmos5l_a22oi_1
X_3928_ _6194_/A _3928_/A VPWR VGND sg13cmos5l_inv_1
Xclkload5 clkload5/X clkload5/A VPWR VGND sg13cmos5l_buf_8
X_6647_ _6647_/Y _6647_/A1 _6642_/Y _6554_/Y VPWR VGND sg13cmos5l_o21ai_1
X_6578_ _6578_/Y _6578_/A _6578_/B VPWR VGND sg13cmos5l_xnor2_1
X_7426__267 _7426_/RESET_B VPWR VGND sg13cmos5l_tiehi
XFILLER_30_1021 VPWR VGND sg13cmos5l_decap_8
XFILLER_3_406 VPWR VGND sg13cmos5l_fill_1
X_5529_ _5530_/A _5527_/C _5528_/Y _5527_/Y VPWR VGND sg13cmos5l_a21o_1
X_7129__197 _7129_/D VPWR VGND sg13cmos5l_tielo
X_7396__300 _7396_/RESET_B VPWR VGND sg13cmos5l_tiehi
XFILLER_8_1000 VPWR VGND sg13cmos5l_decap_8
XFILLER_43_877 VPWR VGND sg13cmos5l_decap_4
XFILLER_7_734 VPWR VGND sg13cmos5l_decap_4
XFILLER_40_82 VPWR VGND sg13cmos5l_fill_1
XFILLER_6_288 VPWR VGND sg13cmos5l_decap_4
XFILLER_18_351 VPWR VGND sg13cmos5l_decap_4
X_5880_ _5888_/S _5873_/Y _5878_/Y _5879_/Y VPWR VGND sg13cmos5l_o21ai_1
X_4900_ _7642_/D _6107_/A _4900_/B VPWR VGND sg13cmos5l_nor2_1
XFILLER_33_310 VPWR VGND sg13cmos5l_fill_1
X_4831_ _4831_/Y _4845_/B _4831_/B _4831_/C VPWR VGND sg13cmos5l_nand3b_1
XFILLER_34_877 VPWR VGND sg13cmos5l_fill_2
X_4762_ _4767_/S _7616_/Q _4762_/B VPWR VGND sg13cmos5l_nor2_1
X_7550_ _7550_/Q _7617_/CLK _7550_/D _7550_/RESET_B VPWR VGND sg13cmos5l_dfrbpq_1
X_4693_ _7602_/D _4728_/A _4693_/B VPWR VGND sg13cmos5l_nor2_1
X_7481_ _7481_/Q _7513_/CLK _7481_/D _7481_/RESET_B VPWR VGND sg13cmos5l_dfrbpq_1
X_6501_ _6501_/Y _7386_/Q _6504_/A2 _6506_/A VPWR VGND sg13cmos5l_o21ai_1
X_6432_ _6451_/B _6432_/A _6662_/A VPWR VGND sg13cmos5l_nor2_1
X_6363_ _7350_/D _6363_/A _6362_/X VPWR VGND sg13cmos5l_nor2b_1
X_5314_ _7181_/D _5314_/A _5314_/B VPWR VGND sg13cmos5l_nor2_1
X_6294_ _6318_/B _6294_/A _6303_/S VPWR VGND sg13cmos5l_and2_1
X_5245_ _5245_/X _5245_/A _5245_/B _5245_/C VPWR VGND sg13cmos5l_and3_1
X_5176_ _5177_/B _5157_/Y _5154_/A _5176_/S VPWR VGND sg13cmos5l_mux2_1
X_7473__552 _7473_/RESET_B VPWR VGND sg13cmos5l_tiehi
X_4127_ _4129_/B _7469_/Q _7470_/Q _7468_/Q _7467_/Q VPWR VGND sg13cmos5l_nor4_1
X_4058_ _4059_/C input8/X _4058_/B _4058_/C VPWR VGND sg13cmos5l_nor3_1
XFILLER_25_822 VPWR VGND sg13cmos5l_decap_4
XFILLER_10_30 VPWR VGND sg13cmos5l_fill_1
XFILLER_10_63 VPWR VGND sg13cmos5l_decap_8
XFILLER_0_921 VPWR VGND sg13cmos5l_decap_8
XFILLER_10_96 VPWR VGND sg13cmos5l_decap_8
X_7478__474 _7478_/RESET_B VPWR VGND sg13cmos5l_tiehi
X_7595__698 _7595_/RESET_B VPWR VGND sg13cmos5l_tiehi
XFILLER_0_998 VPWR VGND sg13cmos5l_decap_8
XFILLER_48_947 VPWR VGND sg13cmos5l_decap_8
X_7357__169 _7357_/D VPWR VGND sg13cmos5l_tielo
XFILLER_35_608 VPWR VGND sg13cmos5l_decap_8
X_7155__588 _7155_/RESET_B VPWR VGND sg13cmos5l_tiehi
XFILLER_27_181 VPWR VGND sg13cmos5l_fill_1
XFILLER_35_60 VPWR VGND sg13cmos5l_fill_2
XFILLER_7_564 VPWR VGND sg13cmos5l_decap_4
X_5030_ _5030_/Y _4681_/Y _5020_/Y _5029_/Y VPWR VGND sg13cmos5l_a21oi_1
Xhold1209 _5800_/A _7262_/Q VPWR VGND sg13cmos5l_dlygate4sd3_1
XFILLER_38_446 VPWR VGND sg13cmos5l_decap_8
Xheichips26_dna_sequencer_147 uo_out[7] VPWR VGND sg13cmos5l_tielo
X_6981_ _6981_/Y _6981_/A _6981_/B _6981_/C VPWR VGND sg13cmos5l_nor3_1
XFILLER_38_457 VPWR VGND sg13cmos5l_fill_2
XFILLER_47_991 VPWR VGND sg13cmos5l_decap_8
X_5932_ _5932_/Y _5933_/B VPWR VGND sg13cmos5l_inv_1
XFILLER_18_170 VPWR VGND sg13cmos5l_fill_1
XFILLER_25_107 VPWR VGND sg13cmos5l_decap_8
XFILLER_15_19 VPWR VGND sg13cmos5l_fill_1
X_5863_ _5863_/X _5863_/A _5863_/B VPWR VGND sg13cmos5l_xor2_1
X_7602_ _7602_/Q _7610_/CLK _7602_/D _7602_/RESET_B VPWR VGND sg13cmos5l_dfrbpq_1
X_5794_ _5794_/Y _7271_/Q _5823_/B VPWR VGND sg13cmos5l_nand2_1
X_4814_ _4836_/A _7626_/Q _4835_/B _4821_/A VPWR VGND sg13cmos5l_a21o_1
X_7533_ _7533_/Q _7571_/CLK _7533_/D _7533_/RESET_B VPWR VGND sg13cmos5l_dfrbpq_1
X_4745_ _4745_/X _4745_/A _4745_/B VPWR VGND sg13cmos5l_and2_1
X_7464_ _7464_/Q _7489_/CLK _7464_/D _7464_/RESET_B VPWR VGND sg13cmos5l_dfrbpq_1
X_4676_ _4676_/Y _4676_/A _4690_/B VPWR VGND sg13cmos5l_nor2_1
X_6415_ _6424_/A _6415_/A _6415_/B VPWR VGND sg13cmos5l_nor2_1
X_7395_ _7395_/Q _7424_/CLK _7395_/D _7395_/RESET_B VPWR VGND sg13cmos5l_dfrbpq_1
X_6346_ _6378_/B _6510_/A _6511_/A VPWR VGND sg13cmos5l_nand2_1
Xoutput18 uo_out[5] _7327_/Q VPWR VGND sg13cmos5l_buf_1
X_7393__303 _7393_/RESET_B VPWR VGND sg13cmos5l_tiehi
X_6277_ _6279_/B _5853_/Y _6263_/Y _6264_/Y _6242_/Y VPWR VGND sg13cmos5l_a22oi_1
X_5228_ _5228_/Y _5200_/A _5228_/B VPWR VGND sg13cmos5l_nand2b_1
X_5159_ _5159_/Y _5139_/Y _5173_/B _5158_/Y VPWR VGND sg13cmos5l_o21ai_1
XFILLER_44_405 VPWR VGND sg13cmos5l_fill_2
XFILLER_44_449 VPWR VGND sg13cmos5l_decap_8
XFILLER_25_641 VPWR VGND sg13cmos5l_fill_1
XFILLER_9_829 VPWR VGND sg13cmos5l_decap_8
XFILLER_4_589 VPWR VGND sg13cmos5l_fill_1
XFILLER_4_578 VPWR VGND sg13cmos5l_decap_8
XFILLER_47_232 VPWR VGND sg13cmos5l_fill_1
XFILLER_46_70 VPWR VGND sg13cmos5l_fill_1
Xclkbuf_leaf_27_clk _7214_/CLK clkbuf_3_4__f_clk/X VPWR VGND sg13cmos5l_buf_8
XFILLER_8_862 VPWR VGND sg13cmos5l_decap_8
XFILLER_7_53 VPWR VGND sg13cmos5l_fill_1
XFILLER_7_42 VPWR VGND sg13cmos5l_decap_8
X_4530_ _4531_/B _4527_/Y _4529_/Y _4540_/C VPWR VGND sg13cmos5l_mux2_1
X_4461_ _4577_/A _4451_/Y _4454_/X _4460_/Y VPWR VGND sg13cmos5l_o21ai_1
X_7180_ _7180_/Q _7239_/CLK _7180_/D _7180_/RESET_B VPWR VGND sg13cmos5l_dfrbpq_1
X_6200_ _6200_/Y _6198_/Y _6199_/Y _6197_/Y VPWR VGND sg13cmos5l_a21oi_1
X_4392_ _4396_/A _4392_/A _4403_/A _4392_/C VPWR VGND sg13cmos5l_or3_1
X_6131_ _6131_/Y _7290_/Q _7339_/Q VPWR VGND sg13cmos5l_nand2b_1
X_6062_ _6063_/B _6026_/Y _6054_/Y _5990_/B VPWR VGND sg13cmos5l_o21ai_1
Xhold1006 _3905_/A _7461_/Q VPWR VGND sg13cmos5l_dlygate4sd3_1
Xhold1028 _4380_/B _4379_/Y VPWR VGND sg13cmos5l_dlygate4sd3_1
Xhold1039 _3913_/A _7523_/Q VPWR VGND sg13cmos5l_dlygate4sd3_1
Xhold1017 _7409_/D _6644_/Y VPWR VGND sg13cmos5l_dlygate4sd3_1
X_5013_ _5013_/Y _5013_/A _5014_/B VPWR VGND sg13cmos5l_nor2b_1
XFILLER_39_766 VPWR VGND sg13cmos5l_fill_1
Xclkbuf_leaf_18_clk _7597_/CLK clkload5/A VPWR VGND sg13cmos5l_buf_8
X_6964_ _6971_/C _7493_/Q _4016_/Y _6970_/B VPWR VGND sg13cmos5l_o21ai_1
X_6895_ _6905_/B _7464_/Q _7463_/Q _7462_/Q VPWR VGND sg13cmos5l_nor3_1
X_5915_ _5915_/X _5915_/A _5915_/B VPWR VGND sg13cmos5l_and2_1
X_5846_ _5847_/B _5846_/A _5835_/A VPWR VGND sg13cmos5l_nor2b_1
X_5777_ _7270_/D _5777_/A _5778_/B VPWR VGND sg13cmos5l_nor2_1
X_4728_ _7608_/D _4728_/A _4728_/B VPWR VGND sg13cmos5l_nor2_1
X_7516_ _7516_/Q _7553_/CLK _7516_/D _7516_/RESET_B VPWR VGND sg13cmos5l_dfrbpq_1
X_4659_ _4667_/B _5101_/A _4661_/B VPWR VGND sg13cmos5l_and2_1
X_7447_ _7447_/Q _7510_/CLK _7447_/D _7447_/RESET_B VPWR VGND sg13cmos5l_dfrbpq_1
X_7378_ _7378_/Q _7428_/CLK _7378_/D _7378_/RESET_B VPWR VGND sg13cmos5l_dfrbpq_1
Xhold862 hold862/X _7188_/Q VPWR VGND sg13cmos5l_dlygate4sd3_1
Xhold851 _3894_/A _7582_/Q VPWR VGND sg13cmos5l_dlygate4sd3_1
Xhold873 _7417_/D _6657_/Y VPWR VGND sg13cmos5l_dlygate4sd3_1
Xhold840 _7387_/D _6504_/Y VPWR VGND sg13cmos5l_dlygate4sd3_1
X_6329_ _6331_/B _6329_/A _6329_/B _6329_/C VPWR VGND sg13cmos5l_nor3_1
Xhold884 _7538_/D _4333_/Y VPWR VGND sg13cmos5l_dlygate4sd3_1
Xhold895 _3958_/A _7596_/Q VPWR VGND sg13cmos5l_dlygate4sd3_1
XFILLER_17_416 VPWR VGND sg13cmos5l_decap_8
XFILLER_18_939 VPWR VGND sg13cmos5l_fill_1
XFILLER_17_438 VPWR VGND sg13cmos5l_decap_8
XFILLER_29_298 VPWR VGND sg13cmos5l_fill_1
XFILLER_16_95 VPWR VGND sg13cmos5l_fill_1
XFILLER_13_655 VPWR VGND sg13cmos5l_decap_4
XFILLER_9_659 VPWR VGND sg13cmos5l_decap_4
XFILLER_32_50 VPWR VGND sg13cmos5l_fill_1
XFILLER_5_865 VPWR VGND sg13cmos5l_decap_8
XFILLER_5_898 VPWR VGND sg13cmos5l_fill_2
X_3961_ _4573_/A _3961_/A VPWR VGND sg13cmos5l_inv_1
X_5700_ _5705_/B _7214_/Q _5701_/B VPWR VGND sg13cmos5l_nand2b_1
XFILLER_17_994 VPWR VGND sg13cmos5l_fill_2
X_6680_ _6681_/C _6682_/A _6691_/A VPWR VGND sg13cmos5l_nand2_1
X_3892_ _3892_/Y _3892_/A VPWR VGND sg13cmos5l_inv_1
X_7116__199 _7116_/D VPWR VGND sg13cmos5l_tielo
X_5631_ _5631_/Y _5618_/B _5622_/Y _5558_/B VPWR VGND sg13cmos5l_o21ai_1
XFILLER_31_485 VPWR VGND sg13cmos5l_fill_2
X_5562_ _7234_/D _5562_/A _5562_/B VPWR VGND sg13cmos5l_nor2_1
X_4513_ _4513_/X _4513_/A _4513_/B VPWR VGND sg13cmos5l_and2_1
X_7301_ _7301_/Q _7332_/CLK _7301_/D _7301_/RESET_B VPWR VGND sg13cmos5l_dfrbpq_1
X_5493_ _7210_/D _5560_/B _5564_/A VPWR VGND sg13cmos5l_nor2_1
X_7232_ _7232_/Q _7239_/CLK _7232_/D _7232_/RESET_B VPWR VGND sg13cmos5l_dfrbpq_1
X_4444_ _4445_/A _4444_/A _4444_/B VPWR VGND sg13cmos5l_xor2_1
Xclkbuf_leaf_7_clk _7394_/CLK clkload1/A VPWR VGND sg13cmos5l_buf_8
X_7163_ _7163_/Q _7610_/CLK _7163_/D _7163_/RESET_B VPWR VGND sg13cmos5l_dfrbpq_1
X_4375_ _4391_/C _4375_/A _4375_/B _7552_/Q VPWR VGND sg13cmos5l_nand3_1
X_6114_ _6117_/A _6114_/A _6114_/B _6122_/B VPWR VGND sg13cmos5l_nand3_1
X_7094_ _7094_/Y _7506_/Q _7094_/B VPWR VGND sg13cmos5l_nand2b_1
X_6045_ _6045_/Y _6050_/A _6050_/B _6044_/Y VPWR VGND sg13cmos5l_a21oi_1
XFILLER_39_541 VPWR VGND sg13cmos5l_fill_2
X_7390__306 _7390_/RESET_B VPWR VGND sg13cmos5l_tiehi
XFILLER_27_736 VPWR VGND sg13cmos5l_decap_4
X_6947_ _6947_/Y _6933_/Y _6939_/Y _6737_/X VPWR VGND sg13cmos5l_o21ai_1
XFILLER_41_249 VPWR VGND sg13cmos5l_decap_8
XFILLER_23_964 VPWR VGND sg13cmos5l_fill_2
X_6878_ _6878_/X _6881_/A _6881_/B VPWR VGND sg13cmos5l_or2_1
X_5829_ _5829_/Y _5809_/Y _5811_/Y _5828_/Y VPWR VGND sg13cmos5l_a21oi_1
XFILLER_6_618 VPWR VGND sg13cmos5l_decap_4
XFILLER_6_629 VPWR VGND sg13cmos5l_fill_2
XFILLER_5_117 VPWR VGND sg13cmos5l_decap_8
XFILLER_2_835 VPWR VGND sg13cmos5l_fill_1
XFILLER_1_334 VPWR VGND sg13cmos5l_fill_1
XFILLER_27_50 VPWR VGND sg13cmos5l_decap_4
XFILLER_45_588 VPWR VGND sg13cmos5l_fill_2
XFILLER_45_566 VPWR VGND sg13cmos5l_decap_4
XFILLER_9_401 VPWR VGND sg13cmos5l_decap_4
XFILLER_14_964 VPWR VGND sg13cmos5l_decap_8
XFILLER_41_772 VPWR VGND sg13cmos5l_fill_1
XFILLER_14_986 VPWR VGND sg13cmos5l_decap_8
XFILLER_9_456 VPWR VGND sg13cmos5l_fill_1
XFILLER_5_673 VPWR VGND sg13cmos5l_fill_1
X_4160_ _4160_/Y _4160_/A _4160_/B VPWR VGND sg13cmos5l_nand2_1
X_4091_ _4092_/B _7496_/Q _7497_/Q _7495_/Q _7494_/Q VPWR VGND sg13cmos5l_nor4_1
XFILLER_49_894 VPWR VGND sg13cmos5l_decap_4
XFILLER_49_883 VPWR VGND sg13cmos5l_fill_1
XFILLER_49_872 VPWR VGND sg13cmos5l_decap_8
X_7315__410 _7315_/RESET_B VPWR VGND sg13cmos5l_tiehi
X_6801_ _6801_/Y _7411_/Q _6801_/B VPWR VGND sg13cmos5l_nand2_1
X_4993_ _4993_/Y _5257_/A _4993_/B VPWR VGND sg13cmos5l_nand2_1
X_6732_ _6732_/Y _6937_/A _6728_/X _6941_/A VPWR VGND sg13cmos5l_o21ai_1
X_3944_ _5560_/A _3944_/A VPWR VGND sg13cmos5l_inv_1
X_3875_ _6626_/B _6486_/A VPWR VGND sg13cmos5l_inv_1
XFILLER_20_934 VPWR VGND sg13cmos5l_decap_4
X_6663_ _7423_/D _6663_/A _6707_/A VPWR VGND sg13cmos5l_nor2_1
X_5614_ _5621_/A _5614_/A _5614_/B VPWR VGND sg13cmos5l_nor2_1
X_6594_ _6608_/A _7379_/Q _6602_/B VPWR VGND sg13cmos5l_nand2b_1
X_7383__165 _7383_/D VPWR VGND sg13cmos5l_tielo
X_5545_ _5545_/Y _5728_/B _5545_/B VPWR VGND sg13cmos5l_nand2_1
X_7322__403 _7322_/RESET_B VPWR VGND sg13cmos5l_tiehi
X_5476_ _5494_/A _7173_/Q _7174_/Q VPWR VGND sg13cmos5l_xor2_1
X_4427_ _4446_/B _4427_/A _4427_/B VPWR VGND sg13cmos5l_xor2_1
X_7215_ _7215_/Q _7277_/CLK _7215_/D _7215_/RESET_B VPWR VGND sg13cmos5l_dfrbpq_1
X_7181__562 _7181_/RESET_B VPWR VGND sg13cmos5l_tiehi
X_7146_ _7146_/Q _7239_/CLK _7146_/D _7146_/RESET_B VPWR VGND sg13cmos5l_dfrbpq_1
X_4358_ _7555_/D _7083_/A _4358_/B VPWR VGND sg13cmos5l_nor2_1
X_4289_ _4290_/A _4355_/A _4281_/X _4284_/Y _4289_/B2 VPWR VGND sg13cmos5l_a22oi_1
X_7077_ _7077_/Y _7090_/B _7474_/Q _7473_/Q _4355_/A _7076_/Y VPWR VGND sg13cmos5l_a221oi_1
X_6028_ _6029_/B _7303_/Q _6034_/B _6006_/Y VPWR VGND sg13cmos5l_a21oi_1
Xfanout20 _6181_/B _6167_/Y VPWR VGND sg13cmos5l_buf_1
Xfanout31 _6826_/A2 _6824_/A2 VPWR VGND sg13cmos5l_buf_1
Xfanout53 _5387_/B _5353_/Y VPWR VGND sg13cmos5l_buf_1
XFILLER_23_761 VPWR VGND sg13cmos5l_decap_8
XFILLER_23_783 VPWR VGND sg13cmos5l_fill_1
Xfanout64 _7006_/B _6893_/Y VPWR VGND sg13cmos5l_buf_1
Xfanout42 _7037_/B _7055_/B VPWR VGND sg13cmos5l_buf_1
Xfanout75 _5993_/B _5994_/B VPWR VGND sg13cmos5l_buf_1
Xfanout86 _5177_/A _4979_/Y VPWR VGND sg13cmos5l_buf_1
Xfanout97 _7071_/A _4084_/Y VPWR VGND sg13cmos5l_buf_1
X_7442__251 _7442_/RESET_B VPWR VGND sg13cmos5l_tiehi
XFILLER_2_621 VPWR VGND sg13cmos5l_fill_1
XFILLER_49_135 VPWR VGND sg13cmos5l_fill_2
XFILLER_38_82 VPWR VGND sg13cmos5l_fill_1
XFILLER_46_864 VPWR VGND sg13cmos5l_decap_8
XFILLER_46_897 VPWR VGND sg13cmos5l_fill_2
XFILLER_9_231 VPWR VGND sg13cmos5l_decap_8
XFILLER_9_242 VPWR VGND sg13cmos5l_fill_2
Xclkload23 clkload23/Y _7560_/CLK VPWR VGND sg13cmos5l_inv_1
Xclkload12 clkload12/Y _7314_/CLK VPWR VGND sg13cmos5l_inv_1
X_5330_ _7193_/D _5330_/A _5332_/B VPWR VGND sg13cmos5l_and2_1
XFILLER_5_492 VPWR VGND sg13cmos5l_fill_2
X_5261_ _5261_/Y _5260_/A _5260_/B _5256_/D VPWR VGND sg13cmos5l_a21oi_1
X_4212_ _4212_/Y _4212_/A _4212_/B VPWR VGND sg13cmos5l_nor2_1
X_7000_ _7481_/D _7000_/A _7000_/B VPWR VGND sg13cmos5l_and2_1
X_5192_ _5483_/A _5195_/B _5192_/B VPWR VGND sg13cmos5l_nand2b_1
X_4143_ _4146_/A _4132_/Y _4141_/Y _4142_/Y VPWR VGND sg13cmos5l_o21ai_1
X_4074_ _4080_/B _4074_/A _4344_/A _4074_/C _4074_/D VPWR VGND sg13cmos5l_nor4_1
X_6715_ _6716_/A _7434_/Q _6715_/B VPWR VGND sg13cmos5l_xnor2_1
X_4976_ _4976_/Y _4976_/A _4994_/B VPWR VGND sg13cmos5l_nor2_1
XFILLER_11_219 VPWR VGND sg13cmos5l_fill_1
X_3927_ _6195_/A _5961_/A VPWR VGND sg13cmos5l_inv_1
XFILLER_20_742 VPWR VGND sg13cmos5l_decap_8
X_6646_ _6646_/Y _6635_/Y _6642_/Y _6645_/Y VPWR VGND sg13cmos5l_a21oi_1
Xclkload6 clkload6/X clkload6/A VPWR VGND sg13cmos5l_buf_8
XFILLER_20_764 VPWR VGND sg13cmos5l_fill_1
X_6577_ _6577_/Y _6767_/A _6577_/B VPWR VGND sg13cmos5l_nand2_1
X_5528_ _5528_/Y _7240_/Q _5776_/A VPWR VGND sg13cmos5l_nor2_1
X_5459_ _5460_/A _5703_/A _5709_/A VPWR VGND sg13cmos5l_and2_1
X_7129_ _7129_/Q _7424_/CLK _7129_/D _7129_/RESET_B VPWR VGND sg13cmos5l_dfrbpq_1
XFILLER_19_319 VPWR VGND sg13cmos5l_decap_8
XFILLER_43_801 VPWR VGND sg13cmos5l_decap_8
XFILLER_39_190 VPWR VGND sg13cmos5l_fill_2
XFILLER_7_768 VPWR VGND sg13cmos5l_decap_8
XFILLER_7_779 VPWR VGND sg13cmos5l_fill_2
XFILLER_6_256 VPWR VGND sg13cmos5l_fill_1
X_7305__420 _7305_/RESET_B VPWR VGND sg13cmos5l_tiehi
XFILLER_2_462 VPWR VGND sg13cmos5l_fill_2
XFILLER_2_484 VPWR VGND sg13cmos5l_decap_4
XFILLER_37_116 VPWR VGND sg13cmos5l_fill_2
XFILLER_18_385 VPWR VGND sg13cmos5l_fill_1
XFILLER_19_897 VPWR VGND sg13cmos5l_decap_8
X_7312__413 _7312_/RESET_B VPWR VGND sg13cmos5l_tiehi
X_4830_ _4831_/B _4830_/A _4848_/B VPWR VGND sg13cmos5l_or2_1
XFILLER_33_322 VPWR VGND sg13cmos5l_decap_4
X_7171__572 _7171_/RESET_B VPWR VGND sg13cmos5l_tiehi
X_4761_ _4762_/B _4771_/B _4758_/Y _4760_/Y VPWR VGND sg13cmos5l_o21ai_1
X_4692_ _4692_/Y _4693_/B VPWR VGND sg13cmos5l_inv_1
X_6500_ _7385_/D _3873_/Y _6500_/A2 _6499_/Y VPWR VGND sg13cmos5l_a21oi_1
X_7480_ _7480_/Q _7513_/CLK _7480_/D _7480_/RESET_B VPWR VGND sg13cmos5l_dfrbpq_1
X_6431_ _6435_/B _7396_/Q _6451_/A VPWR VGND sg13cmos5l_nor2_1
X_6362_ _6362_/X _6362_/A _6396_/B VPWR VGND sg13cmos5l_and2_1
XFILLER_6_790 VPWR VGND sg13cmos5l_decap_8
X_5313_ _5314_/B _5300_/B _5523_/B _5315_/S VPWR VGND sg13cmos5l_mux2_1
X_6293_ _6293_/Y _6293_/A _6294_/A _6293_/C _6293_/D VPWR VGND sg13cmos5l_nor4_1
X_5244_ _5244_/Y _4981_/A _5267_/A _5242_/Y _5243_/Y VPWR VGND sg13cmos5l_a22oi_1
X_5175_ _7163_/D _5175_/A _5175_/B _5175_/C VPWR VGND sg13cmos5l_and3_1
X_4126_ _4140_/A _7469_/Q _7468_/Q _7467_/Q VPWR VGND sg13cmos5l_or3_1
X_4057_ _4058_/C input9/X _7648_/Q VPWR VGND sg13cmos5l_nor2_1
X_7432__261 _7432_/RESET_B VPWR VGND sg13cmos5l_tiehi
XFILLER_40_859 VPWR VGND sg13cmos5l_fill_1
X_4959_ _4969_/B _7134_/Q _4960_/B VPWR VGND sg13cmos5l_nor2b_1
X_6629_ _6629_/Y _6834_/A _6629_/B _6633_/C VPWR VGND sg13cmos5l_nand3b_1
XFILLER_3_215 VPWR VGND sg13cmos5l_fill_1
XFILLER_3_204 VPWR VGND sg13cmos5l_fill_2
XFILLER_0_900 VPWR VGND sg13cmos5l_decap_8
XFILLER_0_977 VPWR VGND sg13cmos5l_decap_8
XFILLER_19_105 VPWR VGND sg13cmos5l_decap_8
XFILLER_25_4 VPWR VGND sg13cmos5l_fill_2
X_6980_ _6981_/C _7475_/Q _6980_/B VPWR VGND sg13cmos5l_nor2_1
XFILLER_47_970 VPWR VGND sg13cmos5l_decap_8
X_5931_ _5933_/B _5680_/X _5917_/X _5919_/Y _5930_/Y VPWR VGND sg13cmos5l_a22oi_1
XFILLER_19_661 VPWR VGND sg13cmos5l_fill_1
XFILLER_46_480 VPWR VGND sg13cmos5l_decap_4
X_5862_ _5862_/X _7309_/Q _7278_/Q VPWR VGND sg13cmos5l_and2_1
X_7601_ _7601_/Q _7634_/CLK _7601_/D _7601_/RESET_B VPWR VGND sg13cmos5l_dfrbpq_1
X_5793_ _5793_/Y _5791_/Y _5792_/Y _5790_/Y VPWR VGND sg13cmos5l_a21oi_1
XFILLER_22_859 VPWR VGND sg13cmos5l_decap_4
X_4813_ _4821_/A _4831_/C _4820_/C _4820_/A VPWR VGND sg13cmos5l_a21oi_1
X_7532_ _7532_/Q _7571_/CLK _7532_/D _7532_/RESET_B VPWR VGND sg13cmos5l_dfrbpq_1
X_4744_ _4748_/B _7612_/Q _4744_/B VPWR VGND sg13cmos5l_or2_1
X_7463_ _7463_/Q _7489_/CLK _7463_/D _7463_/RESET_B VPWR VGND sg13cmos5l_dfrbpq_1
X_4675_ _4675_/Y _4672_/A _4672_/B _4674_/Y VPWR VGND sg13cmos5l_o21ai_1
X_6414_ _6415_/B _6414_/A _6414_/B VPWR VGND sg13cmos5l_xnor2_1
X_7394_ _7394_/Q _7394_/CLK _7394_/D _7394_/RESET_B VPWR VGND sg13cmos5l_dfrbpq_1
X_6345_ _6345_/Y _6348_/A _6340_/A _6344_/Y VPWR VGND sg13cmos5l_a21oi_1
Xoutput19 uo_out[6] _7328_/Q VPWR VGND sg13cmos5l_buf_1
X_6276_ _6276_/Y _6273_/Y _6275_/X _6268_/Y VPWR VGND sg13cmos5l_o21ai_1
X_5227_ _5227_/Y _5227_/A VPWR VGND sg13cmos5l_inv_1
XFILLER_5_1015 VPWR VGND sg13cmos5l_decap_8
X_5158_ _5158_/Y _5157_/A _5157_/B _5154_/A VPWR VGND sg13cmos5l_o21ai_1
X_4109_ _4109_/Y _4110_/B _4099_/Y _4103_/X VPWR VGND sg13cmos5l_o21ai_1
X_5089_ _7149_/D _3891_/Y _5551_/A2 _5088_/Y VPWR VGND sg13cmos5l_a21oi_1
XFILLER_44_428 VPWR VGND sg13cmos5l_decap_4
XFILLER_38_970 VPWR VGND sg13cmos5l_fill_2
XFILLER_40_645 VPWR VGND sg13cmos5l_fill_1
XFILLER_13_859 VPWR VGND sg13cmos5l_fill_2
XFILLER_12_369 VPWR VGND sg13cmos5l_decap_4
XFILLER_8_329 VPWR VGND sg13cmos5l_decap_8
XFILLER_21_881 VPWR VGND sg13cmos5l_fill_2
XFILLER_21_74 VPWR VGND sg13cmos5l_fill_1
X_7302__423 _7302_/RESET_B VPWR VGND sg13cmos5l_tiehi
X_7161__582 _7161_/RESET_B VPWR VGND sg13cmos5l_tiehi
XFILLER_43_1010 VPWR VGND sg13cmos5l_decap_8
XFILLER_0_752 VPWR VGND sg13cmos5l_fill_2
XFILLER_0_796 VPWR VGND sg13cmos5l_decap_8
XFILLER_47_266 VPWR VGND sg13cmos5l_decap_8
XFILLER_29_992 VPWR VGND sg13cmos5l_fill_1
XFILLER_44_995 VPWR VGND sg13cmos5l_fill_1
XFILLER_44_984 VPWR VGND sg13cmos5l_decap_8
XFILLER_7_10 VPWR VGND sg13cmos5l_fill_1
XFILLER_7_76 VPWR VGND sg13cmos5l_decap_8
X_4460_ _4460_/Y _4460_/A _4470_/B VPWR VGND sg13cmos5l_nand2_1
X_4391_ _4392_/C _4391_/A _4391_/B _4391_/C VPWR VGND sg13cmos5l_and3_1
X_7422__271 _7422_/RESET_B VPWR VGND sg13cmos5l_tiehi
X_6130_ _6130_/Y _7291_/Q _7340_/Q VPWR VGND sg13cmos5l_nand2b_1
X_6061_ _6063_/A _6061_/A _6061_/B _6061_/C VPWR VGND sg13cmos5l_nor3_1
Xhold1029 _7560_/D _4419_/Y VPWR VGND sg13cmos5l_dlygate4sd3_1
X_5012_ _5014_/B _4689_/A _5000_/Y _5011_/X _4694_/A VPWR VGND sg13cmos5l_a22oi_1
Xhold1018 _3951_/A _7634_/Q VPWR VGND sg13cmos5l_dlygate4sd3_1
Xhold1007 _5989_/A _7272_/Q VPWR VGND sg13cmos5l_dlygate4sd3_1
XFILLER_38_255 VPWR VGND sg13cmos5l_decap_4
XFILLER_27_918 VPWR VGND sg13cmos5l_decap_8
XFILLER_19_480 VPWR VGND sg13cmos5l_fill_1
X_6963_ _6970_/B _7492_/Q _6792_/B _6962_/Y VPWR VGND sg13cmos5l_o21ai_1
XFILLER_41_409 VPWR VGND sg13cmos5l_decap_4
X_5914_ _5930_/B _7252_/Q _5914_/B VPWR VGND sg13cmos5l_xnor2_1
X_6894_ _6958_/A _7106_/B _7106_/A VPWR VGND sg13cmos5l_nand2b_1
XFILLER_35_962 VPWR VGND sg13cmos5l_fill_2
X_5845_ _7275_/D _5845_/A _5845_/B VPWR VGND sg13cmos5l_nor2_1
XFILLER_21_133 VPWR VGND sg13cmos5l_decap_8
XFILLER_21_144 VPWR VGND sg13cmos5l_fill_1
X_5776_ _7269_/D _5776_/A _5845_/A VPWR VGND sg13cmos5l_nor2_1
X_4727_ _4727_/Y _4728_/B VPWR VGND sg13cmos5l_inv_1
X_7515_ _7515_/Q _7617_/CLK _7515_/D _7515_/RESET_B VPWR VGND sg13cmos5l_dfrbpq_1
X_4658_ _4658_/Y _4690_/A _4664_/B _4652_/X VPWR VGND sg13cmos5l_a21oi_1
X_7446_ _7446_/Q _7651_/CLK _7446_/D _7446_/RESET_B VPWR VGND sg13cmos5l_dfrbpq_1
Xhold830 _5328_/B _7154_/Q VPWR VGND sg13cmos5l_dlygate4sd3_1
X_7377_ _7377_/Q _7428_/CLK _7377_/D _7377_/RESET_B VPWR VGND sg13cmos5l_dfrbpq_1
Xhold852 _7619_/D _4777_/Y VPWR VGND sg13cmos5l_dlygate4sd3_1
Xhold863 hold863/X _7385_/Q VPWR VGND sg13cmos5l_dlygate4sd3_1
Xhold841 _7024_/A _7480_/Q VPWR VGND sg13cmos5l_dlygate4sd3_1
X_4589_ _4589_/Y _4587_/Y _4588_/Y _4586_/Y VPWR VGND sg13cmos5l_a21oi_1
X_6328_ _7342_/D _6328_/A _6328_/B _6328_/C VPWR VGND sg13cmos5l_nor3_1
Xhold885 _6498_/B _7358_/Q VPWR VGND sg13cmos5l_dlygate4sd3_1
Xhold874 hold874/X _7260_/Q VPWR VGND sg13cmos5l_dlygate4sd3_1
Xhold896 _6197_/A _7332_/Q VPWR VGND sg13cmos5l_dlygate4sd3_1
X_6259_ _6259_/X _6255_/Y _6256_/Y _6258_/Y VPWR VGND sg13cmos5l_a21o_1
XFILLER_29_255 VPWR VGND sg13cmos5l_fill_2
XFILLER_29_266 VPWR VGND sg13cmos5l_fill_1
X_7117__635 _7117_/RESET_B VPWR VGND sg13cmos5l_tiehi
XFILLER_25_472 VPWR VGND sg13cmos5l_fill_2
XFILLER_40_442 VPWR VGND sg13cmos5l_decap_8
XFILLER_8_104 VPWR VGND sg13cmos5l_decap_8
XFILLER_9_638 VPWR VGND sg13cmos5l_decap_4
XFILLER_12_166 VPWR VGND sg13cmos5l_decap_4
XFILLER_40_497 VPWR VGND sg13cmos5l_fill_1
XFILLER_8_159 VPWR VGND sg13cmos5l_decap_4
XFILLER_8_148 VPWR VGND sg13cmos5l_fill_2
XFILLER_4_343 VPWR VGND sg13cmos5l_fill_1
XFILLER_4_321 VPWR VGND sg13cmos5l_decap_4
XFILLER_4_354 VPWR VGND sg13cmos5l_decap_8
XFILLER_0_560 VPWR VGND sg13cmos5l_decap_8
XFILLER_0_593 VPWR VGND sg13cmos5l_fill_1
XFILLER_36_704 VPWR VGND sg13cmos5l_decap_8
XFILLER_36_715 VPWR VGND sg13cmos5l_fill_1
XFILLER_36_748 VPWR VGND sg13cmos5l_fill_1
X_3960_ _4460_/A _4784_/A VPWR VGND sg13cmos5l_inv_1
XFILLER_44_770 VPWR VGND sg13cmos5l_decap_4
X_3891_ _3891_/Y _3891_/A VPWR VGND sg13cmos5l_inv_1
XFILLER_32_954 VPWR VGND sg13cmos5l_decap_8
X_5630_ _7237_/D _5630_/A _5630_/B VPWR VGND sg13cmos5l_nor2_1
X_5561_ _7233_/D _5561_/A _5562_/B VPWR VGND sg13cmos5l_nor2_1
X_4512_ _4512_/X _4512_/A _4512_/B VPWR VGND sg13cmos5l_and2_1
X_5492_ _5564_/A _5209_/X _5488_/X _5490_/Y _5491_/Y VPWR VGND sg13cmos5l_a22oi_1
X_7300_ _7300_/Q _7332_/CLK _7300_/D _7300_/RESET_B VPWR VGND sg13cmos5l_dfrbpq_1
X_7231_ _7231_/Q _7239_/CLK _7231_/D _7231_/RESET_B VPWR VGND sg13cmos5l_dfrbpq_1
X_4443_ _4454_/B _7566_/Q _4444_/B VPWR VGND sg13cmos5l_nor2b_1
X_4374_ _4391_/B _7551_/Q _4402_/B VPWR VGND sg13cmos5l_nand2_1
X_7162_ _7162_/Q _7610_/CLK _7162_/D _7162_/RESET_B VPWR VGND sg13cmos5l_dfrbpq_1
X_7093_ _7096_/B _7505_/Q _7085_/Y _7092_/Y _7506_/Q _7089_/Y VPWR VGND sg13cmos5l_a221oi_1
X_6113_ _7316_/D _6180_/A _6113_/B VPWR VGND sg13cmos5l_nor2_1
X_6044_ _6044_/Y _6061_/A _6044_/B VPWR VGND sg13cmos5l_nor2_1
XFILLER_2_1018 VPWR VGND sg13cmos5l_decap_8
X_6946_ _7467_/D _7007_/B _6946_/B VPWR VGND sg13cmos5l_nor2_1
XFILLER_42_729 VPWR VGND sg13cmos5l_decap_8
XFILLER_42_707 VPWR VGND sg13cmos5l_decap_8
XFILLER_23_954 VPWR VGND sg13cmos5l_fill_2
X_6877_ _6881_/B _6858_/A _6858_/B _6876_/Y VPWR VGND sg13cmos5l_o21ai_1
X_5828_ _5828_/Y _5828_/A _5828_/B VPWR VGND sg13cmos5l_nor2_1
X_5759_ _5759_/X _5743_/Y _5960_/B _5759_/S VPWR VGND sg13cmos5l_mux2_1
XFILLER_2_814 VPWR VGND sg13cmos5l_fill_2
X_7429_ _7429_/Q _7510_/CLK _7429_/D _7429_/RESET_B VPWR VGND sg13cmos5l_dfrbpq_1
XFILLER_2_858 VPWR VGND sg13cmos5l_decap_8
XFILLER_33_707 VPWR VGND sg13cmos5l_decap_8
XFILLER_14_910 VPWR VGND sg13cmos5l_decap_8
XFILLER_43_50 VPWR VGND sg13cmos5l_fill_1
XFILLER_25_280 VPWR VGND sg13cmos5l_decap_8
XFILLER_13_486 VPWR VGND sg13cmos5l_fill_1
XFILLER_4_140 VPWR VGND sg13cmos5l_fill_1
X_4090_ _4102_/A _7496_/Q _7495_/Q _7494_/Q VPWR VGND sg13cmos5l_or3_1
XFILLER_48_372 VPWR VGND sg13cmos5l_fill_1
X_6800_ _6800_/Y _7440_/Q _6809_/A _6809_/B _6800_/D VPWR VGND sg13cmos5l_nand4_1
X_4992_ _7133_/D _5038_/A _5110_/A VPWR VGND sg13cmos5l_nor2_1
X_6731_ _6731_/Y _6937_/A _6941_/A VPWR VGND sg13cmos5l_nand2_1
X_3943_ _5561_/A _3943_/A VPWR VGND sg13cmos5l_inv_1
XFILLER_16_291 VPWR VGND sg13cmos5l_decap_8
X_6662_ _7422_/D _6662_/A _6707_/A VPWR VGND sg13cmos5l_nor2_1
X_3874_ _6633_/B _3874_/A VPWR VGND sg13cmos5l_inv_1
X_5613_ _5613_/Y _5618_/A _5618_/B _5612_/Y VPWR VGND sg13cmos5l_a21oi_1
Xclkbuf_3_2__f_clk clkload1/A clkbuf_0_clk/X VPWR VGND sg13cmos5l_buf_8
X_6593_ _6602_/B _7378_/Q _7377_/Q _7376_/Q VPWR VGND sg13cmos5l_or3_1
X_5544_ _5544_/Y _5741_/B _5541_/S _5543_/Y VPWR VGND sg13cmos5l_a21oi_1
X_7502__316 _7502_/RESET_B VPWR VGND sg13cmos5l_tiehi
X_5475_ _5475_/X _7199_/Q _5475_/B VPWR VGND sg13cmos5l_or2_1
X_4426_ _4444_/B _7565_/Q _7564_/Q _7562_/Q _7563_/Q VPWR VGND sg13cmos5l_nor4_1
X_7214_ _7214_/Q _7214_/CLK _7214_/D _7214_/RESET_B VPWR VGND sg13cmos5l_dfrbpq_1
X_7145_ _7145_/Q _7239_/CLK _7145_/D _7145_/RESET_B VPWR VGND sg13cmos5l_dfrbpq_1
X_4357_ _7554_/D _4357_/A _4357_/B VPWR VGND sg13cmos5l_and2_1
X_4288_ _4288_/Y _7499_/Q _4288_/B VPWR VGND sg13cmos5l_xnor2_1
X_7076_ _7076_/Y _7083_/B _6986_/B _6983_/B _7521_/Q VPWR VGND sg13cmos5l_a22oi_1
X_6027_ _6027_/Y _6061_/A _6044_/B VPWR VGND sg13cmos5l_nand2_1
X_6929_ _6948_/B _7436_/Q _7435_/Q VPWR VGND sg13cmos5l_xnor2_1
X_7114__638 _7114_/RESET_B VPWR VGND sg13cmos5l_tiehi
XFILLER_14_239 VPWR VGND sg13cmos5l_fill_2
XFILLER_23_751 VPWR VGND sg13cmos5l_decap_8
Xfanout21 _6653_/A2 _6994_/A2 VPWR VGND sg13cmos5l_buf_1
Xfanout54 _5146_/B _5151_/B VPWR VGND sg13cmos5l_buf_1
Xfanout32 _6824_/A2 _5324_/A2 VPWR VGND sg13cmos5l_buf_1
Xfanout43 _6875_/B _6863_/B VPWR VGND sg13cmos5l_buf_1
Xfanout65 _6889_/A _6782_/A VPWR VGND sg13cmos5l_buf_1
Xfanout98 _7105_/A _4084_/Y VPWR VGND sg13cmos5l_buf_1
XFILLER_13_42 VPWR VGND sg13cmos5l_decap_8
Xfanout76 _5994_/B _5976_/A VPWR VGND sg13cmos5l_buf_1
Xfanout87 _4728_/A _4768_/A VPWR VGND sg13cmos5l_buf_1
XFILLER_10_456 VPWR VGND sg13cmos5l_fill_2
XFILLER_6_449 VPWR VGND sg13cmos5l_decap_4
XFILLER_1_176 VPWR VGND sg13cmos5l_fill_2
XFILLER_2_699 VPWR VGND sg13cmos5l_decap_8
Xhold1190 _4457_/A0 _7562_/Q VPWR VGND sg13cmos5l_dlygate4sd3_1
XFILLER_33_548 VPWR VGND sg13cmos5l_fill_2
XFILLER_9_221 VPWR VGND sg13cmos5l_fill_2
Xclkload24 clkload24/Y _7571_/CLK VPWR VGND sg13cmos5l_inv_2
Xclkload13 clkload13/Y _7394_/CLK VPWR VGND sg13cmos5l_inv_1
XFILLER_47_1019 VPWR VGND sg13cmos5l_decap_8
X_5260_ _5260_/Y _5260_/A _5260_/B VPWR VGND sg13cmos5l_nand2_1
X_4211_ _4212_/B _4170_/X _4209_/Y _7072_/A VPWR VGND sg13cmos5l_o21ai_1
X_5191_ _5192_/B _5558_/A _7200_/Q _7201_/Q VPWR VGND sg13cmos5l_o21ai_1
X_4142_ _4142_/Y _4132_/A _4132_/B _4155_/B _4160_/A VPWR VGND sg13cmos5l_a22oi_1
XFILLER_49_670 VPWR VGND sg13cmos5l_decap_4
X_4073_ _4936_/B _4344_/B _4344_/A VPWR VGND sg13cmos5l_nor2b_1
XFILLER_36_320 VPWR VGND sg13cmos5l_fill_1
XFILLER_36_375 VPWR VGND sg13cmos5l_decap_4
X_4975_ _4975_/Y _4972_/A _4972_/B _4974_/Y VPWR VGND sg13cmos5l_o21ai_1
X_6714_ _6715_/B _7433_/Q _6728_/B VPWR VGND sg13cmos5l_nor2_1
X_3926_ _3926_/Y _7319_/Q VPWR VGND sg13cmos5l_inv_1
X_6645_ _6645_/Y _6645_/A1 _6642_/Y _6554_/Y VPWR VGND sg13cmos5l_o21ai_1
Xclkload7 clkload7/Y clkload7/A VPWR VGND sg13cmos5l_inv_2
X_6576_ _6577_/B _6761_/A _6576_/B VPWR VGND sg13cmos5l_nand2_1
X_5527_ _5527_/Y _7184_/Q _5527_/B _5527_/C VPWR VGND sg13cmos5l_nor3_1
X_5458_ _7206_/D _5542_/A _5458_/B VPWR VGND sg13cmos5l_nor2_1
X_4409_ _4409_/Y _4414_/A _4414_/C VPWR VGND sg13cmos5l_nor2_1
X_5389_ _5390_/A _5383_/A _5389_/B VPWR VGND sg13cmos5l_nand2b_1
X_7128_ _7128_/Q _7394_/CLK _7128_/D _7128_/RESET_B VPWR VGND sg13cmos5l_dfrbpq_1
X_7059_ _7059_/Y _7059_/A _7059_/B VPWR VGND sg13cmos5l_nor2_1
XFILLER_6_202 VPWR VGND sg13cmos5l_decap_4
XFILLER_3_986 VPWR VGND sg13cmos5l_decap_8
XFILLER_38_607 VPWR VGND sg13cmos5l_fill_2
XFILLER_1_34 VPWR VGND sg13cmos5l_fill_2
XFILLER_19_865 VPWR VGND sg13cmos5l_fill_2
XFILLER_46_695 VPWR VGND sg13cmos5l_fill_1
XFILLER_45_172 VPWR VGND sg13cmos5l_decap_8
X_4760_ _4760_/Y _5065_/B _4755_/X _4759_/Y VPWR VGND sg13cmos5l_o21ai_1
X_4691_ _4693_/B _4672_/X _4689_/Y _4690_/Y _4675_/Y VPWR VGND sg13cmos5l_a22oi_1
X_6430_ _6446_/A _7375_/Q _6438_/A VPWR VGND sg13cmos5l_xor2_1
X_6361_ _6361_/X _6411_/A _6396_/B VPWR VGND sg13cmos5l_and2_1
X_5312_ _7180_/D _5314_/A _5312_/B VPWR VGND sg13cmos5l_nor2_1
XFILLER_46_0 VPWR VGND sg13cmos5l_fill_2
X_6292_ _6297_/A _6222_/D _6302_/B _6289_/Y _6113_/B _6290_/Y VPWR VGND sg13cmos5l_a221oi_1
X_5243_ _5243_/Y _7161_/Q _7136_/Q VPWR VGND sg13cmos5l_nor2_1
X_5174_ _5175_/C _5139_/Y _5176_/S VPWR VGND sg13cmos5l_nand2b_1
X_4125_ _4131_/A _4132_/A _4160_/A VPWR VGND sg13cmos5l_and2_1
X_4056_ _4060_/B _4043_/Y _4055_/Y _7650_/Q VPWR VGND sg13cmos5l_o21ai_1
X_4958_ _4965_/A _4947_/X _4951_/Y _5249_/A _4990_/A _4952_/X VPWR VGND sg13cmos5l_a221oi_1
X_4889_ _4892_/B _4889_/A _4887_/Y VPWR VGND sg13cmos5l_nor2b_1
XFILLER_20_540 VPWR VGND sg13cmos5l_decap_8
X_3909_ _6971_/A _6976_/A VPWR VGND sg13cmos5l_inv_1
X_6628_ _6628_/Y _6633_/C _6627_/Y _6626_/Y VPWR VGND sg13cmos5l_a21oi_1
X_6559_ _6560_/B _7400_/Q _7399_/Q _6559_/B1 VPWR VGND sg13cmos5l_o21ai_1
XFILLER_10_21 VPWR VGND sg13cmos5l_decap_8
XFILLER_0_956 VPWR VGND sg13cmos5l_decap_8
XFILLER_43_643 VPWR VGND sg13cmos5l_fill_1
XFILLER_15_334 VPWR VGND sg13cmos5l_fill_2
XFILLER_16_857 VPWR VGND sg13cmos5l_decap_4
XFILLER_11_562 VPWR VGND sg13cmos5l_decap_4
XFILLER_18_4 VPWR VGND sg13cmos5l_decap_8
XFILLER_19_651 VPWR VGND sg13cmos5l_fill_1
XFILLER_20_1000 VPWR VGND sg13cmos5l_fill_2
XFILLER_46_470 VPWR VGND sg13cmos5l_fill_1
X_5930_ _5930_/Y _5930_/A _5930_/B VPWR VGND sg13cmos5l_nor2_1
X_7416__279 _7416_/RESET_B VPWR VGND sg13cmos5l_tiehi
X_7119__198 _7119_/D VPWR VGND sg13cmos5l_tielo
X_5861_ _5861_/X _5887_/A _5861_/B VPWR VGND sg13cmos5l_or2_1
X_7600_ _7600_/Q _7634_/CLK _7600_/D _7600_/RESET_B VPWR VGND sg13cmos5l_dfrbpq_1
X_5792_ _5792_/Y _7261_/Q _7227_/Q VPWR VGND sg13cmos5l_xnor2_1
XFILLER_22_849 VPWR VGND sg13cmos5l_decap_4
X_4812_ _4820_/C _7620_/Q _7586_/Q _7625_/Q VPWR VGND sg13cmos5l_nand3_1
X_7386__312 _7386_/RESET_B VPWR VGND sg13cmos5l_tiehi
X_7531_ _7531_/Q _7571_/CLK _7531_/D _7531_/RESET_B VPWR VGND sg13cmos5l_dfrbpq_1
X_4743_ _4744_/B _4742_/Y _4739_/Y _4754_/C VPWR VGND sg13cmos5l_mux2_1
X_7462_ _7462_/Q _7489_/CLK _7462_/D _7462_/RESET_B VPWR VGND sg13cmos5l_dfrbpq_1
XFILLER_30_860 VPWR VGND sg13cmos5l_fill_1
X_4674_ _4674_/Y _5021_/A _4682_/B VPWR VGND sg13cmos5l_nand2_1
X_6413_ _6414_/B _6413_/A _6413_/B VPWR VGND sg13cmos5l_nor2_1
X_7393_ _7393_/Q _7424_/CLK _7393_/D _7393_/RESET_B VPWR VGND sg13cmos5l_dfrbpq_1
X_6344_ _6344_/Y _7369_/Q _6341_/Y _6343_/Y VPWR VGND sg13cmos5l_o21ai_1
X_6275_ _6275_/X _6117_/Y _6299_/B _6274_/Y VPWR VGND sg13cmos5l_a21o_1
X_5226_ _5227_/A _5483_/A _5231_/B VPWR VGND sg13cmos5l_and2_1
X_7573__206 _7573_/D VPWR VGND sg13cmos5l_tielo
X_5157_ _5157_/Y _5157_/A _5157_/B VPWR VGND sg13cmos5l_nor2_1
X_4108_ _4108_/Y _4108_/A _4108_/B _4108_/C VPWR VGND sg13cmos5l_nor3_1
X_7219__521 _7219_/RESET_B VPWR VGND sg13cmos5l_tiehi
X_5088_ _5088_/Y hold827/X _5551_/A2 _5328_/A VPWR VGND sg13cmos5l_o21ai_1
X_4039_ _4862_/C _4039_/A _7647_/Q VPWR VGND sg13cmos5l_or2_1
XFILLER_8_308 VPWR VGND sg13cmos5l_decap_8
X_7330__388 _7330_/RESET_B VPWR VGND sg13cmos5l_tiehi
XFILLER_48_702 VPWR VGND sg13cmos5l_fill_2
XFILLER_8_842 VPWR VGND sg13cmos5l_fill_2
XFILLER_7_352 VPWR VGND sg13cmos5l_fill_2
X_4390_ _4390_/Y _4390_/A _4390_/B VPWR VGND sg13cmos5l_nor2_1
XFILLER_3_580 VPWR VGND sg13cmos5l_decap_8
X_6060_ _7310_/D _6060_/A _6060_/B VPWR VGND sg13cmos5l_nor2_1
XFILLER_39_735 VPWR VGND sg13cmos5l_decap_4
X_5011_ _5011_/X _5011_/A _5011_/B VPWR VGND sg13cmos5l_xor2_1
Xhold1019 _3949_/A _7163_/Q VPWR VGND sg13cmos5l_dlygate4sd3_1
Xhold1008 _4011_/A _7541_/Q VPWR VGND sg13cmos5l_dlygate4sd3_1
X_6962_ _6962_/Y _7493_/Q _4016_/Y _6961_/Y VPWR VGND sg13cmos5l_a21oi_1
X_5913_ _5917_/A _5913_/A _5913_/B _5913_/C VPWR VGND sg13cmos5l_nor3_1
X_6893_ _6893_/Y _6893_/A _7106_/B VPWR VGND sg13cmos5l_nor2_1
X_5844_ _5845_/B _5828_/B _5826_/Y _5844_/S VPWR VGND sg13cmos5l_mux2_1
X_5775_ _7268_/D _5775_/A _5845_/A VPWR VGND sg13cmos5l_nor2_1
X_7514_ _7514_/Q _7622_/CLK _7514_/D _7514_/RESET_B VPWR VGND sg13cmos5l_dfrbpq_1
XFILLER_30_690 VPWR VGND sg13cmos5l_fill_2
X_4726_ _4728_/B _4710_/Y _4470_/Y _4726_/S VPWR VGND sg13cmos5l_mux2_1
X_4657_ _4664_/B _5100_/A _4657_/B VPWR VGND sg13cmos5l_xnor2_1
X_7445_ _7445_/Q _7513_/CLK _7445_/D _7445_/RESET_B VPWR VGND sg13cmos5l_dfrbpq_1
X_7376_ _7376_/Q _7428_/CLK _7376_/D _7376_/RESET_B VPWR VGND sg13cmos5l_dfrbpq_1
Xhold820 _3872_/A _7360_/Q VPWR VGND sg13cmos5l_dlygate4sd3_1
X_6327_ _6328_/C _6302_/A _6302_/B _6323_/A _6323_/C VPWR VGND sg13cmos5l_a22oi_1
Xhold831 _5584_/A _7225_/Q VPWR VGND sg13cmos5l_dlygate4sd3_1
Xhold864 hold864/X _7446_/Q VPWR VGND sg13cmos5l_dlygate4sd3_1
Xhold853 _3865_/A _7478_/Q VPWR VGND sg13cmos5l_dlygate4sd3_1
X_4588_ _4588_/Y _7582_/Q _7549_/Q VPWR VGND sg13cmos5l_xnor2_1
Xhold842 _7480_/D _6999_/Y VPWR VGND sg13cmos5l_dlygate4sd3_1
Xhold886 _4745_/A _7574_/Q VPWR VGND sg13cmos5l_dlygate4sd3_1
Xhold875 _4939_/A _7122_/Q VPWR VGND sg13cmos5l_dlygate4sd3_1
Xhold897 _7006_/A _7460_/Q VPWR VGND sg13cmos5l_dlygate4sd3_1
X_6258_ _6258_/Y _6240_/Y _6256_/C _6257_/Y VPWR VGND sg13cmos5l_o21ai_1
X_5209_ _5209_/X _7198_/Q _5231_/B VPWR VGND sg13cmos5l_and2_1
X_6189_ _7332_/D _3876_/Y _6826_/A2 _6188_/Y VPWR VGND sg13cmos5l_a21oi_1
XFILLER_45_749 VPWR VGND sg13cmos5l_fill_2
XFILLER_26_952 VPWR VGND sg13cmos5l_decap_4
XFILLER_26_963 VPWR VGND sg13cmos5l_fill_1
XFILLER_12_123 VPWR VGND sg13cmos5l_decap_8
XFILLER_13_679 VPWR VGND sg13cmos5l_fill_1
XFILLER_32_900 VPWR VGND sg13cmos5l_fill_1
XFILLER_35_248 VPWR VGND sg13cmos5l_fill_2
XFILLER_17_996 VPWR VGND sg13cmos5l_fill_1
X_3890_ _3890_/Y _3890_/A VPWR VGND sg13cmos5l_inv_1
XFILLER_32_999 VPWR VGND sg13cmos5l_decap_8
X_5560_ _7232_/D _5560_/A _5560_/B VPWR VGND sg13cmos5l_nor2_1
X_4511_ _7570_/D _4519_/A _4511_/B VPWR VGND sg13cmos5l_nor2_1
X_5491_ _5491_/Y _5491_/A _5501_/B VPWR VGND sg13cmos5l_nor2_1
X_7209__531 _7209_/RESET_B VPWR VGND sg13cmos5l_tiehi
X_7230_ _7230_/Q _7272_/CLK _7230_/D _7230_/RESET_B VPWR VGND sg13cmos5l_dfrbpq_1
X_4442_ _4449_/A _4442_/A VPWR VGND sg13cmos5l_inv_1
X_4373_ _4391_/A _7553_/Q _4402_/B VPWR VGND sg13cmos5l_xnor2_1
X_7161_ _7161_/Q _7610_/CLK _7161_/D _7161_/RESET_B VPWR VGND sg13cmos5l_dfrbpq_1
X_6112_ _6113_/B _6112_/A _6112_/B VPWR VGND sg13cmos5l_and2_1
X_7092_ _7092_/Y _7094_/B VPWR VGND sg13cmos5l_inv_1
X_6043_ _6050_/B _6043_/A VPWR VGND sg13cmos5l_inv_1
X_7587__706 _7587_/RESET_B VPWR VGND sg13cmos5l_tiehi
X_6945_ _6946_/B _6943_/X _6944_/Y _6940_/Y VPWR VGND sg13cmos5l_a21oi_1
X_7216__524 _7216_/RESET_B VPWR VGND sg13cmos5l_tiehi
XFILLER_41_229 VPWR VGND sg13cmos5l_decap_4
X_6876_ _6876_/Y _6876_/A _6876_/B VPWR VGND sg13cmos5l_xnor2_1
X_5827_ _5828_/B _5785_/A _5683_/B _5827_/S VPWR VGND sg13cmos5l_mux2_1
XFILLER_22_476 VPWR VGND sg13cmos5l_fill_2
X_7151__593 _7151_/RESET_B VPWR VGND sg13cmos5l_tiehi
XFILLER_33_1010 VPWR VGND sg13cmos5l_decap_4
X_5758_ _7255_/D _5847_/A _5758_/B VPWR VGND sg13cmos5l_nor2_1
X_4709_ _4714_/B _4709_/A _4709_/B VPWR VGND sg13cmos5l_xor2_1
X_7428_ _7428_/Q _7428_/CLK _7428_/D _7428_/RESET_B VPWR VGND sg13cmos5l_dfrbpq_1
X_5689_ _5701_/B _7213_/Q _7212_/Q _7210_/Q _7211_/Q VPWR VGND sg13cmos5l_nor4_1
X_7223__517 _7223_/RESET_B VPWR VGND sg13cmos5l_tiehi
X_7359_ _7359_/Q _7651_/CLK _7359_/D _7359_/RESET_B VPWR VGND sg13cmos5l_dfrbpq_1
XFILLER_18_749 VPWR VGND sg13cmos5l_fill_2
XFILLER_26_782 VPWR VGND sg13cmos5l_decap_8
X_7289__179 _7289_/D VPWR VGND sg13cmos5l_tielo
XFILLER_13_465 VPWR VGND sg13cmos5l_fill_1
XFILLER_9_447 VPWR VGND sg13cmos5l_decap_8
XFILLER_4_185 VPWR VGND sg13cmos5l_fill_1
XFILLER_4_67 VPWR VGND sg13cmos5l_decap_4
X_7493__387 _7493_/RESET_B VPWR VGND sg13cmos5l_tiehi
XFILLER_36_535 VPWR VGND sg13cmos5l_fill_1
X_6730_ _6941_/A _7461_/Q _6730_/B VPWR VGND sg13cmos5l_xnor2_1
X_4991_ _5110_/A _4972_/X _4989_/X _4990_/Y _4975_/Y VPWR VGND sg13cmos5l_a22oi_1
XFILLER_17_760 VPWR VGND sg13cmos5l_decap_8
XFILLER_17_771 VPWR VGND sg13cmos5l_fill_2
X_3942_ _5562_/A _3942_/A VPWR VGND sg13cmos5l_inv_1
X_3873_ _3873_/Y _3873_/A VPWR VGND sg13cmos5l_inv_1
X_6661_ _7421_/D _6661_/A _6661_/B VPWR VGND sg13cmos5l_and2_1
X_6592_ _7402_/D _6707_/A _6699_/A VPWR VGND sg13cmos5l_nor2_1
X_5612_ _5612_/Y _5612_/A _5612_/B VPWR VGND sg13cmos5l_nor2_1
X_5543_ _5543_/Y _5530_/A _5541_/S _5558_/B VPWR VGND sg13cmos5l_o21ai_1
X_5474_ _5475_/B _7198_/Q _7173_/Q _7174_/Q VPWR VGND sg13cmos5l_nor3_1
X_4425_ _4427_/B _7564_/Q _7562_/Q _7563_/Q VPWR VGND sg13cmos5l_nor3_1
X_7213_ _7213_/Q _7214_/CLK _7213_/D _7213_/RESET_B VPWR VGND sg13cmos5l_dfrbpq_1
X_4356_ _7553_/D _7090_/B _4358_/B VPWR VGND sg13cmos5l_nor2_1
X_7144_ _7144_/Q _7635_/CLK _7144_/D _7144_/RESET_B VPWR VGND sg13cmos5l_dfrbpq_1
XFILLER_48_29 VPWR VGND sg13cmos5l_fill_1
X_4287_ _7532_/D _4337_/A _4287_/B VPWR VGND sg13cmos5l_nor2_1
X_7075_ _7075_/Y _7083_/A _7524_/Q _6968_/Y VPWR VGND sg13cmos5l_a21oi_1
X_6026_ _6026_/Y _6044_/B VPWR VGND sg13cmos5l_inv_1
XFILLER_27_546 VPWR VGND sg13cmos5l_fill_1
XFILLER_42_538 VPWR VGND sg13cmos5l_decap_4
X_6928_ _6930_/B _7457_/Q _7435_/Q VPWR VGND sg13cmos5l_nor2_1
Xfanout22 _6657_/A2 _6994_/A2 VPWR VGND sg13cmos5l_buf_1
Xfanout44 _6224_/B _6215_/B VPWR VGND sg13cmos5l_buf_1
Xfanout55 _5151_/B _5122_/Y VPWR VGND sg13cmos5l_buf_1
Xfanout33 _7112_/A2 _7108_/A2 VPWR VGND sg13cmos5l_buf_1
X_6859_ _6860_/B _7452_/Q _6875_/B _6844_/Y VPWR VGND sg13cmos5l_a21oi_1
Xfanout77 _5976_/A _5849_/Y VPWR VGND sg13cmos5l_buf_1
Xfanout88 _4788_/B _4768_/A VPWR VGND sg13cmos5l_buf_1
Xfanout99 _7072_/A _4083_/Y VPWR VGND sg13cmos5l_buf_1
Xfanout66 _6782_/A _6712_/Y VPWR VGND sg13cmos5l_buf_1
XFILLER_49_148 VPWR VGND sg13cmos5l_fill_1
XFILLER_38_51 VPWR VGND sg13cmos5l_fill_2
XFILLER_45_343 VPWR VGND sg13cmos5l_decap_8
Xhold1180 _7057_/A _7038_/Y VPWR VGND sg13cmos5l_dlygate4sd3_1
Xhold1191 _4012_/A _7540_/Q VPWR VGND sg13cmos5l_dlygate4sd3_1
XFILLER_46_899 VPWR VGND sg13cmos5l_fill_1
XFILLER_41_582 VPWR VGND sg13cmos5l_decap_8
X_7507__751 _7507_/RESET_B VPWR VGND sg13cmos5l_tiehi
Xclkload14 clkload14/Y _7424_/CLK VPWR VGND sg13cmos5l_inv_2
Xclkload25 clkload25/X _7597_/CLK VPWR VGND sg13cmos5l_buf_8
XFILLER_9_288 VPWR VGND sg13cmos5l_fill_1
XFILLER_6_984 VPWR VGND sg13cmos5l_decap_8
X_7206__534 _7206_/RESET_B VPWR VGND sg13cmos5l_tiehi
X_4210_ _4212_/A _4210_/A _4209_/Y VPWR VGND sg13cmos5l_nor2b_1
X_5190_ _5195_/B _7201_/Q _5558_/A _7200_/Q VPWR VGND sg13cmos5l_nor3_1
X_4141_ _4141_/Y _4135_/X _4139_/Y _4140_/X VPWR VGND sg13cmos5l_a21oi_1
X_7493__151 _7493_/D VPWR VGND sg13cmos5l_tielo
X_4072_ _4344_/B _4072_/A _4072_/B VPWR VGND sg13cmos5l_nand2_1
XFILLER_49_693 VPWR VGND sg13cmos5l_decap_8
XFILLER_37_844 VPWR VGND sg13cmos5l_decap_8
XFILLER_36_343 VPWR VGND sg13cmos5l_fill_1
XFILLER_36_354 VPWR VGND sg13cmos5l_decap_4
X_7213__527 _7213_/RESET_B VPWR VGND sg13cmos5l_tiehi
X_4974_ _4974_/Y _4981_/B _4982_/B VPWR VGND sg13cmos5l_nand2_1
X_7584__709 _7584_/RESET_B VPWR VGND sg13cmos5l_tiehi
X_6713_ _6728_/B _7432_/Q _7431_/Q _7430_/Q VPWR VGND sg13cmos5l_or3_1
X_3925_ _3925_/Y _7320_/Q VPWR VGND sg13cmos5l_inv_1
X_6644_ _6644_/Y _6628_/Y _6642_/Y _6643_/Y VPWR VGND sg13cmos5l_a21oi_1
Xclkload8 clkload8/Y clkload8/A VPWR VGND sg13cmos5l_inv_1
X_6575_ _6575_/X _6575_/A _6767_/A VPWR VGND sg13cmos5l_and2_1
X_5526_ _5526_/Y _7217_/Q _5520_/Y _5531_/B _7218_/Q VPWR VGND sg13cmos5l_a22oi_1
X_5457_ _5458_/B _5441_/X _5455_/X _5456_/Y _5444_/Y VPWR VGND sg13cmos5l_a22oi_1
X_4408_ _4414_/C _4380_/A _4380_/B _4389_/Y _4407_/Y _4390_/Y VPWR VGND sg13cmos5l_a221oi_1
XFILLER_8_1014 VPWR VGND sg13cmos5l_decap_8
X_5388_ _5389_/B _5388_/A _5388_/B VPWR VGND sg13cmos5l_xnor2_1
X_7127_ _7127_/Q _7424_/CLK _7127_/D _7127_/RESET_B VPWR VGND sg13cmos5l_dfrbpq_1
X_4339_ _4339_/Y _4540_/B _4336_/S _4338_/Y VPWR VGND sg13cmos5l_a21oi_1
X_7058_ _7059_/B _7039_/B _7056_/Y _7006_/B VPWR VGND sg13cmos5l_o21ai_1
XFILLER_46_118 VPWR VGND sg13cmos5l_fill_2
X_6009_ _6009_/Y _6007_/Y _6008_/Y _6006_/Y VPWR VGND sg13cmos5l_a21oi_1
XFILLER_39_192 VPWR VGND sg13cmos5l_fill_1
XFILLER_28_877 VPWR VGND sg13cmos5l_decap_8
XFILLER_27_365 VPWR VGND sg13cmos5l_fill_2
XFILLER_42_335 VPWR VGND sg13cmos5l_decap_8
XFILLER_15_538 VPWR VGND sg13cmos5l_fill_1
XFILLER_42_368 VPWR VGND sg13cmos5l_decap_8
XFILLER_24_31 VPWR VGND sg13cmos5l_decap_8
XFILLER_10_221 VPWR VGND sg13cmos5l_fill_2
XFILLER_7_748 VPWR VGND sg13cmos5l_fill_2
XFILLER_10_265 VPWR VGND sg13cmos5l_decap_8
XFILLER_3_910 VPWR VGND sg13cmos5l_fill_2
XFILLER_3_965 VPWR VGND sg13cmos5l_decap_8
XFILLER_19_888 VPWR VGND sg13cmos5l_decap_4
XFILLER_33_335 VPWR VGND sg13cmos5l_fill_2
X_4690_ _4690_/Y _4690_/A _4690_/B VPWR VGND sg13cmos5l_nor2_1
X_6360_ _7348_/D _6425_/A _6411_/D VPWR VGND sg13cmos5l_nor2_1
X_5311_ _5311_/X _5292_/Y _5518_/B _5315_/S VPWR VGND sg13cmos5l_mux2_1
X_6291_ _6321_/B _6113_/B _6289_/Y _6290_/Y VPWR VGND sg13cmos5l_a21o_1
X_5242_ _5242_/Y _4981_/A _7137_/Q VPWR VGND sg13cmos5l_nand2b_1
XFILLER_39_0 VPWR VGND sg13cmos5l_fill_2
X_5173_ _5175_/B _5176_/S _5173_/B VPWR VGND sg13cmos5l_nand2b_1
X_4124_ _4124_/Y _7493_/Q _4124_/B VPWR VGND sg13cmos5l_xnor2_1
Xinput1 input1/X rst_n VPWR VGND sg13cmos5l_buf_1
X_4055_ _4055_/Y input8/X _4058_/B _4871_/C VPWR VGND sg13cmos5l_o21ai_1
X_4957_ _4990_/A _7133_/Q _4957_/B VPWR VGND sg13cmos5l_xor2_1
X_7629__661 _7629_/RESET_B VPWR VGND sg13cmos5l_tiehi
X_7287__447 _7287_/RESET_B VPWR VGND sg13cmos5l_tiehi
X_4888_ _4888_/X _4889_/A _4888_/B VPWR VGND sg13cmos5l_or2_1
X_3908_ _3908_/Y _7460_/Q VPWR VGND sg13cmos5l_inv_1
XFILLER_20_552 VPWR VGND sg13cmos5l_decap_8
X_6627_ _6627_/Y _6834_/A _6830_/A VPWR VGND sg13cmos5l_nor2b_1
X_6558_ _6570_/B _7401_/Q _7400_/Q _7399_/Q VPWR VGND sg13cmos5l_or3_1
XFILLER_4_718 VPWR VGND sg13cmos5l_decap_8
XFILLER_3_206 VPWR VGND sg13cmos5l_fill_1
XFILLER_3_228 VPWR VGND sg13cmos5l_decap_4
X_5509_ _5509_/Y _7238_/Q _5527_/B _5523_/B _7237_/Q _5508_/Y VPWR VGND sg13cmos5l_a221oi_1
X_7148__598 _7148_/RESET_B VPWR VGND sg13cmos5l_tiehi
X_6489_ _6489_/Y _6485_/Y _6486_/Y _6488_/Y VPWR VGND sg13cmos5l_o21ai_1
XFILLER_0_935 VPWR VGND sg13cmos5l_decap_8
X_7636__654 _7636_/RESET_B VPWR VGND sg13cmos5l_tiehi
XFILLER_27_195 VPWR VGND sg13cmos5l_fill_1
XFILLER_42_187 VPWR VGND sg13cmos5l_fill_1
XFILLER_30_316 VPWR VGND sg13cmos5l_decap_4
X_7485__426 _7485_/RESET_B VPWR VGND sg13cmos5l_tiehi
XFILLER_42_198 VPWR VGND sg13cmos5l_fill_2
XFILLER_23_390 VPWR VGND sg13cmos5l_fill_1
X_7444__156 _7444_/D VPWR VGND sg13cmos5l_tielo
X_7409__287 _7409_/RESET_B VPWR VGND sg13cmos5l_tiehi
XFILLER_3_751 VPWR VGND sg13cmos5l_fill_1
X_7203__537 _7203_/RESET_B VPWR VGND sg13cmos5l_tiehi
XFILLER_3_784 VPWR VGND sg13cmos5l_fill_2
XFILLER_25_6 VPWR VGND sg13cmos5l_fill_1
XFILLER_46_493 VPWR VGND sg13cmos5l_fill_2
X_5860_ _5860_/Y _5859_/A _5887_/A _5860_/C VPWR VGND sg13cmos5l_nand3b_1
XFILLER_33_110 VPWR VGND sg13cmos5l_fill_1
X_4811_ _4831_/C _4830_/A _4848_/B VPWR VGND sg13cmos5l_nand2_1
X_5791_ _5791_/Y _7260_/Q _7226_/Q VPWR VGND sg13cmos5l_xnor2_1
X_7530_ _7530_/Q _7560_/CLK _7530_/D _7530_/RESET_B VPWR VGND sg13cmos5l_dfrbpq_1
X_4742_ _4742_/Y _5102_/A _5098_/A VPWR VGND sg13cmos5l_nand2_1
X_4673_ _4673_/Y _5097_/A _5021_/A VPWR VGND sg13cmos5l_nor2_1
X_7461_ _7461_/Q _7490_/CLK _7461_/D _7461_/RESET_B VPWR VGND sg13cmos5l_dfrbpq_1
X_6412_ _6412_/Y _6412_/A _6412_/B VPWR VGND sg13cmos5l_nand2_1
X_7392_ _7392_/Q _7394_/CLK _7392_/D _7392_/RESET_B VPWR VGND sg13cmos5l_dfrbpq_1
X_6343_ _6343_/Y _7368_/Q _7346_/Q _6343_/C VPWR VGND sg13cmos5l_nand3_1
X_6274_ _6274_/Y _6112_/A _6112_/B _6263_/Y _6191_/A _6271_/Y VPWR VGND sg13cmos5l_a221oi_1
X_5225_ _7169_/D _5314_/A _5340_/A VPWR VGND sg13cmos5l_nor2_1
X_5156_ _5157_/B _5116_/A _5116_/B _5110_/A VPWR VGND sg13cmos5l_a21oi_1
X_4107_ _4108_/C _7083_/B _4105_/B _4106_/Y VPWR VGND sg13cmos5l_a21oi_1
X_5087_ _7148_/D _5087_/A _5087_/B VPWR VGND sg13cmos5l_and2_1
X_4038_ _4058_/B _7648_/Q _7647_/Q VPWR VGND sg13cmos5l_nor2_1
XFILLER_24_110 VPWR VGND sg13cmos5l_fill_2
XFILLER_25_611 VPWR VGND sg13cmos5l_fill_1
X_5989_ _7303_/D _5989_/A _5990_/B VPWR VGND sg13cmos5l_and2_1
XFILLER_21_87 VPWR VGND sg13cmos5l_fill_1
XFILLER_0_721 VPWR VGND sg13cmos5l_decap_4
XFILLER_0_732 VPWR VGND sg13cmos5l_decap_8
XFILLER_16_622 VPWR VGND sg13cmos5l_fill_2
XFILLER_43_452 VPWR VGND sg13cmos5l_decap_4
XFILLER_15_154 VPWR VGND sg13cmos5l_decap_8
XFILLER_31_614 VPWR VGND sg13cmos5l_fill_1
XFILLER_7_342 VPWR VGND sg13cmos5l_fill_1
XFILLER_8_876 VPWR VGND sg13cmos5l_fill_1
X_5010_ _5017_/B _7609_/Q _5011_/B VPWR VGND sg13cmos5l_xnor2_1
X_7277__457 _7277_/RESET_B VPWR VGND sg13cmos5l_tiehi
Xhold1009 _7541_/D _4339_/Y VPWR VGND sg13cmos5l_dlygate4sd3_1
XFILLER_26_419 VPWR VGND sg13cmos5l_fill_2
X_6961_ _6961_/Y _7492_/Q _6792_/B _6816_/B _7491_/Q _6960_/Y VPWR VGND sg13cmos5l_a221oi_1
X_5912_ _5913_/C _5912_/A _5930_/A VPWR VGND sg13cmos5l_nor2_1
X_6892_ _7460_/D _6874_/Y _6892_/A2 _6889_/A VPWR VGND sg13cmos5l_a21oi_1
XFILLER_34_441 VPWR VGND sg13cmos5l_decap_8
X_5843_ _7274_/D _5843_/A1 _5844_/S _5842_/Y VPWR VGND sg13cmos5l_a21oi_1
XFILLER_10_809 VPWR VGND sg13cmos5l_decap_8
X_5774_ _7267_/D _5774_/A _5774_/B VPWR VGND sg13cmos5l_and2_1
X_7513_ _7513_/Q _7513_/CLK _7513_/D _7513_/RESET_B VPWR VGND sg13cmos5l_dfrbpq_1
X_7626__664 _7626_/RESET_B VPWR VGND sg13cmos5l_tiehi
X_4725_ _7607_/D _4728_/A _4725_/B VPWR VGND sg13cmos5l_nor2_1
X_4656_ _4689_/A _7633_/Q _4657_/B VPWR VGND sg13cmos5l_xnor2_1
X_7444_ _7444_/Q _7513_/CLK _7444_/D _7444_/RESET_B VPWR VGND sg13cmos5l_dfrbpq_1
X_7375_ _7375_/Q _7375_/CLK _7375_/D _7375_/RESET_B VPWR VGND sg13cmos5l_dfrbpq_1
X_4587_ _4587_/Y _7581_/Q _7548_/Q VPWR VGND sg13cmos5l_xnor2_1
Xhold810 _3863_/A _7479_/Q VPWR VGND sg13cmos5l_dlygate4sd3_1
Xhold821 _7386_/D _6502_/Y VPWR VGND sg13cmos5l_dlygate4sd3_1
X_6326_ _6328_/B _6329_/A _6326_/B _6329_/C VPWR VGND sg13cmos5l_nor3_1
Xhold832 _7262_/D _5769_/Y VPWR VGND sg13cmos5l_dlygate4sd3_1
Xhold843 _3890_/A _7150_/Q VPWR VGND sg13cmos5l_dlygate4sd3_1
Xhold854 _3860_/A _7512_/Q VPWR VGND sg13cmos5l_dlygate4sd3_1
Xhold876 _6969_/B _7475_/Q VPWR VGND sg13cmos5l_dlygate4sd3_1
Xhold865 _3887_/A _7224_/Q VPWR VGND sg13cmos5l_dlygate4sd3_1
Xhold887 _7574_/D _4551_/Y VPWR VGND sg13cmos5l_dlygate4sd3_1
Xhold898 hold898/X _7386_/Q VPWR VGND sg13cmos5l_dlygate4sd3_1
X_6257_ _6257_/Y _6260_/B _6254_/C _6254_/A VPWR VGND sg13cmos5l_o21ai_1
X_5208_ _5208_/X _5208_/A _5208_/B VPWR VGND sg13cmos5l_or2_1
X_6188_ _6188_/Y _6197_/A _6826_/A2 _6659_/A VPWR VGND sg13cmos5l_o21ai_1
X_5139_ _5139_/Y _5139_/A _5153_/A _5139_/C VPWR VGND sg13cmos5l_nor3_1
X_7633__657 _7633_/RESET_B VPWR VGND sg13cmos5l_tiehi
XFILLER_44_205 VPWR VGND sg13cmos5l_fill_1
XFILLER_44_238 VPWR VGND sg13cmos5l_fill_2
XFILLER_41_923 VPWR VGND sg13cmos5l_fill_2
XFILLER_41_912 VPWR VGND sg13cmos5l_fill_1
XFILLER_16_54 VPWR VGND sg13cmos5l_decap_8
XFILLER_25_474 VPWR VGND sg13cmos5l_fill_1
XFILLER_5_846 VPWR VGND sg13cmos5l_decap_8
XFILLER_5_879 VPWR VGND sg13cmos5l_fill_1
X_7458__645 _7458_/RESET_B VPWR VGND sg13cmos5l_tiehi
XFILLER_0_584 VPWR VGND sg13cmos5l_decap_8
XFILLER_17_931 VPWR VGND sg13cmos5l_decap_4
XFILLER_43_260 VPWR VGND sg13cmos5l_fill_2
XFILLER_31_400 VPWR VGND sg13cmos5l_fill_2
XFILLER_31_433 VPWR VGND sg13cmos5l_fill_2
X_7465__627 _7465_/RESET_B VPWR VGND sg13cmos5l_tiehi
X_7604__203 _7604_/D VPWR VGND sg13cmos5l_tielo
X_4510_ _4511_/B _4580_/B VPWR VGND sg13cmos5l_inv_1
X_5490_ _5490_/Y _5488_/A _5488_/B _5489_/Y VPWR VGND sg13cmos5l_o21ai_1
X_4441_ _4442_/A _7597_/Q _4441_/B VPWR VGND sg13cmos5l_xnor2_1
X_7160_ _7160_/Q _7634_/CLK _7160_/D _7160_/RESET_B VPWR VGND sg13cmos5l_dfrbpq_1
X_4372_ _4379_/C _4402_/B VPWR VGND sg13cmos5l_inv_1
X_6111_ _6112_/B _6145_/A _6114_/B _6122_/B VPWR VGND sg13cmos5l_nand3_1
X_7091_ _7094_/B _6989_/Y _7090_/Y _7091_/S VPWR VGND sg13cmos5l_mux2_1
X_6042_ _6043_/A _5933_/B _5892_/B _6042_/S VPWR VGND sg13cmos5l_mux2_1
X_6944_ _6944_/Y _6944_/A _6955_/B VPWR VGND sg13cmos5l_nor2_1
XFILLER_23_956 VPWR VGND sg13cmos5l_fill_1
X_6875_ _6876_/B _7455_/Q _6875_/B VPWR VGND sg13cmos5l_xnor2_1
X_5826_ _5826_/Y _5828_/A VPWR VGND sg13cmos5l_inv_1
X_5757_ _5758_/B _5744_/B _3970_/Y _5759_/S VPWR VGND sg13cmos5l_mux2_1
X_4708_ _4713_/B _7571_/Q _4709_/B VPWR VGND sg13cmos5l_nor2b_1
X_7427_ _7427_/Q _7490_/CLK _7427_/D _7427_/RESET_B VPWR VGND sg13cmos5l_dfrbpq_1
X_5688_ _5698_/B _7212_/Q _7210_/Q _7211_/Q VPWR VGND sg13cmos5l_or3_1
X_4639_ _7596_/D _4622_/A _4630_/X _4638_/Y VPWR VGND sg13cmos5l_a21oi_1
X_7358_ _7358_/Q clkload6/A _7358_/D _7358_/RESET_B VPWR VGND sg13cmos5l_dfrbpq_1
X_7289_ _7289_/Q _7314_/CLK _7289_/D _7289_/RESET_B VPWR VGND sg13cmos5l_dfrbpq_1
X_6309_ _6310_/A _6309_/A _6309_/B VPWR VGND sg13cmos5l_nor2_1
XFILLER_18_717 VPWR VGND sg13cmos5l_decap_8
XFILLER_26_772 VPWR VGND sg13cmos5l_fill_2
XFILLER_13_411 VPWR VGND sg13cmos5l_fill_1
XFILLER_41_786 VPWR VGND sg13cmos5l_fill_1
XFILLER_13_477 VPWR VGND sg13cmos5l_fill_2
XFILLER_40_296 VPWR VGND sg13cmos5l_fill_1
X_7267__467 _7267_/RESET_B VPWR VGND sg13cmos5l_tiehi
XFILLER_49_831 VPWR VGND sg13cmos5l_decap_4
XFILLER_49_853 VPWR VGND sg13cmos5l_decap_4
XFILLER_36_569 VPWR VGND sg13cmos5l_decap_8
X_4990_ _4990_/Y _4990_/A _4994_/B VPWR VGND sg13cmos5l_nor2_1
X_3941_ _5775_/A _3941_/A VPWR VGND sg13cmos5l_inv_1
XFILLER_32_720 VPWR VGND sg13cmos5l_fill_2
XFILLER_32_731 VPWR VGND sg13cmos5l_fill_2
XFILLER_17_1028 VPWR VGND sg13cmos5l_fill_1
XFILLER_20_926 VPWR VGND sg13cmos5l_decap_4
X_7645__347 _7645_/RESET_B VPWR VGND sg13cmos5l_tiehi
X_3872_ _3872_/Y _3872_/A VPWR VGND sg13cmos5l_inv_1
X_6660_ _7420_/D _6660_/A _6660_/B VPWR VGND sg13cmos5l_and2_1
XFILLER_32_764 VPWR VGND sg13cmos5l_fill_1
X_6591_ _6699_/A _6576_/B _6578_/Y _6575_/X VPWR VGND sg13cmos5l_a21oi_1
X_5611_ _5618_/B _5611_/A VPWR VGND sg13cmos5l_inv_1
X_5542_ _7218_/D _5542_/A _5542_/B VPWR VGND sg13cmos5l_nor2_1
X_7623__667 _7623_/RESET_B VPWR VGND sg13cmos5l_tiehi
X_5473_ _5473_/Y _5472_/A _5472_/B _5221_/A VPWR VGND sg13cmos5l_a21oi_1
X_7593__700 _7593_/RESET_B VPWR VGND sg13cmos5l_tiehi
X_7212_ _7212_/Q _7214_/CLK _7212_/D _7212_/RESET_B VPWR VGND sg13cmos5l_dfrbpq_1
X_4424_ _4714_/A _4441_/B _4423_/Y VPWR VGND sg13cmos5l_nor2b_1
X_7143_ _7143_/Q _7611_/CLK _7143_/D _7143_/RESET_B VPWR VGND sg13cmos5l_dfrbpq_1
X_4355_ _7552_/D _4355_/A _4358_/B VPWR VGND sg13cmos5l_nor2_1
X_7074_ _7502_/D _7105_/A _7074_/B VPWR VGND sg13cmos5l_nor2_1
X_4286_ _4286_/Y _4287_/B VPWR VGND sg13cmos5l_inv_1
X_6025_ _6044_/B _5999_/B _5889_/B _6042_/S VPWR VGND sg13cmos5l_mux2_1
X_6927_ _6934_/B _6927_/A _6952_/A VPWR VGND sg13cmos5l_nor2_1
XFILLER_23_742 VPWR VGND sg13cmos5l_fill_1
Xfanout45 _6215_/B _6200_/Y VPWR VGND sg13cmos5l_buf_1
XFILLER_22_230 VPWR VGND sg13cmos5l_fill_1
Xfanout34 _5769_/A2 _7108_/A2 VPWR VGND sg13cmos5l_buf_1
Xfanout56 _4835_/B _4848_/B VPWR VGND sg13cmos5l_buf_1
Xfanout23 _6994_/A2 fanout28/X VPWR VGND sg13cmos5l_buf_1
X_6858_ _6868_/B _6858_/A _6858_/B VPWR VGND sg13cmos5l_nor2_1
XFILLER_11_937 VPWR VGND sg13cmos5l_decap_8
Xfanout78 _5845_/A _5778_/B VPWR VGND sg13cmos5l_buf_1
X_5809_ _5809_/Y _5833_/B _5809_/B _5809_/C VPWR VGND sg13cmos5l_nand3b_1
Xfanout89 _4768_/A _4679_/Y VPWR VGND sg13cmos5l_buf_1
Xfanout67 _6891_/A _6711_/Y VPWR VGND sg13cmos5l_buf_1
XFILLER_6_407 VPWR VGND sg13cmos5l_decap_8
XFILLER_10_458 VPWR VGND sg13cmos5l_fill_1
XFILLER_10_469 VPWR VGND sg13cmos5l_decap_8
X_6789_ _6809_/A _6789_/A _6789_/B _6801_/B VPWR VGND sg13cmos5l_nand3_1
XFILLER_6_418 VPWR VGND sg13cmos5l_decap_8
XFILLER_13_88 VPWR VGND sg13cmos5l_decap_8
XFILLER_8_4 VPWR VGND sg13cmos5l_fill_1
XFILLER_49_105 VPWR VGND sg13cmos5l_fill_2
XFILLER_49_116 VPWR VGND sg13cmos5l_decap_8
XFILLER_1_178 VPWR VGND sg13cmos5l_fill_1
XFILLER_46_801 VPWR VGND sg13cmos5l_decap_8
XFILLER_46_834 VPWR VGND sg13cmos5l_decap_4
Xhold1170 _5624_/A1 _5603_/Y VPWR VGND sg13cmos5l_dlygate4sd3_1
Xhold1181 _7489_/D _7059_/Y VPWR VGND sg13cmos5l_dlygate4sd3_1
Xhold1192 _4186_/A _7517_/Q VPWR VGND sg13cmos5l_dlygate4sd3_1
XFILLER_45_355 VPWR VGND sg13cmos5l_decap_8
XFILLER_26_580 VPWR VGND sg13cmos5l_fill_2
XFILLER_13_263 VPWR VGND sg13cmos5l_decap_8
XFILLER_10_970 VPWR VGND sg13cmos5l_decap_8
Xclkload15 clkload15/Y _7239_/CLK VPWR VGND sg13cmos5l_inv_1
XFILLER_6_963 VPWR VGND sg13cmos5l_decap_8
X_4140_ _4140_/X _4140_/A _4140_/B _4160_/B VPWR VGND sg13cmos5l_and3_1
X_4071_ _4072_/B _7649_/Q _4043_/B _4070_/Y _4071_/B2 _4059_/A VPWR VGND sg13cmos5l_a221oi_1
XFILLER_37_812 VPWR VGND sg13cmos5l_fill_1
XFILLER_48_182 VPWR VGND sg13cmos5l_fill_2
XFILLER_37_867 VPWR VGND sg13cmos5l_fill_1
XFILLER_24_528 VPWR VGND sg13cmos5l_fill_2
X_4973_ _4973_/X _7161_/Q _4993_/B VPWR VGND sg13cmos5l_and2_1
X_3924_ _6095_/A _7344_/Q VPWR VGND sg13cmos5l_inv_1
X_6712_ _6712_/Y _6993_/B _7002_/A VPWR VGND sg13cmos5l_nand2b_1
X_6643_ _6643_/Y _6789_/B _6642_/Y _6661_/B VPWR VGND sg13cmos5l_o21ai_1
XFILLER_20_712 VPWR VGND sg13cmos5l_fill_2
Xclkload9 clkload9/Y clkload9/A VPWR VGND sg13cmos5l_inv_8
X_6574_ _6767_/A _7429_/Q _6574_/B VPWR VGND sg13cmos5l_xnor2_1
XFILLER_30_1014 VPWR VGND sg13cmos5l_decap_8
X_5525_ _5531_/B _5513_/Y _5523_/Y _5524_/Y _5527_/C VPWR VGND sg13cmos5l_a22oi_1
X_5456_ _5456_/Y _5456_/A _5461_/B VPWR VGND sg13cmos5l_nor2_1
X_4407_ _4407_/Y _4407_/A _4407_/B VPWR VGND sg13cmos5l_nor2_1
X_5387_ _5388_/B _7195_/Q _5387_/B VPWR VGND sg13cmos5l_xnor2_1
X_7126_ _7126_/Q _7394_/CLK _7126_/D _7126_/RESET_B VPWR VGND sg13cmos5l_dfrbpq_1
X_4338_ _4338_/Y _4324_/X _4336_/S _4357_/B VPWR VGND sg13cmos5l_o21ai_1
XFILLER_47_609 VPWR VGND sg13cmos5l_fill_2
X_4269_ _4518_/A _4498_/A _4269_/B VPWR VGND sg13cmos5l_nor2_1
X_7057_ _7059_/A _7057_/A _7056_/Y VPWR VGND sg13cmos5l_nor2b_1
X_6008_ _6008_/Y _7298_/Q _7264_/Q VPWR VGND sg13cmos5l_xnor2_1
XFILLER_28_823 VPWR VGND sg13cmos5l_fill_1
XFILLER_11_723 VPWR VGND sg13cmos5l_fill_2
XFILLER_7_727 VPWR VGND sg13cmos5l_fill_2
XFILLER_6_237 VPWR VGND sg13cmos5l_decap_4
XFILLER_46_1021 VPWR VGND sg13cmos5l_decap_8
XFILLER_37_108 VPWR VGND sg13cmos5l_decap_4
XFILLER_46_664 VPWR VGND sg13cmos5l_fill_2
XFILLER_18_355 VPWR VGND sg13cmos5l_fill_1
XFILLER_45_185 VPWR VGND sg13cmos5l_decap_4
XFILLER_14_583 VPWR VGND sg13cmos5l_fill_2
X_5310_ _7179_/D _5314_/A _5310_/B VPWR VGND sg13cmos5l_nor2_1
X_6290_ _6290_/Y _6293_/A _6290_/B _6293_/C _6293_/D VPWR VGND sg13cmos5l_nor4_1
XFILLER_5_270 VPWR VGND sg13cmos5l_fill_1
XFILLER_46_2 VPWR VGND sg13cmos5l_fill_1
X_5241_ _5267_/A _7137_/Q _7136_/Q VPWR VGND sg13cmos5l_xnor2_1
X_7536__211 _7536_/D VPWR VGND sg13cmos5l_tielo
X_7590__703 _7590_/RESET_B VPWR VGND sg13cmos5l_tiehi
X_5172_ _7162_/D _5172_/A1 _5176_/S _5171_/Y VPWR VGND sg13cmos5l_a21oi_1
X_4123_ _4132_/A _4124_/B _4123_/B VPWR VGND sg13cmos5l_nand2b_1
X_4054_ _8273_/A _4901_/A _4058_/B VPWR VGND sg13cmos5l_nand2_1
Xinput2 input2/X ui_in[0] VPWR VGND sg13cmos5l_buf_1
XFILLER_49_491 VPWR VGND sg13cmos5l_fill_2
XFILLER_49_480 VPWR VGND sg13cmos5l_decap_8
XFILLER_37_686 VPWR VGND sg13cmos5l_fill_2
XFILLER_25_826 VPWR VGND sg13cmos5l_fill_2
XFILLER_40_829 VPWR VGND sg13cmos5l_fill_1
X_4956_ _4960_/B _7133_/Q _7132_/Q _7130_/Q _7131_/Q VPWR VGND sg13cmos5l_nor4_1
X_3907_ _6737_/A _7004_/A VPWR VGND sg13cmos5l_inv_1
X_4887_ _4887_/Y _3892_/A _4901_/A _4888_/B VPWR VGND sg13cmos5l_o21ai_1
X_6626_ _6626_/Y _7383_/Q _6626_/B _6633_/C VPWR VGND sg13cmos5l_nor3_1
X_6557_ _6751_/A _7426_/Q _7427_/Q VPWR VGND sg13cmos5l_xnor2_1
X_5508_ _5508_/Y _5775_/A _7181_/Q _7180_/Q _5451_/A _5507_/Y VPWR VGND sg13cmos5l_a221oi_1
X_6488_ _6488_/Y _7381_/Q _6485_/B _6487_/X _7382_/Q VPWR VGND sg13cmos5l_a22oi_1
X_5439_ _5439_/Y _5429_/X _5702_/A VPWR VGND sg13cmos5l_nand2b_1
XFILLER_0_914 VPWR VGND sg13cmos5l_decap_8
XFILLER_10_56 VPWR VGND sg13cmos5l_decap_8
X_7109_ _7109_/Y _7511_/Q _7112_/A2 _7113_/A VPWR VGND sg13cmos5l_o21ai_1
XFILLER_15_336 VPWR VGND sg13cmos5l_fill_1
XFILLER_35_53 VPWR VGND sg13cmos5l_fill_2
XFILLER_24_870 VPWR VGND sg13cmos5l_fill_2
XFILLER_7_568 VPWR VGND sg13cmos5l_fill_2
XFILLER_3_796 VPWR VGND sg13cmos5l_decap_8
XFILLER_2_284 VPWR VGND sg13cmos5l_fill_1
XFILLER_47_984 VPWR VGND sg13cmos5l_decap_8
X_4810_ _4820_/A _4810_/A _4848_/B VPWR VGND sg13cmos5l_xnor2_1
X_5790_ _5790_/Y _7262_/Q _5800_/B VPWR VGND sg13cmos5l_nand2_1
XFILLER_14_391 VPWR VGND sg13cmos5l_decap_4
X_4741_ _4754_/C _4745_/B _4741_/B VPWR VGND sg13cmos5l_and2_1
X_4672_ _4672_/X _4672_/A _4672_/B VPWR VGND sg13cmos5l_or2_1
X_7460_ _7460_/Q _7490_/CLK _7460_/D _7460_/RESET_B VPWR VGND sg13cmos5l_dfrbpq_1
X_6411_ _6412_/B _6411_/A _6411_/B _6411_/C _6411_/D VPWR VGND sg13cmos5l_nand4_1
X_7391_ _7391_/Q _7394_/CLK _7391_/D _7391_/RESET_B VPWR VGND sg13cmos5l_dfrbpq_1
X_6342_ _6343_/C _7369_/Q _7347_/Q VPWR VGND sg13cmos5l_nand2_1
X_6273_ _6273_/Y _6295_/A _6294_/A _6290_/B _6113_/B VPWR VGND sg13cmos5l_a22oi_1
X_5224_ _5340_/A _5222_/Y _5223_/X _5229_/S VPWR VGND sg13cmos5l_mux2_1
X_5155_ _5157_/A _5155_/A _5155_/B _5155_/C VPWR VGND sg13cmos5l_nor3_1
X_4106_ _4106_/Y _4106_/A _4106_/B VPWR VGND sg13cmos5l_xnor2_1
XFILLER_38_951 VPWR VGND sg13cmos5l_fill_1
X_5086_ _5086_/Y _5073_/Y hold972/X _5177_/A VPWR VGND sg13cmos5l_a21oi_1
X_4037_ _4883_/B hold948/X _4035_/B _7646_/Q VPWR VGND sg13cmos5l_o21ai_1
XFILLER_24_133 VPWR VGND sg13cmos5l_fill_2
X_5988_ _7302_/D _6659_/A _5988_/B VPWR VGND sg13cmos5l_and2_1
XFILLER_24_177 VPWR VGND sg13cmos5l_fill_1
XFILLER_24_199 VPWR VGND sg13cmos5l_fill_1
X_4939_ _4941_/C _4939_/A _4939_/B VPWR VGND sg13cmos5l_xnor2_1
X_6609_ _6609_/Y _6609_/A VPWR VGND sg13cmos5l_inv_1
X_7589_ _7589_/Q _7597_/CLK _7589_/D _7589_/RESET_B VPWR VGND sg13cmos5l_dfrbpq_1
XFILLER_4_516 VPWR VGND sg13cmos5l_fill_1
XFILLER_0_788 VPWR VGND sg13cmos5l_decap_4
XFILLER_46_63 VPWR VGND sg13cmos5l_decap_8
XFILLER_28_483 VPWR VGND sg13cmos5l_fill_1
XFILLER_15_122 VPWR VGND sg13cmos5l_decap_4
X_7415__281 _7415_/RESET_B VPWR VGND sg13cmos5l_tiehi
XFILLER_43_475 VPWR VGND sg13cmos5l_fill_2
XFILLER_16_678 VPWR VGND sg13cmos5l_fill_2
XFILLER_31_604 VPWR VGND sg13cmos5l_fill_1
XFILLER_31_659 VPWR VGND sg13cmos5l_fill_2
XFILLER_12_851 VPWR VGND sg13cmos5l_decap_8
XFILLER_8_855 VPWR VGND sg13cmos5l_decap_8
XFILLER_12_884 VPWR VGND sg13cmos5l_decap_4
X_6960_ _6960_/Y _6976_/B _7442_/Q _7441_/Q _4144_/A _6959_/Y VPWR VGND sg13cmos5l_a221oi_1
XFILLER_47_792 VPWR VGND sg13cmos5l_fill_1
X_5911_ _5913_/B _5915_/A _5915_/B VPWR VGND sg13cmos5l_nor2_1
X_6891_ _7459_/D _6891_/A _6891_/B VPWR VGND sg13cmos5l_and2_1
X_5842_ _5842_/Y _5811_/Y _5844_/S _5774_/B VPWR VGND sg13cmos5l_o21ai_1
XFILLER_34_475 VPWR VGND sg13cmos5l_fill_1
X_5773_ _7266_/D _5773_/A _5774_/B VPWR VGND sg13cmos5l_and2_1
X_7512_ _7512_/Q _7513_/CLK _7512_/D _7512_/RESET_B VPWR VGND sg13cmos5l_dfrbpq_1
X_4724_ _4725_/B _4701_/X _4726_/S _4723_/Y VPWR VGND sg13cmos5l_o21ai_1
X_4655_ _4661_/B _7633_/Q _7632_/Q _5098_/A VPWR VGND sg13cmos5l_nor3_1
X_7443_ _7443_/Q _7513_/CLK _7443_/D _7443_/RESET_B VPWR VGND sg13cmos5l_dfrbpq_1
X_7374_ _7374_/Q _7375_/CLK _7374_/D _7374_/RESET_B VPWR VGND sg13cmos5l_dfrbpq_1
Xhold800 _4031_/A _7643_/Q VPWR VGND sg13cmos5l_dlygate4sd3_1
Xhold811 _7511_/D _7110_/Y VPWR VGND sg13cmos5l_dlygate4sd3_1
X_4586_ _4586_/Y _4586_/A _4586_/B VPWR VGND sg13cmos5l_nand2_1
X_6325_ _7341_/D _6325_/A _6325_/B _6325_/C VPWR VGND sg13cmos5l_nor3_1
Xhold822 _3891_/A _7149_/Q VPWR VGND sg13cmos5l_dlygate4sd3_1
Xhold844 _7150_/D _5091_/Y VPWR VGND sg13cmos5l_dlygate4sd3_1
Xhold833 _4871_/A _7637_/Q VPWR VGND sg13cmos5l_dlygate4sd3_1
Xhold855 hold855/X _7546_/Q VPWR VGND sg13cmos5l_dlygate4sd3_1
Xhold877 hold877/X _6969_/Y VPWR VGND sg13cmos5l_dlygate4sd3_1
Xhold866 hold866/X _7261_/Q VPWR VGND sg13cmos5l_dlygate4sd3_1
Xhold888 hold888/X _7114_/Q VPWR VGND sg13cmos5l_dlygate4sd3_1
X_6256_ _6256_/Y _6256_/A _6256_/B _6256_/C VPWR VGND sg13cmos5l_nor3_1
Xhold899 _6162_/A _7326_/Q VPWR VGND sg13cmos5l_dlygate4sd3_1
X_5207_ _5208_/B _5489_/B _5228_/B _5206_/Y VPWR VGND sg13cmos5l_o21ai_1
X_6187_ _6187_/Y _3877_/Y _7108_/A2 _6186_/Y VPWR VGND sg13cmos5l_a21oi_1
X_5138_ _5139_/C _5138_/A _5147_/C _5138_/C VPWR VGND sg13cmos5l_and3_1
XFILLER_17_409 VPWR VGND sg13cmos5l_decap_8
XFILLER_38_792 VPWR VGND sg13cmos5l_fill_1
X_5069_ _5069_/Y _7142_/Q _5057_/Y _5060_/Y _7143_/Q VPWR VGND sg13cmos5l_a22oi_1
XFILLER_40_456 VPWR VGND sg13cmos5l_decap_4
XFILLER_40_489 VPWR VGND sg13cmos5l_fill_2
XFILLER_32_32 VPWR VGND sg13cmos5l_fill_2
XFILLER_5_814 VPWR VGND sg13cmos5l_fill_1
XFILLER_10_1023 VPWR VGND sg13cmos5l_decap_4
XFILLER_4_335 VPWR VGND sg13cmos5l_fill_2
XFILLER_0_541 VPWR VGND sg13cmos5l_fill_2
XFILLER_0_574 VPWR VGND sg13cmos5l_fill_2
XFILLER_35_228 VPWR VGND sg13cmos5l_fill_2
XFILLER_28_291 VPWR VGND sg13cmos5l_decap_8
XFILLER_16_475 VPWR VGND sg13cmos5l_decap_4
XFILLER_32_979 VPWR VGND sg13cmos5l_fill_1
X_7383__317 _7383_/RESET_B VPWR VGND sg13cmos5l_tiehi
XFILLER_7_184 VPWR VGND sg13cmos5l_decap_8
X_7283__451 _7283_/RESET_B VPWR VGND sg13cmos5l_tiehi
X_4440_ _4448_/B _4787_/A _4441_/B VPWR VGND sg13cmos5l_and2_1
XFILLER_7_195 VPWR VGND sg13cmos5l_fill_1
X_6110_ _6112_/A _6122_/B _6110_/B VPWR VGND sg13cmos5l_nand2b_1
X_4371_ _4386_/B _4369_/Y _4370_/Y _4368_/Y VPWR VGND sg13cmos5l_a21oi_1
X_7090_ _7090_/Y _7090_/A _7090_/B VPWR VGND sg13cmos5l_nor2_1
XFILLER_39_501 VPWR VGND sg13cmos5l_fill_2
X_6041_ _6050_/A _6048_/B _6041_/B VPWR VGND sg13cmos5l_nand2b_1
XFILLER_14_0 VPWR VGND sg13cmos5l_fill_1
X_6943_ _6943_/X _6934_/X _6938_/X _6941_/Y VPWR VGND sg13cmos5l_a21o_1
X_7290__444 _7290_/RESET_B VPWR VGND sg13cmos5l_tiehi
XFILLER_19_291 VPWR VGND sg13cmos5l_decap_8
X_6874_ _6874_/Y _6881_/A VPWR VGND sg13cmos5l_inv_1
XFILLER_35_762 VPWR VGND sg13cmos5l_fill_1
X_5825_ _5828_/A _5833_/B _5825_/B VPWR VGND sg13cmos5l_nor2_1
XFILLER_22_412 VPWR VGND sg13cmos5l_fill_2
XFILLER_10_607 VPWR VGND sg13cmos5l_fill_1
X_5756_ _7254_/D _5847_/A _5756_/B VPWR VGND sg13cmos5l_nor2_1
X_5687_ _7245_/D _5847_/A _5687_/B VPWR VGND sg13cmos5l_nor2_1
X_4707_ _4707_/X _4466_/A _4700_/Y _4706_/Y VPWR VGND sg13cmos5l_a21o_1
X_4638_ _4638_/Y _4622_/B _4630_/X _4575_/B VPWR VGND sg13cmos5l_o21ai_1
X_7426_ _7426_/Q _7428_/CLK _7426_/D _7426_/RESET_B VPWR VGND sg13cmos5l_dfrbpq_1
X_7405__291 _7405_/RESET_B VPWR VGND sg13cmos5l_tiehi
X_7357_ _7357_/Q _7424_/CLK _7357_/D _7357_/RESET_B VPWR VGND sg13cmos5l_dfrbpq_1
X_4569_ _7586_/D _4569_/A _4586_/B VPWR VGND sg13cmos5l_and2_1
X_6308_ _6329_/B _6286_/B _6285_/Y _6124_/A VPWR VGND sg13cmos5l_a21o_1
X_7288_ _7288_/Q _7344_/CLK _7288_/D _7288_/RESET_B VPWR VGND sg13cmos5l_dfrbpq_1
X_6239_ _6256_/A _6240_/A _6240_/B _6240_/C VPWR VGND sg13cmos5l_and3_1
XFILLER_40_1005 VPWR VGND sg13cmos5l_fill_1
XFILLER_40_1027 VPWR VGND sg13cmos5l_fill_2
Xhold1330 _4645_/B1 _7601_/Q VPWR VGND sg13cmos5l_dlygate4sd3_1
XFILLER_45_537 VPWR VGND sg13cmos5l_fill_1
XFILLER_27_43 VPWR VGND sg13cmos5l_fill_2
XFILLER_27_54 VPWR VGND sg13cmos5l_fill_1
XFILLER_45_548 VPWR VGND sg13cmos5l_fill_1
XFILLER_14_924 VPWR VGND sg13cmos5l_fill_1
X_7412__284 _7412_/RESET_B VPWR VGND sg13cmos5l_tiehi
XFILLER_9_405 VPWR VGND sg13cmos5l_fill_1
XFILLER_43_86 VPWR VGND sg13cmos5l_fill_2
XFILLER_4_154 VPWR VGND sg13cmos5l_fill_1
XFILLER_49_865 VPWR VGND sg13cmos5l_decap_8
XFILLER_49_898 VPWR VGND sg13cmos5l_fill_1
XFILLER_1_1010 VPWR VGND sg13cmos5l_decap_8
X_3940_ _5451_/A _5450_/A VPWR VGND sg13cmos5l_inv_1
X_3871_ _3871_/Y _6404_/A VPWR VGND sg13cmos5l_inv_1
X_7469__594 _7469_/RESET_B VPWR VGND sg13cmos5l_tiehi
X_6590_ _7401_/D _6707_/A _6590_/B VPWR VGND sg13cmos5l_nor2_1
X_5610_ _5611_/A _5504_/B _5463_/B _5610_/S VPWR VGND sg13cmos5l_mux2_1
XFILLER_32_798 VPWR VGND sg13cmos5l_decap_4
X_5541_ _5542_/B _5531_/B _5737_/B _5541_/S VPWR VGND sg13cmos5l_mux2_1
XFILLER_31_297 VPWR VGND sg13cmos5l_decap_8
XFILLER_8_482 VPWR VGND sg13cmos5l_decap_4
XFILLER_8_493 VPWR VGND sg13cmos5l_decap_4
X_5472_ _5497_/A _5472_/A _5472_/B VPWR VGND sg13cmos5l_and2_1
X_7211_ _7211_/Q _7214_/CLK _7211_/D _7211_/RESET_B VPWR VGND sg13cmos5l_dfrbpq_1
X_4423_ _4423_/Y _7595_/Q _4784_/A _7596_/Q VPWR VGND sg13cmos5l_o21ai_1
X_7142_ _7142_/Q _7611_/CLK _7142_/D _7142_/RESET_B VPWR VGND sg13cmos5l_dfrbpq_1
X_4354_ _7551_/D _7086_/B _4358_/B VPWR VGND sg13cmos5l_nor2_1
X_7073_ _7501_/D _7105_/A _7073_/B VPWR VGND sg13cmos5l_nor2_1
X_4285_ _4287_/B _4116_/A _4281_/X _4284_/Y _3966_/Y VPWR VGND sg13cmos5l_a22oi_1
X_6024_ _6061_/A _6024_/A _6048_/B _6024_/C VPWR VGND sg13cmos5l_nor3_1
X_6926_ _6952_/A _6926_/A _6925_/Y VPWR VGND sg13cmos5l_nor2b_1
Xfanout46 _6039_/B _6009_/Y VPWR VGND sg13cmos5l_buf_1
Xfanout35 _7108_/A2 _5324_/A2 VPWR VGND sg13cmos5l_buf_1
Xfanout24 _6999_/A2 _5984_/A2 VPWR VGND sg13cmos5l_buf_1
X_6857_ _6858_/B _6848_/A _6875_/B _6855_/A _6856_/Y VPWR VGND sg13cmos5l_a22oi_1
Xfanout68 _6707_/A _6709_/A VPWR VGND sg13cmos5l_buf_1
Xfanout79 _5847_/A _5778_/B VPWR VGND sg13cmos5l_buf_1
X_5808_ _5808_/Y _5808_/A _5819_/C _5808_/C VPWR VGND sg13cmos5l_nand3_1
XFILLER_22_286 VPWR VGND sg13cmos5l_decap_4
Xfanout57 _4848_/B _4805_/Y VPWR VGND sg13cmos5l_buf_1
X_6788_ _6801_/B _6784_/Y _6786_/Y _6787_/Y VPWR VGND sg13cmos5l_o21ai_1
X_5739_ _5744_/B _5729_/Y _5737_/Y _5738_/Y _5741_/C VPWR VGND sg13cmos5l_a22oi_1
X_7409_ _7409_/Q _7490_/CLK _7409_/D _7409_/RESET_B VPWR VGND sg13cmos5l_dfrbpq_1
X_7184__190 _7184_/D VPWR VGND sg13cmos5l_tielo
XFILLER_2_658 VPWR VGND sg13cmos5l_fill_1
XFILLER_49_128 VPWR VGND sg13cmos5l_decap_8
Xhold1160 _4633_/A1 _4612_/Y VPWR VGND sg13cmos5l_dlygate4sd3_1
Xhold1182 _3971_/A _7254_/Q VPWR VGND sg13cmos5l_dlygate4sd3_1
X_7273__461 _7273_/RESET_B VPWR VGND sg13cmos5l_tiehi
Xhold1171 _5818_/A _7266_/Q VPWR VGND sg13cmos5l_dlygate4sd3_1
Xhold1193 _6677_/A _7421_/Q VPWR VGND sg13cmos5l_dlygate4sd3_1
XFILLER_45_367 VPWR VGND sg13cmos5l_decap_4
XFILLER_41_551 VPWR VGND sg13cmos5l_decap_8
XFILLER_9_279 VPWR VGND sg13cmos5l_decap_4
Xclkload16 clkload16/Y _7272_/CLK VPWR VGND sg13cmos5l_inv_1
X_7280__454 _7280_/RESET_B VPWR VGND sg13cmos5l_tiehi
XFILLER_5_485 VPWR VGND sg13cmos5l_decap_8
X_4070_ _4070_/Y _4883_/B _4070_/B VPWR VGND sg13cmos5l_nand2_1
X_4972_ _4972_/X _4972_/A _4972_/B VPWR VGND sg13cmos5l_or2_1
X_3923_ _6145_/A _7340_/Q VPWR VGND sg13cmos5l_inv_1
X_6711_ _6711_/Y _6711_/A _6993_/B VPWR VGND sg13cmos5l_nor2_1
XFILLER_32_551 VPWR VGND sg13cmos5l_fill_2
X_6642_ _6642_/Y _6641_/Y _6642_/B VPWR VGND sg13cmos5l_nand2b_1
X_6573_ _6573_/Y _6573_/A _6565_/Y VPWR VGND sg13cmos5l_nor2b_1
X_5524_ _5524_/Y _7240_/Q _5775_/A VPWR VGND sg13cmos5l_nor2_1
X_5455_ _5455_/X _5698_/A _5709_/A VPWR VGND sg13cmos5l_and2_1
X_4406_ _4407_/B _4396_/A _4414_/B _4401_/Y _4404_/Y _4405_/Y VPWR VGND sg13cmos5l_a221oi_1
X_7326__395 _7326_/RESET_B VPWR VGND sg13cmos5l_tiehi
X_5386_ _5386_/Y _5406_/A _5381_/X _5376_/Y VPWR VGND sg13cmos5l_o21ai_1
X_7125_ _7125_/Q _7394_/CLK _7125_/D _7125_/RESET_B VPWR VGND sg13cmos5l_dfrbpq_1
X_7402__294 _7402_/RESET_B VPWR VGND sg13cmos5l_tiehi
X_4337_ _7540_/D _4337_/A _4337_/B VPWR VGND sg13cmos5l_nor2_1
X_4268_ _7529_/D _4337_/A _4268_/B VPWR VGND sg13cmos5l_nor2_1
X_7056_ _7056_/Y _7052_/A _7052_/B _7054_/Y _7046_/Y _7055_/Y VPWR VGND sg13cmos5l_a221oi_1
X_6007_ _6007_/Y _7297_/Q _7263_/Q VPWR VGND sg13cmos5l_xnor2_1
XFILLER_27_301 VPWR VGND sg13cmos5l_decap_8
X_4199_ _4199_/Y _4213_/A _4188_/X VPWR VGND sg13cmos5l_nor2b_1
XFILLER_27_312 VPWR VGND sg13cmos5l_fill_2
X_6909_ _6909_/Y _6903_/Y _6907_/Y _6908_/Y VPWR VGND sg13cmos5l_a21oi_1
XFILLER_24_11 VPWR VGND sg13cmos5l_fill_2
XFILLER_6_216 VPWR VGND sg13cmos5l_fill_2
XFILLER_11_779 VPWR VGND sg13cmos5l_decap_4
XFILLER_46_1000 VPWR VGND sg13cmos5l_decap_8
XFILLER_2_455 VPWR VGND sg13cmos5l_decap_8
XFILLER_49_74 VPWR VGND sg13cmos5l_decap_4
XFILLER_18_301 VPWR VGND sg13cmos5l_fill_2
XFILLER_46_621 VPWR VGND sg13cmos5l_decap_4
XFILLER_33_326 VPWR VGND sg13cmos5l_fill_1
X_7583__711 _7583_/RESET_B VPWR VGND sg13cmos5l_tiehi
XFILLER_42_882 VPWR VGND sg13cmos5l_fill_2
XFILLER_6_750 VPWR VGND sg13cmos5l_decap_8
X_5240_ _5240_/X _5245_/B _5245_/C _5245_/A VPWR VGND sg13cmos5l_a21o_1
XFILLER_6_783 VPWR VGND sg13cmos5l_decap_8
XFILLER_39_2 VPWR VGND sg13cmos5l_fill_1
X_5171_ _5171_/Y _5175_/A _5171_/B VPWR VGND sg13cmos5l_nand2_1
X_4122_ _4123_/B _6971_/B _7491_/Q _7492_/Q VPWR VGND sg13cmos5l_o21ai_1
X_4053_ _7644_/D _4041_/B _4040_/Y _6108_/B VPWR VGND sg13cmos5l_o21ai_1
Xinput3 input3/X ui_in[1] VPWR VGND sg13cmos5l_buf_1
XFILLER_25_816 VPWR VGND sg13cmos5l_fill_1
X_4955_ _5249_/A _4962_/B _4955_/B VPWR VGND sg13cmos5l_nand2b_1
X_3906_ _7005_/A _6802_/B VPWR VGND sg13cmos5l_inv_1
X_4886_ _4888_/B input9/X _4886_/B VPWR VGND sg13cmos5l_nand2_1
XFILLER_20_565 VPWR VGND sg13cmos5l_decap_8
X_6625_ _6633_/C _7429_/Q _6624_/Y _6623_/Y VPWR VGND sg13cmos5l_o21ai_1
X_6556_ _6568_/B _7426_/Q _7427_/Q VPWR VGND sg13cmos5l_nor2_1
X_5507_ _5507_/Y _5450_/A _5518_/B _5514_/B _7235_/Q VPWR VGND sg13cmos5l_a22oi_1
X_6487_ _6487_/X _6487_/A _6613_/B VPWR VGND sg13cmos5l_and2_1
X_7263__471 _7263_/RESET_B VPWR VGND sg13cmos5l_tiehi
X_5438_ _5461_/B _7209_/Q _5438_/B VPWR VGND sg13cmos5l_xor2_1
X_5369_ _5370_/C _5369_/A _5384_/A _5369_/C VPWR VGND sg13cmos5l_and3_1
X_7108_ _7510_/D _3865_/Y _7108_/A2 _7107_/Y VPWR VGND sg13cmos5l_a21oi_1
X_7039_ _7046_/A _7038_/Y _7039_/B _7039_/C VPWR VGND sg13cmos5l_nand3b_1
XFILLER_19_77 VPWR VGND sg13cmos5l_fill_1
XFILLER_42_112 VPWR VGND sg13cmos5l_fill_2
X_7270__464 _7270_/RESET_B VPWR VGND sg13cmos5l_tiehi
XFILLER_15_359 VPWR VGND sg13cmos5l_fill_2
XFILLER_30_307 VPWR VGND sg13cmos5l_fill_1
XFILLER_11_576 VPWR VGND sg13cmos5l_fill_1
XFILLER_3_742 VPWR VGND sg13cmos5l_fill_2
XFILLER_19_610 VPWR VGND sg13cmos5l_fill_1
XFILLER_47_963 VPWR VGND sg13cmos5l_decap_8
XFILLER_46_484 VPWR VGND sg13cmos5l_fill_1
XFILLER_18_164 VPWR VGND sg13cmos5l_fill_1
X_4740_ _4741_/B _5102_/A _7579_/Q VPWR VGND sg13cmos5l_nand2_1
X_4671_ _4672_/B _5021_/A _4682_/B _4670_/Y VPWR VGND sg13cmos5l_o21ai_1
X_6410_ _6410_/X _6411_/D _6410_/B VPWR VGND sg13cmos5l_or2_1
XFILLER_30_885 VPWR VGND sg13cmos5l_fill_1
X_7390_ _7390_/Q clkload8/A _7390_/D _7390_/RESET_B VPWR VGND sg13cmos5l_dfrbpq_1
X_6341_ _6341_/Y _7346_/Q _7347_/Q VPWR VGND sg13cmos5l_xnor2_1
XFILLER_44_0 VPWR VGND sg13cmos5l_decap_8
X_6272_ _6290_/B _6191_/A _6263_/Y _6271_/Y VPWR VGND sg13cmos5l_a21o_1
X_5223_ _5223_/X _5189_/B _5187_/C _5232_/B VPWR VGND sg13cmos5l_a21o_1
X_5154_ _5154_/Y _5154_/A VPWR VGND sg13cmos5l_inv_1
X_4105_ _4108_/B _7083_/B _4105_/B VPWR VGND sg13cmos5l_nor2_1
XFILLER_5_1008 VPWR VGND sg13cmos5l_decap_8
X_5085_ _5085_/Y _5284_/B _5085_/B VPWR VGND sg13cmos5l_nand2_1
XFILLER_38_963 VPWR VGND sg13cmos5l_decap_8
X_4036_ _4036_/Y _4871_/C _4067_/C VPWR VGND sg13cmos5l_nor2_1
X_7451__674 _7451_/RESET_B VPWR VGND sg13cmos5l_tiehi
XFILLER_24_112 VPWR VGND sg13cmos5l_fill_1
X_7252__183 _7252_/D VPWR VGND sg13cmos5l_tielo
X_5987_ _7301_/D _5987_/A _5987_/B VPWR VGND sg13cmos5l_and2_1
X_4938_ _4941_/B _4938_/A _4938_/B VPWR VGND sg13cmos5l_and2_1
XFILLER_33_690 VPWR VGND sg13cmos5l_fill_1
X_4869_ _4869_/Y _4878_/A _4869_/B VPWR VGND sg13cmos5l_nor2_1
X_6608_ _6609_/A _6608_/A _6610_/C VPWR VGND sg13cmos5l_nor2_1
XFILLER_21_896 VPWR VGND sg13cmos5l_fill_1
XFILLER_21_45 VPWR VGND sg13cmos5l_fill_1
X_7588_ _7588_/Q _7597_/CLK _7588_/D _7588_/RESET_B VPWR VGND sg13cmos5l_dfrbpq_1
X_6539_ _6543_/B _6514_/A _6538_/B _6538_/Y VPWR VGND sg13cmos5l_a21oi_1
XFILLER_0_745 VPWR VGND sg13cmos5l_decap_8
XFILLER_46_53 VPWR VGND sg13cmos5l_fill_2
XFILLER_16_624 VPWR VGND sg13cmos5l_fill_1
XFILLER_44_977 VPWR VGND sg13cmos5l_decap_8
XFILLER_8_834 VPWR VGND sg13cmos5l_fill_1
XFILLER_11_362 VPWR VGND sg13cmos5l_decap_8
XFILLER_11_373 VPWR VGND sg13cmos5l_fill_1
XFILLER_7_388 VPWR VGND sg13cmos5l_fill_1
X_7619__673 _7619_/RESET_B VPWR VGND sg13cmos5l_tiehi
XFILLER_39_749 VPWR VGND sg13cmos5l_fill_2
XFILLER_38_237 VPWR VGND sg13cmos5l_fill_2
XFILLER_16_4 VPWR VGND sg13cmos5l_decap_4
XFILLER_38_259 VPWR VGND sg13cmos5l_fill_2
XFILLER_47_771 VPWR VGND sg13cmos5l_fill_2
X_5910_ _5915_/B _7251_/Q _5910_/B VPWR VGND sg13cmos5l_xnor2_1
X_6890_ _6891_/B _6869_/Y _6879_/B _6890_/S VPWR VGND sg13cmos5l_mux2_1
X_5841_ _7273_/D _5841_/A _5841_/B VPWR VGND sg13cmos5l_nor2_1
XFILLER_35_988 VPWR VGND sg13cmos5l_decap_4
X_5772_ _7265_/D _5987_/A _5800_/B VPWR VGND sg13cmos5l_and2_1
X_7511_ _7511_/Q _7513_/CLK _7511_/D _7511_/RESET_B VPWR VGND sg13cmos5l_dfrbpq_1
X_4723_ _4723_/Y _4723_/A _4726_/S VPWR VGND sg13cmos5l_nand2_1
X_7442_ _7442_/Q _7553_/CLK _7442_/D _7442_/RESET_B VPWR VGND sg13cmos5l_dfrbpq_1
X_4654_ _4690_/A _7602_/Q _4654_/B VPWR VGND sg13cmos5l_xor2_1
X_7373_ _7373_/Q _7375_/CLK _7373_/D _7373_/RESET_B VPWR VGND sg13cmos5l_dfrbpq_1
X_4585_ _4585_/X _4578_/B _4458_/Y _4619_/S VPWR VGND sg13cmos5l_mux2_1
Xhold801 _7645_/D _4031_/Y VPWR VGND sg13cmos5l_dlygate4sd3_1
Xhold812 _5087_/B _7617_/Q VPWR VGND sg13cmos5l_dlygate4sd3_1
X_6324_ _6325_/C _6323_/A _6323_/C _6298_/Y VPWR VGND sg13cmos5l_a21oi_1
Xhold823 _7186_/D _5321_/Y VPWR VGND sg13cmos5l_dlygate4sd3_1
Xhold834 hold834/X _4870_/Y VPWR VGND sg13cmos5l_dlygate4sd3_1
Xhold845 hold845/X _7187_/Q VPWR VGND sg13cmos5l_dlygate4sd3_1
Xhold878 _7475_/D _6992_/Y VPWR VGND sg13cmos5l_dlygate4sd3_1
Xhold889 hold889/X _4913_/X VPWR VGND sg13cmos5l_dlygate4sd3_1
X_6255_ _6255_/Y _5867_/A _6242_/Y _6251_/X _6252_/Y VPWR VGND sg13cmos5l_a22oi_1
Xhold867 _3878_/A _7297_/Q VPWR VGND sg13cmos5l_dlygate4sd3_1
Xhold856 _4375_/A _7547_/Q VPWR VGND sg13cmos5l_dlygate4sd3_1
X_5206_ _5206_/Y _5485_/A _5232_/A VPWR VGND sg13cmos5l_nand2_1
X_6186_ _6186_/Y _7331_/Q _7108_/A2 _5987_/A VPWR VGND sg13cmos5l_o21ai_1
X_5137_ _5163_/A _5137_/A _5153_/A _5137_/C VPWR VGND sg13cmos5l_or3_1
X_5068_ _5068_/X _7144_/Q _5068_/B VPWR VGND sg13cmos5l_or2_1
XFILLER_29_248 VPWR VGND sg13cmos5l_fill_2
X_4019_ _6813_/B _7441_/Q VPWR VGND sg13cmos5l_inv_1
XFILLER_37_292 VPWR VGND sg13cmos5l_fill_2
XFILLER_12_159 VPWR VGND sg13cmos5l_decap_8
XFILLER_21_693 VPWR VGND sg13cmos5l_fill_1
XFILLER_4_314 VPWR VGND sg13cmos5l_decap_8
XFILLER_4_303 VPWR VGND sg13cmos5l_fill_2
XFILLER_4_347 VPWR VGND sg13cmos5l_decap_8
XFILLER_4_369 VPWR VGND sg13cmos5l_decap_8
XFILLER_48_546 VPWR VGND sg13cmos5l_fill_2
XFILLER_29_793 VPWR VGND sg13cmos5l_fill_2
XFILLER_44_774 VPWR VGND sg13cmos5l_fill_2
XFILLER_44_763 VPWR VGND sg13cmos5l_fill_2
XFILLER_31_402 VPWR VGND sg13cmos5l_fill_1
XFILLER_32_914 VPWR VGND sg13cmos5l_fill_1
XFILLER_12_660 VPWR VGND sg13cmos5l_fill_1
XFILLER_8_664 VPWR VGND sg13cmos5l_fill_2
X_4370_ _4370_/Y _7546_/Q _7514_/Q VPWR VGND sg13cmos5l_xnor2_1
X_6040_ _6040_/Y _6040_/A _6040_/B VPWR VGND sg13cmos5l_xnor2_1
X_6942_ _6942_/Y _6934_/X _6938_/X _6941_/Y VPWR VGND sg13cmos5l_a21oi_1
X_6873_ _6881_/A _6835_/A _6873_/B VPWR VGND sg13cmos5l_nand2b_1
X_5824_ _5825_/B _5824_/A _5824_/B VPWR VGND sg13cmos5l_xnor2_1
XFILLER_23_947 VPWR VGND sg13cmos5l_fill_2
XFILLER_34_284 VPWR VGND sg13cmos5l_fill_2
X_5755_ _5755_/X _5733_/Y _5945_/B _5759_/S VPWR VGND sg13cmos5l_mux2_1
X_5686_ _5831_/A _5687_/B VPWR VGND sg13cmos5l_inv_1
X_4706_ _4706_/Y _4702_/Y _4703_/Y _4705_/A _7594_/Q VPWR VGND sg13cmos5l_a22oi_1
X_4637_ _7595_/D _4606_/B _4631_/Y _4636_/Y VPWR VGND sg13cmos5l_a21oi_1
X_7425_ _7425_/Q _7490_/CLK _7425_/D _7425_/RESET_B VPWR VGND sg13cmos5l_dfrbpq_1
X_7356_ _7356_/Q _7424_/CLK _7356_/D _7356_/RESET_B VPWR VGND sg13cmos5l_dfrbpq_1
X_4568_ _7585_/D _5326_/A _4568_/B VPWR VGND sg13cmos5l_and2_1
X_4499_ _4508_/A _4496_/A _4496_/B _4498_/Y VPWR VGND sg13cmos5l_o21ai_1
X_6307_ _6307_/Y _6286_/B _6285_/Y _6124_/A VPWR VGND sg13cmos5l_a21oi_1
X_7287_ _7287_/Q clkload7/A _7287_/D _7287_/RESET_B VPWR VGND sg13cmos5l_dfrbpq_1
X_6238_ _6240_/C _6253_/C _7288_/Q VPWR VGND sg13cmos5l_nand2b_1
X_6169_ _7322_/D _6180_/A _6169_/B VPWR VGND sg13cmos5l_nor2_1
Xhold1331 _6204_/A _7336_/Q VPWR VGND sg13cmos5l_dlygate4sd3_1
Xhold1320 _5001_/B1 _7607_/Q VPWR VGND sg13cmos5l_dlygate4sd3_1
XFILLER_17_218 VPWR VGND sg13cmos5l_fill_2
XFILLER_14_903 VPWR VGND sg13cmos5l_decap_8
XFILLER_25_240 VPWR VGND sg13cmos5l_fill_2
XFILLER_26_796 VPWR VGND sg13cmos5l_fill_2
XFILLER_40_254 VPWR VGND sg13cmos5l_fill_2
XFILLER_13_479 VPWR VGND sg13cmos5l_fill_1
Xclkbuf_leaf_20_clk _7617_/CLK clkload3/A VPWR VGND sg13cmos5l_buf_8
XFILLER_5_689 VPWR VGND sg13cmos5l_fill_1
XFILLER_16_284 VPWR VGND sg13cmos5l_decap_8
X_3870_ _3870_/Y _3870_/A VPWR VGND sg13cmos5l_inv_1
Xclkbuf_leaf_11_clk _7489_/CLK clkload2/A VPWR VGND sg13cmos5l_buf_8
X_5540_ _7217_/D _5542_/A _5540_/B VPWR VGND sg13cmos5l_nor2_1
XFILLER_9_962 VPWR VGND sg13cmos5l_decap_4
X_5471_ _5472_/B _7173_/Q _7174_/Q _7175_/Q VPWR VGND sg13cmos5l_o21ai_1
X_7210_ _7210_/Q _7214_/CLK _7210_/D _7210_/RESET_B VPWR VGND sg13cmos5l_dfrbpq_1
X_4422_ _4441_/B _7596_/Q _7595_/Q _4784_/A VPWR VGND sg13cmos5l_nor3_1
X_7141_ _7141_/Q _7200_/CLK _7141_/D _7141_/RESET_B VPWR VGND sg13cmos5l_dfrbpq_1
X_7539__221 _7539_/RESET_B VPWR VGND sg13cmos5l_tiehi
X_4353_ _7550_/D _4569_/A _4375_/B VPWR VGND sg13cmos5l_and2_1
X_4284_ _4284_/Y _4296_/B _4296_/C _4283_/Y _4281_/B VPWR VGND sg13cmos5l_a22oi_1
X_7072_ _7500_/D _7072_/A _7072_/B VPWR VGND sg13cmos5l_and2_1
X_6023_ _6024_/C _6023_/A _6036_/A _6023_/C VPWR VGND sg13cmos5l_and3_1
XFILLER_39_332 VPWR VGND sg13cmos5l_decap_4
X_6925_ _6925_/Y _7436_/Q _7435_/Q _7437_/Q VPWR VGND sg13cmos5l_o21ai_1
Xfanout47 _6034_/B _6009_/Y VPWR VGND sg13cmos5l_buf_1
XFILLER_22_243 VPWR VGND sg13cmos5l_fill_2
Xfanout36 _5323_/A2 _5325_/A2 VPWR VGND sg13cmos5l_buf_1
Xfanout25 _5984_/A2 fanout28/X VPWR VGND sg13cmos5l_buf_1
X_6856_ _6856_/Y _7455_/Q _6875_/B VPWR VGND sg13cmos5l_nand2_1
Xfanout69 _6661_/B _6554_/Y VPWR VGND sg13cmos5l_buf_1
XFILLER_13_13 VPWR VGND sg13cmos5l_fill_2
X_5807_ _5833_/B _5833_/A _5806_/X _5794_/Y VPWR VGND sg13cmos5l_o21ai_1
X_3999_ _5286_/B _3999_/A VPWR VGND sg13cmos5l_inv_1
XFILLER_22_265 VPWR VGND sg13cmos5l_decap_4
XFILLER_23_788 VPWR VGND sg13cmos5l_fill_2
XFILLER_23_799 VPWR VGND sg13cmos5l_fill_2
X_6787_ _6787_/Y _7461_/Q _6789_/A _7412_/Q _3908_/Y VPWR VGND sg13cmos5l_a22oi_1
Xfanout58 _4611_/B _4589_/Y VPWR VGND sg13cmos5l_buf_1
X_5738_ _5738_/Y _7277_/Q _5991_/A VPWR VGND sg13cmos5l_nor2_1
XFILLER_10_427 VPWR VGND sg13cmos5l_decap_8
XFILLER_10_449 VPWR VGND sg13cmos5l_decap_8
X_5669_ _5774_/B _6554_/A _5979_/B VPWR VGND sg13cmos5l_nor2_1
X_7408_ _7408_/Q _7489_/CLK _7408_/D _7408_/RESET_B VPWR VGND sg13cmos5l_dfrbpq_1
X_7339_ _7339_/Q _7344_/CLK _7339_/D _7339_/RESET_B VPWR VGND sg13cmos5l_dfrbpq_1
XFILLER_49_107 VPWR VGND sg13cmos5l_fill_1
XFILLER_46_825 VPWR VGND sg13cmos5l_fill_2
Xhold1150 _3901_/A _7369_/Q VPWR VGND sg13cmos5l_dlygate4sd3_1
X_7492__390 _7492_/RESET_B VPWR VGND sg13cmos5l_tiehi
Xhold1194 _6440_/B _7372_/Q VPWR VGND sg13cmos5l_dlygate4sd3_1
Xhold1183 _5756_/B _5755_/X VPWR VGND sg13cmos5l_dlygate4sd3_1
Xhold1161 _5382_/A _7192_/Q VPWR VGND sg13cmos5l_dlygate4sd3_1
Xhold1172 _5838_/A1 _5819_/Y VPWR VGND sg13cmos5l_dlygate4sd3_1
XFILLER_26_582 VPWR VGND sg13cmos5l_fill_1
XFILLER_9_203 VPWR VGND sg13cmos5l_decap_4
XFILLER_41_596 VPWR VGND sg13cmos5l_fill_2
Xclkload17 clkload17/Y _7634_/CLK VPWR VGND sg13cmos5l_inv_1
XFILLER_6_998 VPWR VGND sg13cmos5l_decap_8
X_7577__719 _7577_/RESET_B VPWR VGND sg13cmos5l_tiehi
XFILLER_48_7 VPWR VGND sg13cmos5l_fill_2
XFILLER_23_1012 VPWR VGND sg13cmos5l_decap_8
XFILLER_49_674 VPWR VGND sg13cmos5l_fill_1
XFILLER_49_663 VPWR VGND sg13cmos5l_decap_8
Xclkbuf_leaf_0_clk _7344_/CLK clkbuf_leaf_5_clk/A VPWR VGND sg13cmos5l_buf_8
XFILLER_48_184 VPWR VGND sg13cmos5l_fill_1
X_7137__609 _7137_/RESET_B VPWR VGND sg13cmos5l_tiehi
XFILLER_36_335 VPWR VGND sg13cmos5l_fill_2
X_4971_ _4972_/B _4981_/B _4982_/B _4970_/Y VPWR VGND sg13cmos5l_o21ai_1
XFILLER_17_571 VPWR VGND sg13cmos5l_fill_1
XFILLER_36_379 VPWR VGND sg13cmos5l_fill_1
X_6710_ _7428_/D _6661_/B _6699_/B _7402_/D VPWR VGND sg13cmos5l_a21o_1
X_3922_ _6140_/A _7341_/Q VPWR VGND sg13cmos5l_inv_1
XFILLER_20_714 VPWR VGND sg13cmos5l_fill_1
X_6641_ _6641_/Y _6649_/B _6638_/Y _6789_/A VPWR VGND sg13cmos5l_o21ai_1
X_6572_ _6573_/A _6761_/A _6576_/B _6571_/Y VPWR VGND sg13cmos5l_o21ai_1
X_5523_ _5523_/Y _7184_/Q _5523_/B VPWR VGND sg13cmos5l_nor2_1
X_5454_ _7205_/D _5542_/A _5454_/B VPWR VGND sg13cmos5l_nor2_1
X_4405_ _4405_/Y _4405_/A _4405_/B VPWR VGND sg13cmos5l_nor2_1
X_5385_ _5385_/Y _5406_/A _5381_/X _5384_/Y _5349_/Y VPWR VGND sg13cmos5l_a22oi_1
X_7124_ _7124_/Q _7394_/CLK _7124_/D _7124_/RESET_B VPWR VGND sg13cmos5l_dfrbpq_1
X_4336_ _4337_/B _4320_/Y _4536_/B _4336_/S VPWR VGND sg13cmos5l_mux2_1
XFILLER_8_1028 VPWR VGND sg13cmos5l_fill_1
X_4267_ _4268_/B _4249_/X _4512_/A _4266_/Y _4263_/S VPWR VGND sg13cmos5l_a22oi_1
X_7055_ _7055_/Y _7055_/A _7055_/B _7055_/C VPWR VGND sg13cmos5l_nor3_1
X_4198_ _4198_/Y _4198_/A VPWR VGND sg13cmos5l_inv_1
X_6006_ _6006_/Y _7299_/Q _7265_/Q VPWR VGND sg13cmos5l_nand2_1
XFILLER_28_836 VPWR VGND sg13cmos5l_fill_1
XFILLER_15_508 VPWR VGND sg13cmos5l_fill_2
XFILLER_43_839 VPWR VGND sg13cmos5l_decap_4
X_6908_ _6908_/Y _4132_/A _6906_/A _4124_/Y VPWR VGND sg13cmos5l_o21ai_1
XFILLER_42_349 VPWR VGND sg13cmos5l_fill_2
X_6839_ _6840_/C _6836_/A _6839_/B VPWR VGND sg13cmos5l_nand2b_1
XFILLER_11_725 VPWR VGND sg13cmos5l_fill_1
XFILLER_24_56 VPWR VGND sg13cmos5l_fill_2
XFILLER_10_246 VPWR VGND sg13cmos5l_fill_1
XFILLER_10_279 VPWR VGND sg13cmos5l_decap_8
X_7407__162 _7407_/D VPWR VGND sg13cmos5l_tielo
XFILLER_3_979 VPWR VGND sg13cmos5l_decap_8
X_7652__640 _7652_/RESET_B VPWR VGND sg13cmos5l_tiehi
XFILLER_46_600 VPWR VGND sg13cmos5l_fill_1
XFILLER_45_110 VPWR VGND sg13cmos5l_decap_4
XFILLER_19_858 VPWR VGND sg13cmos5l_decap_8
XFILLER_46_666 VPWR VGND sg13cmos5l_fill_1
XFILLER_46_688 VPWR VGND sg13cmos5l_decap_8
XFILLER_26_390 VPWR VGND sg13cmos5l_fill_2
X_7529__231 _7529_/RESET_B VPWR VGND sg13cmos5l_tiehi
X_5170_ _5171_/B _5176_/S _5170_/B VPWR VGND sg13cmos5l_nand2b_1
X_7536__224 _7536_/RESET_B VPWR VGND sg13cmos5l_tiehi
X_4121_ _4124_/B _6971_/B _7491_/Q _7492_/Q VPWR VGND sg13cmos5l_nor3_1
XFILLER_2_990 VPWR VGND sg13cmos5l_decap_8
X_4052_ _7650_/D _7648_/D _7649_/D _7647_/D VPWR VGND sg13cmos5l_or3_1
XFILLER_37_611 VPWR VGND sg13cmos5l_fill_2
Xinput4 input4/X ui_in[2] VPWR VGND sg13cmos5l_buf_1
X_4954_ _4955_/B _7163_/Q _4981_/A _7164_/Q VPWR VGND sg13cmos5l_o21ai_1
X_7135__196 _7135_/D VPWR VGND sg13cmos5l_tielo
X_3905_ _7007_/A _3905_/A VPWR VGND sg13cmos5l_inv_1
X_4885_ _4885_/X _4889_/A _4886_/B VPWR VGND sg13cmos5l_or2_1
X_7543__217 _7543_/RESET_B VPWR VGND sg13cmos5l_tiehi
X_6624_ _6624_/Y _7383_/Q _7428_/Q VPWR VGND sg13cmos5l_nor2_1
X_6555_ _6709_/A _6820_/B _6660_/A VPWR VGND sg13cmos5l_nand2b_1
X_5506_ _7214_/D _5558_/B _5614_/B VPWR VGND sg13cmos5l_and2_1
X_6486_ _6486_/Y _6486_/A _6486_/B VPWR VGND sg13cmos5l_nand2_1
X_5437_ _5452_/B _7209_/Q _5438_/B VPWR VGND sg13cmos5l_xnor2_1
X_5368_ _5400_/A _5368_/A _5383_/A _5368_/C VPWR VGND sg13cmos5l_nor3_1
XFILLER_0_949 VPWR VGND sg13cmos5l_decap_8
X_5299_ _5299_/Y _5297_/C _5298_/Y _5297_/Y VPWR VGND sg13cmos5l_a21oi_1
X_7107_ _7107_/Y _3864_/A _7112_/A2 _7000_/A VPWR VGND sg13cmos5l_o21ai_1
X_4319_ _4320_/B _4575_/A _4572_/A _4324_/S VPWR VGND sg13cmos5l_o21ai_1
X_7038_ _7038_/Y _7041_/B _7038_/B VPWR VGND sg13cmos5l_nor2_1
XFILLER_16_817 VPWR VGND sg13cmos5l_fill_1
X_7567__729 _7567_/RESET_B VPWR VGND sg13cmos5l_tiehi
XFILLER_7_548 VPWR VGND sg13cmos5l_decap_8
X_7127__619 _7127_/RESET_B VPWR VGND sg13cmos5l_tiehi
XFILLER_4_0 VPWR VGND sg13cmos5l_fill_2
XFILLER_38_408 VPWR VGND sg13cmos5l_decap_4
XFILLER_19_666 VPWR VGND sg13cmos5l_fill_2
XFILLER_46_463 VPWR VGND sg13cmos5l_fill_2
XFILLER_19_688 VPWR VGND sg13cmos5l_fill_2
XFILLER_19_699 VPWR VGND sg13cmos5l_fill_2
XFILLER_33_179 VPWR VGND sg13cmos5l_fill_2
XFILLER_30_820 VPWR VGND sg13cmos5l_fill_1
X_4670_ _4670_/Y _4663_/X _5017_/A VPWR VGND sg13cmos5l_nand2b_1
X_6340_ _6340_/Y _6340_/A VPWR VGND sg13cmos5l_inv_1
X_6271_ _6271_/Y _6247_/A _6247_/B _6259_/X _6269_/B _6261_/B VPWR VGND sg13cmos5l_a221oi_1
X_5222_ _5222_/Y _5222_/A VPWR VGND sg13cmos5l_inv_1
X_5153_ _5154_/A _5153_/A _5153_/B VPWR VGND sg13cmos5l_or2_1
X_4104_ _4105_/B _7521_/Q _7494_/Q VPWR VGND sg13cmos5l_nand2_1
X_5084_ _7145_/D _5177_/A _5084_/B VPWR VGND sg13cmos5l_nor2_1
X_4035_ _4067_/C _7639_/Q _4035_/B VPWR VGND sg13cmos5l_nor2_1
XFILLER_37_474 VPWR VGND sg13cmos5l_fill_1
X_5986_ _7300_/D _6827_/A _5986_/B VPWR VGND sg13cmos5l_and2_1
X_4937_ _7126_/D _6427_/A _4941_/A VPWR VGND sg13cmos5l_nor2_1
X_4868_ _4868_/Y _4871_/B _4872_/C _4867_/Y VPWR VGND sg13cmos5l_a21oi_1
X_6607_ _6610_/C _6605_/X _6606_/Y _6595_/Y VPWR VGND sg13cmos5l_a21oi_1
X_4799_ _4838_/S _4796_/Y _4798_/Y _4789_/Y VPWR VGND sg13cmos5l_o21ai_1
X_7587_ _7587_/Q _7617_/CLK _7587_/D _7587_/RESET_B VPWR VGND sg13cmos5l_dfrbpq_1
X_6538_ _6538_/Y _6538_/A _6538_/B VPWR VGND sg13cmos5l_nor2_1
XFILLER_21_79 VPWR VGND sg13cmos5l_fill_2
X_6469_ _6538_/A _6356_/B _6468_/B _6468_/Y VPWR VGND sg13cmos5l_a21oi_1
X_7519__241 _7519_/RESET_B VPWR VGND sg13cmos5l_tiehi
XFILLER_43_400 VPWR VGND sg13cmos5l_decap_8
XFILLER_29_997 VPWR VGND sg13cmos5l_decap_8
XFILLER_43_422 VPWR VGND sg13cmos5l_fill_2
XFILLER_43_477 VPWR VGND sg13cmos5l_fill_1
X_7526__234 _7526_/RESET_B VPWR VGND sg13cmos5l_tiehi
XFILLER_8_824 VPWR VGND sg13cmos5l_fill_2
XFILLER_7_59 VPWR VGND sg13cmos5l_fill_1
X_7496__355 _7496_/RESET_B VPWR VGND sg13cmos5l_tiehi
X_7533__227 _7533_/RESET_B VPWR VGND sg13cmos5l_tiehi
XFILLER_19_441 VPWR VGND sg13cmos5l_fill_1
XFILLER_35_901 VPWR VGND sg13cmos5l_fill_1
X_5840_ _5841_/B _5816_/Y _5844_/S _5774_/B VPWR VGND sg13cmos5l_o21ai_1
XFILLER_34_455 VPWR VGND sg13cmos5l_decap_4
XFILLER_22_639 VPWR VGND sg13cmos5l_fill_1
X_5771_ _7264_/D _5987_/A _5771_/B VPWR VGND sg13cmos5l_and2_1
X_4722_ _7606_/D _4788_/B _4793_/A VPWR VGND sg13cmos5l_nor2_1
X_7510_ _7510_/Q _7510_/CLK _7510_/D _7510_/RESET_B VPWR VGND sg13cmos5l_dfrbpq_1
X_7441_ _7441_/Q _7553_/CLK _7441_/D _7441_/RESET_B VPWR VGND sg13cmos5l_dfrbpq_1
X_4653_ _4663_/B _7602_/Q _7601_/Q _7599_/Q _7600_/Q VPWR VGND sg13cmos5l_nor4_1
X_7372_ _7372_/Q _7375_/CLK _7372_/D _7372_/RESET_B VPWR VGND sg13cmos5l_dfrbpq_1
X_4584_ _4619_/S _4581_/Y _4583_/Y _4576_/Y VPWR VGND sg13cmos5l_o21ai_1
Xhold802 _6827_/B _7418_/Q VPWR VGND sg13cmos5l_dlygate4sd3_1
X_6323_ _6325_/B _6323_/A _6323_/B _6323_/C VPWR VGND sg13cmos5l_and3_1
Xhold813 _5763_/B _7222_/Q VPWR VGND sg13cmos5l_dlygate4sd3_1
Xhold835 _7637_/D _4874_/Y VPWR VGND sg13cmos5l_dlygate4sd3_1
Xhold846 _3870_/A _7415_/Q VPWR VGND sg13cmos5l_dlygate4sd3_1
Xhold824 _6993_/B _7445_/Q VPWR VGND sg13cmos5l_dlygate4sd3_1
Xhold879 _6175_/A _7325_/Q VPWR VGND sg13cmos5l_dlygate4sd3_1
X_6254_ _6256_/C _6254_/A _6260_/B _6254_/C VPWR VGND sg13cmos5l_nor3_1
Xhold868 _7330_/D _6185_/Y VPWR VGND sg13cmos5l_dlygate4sd3_1
Xhold857 _3895_/A _7581_/Q VPWR VGND sg13cmos5l_dlygate4sd3_1
X_7557__739 _7557_/RESET_B VPWR VGND sg13cmos5l_tiehi
X_5205_ _5232_/B _7172_/Q _5205_/B VPWR VGND sg13cmos5l_xor2_1
X_6185_ _6185_/Y _3878_/Y _6826_/A2 _6184_/Y VPWR VGND sg13cmos5l_a21oi_1
X_5136_ _5137_/C _5136_/A _5136_/B _5136_/C VPWR VGND sg13cmos5l_and3_1
X_5067_ _5067_/Y _5065_/C _5066_/Y _5065_/Y VPWR VGND sg13cmos5l_a21oi_1
X_7434__158 _7434_/D VPWR VGND sg13cmos5l_tielo
XFILLER_26_901 VPWR VGND sg13cmos5l_fill_2
X_4018_ _6816_/B _7442_/Q VPWR VGND sg13cmos5l_inv_1
XFILLER_26_956 VPWR VGND sg13cmos5l_fill_2
X_5969_ _5969_/X _5954_/C _6150_/B _5975_/S VPWR VGND sg13cmos5l_mux2_1
XFILLER_25_488 VPWR VGND sg13cmos5l_fill_2
XFILLER_12_138 VPWR VGND sg13cmos5l_fill_1
XFILLER_32_34 VPWR VGND sg13cmos5l_fill_1
X_7639_ _7639_/Q _7651_/CLK _7639_/D _7639_/RESET_B VPWR VGND sg13cmos5l_dfrbpq_1
XFILLER_5_838 VPWR VGND sg13cmos5l_fill_2
XFILLER_4_337 VPWR VGND sg13cmos5l_fill_1
XFILLER_0_510 VPWR VGND sg13cmos5l_decap_8
XFILLER_17_912 VPWR VGND sg13cmos5l_fill_1
XFILLER_35_208 VPWR VGND sg13cmos5l_fill_2
XFILLER_16_455 VPWR VGND sg13cmos5l_fill_2
XFILLER_7_120 VPWR VGND sg13cmos5l_fill_1
XFILLER_26_1010 VPWR VGND sg13cmos5l_decap_8
X_7203__189 _7203_/D VPWR VGND sg13cmos5l_tielo
XFILLER_26_208 VPWR VGND sg13cmos5l_fill_2
X_6941_ _6941_/Y _6941_/A _6955_/B VPWR VGND sg13cmos5l_nor2_1
X_6872_ _6872_/Y _6861_/X _6862_/X _6879_/A _6879_/B VPWR VGND sg13cmos5l_a22oi_1
XFILLER_34_241 VPWR VGND sg13cmos5l_fill_1
X_5823_ _5824_/B _7269_/Q _5823_/B VPWR VGND sg13cmos5l_xor2_1
XFILLER_22_414 VPWR VGND sg13cmos5l_fill_1
XFILLER_22_458 VPWR VGND sg13cmos5l_decap_4
X_5754_ _7253_/D _5847_/A _5754_/B VPWR VGND sg13cmos5l_nor2_1
XFILLER_31_970 VPWR VGND sg13cmos5l_decap_8
X_5685_ _5687_/B _5684_/A _5915_/A _5657_/Y _5677_/B VPWR VGND sg13cmos5l_a22oi_1
X_4705_ _4705_/Y _4705_/A VPWR VGND sg13cmos5l_inv_1
X_4636_ _4636_/Y _4606_/A _4631_/Y _4575_/B VPWR VGND sg13cmos5l_o21ai_1
X_7424_ _7424_/Q _7424_/CLK _7424_/D _7424_/RESET_B VPWR VGND sg13cmos5l_dfrbpq_1
X_7579__205 _7579_/D VPWR VGND sg13cmos5l_tielo
X_7355_ _7355_/Q _7375_/CLK _7355_/D _7355_/RESET_B VPWR VGND sg13cmos5l_dfrbpq_1
X_6306_ _6306_/X _6297_/X _6301_/Y _6305_/X VPWR VGND sg13cmos5l_a21o_1
X_4567_ _7584_/D _5328_/A _4567_/B VPWR VGND sg13cmos5l_and2_1
X_4498_ _4498_/Y _4498_/A _4513_/B VPWR VGND sg13cmos5l_nand2_1
X_7286_ _7286_/Q _7344_/CLK _7286_/D _7286_/RESET_B VPWR VGND sg13cmos5l_dfrbpq_1
X_6237_ _6261_/B _7289_/Q _6240_/B VPWR VGND sg13cmos5l_nand2b_1
X_6168_ _6168_/X _6151_/Y _3881_/Y _6181_/B VPWR VGND sg13cmos5l_mux2_1
Xhold1310 hold1310/X _7526_/Q VPWR VGND sg13cmos5l_dlygate4sd3_1
Xhold1321 _4701_/A _7570_/Q VPWR VGND sg13cmos5l_dlygate4sd3_1
X_5119_ _5119_/Y _5119_/A _5119_/B VPWR VGND sg13cmos5l_nand2_1
X_7516__244 _7516_/RESET_B VPWR VGND sg13cmos5l_tiehi
XFILLER_45_517 VPWR VGND sg13cmos5l_fill_2
X_6099_ _6126_/B _7321_/Q _6099_/B VPWR VGND sg13cmos5l_xor2_1
XFILLER_27_45 VPWR VGND sg13cmos5l_fill_1
XFILLER_41_745 VPWR VGND sg13cmos5l_fill_1
XFILLER_13_458 VPWR VGND sg13cmos5l_decap_8
X_7464__630 _7464_/RESET_B VPWR VGND sg13cmos5l_tiehi
X_7609__684 _7609_/RESET_B VPWR VGND sg13cmos5l_tiehi
X_7523__237 _7523_/RESET_B VPWR VGND sg13cmos5l_tiehi
XFILLER_4_178 VPWR VGND sg13cmos5l_decap_8
XFILLER_0_351 VPWR VGND sg13cmos5l_decap_8
X_7616__677 _7616_/RESET_B VPWR VGND sg13cmos5l_tiehi
XFILLER_44_583 VPWR VGND sg13cmos5l_fill_1
XFILLER_8_440 VPWR VGND sg13cmos5l_decap_8
X_5470_ _5501_/A _7176_/Q _5472_/A VPWR VGND sg13cmos5l_xor2_1
X_7146__600 _7146_/RESET_B VPWR VGND sg13cmos5l_tiehi
X_4421_ _4421_/Y _4773_/B _4569_/A VPWR VGND sg13cmos5l_nand2b_1
X_7140_ _7140_/Q _7200_/CLK _7140_/D _7140_/RESET_B VPWR VGND sg13cmos5l_dfrbpq_1
X_4352_ _7549_/D _7106_/A _4352_/B VPWR VGND sg13cmos5l_and2_1
X_4283_ _4283_/Y _7503_/Q _4283_/B VPWR VGND sg13cmos5l_nand2b_1
X_7071_ _7499_/D _7071_/A _7071_/B VPWR VGND sg13cmos5l_nor2_1
X_7476__512 _7476_/RESET_B VPWR VGND sg13cmos5l_tiehi
X_6022_ _6048_/B _6052_/A _6021_/X _6010_/Y VPWR VGND sg13cmos5l_o21ai_1
X_6924_ _6934_/A _6937_/A _6955_/A VPWR VGND sg13cmos5l_nor2_1
Xfanout26 _5551_/A2 fanout28/X VPWR VGND sg13cmos5l_buf_1
Xfanout37 _5325_/A2 _5324_/A2 VPWR VGND sg13cmos5l_buf_1
XFILLER_23_734 VPWR VGND sg13cmos5l_fill_2
X_6855_ _6855_/Y _6855_/A VPWR VGND sg13cmos5l_inv_1
Xfanout59 _4616_/B _4589_/Y VPWR VGND sg13cmos5l_buf_1
X_3998_ _5290_/B _3998_/A VPWR VGND sg13cmos5l_inv_1
X_5806_ _5806_/X _7270_/Q _5823_/B _5805_/Y VPWR VGND sg13cmos5l_a21o_1
Xfanout48 _5823_/B _5793_/Y VPWR VGND sg13cmos5l_buf_1
X_6786_ _6786_/Y _7005_/A _7411_/Q _6785_/Y VPWR VGND sg13cmos5l_o21ai_1
X_5737_ _5737_/Y _7221_/Q _5737_/B VPWR VGND sg13cmos5l_nor2_1
X_7407_ _7407_/Q _7428_/CLK _7407_/D _7407_/RESET_B VPWR VGND sg13cmos5l_dfrbpq_1
X_5668_ _5671_/A _5638_/X _5667_/Y _5677_/C VPWR VGND sg13cmos5l_mux2_1
X_4619_ _4622_/B _4515_/X _4473_/Y _4619_/S VPWR VGND sg13cmos5l_mux2_1
X_5599_ _5601_/B _5565_/A _5454_/B _5610_/S VPWR VGND sg13cmos5l_mux2_1
X_7338_ _7338_/Q _7344_/CLK _7338_/D _7338_/RESET_B VPWR VGND sg13cmos5l_dfrbpq_1
X_7269_ _7269_/Q _7272_/CLK _7269_/D _7269_/RESET_B VPWR VGND sg13cmos5l_dfrbpq_1
XFILLER_46_815 VPWR VGND sg13cmos5l_decap_4
Xhold1151 _3929_/A _7312_/Q VPWR VGND sg13cmos5l_dlygate4sd3_1
Xhold1140 _4608_/A _7588_/Q VPWR VGND sg13cmos5l_dlygate4sd3_1
Xhold1173 _5696_/A _7210_/Q VPWR VGND sg13cmos5l_dlygate4sd3_1
Xhold1162 _5403_/A2 _5384_/B VPWR VGND sg13cmos5l_dlygate4sd3_1
XFILLER_18_539 VPWR VGND sg13cmos5l_fill_2
Xhold1184 _6414_/A _7366_/Q VPWR VGND sg13cmos5l_dlygate4sd3_1
Xhold1195 _5597_/A _7230_/Q VPWR VGND sg13cmos5l_dlygate4sd3_1
XFILLER_26_572 VPWR VGND sg13cmos5l_fill_2
XFILLER_41_575 VPWR VGND sg13cmos5l_decap_8
Xclkload18 clkload18/Y _7610_/CLK VPWR VGND sg13cmos5l_inv_1
XFILLER_6_977 VPWR VGND sg13cmos5l_decap_8
XFILLER_49_686 VPWR VGND sg13cmos5l_decap_8
X_4970_ _4970_/Y _4994_/A _5257_/A VPWR VGND sg13cmos5l_nand2_1
X_3921_ _6160_/A _7343_/Q VPWR VGND sg13cmos5l_inv_1
X_6640_ _6642_/B _6636_/Y _6637_/Y _6639_/Y VPWR VGND sg13cmos5l_o21ai_1
X_6571_ _6571_/Y _6751_/A _6571_/B VPWR VGND sg13cmos5l_nand2_1
X_5522_ _5522_/Y _7217_/Q _5520_/Y _5521_/X VPWR VGND sg13cmos5l_o21ai_1
XFILLER_9_760 VPWR VGND sg13cmos5l_fill_2
XFILLER_9_771 VPWR VGND sg13cmos5l_decap_8
XFILLER_30_1028 VPWR VGND sg13cmos5l_fill_1
X_5453_ _5454_/B _5441_/X _5450_/Y _5452_/X _5444_/Y VPWR VGND sg13cmos5l_a22oi_1
X_7506__276 _7506_/RESET_B VPWR VGND sg13cmos5l_tiehi
X_4404_ _4404_/Y _4404_/A _4404_/B VPWR VGND sg13cmos5l_nor2_1
X_5384_ _5384_/Y _5384_/A _5384_/B VPWR VGND sg13cmos5l_nand2_1
XFILLER_5_70 VPWR VGND sg13cmos5l_fill_1
X_4335_ _7539_/D _4337_/A _4335_/B VPWR VGND sg13cmos5l_nor2_1
X_7123_ _7123_/Q _7394_/CLK _7123_/D _7123_/RESET_B VPWR VGND sg13cmos5l_dfrbpq_1
XFILLER_8_1007 VPWR VGND sg13cmos5l_decap_8
X_4266_ _4266_/Y _4266_/A _4266_/B VPWR VGND sg13cmos5l_nor2_1
X_7054_ _7054_/Y _7054_/A _7054_/B VPWR VGND sg13cmos5l_nor2_1
X_4197_ _4198_/A _7073_/B _4196_/B _4196_/Y VPWR VGND sg13cmos5l_a21oi_1
X_6005_ _6005_/Y _6005_/A VPWR VGND sg13cmos5l_inv_1
XFILLER_42_328 VPWR VGND sg13cmos5l_decap_8
X_6907_ _6907_/Y _4160_/B _6897_/Y _6906_/A _4132_/A VPWR VGND sg13cmos5l_a22oi_1
XFILLER_24_13 VPWR VGND sg13cmos5l_fill_1
X_6838_ _6840_/B _6870_/A _6838_/B VPWR VGND sg13cmos5l_or2_1
XFILLER_10_214 VPWR VGND sg13cmos5l_decap_4
XFILLER_11_748 VPWR VGND sg13cmos5l_decap_8
X_6769_ _6769_/Y _6769_/A _6773_/B VPWR VGND sg13cmos5l_nor2_1
X_7606__687 _7606_/RESET_B VPWR VGND sg13cmos5l_tiehi
XFILLER_6_4 VPWR VGND sg13cmos5l_fill_2
XFILLER_3_958 VPWR VGND sg13cmos5l_decap_8
XFILLER_2_424 VPWR VGND sg13cmos5l_fill_2
X_7576__720 _7576_/RESET_B VPWR VGND sg13cmos5l_tiehi
XFILLER_2_479 VPWR VGND sg13cmos5l_fill_1
XFILLER_46_612 VPWR VGND sg13cmos5l_decap_4
XFILLER_45_144 VPWR VGND sg13cmos5l_decap_8
X_7136__610 _7136_/RESET_B VPWR VGND sg13cmos5l_tiehi
XFILLER_45_155 VPWR VGND sg13cmos5l_fill_1
XFILLER_42_884 VPWR VGND sg13cmos5l_fill_1
XFILLER_14_597 VPWR VGND sg13cmos5l_fill_1
X_7143__603 _7143_/RESET_B VPWR VGND sg13cmos5l_tiehi
X_4120_ _4120_/X _4120_/A _4120_/B _4298_/A VPWR VGND sg13cmos5l_or3_1
XFILLER_49_450 VPWR VGND sg13cmos5l_decap_8
X_4051_ _7647_/D _6107_/A _4051_/B VPWR VGND sg13cmos5l_nor2_1
XFILLER_49_472 VPWR VGND sg13cmos5l_decap_4
Xinput5 input5/X ui_in[3] VPWR VGND sg13cmos5l_buf_1
XFILLER_36_111 VPWR VGND sg13cmos5l_fill_2
XFILLER_36_144 VPWR VGND sg13cmos5l_fill_2
XFILLER_18_881 VPWR VGND sg13cmos5l_fill_2
X_4953_ _4962_/B _7164_/Q _7163_/Q _5330_/A VPWR VGND sg13cmos5l_nor3_1
XFILLER_36_188 VPWR VGND sg13cmos5l_fill_1
X_3904_ _6832_/A _6629_/B VPWR VGND sg13cmos5l_inv_1
X_4884_ _4886_/B _7649_/Q _7644_/Q _4871_/C VPWR VGND sg13cmos5l_o21ai_1
X_6623_ _6623_/Y _6618_/Y _6620_/Y _6622_/Y VPWR VGND sg13cmos5l_o21ai_1
X_6554_ _6554_/Y _6554_/A _6820_/B VPWR VGND sg13cmos5l_nor2_1
X_5505_ _5614_/B _5485_/B _5501_/B _5231_/Y VPWR VGND sg13cmos5l_o21ai_1
X_6485_ _6485_/Y _7381_/Q _6485_/B VPWR VGND sg13cmos5l_nor2_1
X_5436_ _5450_/B _5778_/A _5436_/B VPWR VGND sg13cmos5l_xnor2_1
XFILLER_0_928 VPWR VGND sg13cmos5l_decap_8
X_5367_ _5368_/C _5367_/A _5367_/B _5367_/C VPWR VGND sg13cmos5l_and3_1
X_5298_ _5298_/Y _7203_/Q _5560_/A VPWR VGND sg13cmos5l_nor2_1
X_7106_ _7509_/D _7106_/A _7106_/B VPWR VGND sg13cmos5l_and2_1
X_4318_ _4320_/A _4324_/S _4318_/B VPWR VGND sg13cmos5l_nand2b_1
X_4249_ _4249_/X _4249_/A _4249_/B VPWR VGND sg13cmos5l_or2_1
X_7037_ _7038_/B _7037_/A _7037_/B VPWR VGND sg13cmos5l_xnor2_1
XFILLER_27_122 VPWR VGND sg13cmos5l_fill_1
XFILLER_35_89 VPWR VGND sg13cmos5l_fill_1
XFILLER_7_516 VPWR VGND sg13cmos5l_decap_8
X_7379__324 _7379_/RESET_B VPWR VGND sg13cmos5l_tiehi
XFILLER_3_777 VPWR VGND sg13cmos5l_fill_2
XFILLER_47_998 VPWR VGND sg13cmos5l_decap_8
XFILLER_19_678 VPWR VGND sg13cmos5l_fill_1
XFILLER_15_862 VPWR VGND sg13cmos5l_decap_4
XFILLER_14_372 VPWR VGND sg13cmos5l_fill_1
X_6270_ _6294_/A _7284_/Q _6265_/Y _6269_/Y VPWR VGND sg13cmos5l_o21ai_1
X_5221_ _5222_/A _5221_/A _5231_/B VPWR VGND sg13cmos5l_and2_1
X_5152_ _5153_/B _5152_/A _5152_/B VPWR VGND sg13cmos5l_xnor2_1
X_4103_ _4103_/X _4102_/A _4102_/B _4102_/C VPWR VGND sg13cmos5l_a21o_1
X_5083_ _5083_/X _5067_/Y _5297_/B _5083_/S VPWR VGND sg13cmos5l_mux2_1
X_4034_ _4035_/B _4875_/A _4871_/A _4871_/B VPWR VGND sg13cmos5l_or3_1
XFILLER_37_464 VPWR VGND sg13cmos5l_decap_4
XFILLER_37_497 VPWR VGND sg13cmos5l_fill_1
X_7566__730 _7566_/RESET_B VPWR VGND sg13cmos5l_tiehi
XFILLER_36_1012 VPWR VGND sg13cmos5l_decap_8
X_5985_ _5985_/Y _3876_/Y _6994_/A2 _5984_/Y VPWR VGND sg13cmos5l_a21oi_1
X_4936_ _4941_/A input7/X _4936_/B VPWR VGND sg13cmos5l_nand2_1
X_4867_ _4867_/Y _4871_/B _7646_/Q _4872_/C VPWR VGND sg13cmos5l_a21oi_1
X_6606_ _6606_/Y _6610_/B _6608_/A _6603_/B _6603_/A VPWR VGND sg13cmos5l_a22oi_1
X_7586_ _7586_/Q _7630_/CLK _7586_/D _7586_/RESET_B VPWR VGND sg13cmos5l_dfrbpq_1
X_6537_ _6543_/A _6537_/A _6537_/B VPWR VGND sg13cmos5l_or2_1
XFILLER_20_386 VPWR VGND sg13cmos5l_fill_2
X_4798_ _4798_/Y _4798_/A VPWR VGND sg13cmos5l_inv_1
X_6468_ _6468_/Y _6468_/A _6468_/B VPWR VGND sg13cmos5l_nor2_1
X_7126__620 _7126_/RESET_B VPWR VGND sg13cmos5l_tiehi
XFILLER_0_703 VPWR VGND sg13cmos5l_fill_1
X_5419_ _5419_/Y _7205_/Q _7204_/Q _7235_/Q VPWR VGND sg13cmos5l_nand3b_1
X_6399_ _6399_/Y _7360_/Q _7125_/Q VPWR VGND sg13cmos5l_xnor2_1
XFILLER_0_725 VPWR VGND sg13cmos5l_fill_2
X_7573__723 _7573_/RESET_B VPWR VGND sg13cmos5l_tiehi
XFILLER_44_902 VPWR VGND sg13cmos5l_fill_2
XFILLER_15_114 VPWR VGND sg13cmos5l_fill_1
XFILLER_43_456 VPWR VGND sg13cmos5l_fill_1
XFILLER_43_445 VPWR VGND sg13cmos5l_decap_8
X_7133__613 _7133_/RESET_B VPWR VGND sg13cmos5l_tiehi
X_7489__396 _7489_/RESET_B VPWR VGND sg13cmos5l_tiehi
XFILLER_12_865 VPWR VGND sg13cmos5l_decap_4
X_7580__716 _7580_/RESET_B VPWR VGND sg13cmos5l_tiehi
XFILLER_8_869 VPWR VGND sg13cmos5l_decap_8
XFILLER_7_49 VPWR VGND sg13cmos5l_decap_4
XFILLER_3_530 VPWR VGND sg13cmos5l_decap_4
X_7140__606 _7140_/RESET_B VPWR VGND sg13cmos5l_tiehi
XFILLER_30_8 VPWR VGND sg13cmos5l_fill_2
XFILLER_4_1010 VPWR VGND sg13cmos5l_decap_8
XFILLER_38_239 VPWR VGND sg13cmos5l_fill_1
XFILLER_34_434 VPWR VGND sg13cmos5l_decap_8
X_5770_ _7263_/D _5987_/A _5770_/B VPWR VGND sg13cmos5l_and2_1
XFILLER_21_128 VPWR VGND sg13cmos5l_fill_1
X_4721_ _4793_/A _4705_/Y _4460_/Y _4726_/S VPWR VGND sg13cmos5l_mux2_1
X_4652_ _4652_/X _5007_/A _4654_/B _4652_/C VPWR VGND sg13cmos5l_and3_1
X_7440_ _7440_/Q _7513_/CLK _7440_/D _7440_/RESET_B VPWR VGND sg13cmos5l_dfrbpq_1
X_7371_ _7371_/Q _7375_/CLK _7371_/D _7371_/RESET_B VPWR VGND sg13cmos5l_dfrbpq_1
X_4583_ _4583_/Y _4473_/Y _4516_/B _4582_/Y VPWR VGND sg13cmos5l_o21ai_1
Xhold803 _4560_/B _7544_/Q VPWR VGND sg13cmos5l_dlygate4sd3_1
Xhold825 _4026_/A _7642_/Q VPWR VGND sg13cmos5l_dlygate4sd3_1
X_6322_ _7340_/D _6325_/A _6322_/B _6322_/C VPWR VGND sg13cmos5l_nor3_1
Xhold814 _6183_/B _7296_/Q VPWR VGND sg13cmos5l_dlygate4sd3_1
Xhold836 _4059_/A _7645_/Q VPWR VGND sg13cmos5l_dlygate4sd3_1
X_6253_ _6254_/C _7289_/Q _6253_/B _6253_/C VPWR VGND sg13cmos5l_and3_1
Xhold847 _7446_/D _6822_/Y VPWR VGND sg13cmos5l_dlygate4sd3_1
Xhold858 _7581_/D _4562_/Y VPWR VGND sg13cmos5l_dlygate4sd3_1
Xhold869 _3873_/A _7359_/Q VPWR VGND sg13cmos5l_dlygate4sd3_1
X_5204_ _5228_/B _7172_/Q _5205_/B VPWR VGND sg13cmos5l_xnor2_1
X_6184_ _6184_/Y _7330_/Q _6826_/A2 _6827_/A VPWR VGND sg13cmos5l_o21ai_1
X_5135_ _5153_/A _5137_/A _5134_/X _5123_/Y VPWR VGND sg13cmos5l_o21ai_1
X_5066_ _5066_/Y _7166_/Q _7164_/Q VPWR VGND sg13cmos5l_nor2b_1
X_4017_ _6792_/B _4017_/A VPWR VGND sg13cmos5l_inv_1
XFILLER_25_412 VPWR VGND sg13cmos5l_fill_1
XFILLER_41_905 VPWR VGND sg13cmos5l_decap_8
X_7369__334 _7369_/RESET_B VPWR VGND sg13cmos5l_tiehi
X_5968_ _5975_/S _7295_/Q _5968_/B _5968_/C VPWR VGND sg13cmos5l_nor3_1
X_4919_ _4919_/Y _4921_/B _6363_/A _4919_/B1 VPWR VGND sg13cmos5l_o21ai_1
X_5899_ _5907_/C _7247_/Q _7248_/Q _7249_/Q VPWR VGND sg13cmos5l_o21ai_1
X_7638_ _7638_/Q _7651_/CLK _7638_/D _7638_/RESET_B VPWR VGND sg13cmos5l_dfrbpq_1
X_7569_ _7569_/Q _7597_/CLK _7569_/D _7569_/RESET_B VPWR VGND sg13cmos5l_dfrbpq_1
XFILLER_10_1004 VPWR VGND sg13cmos5l_fill_2
X_7376__327 _7376_/RESET_B VPWR VGND sg13cmos5l_tiehi
XFILLER_48_548 VPWR VGND sg13cmos5l_fill_1
XFILLER_29_740 VPWR VGND sg13cmos5l_fill_1
XFILLER_17_924 VPWR VGND sg13cmos5l_decap_8
XFILLER_17_979 VPWR VGND sg13cmos5l_decap_8
XFILLER_43_253 VPWR VGND sg13cmos5l_decap_8
XFILLER_40_971 VPWR VGND sg13cmos5l_fill_1
XFILLER_40_960 VPWR VGND sg13cmos5l_decap_8
XFILLER_11_150 VPWR VGND sg13cmos5l_fill_1
XFILLER_4_861 VPWR VGND sg13cmos5l_decap_8
X_7556__740 _7556_/RESET_B VPWR VGND sg13cmos5l_tiehi
XFILLER_21_4 VPWR VGND sg13cmos5l_fill_1
X_6940_ _6940_/Y _6934_/X _6938_/X _6734_/Y VPWR VGND sg13cmos5l_a21oi_1
X_6871_ _6879_/B _6838_/B _6870_/B _6870_/Y VPWR VGND sg13cmos5l_a21oi_1
X_5822_ _5822_/Y _5809_/Y _5811_/Y _5820_/Y VPWR VGND sg13cmos5l_o21ai_1
XFILLER_23_949 VPWR VGND sg13cmos5l_fill_1
X_5753_ _5753_/X _5736_/Y _5951_/B _5759_/S VPWR VGND sg13cmos5l_mux2_1
XFILLER_16_990 VPWR VGND sg13cmos5l_fill_1
X_7563__733 _7563_/RESET_B VPWR VGND sg13cmos5l_tiehi
XFILLER_31_960 VPWR VGND sg13cmos5l_fill_1
XFILLER_31_982 VPWR VGND sg13cmos5l_fill_1
X_4704_ _4705_/A _4704_/A _4704_/B VPWR VGND sg13cmos5l_xnor2_1
X_5684_ _5684_/Y _5684_/A _5915_/A VPWR VGND sg13cmos5l_nand2_1
X_4635_ _7594_/D _4635_/A1 _4630_/X _4634_/Y VPWR VGND sg13cmos5l_a21oi_1
X_7423_ _7423_/Q _7424_/CLK _7423_/D _7423_/RESET_B VPWR VGND sg13cmos5l_dfrbpq_1
X_7354_ _7354_/Q _7424_/CLK _7354_/D _7354_/RESET_B VPWR VGND sg13cmos5l_dfrbpq_1
X_4566_ _7583_/D _3893_/Y _5550_/A2 _4565_/Y VPWR VGND sg13cmos5l_a21oi_1
X_6305_ _6305_/X _6311_/A _6326_/B _6304_/Y VPWR VGND sg13cmos5l_a21o_1
X_4497_ _4501_/A _4224_/Y _4512_/B VPWR VGND sg13cmos5l_nand2b_1
X_7285_ _7285_/Q clkload7/A _7285_/D _7285_/RESET_B VPWR VGND sg13cmos5l_dfrbpq_1
X_6236_ _6260_/B _6253_/B _6253_/C _7289_/Q VPWR VGND sg13cmos5l_a21oi_1
Xhold1300 _4292_/B1 _7501_/Q VPWR VGND sg13cmos5l_dlygate4sd3_1
X_6167_ _6167_/Y _6164_/Y _6165_/Y _6166_/Y VPWR VGND sg13cmos5l_a21oi_1
Xhold1311 _6578_/A _7403_/Q VPWR VGND sg13cmos5l_dlygate4sd3_1
X_7570__726 _7570_/RESET_B VPWR VGND sg13cmos5l_tiehi
X_5118_ _5167_/B _5116_/A _5116_/B _5106_/B VPWR VGND sg13cmos5l_a21oi_1
Xhold1322 _5123_/A _7160_/Q VPWR VGND sg13cmos5l_dlygate4sd3_1
X_6098_ _6098_/Y _6098_/A _6114_/B _6098_/C VPWR VGND sg13cmos5l_nand3_1
X_5049_ _5049_/Y _5331_/A _7613_/Q _5046_/Y _5047_/Y _5048_/Y VPWR VGND sg13cmos5l_a221oi_1
XFILLER_26_710 VPWR VGND sg13cmos5l_fill_2
XFILLER_40_234 VPWR VGND sg13cmos5l_fill_1
X_7130__616 _7130_/RESET_B VPWR VGND sg13cmos5l_tiehi
XFILLER_40_256 VPWR VGND sg13cmos5l_fill_1
XFILLER_1_831 VPWR VGND sg13cmos5l_fill_2
XFILLER_49_846 VPWR VGND sg13cmos5l_decap_8
XFILLER_49_879 VPWR VGND sg13cmos5l_decap_4
XFILLER_1_1024 VPWR VGND sg13cmos5l_decap_4
XFILLER_17_90 VPWR VGND sg13cmos5l_fill_2
XFILLER_9_997 VPWR VGND sg13cmos5l_decap_8
X_4420_ _4420_/Y _6711_/A _4773_/B VPWR VGND sg13cmos5l_nor2_1
X_4351_ _7548_/D _5555_/A _4351_/B VPWR VGND sg13cmos5l_and2_1
X_7070_ _7497_/D _7071_/A _7070_/B VPWR VGND sg13cmos5l_nor2_1
X_4282_ _4296_/C _7501_/Q _7499_/Q _7500_/Q VPWR VGND sg13cmos5l_nor3_1
X_6021_ _6021_/X _7307_/Q _6039_/B _6052_/B VPWR VGND sg13cmos5l_a21o_1
XFILLER_39_378 VPWR VGND sg13cmos5l_fill_1
X_6923_ _6955_/A _6923_/A _6926_/A VPWR VGND sg13cmos5l_xnor2_1
Xfanout27 _5550_/A2 fanout28/X VPWR VGND sg13cmos5l_buf_1
Xfanout38 _5324_/A2 _4343_/Y VPWR VGND sg13cmos5l_buf_1
X_6854_ _6855_/A _7455_/Q _6875_/B _6876_/A VPWR VGND sg13cmos5l_o21ai_1
XFILLER_11_908 VPWR VGND sg13cmos5l_fill_2
X_5805_ _5805_/Y _7271_/Q _5823_/B VPWR VGND sg13cmos5l_nor2_1
X_3997_ _5293_/B _3997_/A VPWR VGND sg13cmos5l_inv_1
Xfanout49 _5818_/B _5793_/Y VPWR VGND sg13cmos5l_buf_1
XFILLER_23_768 VPWR VGND sg13cmos5l_fill_2
X_6785_ _6785_/Y _7412_/Q _7460_/Q VPWR VGND sg13cmos5l_nand2b_1
X_5736_ _5736_/Y _5729_/Y _5734_/Y _5735_/Y _5741_/C VPWR VGND sg13cmos5l_a22oi_1
X_7366__337 _7366_/RESET_B VPWR VGND sg13cmos5l_tiehi
X_5667_ _5667_/Y _5667_/A _5677_/B VPWR VGND sg13cmos5l_nor2b_1
X_7406_ _7406_/Q _7428_/CLK _7406_/D _7406_/RESET_B VPWR VGND sg13cmos5l_dfrbpq_1
X_4618_ _4622_/A _4625_/B _4618_/B VPWR VGND sg13cmos5l_nand2b_1
X_5598_ _5601_/A _5616_/B _5598_/B VPWR VGND sg13cmos5l_nor2_1
XFILLER_2_617 VPWR VGND sg13cmos5l_decap_4
X_7337_ _7337_/Q clkload7/A _7337_/D _7337_/RESET_B VPWR VGND sg13cmos5l_dfrbpq_1
X_4549_ _4554_/S _7579_/Q _4549_/B VPWR VGND sg13cmos5l_nor2_1
X_7268_ _7268_/Q _7272_/CLK _7268_/D _7268_/RESET_B VPWR VGND sg13cmos5l_dfrbpq_1
X_6219_ _6220_/B _7333_/Q _6215_/B _6197_/Y VPWR VGND sg13cmos5l_a21oi_1
X_7199_ _7199_/Q _7214_/CLK _7199_/D _7199_/RESET_B VPWR VGND sg13cmos5l_dfrbpq_1
X_7197__543 _7197_/RESET_B VPWR VGND sg13cmos5l_tiehi
Xhold1130 _3991_/A _7182_/Q VPWR VGND sg13cmos5l_dlygate4sd3_1
Xhold1141 _4609_/B _4608_/X VPWR VGND sg13cmos5l_dlygate4sd3_1
XFILLER_46_838 VPWR VGND sg13cmos5l_fill_2
Xhold1163 _6735_/A0 _7430_/Q VPWR VGND sg13cmos5l_dlygate4sd3_1
Xhold1185 _6426_/A2 _6410_/B VPWR VGND sg13cmos5l_dlygate4sd3_1
Xhold1152 _5146_/A _7155_/Q VPWR VGND sg13cmos5l_dlygate4sd3_1
Xhold1174 _7032_/A _7485_/Q VPWR VGND sg13cmos5l_dlygate4sd3_1
Xhold1196 _5625_/A _5601_/A VPWR VGND sg13cmos5l_dlygate4sd3_1
XFILLER_41_598 VPWR VGND sg13cmos5l_fill_1
XFILLER_9_238 VPWR VGND sg13cmos5l_decap_4
Xclkload19 clkload19/Y _7200_/CLK VPWR VGND sg13cmos5l_inv_4
XFILLER_6_956 VPWR VGND sg13cmos5l_decap_8
XFILLER_48_9 VPWR VGND sg13cmos5l_fill_1
XFILLER_1_661 VPWR VGND sg13cmos5l_decap_4
XFILLER_49_643 VPWR VGND sg13cmos5l_fill_1
XFILLER_49_632 VPWR VGND sg13cmos5l_decap_8
X_7553__743 _7553_/RESET_B VPWR VGND sg13cmos5l_tiehi
XFILLER_48_175 VPWR VGND sg13cmos5l_decap_8
XFILLER_36_304 VPWR VGND sg13cmos5l_fill_1
XFILLER_45_882 VPWR VGND sg13cmos5l_fill_1
XFILLER_45_871 VPWR VGND sg13cmos5l_decap_8
X_3920_ _6155_/A _7342_/Q VPWR VGND sg13cmos5l_inv_1
X_6570_ _6576_/B _7402_/Q _6570_/B VPWR VGND sg13cmos5l_xnor2_1
XFILLER_20_749 VPWR VGND sg13cmos5l_decap_8
X_5521_ _5521_/X _7216_/Q _5521_/B VPWR VGND sg13cmos5l_and2_1
XFILLER_30_1007 VPWR VGND sg13cmos5l_decap_8
X_7560__736 _7560_/RESET_B VPWR VGND sg13cmos5l_tiehi
X_5452_ _5452_/X _5452_/A _5452_/B VPWR VGND sg13cmos5l_and2_1
X_4403_ _4404_/B _4403_/A _4403_/B VPWR VGND sg13cmos5l_nor2_1
X_5383_ _5384_/B _5383_/A _5383_/B VPWR VGND sg13cmos5l_nor2_1
XFILLER_5_60 VPWR VGND sg13cmos5l_fill_2
X_7122_ _7122_/Q _7394_/CLK _7122_/D _7122_/RESET_B VPWR VGND sg13cmos5l_dfrbpq_1
X_4334_ _4335_/B _4315_/B _4013_/Y _4336_/S VPWR VGND sg13cmos5l_mux2_1
X_7053_ _7054_/B _7053_/A _7041_/Y VPWR VGND sg13cmos5l_nor2b_1
X_4265_ _4512_/A _4498_/A _4265_/B VPWR VGND sg13cmos5l_nor2_1
X_6004_ _6005_/A _5996_/A _5883_/B _6042_/S VPWR VGND sg13cmos5l_mux2_1
X_4196_ _4196_/Y _7069_/B _4196_/B VPWR VGND sg13cmos5l_nor2_1
XFILLER_28_816 VPWR VGND sg13cmos5l_decap_8
XFILLER_43_808 VPWR VGND sg13cmos5l_fill_2
XFILLER_39_197 VPWR VGND sg13cmos5l_fill_2
X_6906_ _6906_/Y _6906_/A VPWR VGND sg13cmos5l_inv_1
XFILLER_36_893 VPWR VGND sg13cmos5l_fill_2
XFILLER_23_510 VPWR VGND sg13cmos5l_fill_2
X_6837_ _6840_/A _6771_/B _6837_/B _6837_/C VPWR VGND sg13cmos5l_nand3b_1
XFILLER_24_58 VPWR VGND sg13cmos5l_fill_1
X_6768_ _6768_/X _6777_/B _6768_/B VPWR VGND sg13cmos5l_or2_1
X_6699_ _6699_/Y _6699_/A _6699_/B VPWR VGND sg13cmos5l_nand2_1
XFILLER_40_35 VPWR VGND sg13cmos5l_fill_2
X_5719_ _5785_/A _5460_/Y _5703_/B _5719_/S VPWR VGND sg13cmos5l_mux2_1
XFILLER_46_1014 VPWR VGND sg13cmos5l_decap_8
XFILLER_45_123 VPWR VGND sg13cmos5l_fill_1
XFILLER_27_893 VPWR VGND sg13cmos5l_fill_2
XFILLER_6_797 VPWR VGND sg13cmos5l_decap_8
X_4050_ _4051_/B _4041_/B _4863_/A _4872_/B VPWR VGND sg13cmos5l_a21oi_1
Xinput6 input6/X ui_in[4] VPWR VGND sg13cmos5l_buf_1
X_7256__481 _7256_/RESET_B VPWR VGND sg13cmos5l_tiehi
XFILLER_36_156 VPWR VGND sg13cmos5l_fill_1
X_4952_ _4952_/X _5245_/A _4957_/B _4952_/C VPWR VGND sg13cmos5l_and3_1
X_3903_ _6831_/A _3903_/A VPWR VGND sg13cmos5l_inv_1
X_4883_ _4889_/A _4030_/Y _4883_/B _4883_/C VPWR VGND sg13cmos5l_nand3b_1
X_6622_ _6622_/Y _7429_/Q _6622_/B VPWR VGND sg13cmos5l_nand2_1
X_6553_ _7397_/D _6533_/Y _6534_/X _6511_/B VPWR VGND sg13cmos5l_a21oi_1
X_6484_ _6485_/B _6451_/B _6478_/Y _6480_/Y _6483_/Y VPWR VGND sg13cmos5l_a22oi_1
X_5504_ _7213_/D _5560_/B _5504_/B VPWR VGND sg13cmos5l_nor2_1
XFILLER_9_591 VPWR VGND sg13cmos5l_fill_1
X_5435_ _5709_/A _7240_/Q _5436_/B VPWR VGND sg13cmos5l_xnor2_1
XFILLER_0_907 VPWR VGND sg13cmos5l_decap_8
X_5366_ _5383_/A _5368_/A _5365_/X _5354_/Y VPWR VGND sg13cmos5l_o21ai_1
X_7105_ _7507_/D _7105_/A _7105_/B VPWR VGND sg13cmos5l_nor2_1
X_5297_ _5297_/Y _7147_/Q _5297_/B _5297_/C VPWR VGND sg13cmos5l_nor3_1
X_4317_ _4318_/B _7508_/Q _4317_/B VPWR VGND sg13cmos5l_nand2b_1
X_4248_ _4249_/B _4261_/A _4266_/B _4247_/Y VPWR VGND sg13cmos5l_a21o_1
X_7036_ _7039_/C _7045_/B _7060_/A VPWR VGND sg13cmos5l_nand2b_1
XFILLER_19_36 VPWR VGND sg13cmos5l_fill_2
XFILLER_19_47 VPWR VGND sg13cmos5l_fill_1
XFILLER_19_58 VPWR VGND sg13cmos5l_fill_1
X_7194__546 _7194_/RESET_B VPWR VGND sg13cmos5l_tiehi
X_4179_ _4194_/A _4193_/B _4193_/C _4193_/A VPWR VGND sg13cmos5l_a21oi_1
XFILLER_43_649 VPWR VGND sg13cmos5l_fill_2
X_7612__681 _7612_/RESET_B VPWR VGND sg13cmos5l_tiehi
XFILLER_11_502 VPWR VGND sg13cmos5l_decap_8
XFILLER_11_524 VPWR VGND sg13cmos5l_fill_2
XFILLER_11_557 VPWR VGND sg13cmos5l_fill_2
Xclkbuf_3_3__f_clk clkload2/A clkbuf_0_clk/X VPWR VGND sg13cmos5l_buf_8
XFILLER_13_1024 VPWR VGND sg13cmos5l_decap_4
XFILLER_2_200 VPWR VGND sg13cmos5l_fill_1
XFILLER_4_2 VPWR VGND sg13cmos5l_fill_1
XFILLER_46_421 VPWR VGND sg13cmos5l_fill_1
XFILLER_46_410 VPWR VGND sg13cmos5l_fill_2
XFILLER_18_101 VPWR VGND sg13cmos5l_decap_8
X_7550__746 _7550_/RESET_B VPWR VGND sg13cmos5l_tiehi
XFILLER_47_977 VPWR VGND sg13cmos5l_decap_8
XFILLER_19_668 VPWR VGND sg13cmos5l_fill_1
XFILLER_25_90 VPWR VGND sg13cmos5l_fill_2
XFILLER_30_800 VPWR VGND sg13cmos5l_fill_2
X_7349__173 _7349_/D VPWR VGND sg13cmos5l_tielo
XFILLER_6_550 VPWR VGND sg13cmos5l_fill_2
X_5220_ _7168_/D _5314_/A _5336_/A VPWR VGND sg13cmos5l_nor2_1
X_5151_ _5152_/B _7158_/Q _5151_/B VPWR VGND sg13cmos5l_xor2_1
X_4102_ _4108_/A _4102_/A _4102_/B _4102_/C VPWR VGND sg13cmos5l_and3_1
X_5082_ _7144_/D _5177_/A _5082_/B VPWR VGND sg13cmos5l_nor2_1
X_4033_ _7652_/D _4033_/A VPWR VGND sg13cmos5l_inv_1
XFILLER_49_270 VPWR VGND sg13cmos5l_decap_4
X_5984_ _5984_/Y _7262_/Q _5984_/A2 _7000_/A VPWR VGND sg13cmos5l_o21ai_1
X_4935_ _7125_/D _6427_/A _4939_/B VPWR VGND sg13cmos5l_nor2_1
XFILLER_33_682 VPWR VGND sg13cmos5l_fill_2
XFILLER_21_866 VPWR VGND sg13cmos5l_fill_1
X_4866_ _4878_/A _4872_/C _4865_/Y _6505_/A VPWR VGND sg13cmos5l_o21ai_1
XFILLER_32_192 VPWR VGND sg13cmos5l_fill_1
X_6605_ _6605_/X _6605_/A _6605_/B _6605_/C VPWR VGND sg13cmos5l_or3_1
XFILLER_21_877 VPWR VGND sg13cmos5l_decap_4
X_4797_ _4798_/A _4693_/B _4727_/Y _4843_/B _4696_/A VPWR VGND sg13cmos5l_a22oi_1
X_7585_ _7585_/Q _7622_/CLK _7585_/D _7585_/RESET_B VPWR VGND sg13cmos5l_dfrbpq_1
X_6536_ _6536_/Y _6536_/A _6536_/B VPWR VGND sg13cmos5l_xnor2_1
XFILLER_4_509 VPWR VGND sg13cmos5l_decap_8
X_6467_ _7376_/D _6510_/B _6517_/A VPWR VGND sg13cmos5l_and2_1
X_5418_ _5418_/Y _7235_/Q _7204_/Q VPWR VGND sg13cmos5l_nand2_1
X_6398_ _6398_/Y _7359_/Q _7124_/Q VPWR VGND sg13cmos5l_xnor2_1
X_5349_ _5349_/Y _5337_/B _5347_/Y _5348_/X VPWR VGND sg13cmos5l_a21oi_1
XFILLER_43_1017 VPWR VGND sg13cmos5l_fill_2
XFILLER_46_34 VPWR VGND sg13cmos5l_fill_2
X_7019_ _7019_/Y _7479_/Q _7450_/Q VPWR VGND sg13cmos5l_xnor2_1
XFILLER_44_936 VPWR VGND sg13cmos5l_fill_2
XFILLER_30_107 VPWR VGND sg13cmos5l_fill_2
XFILLER_11_310 VPWR VGND sg13cmos5l_fill_1
XFILLER_7_28 VPWR VGND sg13cmos5l_fill_2
XFILLER_12_877 VPWR VGND sg13cmos5l_decap_8
XFILLER_12_888 VPWR VGND sg13cmos5l_fill_1
XFILLER_3_520 VPWR VGND sg13cmos5l_fill_2
X_7246__491 _7246_/RESET_B VPWR VGND sg13cmos5l_tiehi
X_7379__166 _7379_/D VPWR VGND sg13cmos5l_tielo
XFILLER_46_284 VPWR VGND sg13cmos5l_fill_2
X_7253__484 _7253_/RESET_B VPWR VGND sg13cmos5l_tiehi
XFILLER_14_170 VPWR VGND sg13cmos5l_decap_8
X_4720_ _7605_/D _4728_/A _4791_/A VPWR VGND sg13cmos5l_nor2_1
X_4651_ _4651_/Y _4646_/Y _4651_/B VPWR VGND sg13cmos5l_nand2b_1
X_7370_ _7370_/Q _7375_/CLK _7370_/D _7370_/RESET_B VPWR VGND sg13cmos5l_dfrbpq_1
X_4582_ _4582_/Y _4623_/B _4623_/A VPWR VGND sg13cmos5l_nand2b_1
X_6321_ _6322_/C _6323_/A _6321_/B _6323_/C VPWR VGND sg13cmos5l_and3_1
Xhold826 _4900_/B _4899_/Y VPWR VGND sg13cmos5l_dlygate4sd3_1
Xhold837 _5988_/B _7265_/Q VPWR VGND sg13cmos5l_dlygate4sd3_1
Xhold804 _5327_/B _7153_/Q VPWR VGND sg13cmos5l_dlygate4sd3_1
Xhold815 _6651_/B _7384_/Q VPWR VGND sg13cmos5l_dlygate4sd3_1
XFILLER_42_0 VPWR VGND sg13cmos5l_decap_4
X_6252_ _6252_/Y _5853_/Y _6242_/A _6249_/X _5887_/A VPWR VGND sg13cmos5l_a22oi_1
X_7602__691 _7602_/RESET_B VPWR VGND sg13cmos5l_tiehi
Xhold848 _3877_/A _7298_/Q VPWR VGND sg13cmos5l_dlygate4sd3_1
Xhold859 hold859/X _7447_/Q VPWR VGND sg13cmos5l_dlygate4sd3_1
X_5203_ _5489_/B _5562_/A _5203_/B VPWR VGND sg13cmos5l_xnor2_1
X_6183_ _7329_/D _6659_/A _6183_/B VPWR VGND sg13cmos5l_and2_1
X_7260__477 _7260_/RESET_B VPWR VGND sg13cmos5l_tiehi
X_5134_ _5134_/X _7159_/Q _5151_/B _5133_/Y VPWR VGND sg13cmos5l_a21o_1
X_7397__299 _7397_/RESET_B VPWR VGND sg13cmos5l_tiehi
X_5065_ _5065_/Y _7616_/Q _5065_/B _5065_/C VPWR VGND sg13cmos5l_nor3_1
XFILLER_37_240 VPWR VGND sg13cmos5l_fill_1
X_4016_ _4016_/Y _7444_/Q VPWR VGND sg13cmos5l_inv_1
X_7191__549 _7191_/RESET_B VPWR VGND sg13cmos5l_tiehi
X_5967_ _5968_/C _7294_/Q _5967_/B VPWR VGND sg13cmos5l_nor2_1
XFILLER_12_107 VPWR VGND sg13cmos5l_fill_1
XFILLER_40_449 VPWR VGND sg13cmos5l_decap_8
X_4918_ _4918_/Y _7119_/Q hold1044/X VPWR VGND sg13cmos5l_nor2b_1
Xclkbuf_leaf_32_clk _7314_/CLK clkload0/A VPWR VGND sg13cmos5l_buf_8
X_5898_ _5907_/B _7249_/Q _7247_/Q _7248_/Q VPWR VGND sg13cmos5l_or3_1
X_7637_ _7637_/Q clkload6/A _7637_/D _7637_/RESET_B VPWR VGND sg13cmos5l_dfrbpq_1
XFILLER_32_25 VPWR VGND sg13cmos5l_decap_8
XFILLER_20_151 VPWR VGND sg13cmos5l_decap_4
X_4849_ _4850_/C _4849_/A _4849_/B VPWR VGND sg13cmos5l_nor2_1
X_7568_ _7568_/Q _7571_/CLK _7568_/D _7568_/RESET_B VPWR VGND sg13cmos5l_dfrbpq_1
XFILLER_5_829 VPWR VGND sg13cmos5l_decap_4
XFILLER_10_1016 VPWR VGND sg13cmos5l_decap_8
X_7499_ _7499_/Q _7560_/CLK _7499_/D _7499_/RESET_B VPWR VGND sg13cmos5l_dfrbpq_1
XFILLER_10_1027 VPWR VGND sg13cmos5l_fill_2
X_6519_ _6519_/Y _7387_/Q _6525_/B VPWR VGND sg13cmos5l_nand2_1
XFILLER_0_534 VPWR VGND sg13cmos5l_decap_8
XFILLER_0_567 VPWR VGND sg13cmos5l_decap_8
XFILLER_17_958 VPWR VGND sg13cmos5l_decap_4
XFILLER_16_468 VPWR VGND sg13cmos5l_decap_8
Xclkbuf_leaf_23_clk _7635_/CLK clkbuf_3_4__f_clk/X VPWR VGND sg13cmos5l_buf_8
XFILLER_40_994 VPWR VGND sg13cmos5l_fill_2
XFILLER_7_177 VPWR VGND sg13cmos5l_decap_8
XFILLER_47_560 VPWR VGND sg13cmos5l_decap_8
XFILLER_19_262 VPWR VGND sg13cmos5l_fill_1
X_6870_ _6870_/Y _6870_/A _6870_/B VPWR VGND sg13cmos5l_nor2_1
X_5821_ _5821_/Y _5789_/X _5819_/Y _5817_/Y VPWR VGND sg13cmos5l_a21oi_1
X_5752_ _5759_/S _5748_/Y _5750_/Y _5751_/Y VPWR VGND sg13cmos5l_a21oi_1
X_4703_ _4703_/Y _7593_/Q _7568_/Q VPWR VGND sg13cmos5l_nor2_1
Xclkbuf_leaf_14_clk _7553_/CLK clkload4/A VPWR VGND sg13cmos5l_buf_8
X_5683_ _7244_/D _5847_/A _5683_/B VPWR VGND sg13cmos5l_nor2_1
XFILLER_33_1027 VPWR VGND sg13cmos5l_fill_2
X_7422_ _7422_/Q clkload8/A _7422_/D _7422_/RESET_B VPWR VGND sg13cmos5l_dfrbpq_1
X_4634_ _4634_/Y _4613_/B _4630_/X _4575_/B VPWR VGND sg13cmos5l_o21ai_1
X_7353_ _7353_/Q _7375_/CLK _7353_/D _7353_/RESET_B VPWR VGND sg13cmos5l_dfrbpq_1
X_4565_ _4565_/Y _4375_/A _5551_/A2 _4569_/A VPWR VGND sg13cmos5l_o21ai_1
X_6304_ _6304_/Y _6222_/C _6302_/B _6289_/Y _6268_/B _6299_/X VPWR VGND sg13cmos5l_a221oi_1
X_4496_ _4512_/B _4496_/A _4496_/B VPWR VGND sg13cmos5l_or2_1
X_7284_ _7284_/Q _7344_/CLK _7284_/D _7284_/RESET_B VPWR VGND sg13cmos5l_dfrbpq_1
X_6235_ _6240_/B _6253_/B _6253_/C VPWR VGND sg13cmos5l_nand2_1
X_7123__624 _7123_/RESET_B VPWR VGND sg13cmos5l_tiehi
X_6166_ _6166_/Y _6181_/A _6137_/Y _3879_/Y VPWR VGND sg13cmos5l_o21ai_1
Xhold1301 _6596_/A _7377_/Q VPWR VGND sg13cmos5l_dlygate4sd3_1
Xhold1323 _5198_/A _7171_/Q VPWR VGND sg13cmos5l_dlygate4sd3_1
X_6097_ _6098_/C _6122_/A _6097_/B VPWR VGND sg13cmos5l_nand2b_1
X_5117_ _5167_/A _5117_/A _5155_/B _5155_/C VPWR VGND sg13cmos5l_nor3_1
Xhold1312 _6207_/A _7335_/Q VPWR VGND sg13cmos5l_dlygate4sd3_1
XFILLER_45_519 VPWR VGND sg13cmos5l_fill_1
X_5048_ _5048_/Y _7164_/Q _5065_/B VPWR VGND sg13cmos5l_nor2_1
XFILLER_27_36 VPWR VGND sg13cmos5l_fill_2
XFILLER_38_582 VPWR VGND sg13cmos5l_fill_1
XFILLER_14_917 VPWR VGND sg13cmos5l_decap_8
XFILLER_25_287 VPWR VGND sg13cmos5l_decap_4
X_6999_ _6999_/Y _3861_/Y _6999_/A2 _6998_/Y VPWR VGND sg13cmos5l_a21oi_1
XFILLER_40_268 VPWR VGND sg13cmos5l_fill_1
XFILLER_5_637 VPWR VGND sg13cmos5l_fill_2
XFILLER_49_1023 VPWR VGND sg13cmos5l_decap_4
X_7243__494 _7243_/RESET_B VPWR VGND sg13cmos5l_tiehi
XFILLER_1_887 VPWR VGND sg13cmos5l_fill_2
XFILLER_1_1003 VPWR VGND sg13cmos5l_decap_8
XFILLER_44_563 VPWR VGND sg13cmos5l_fill_1
XFILLER_16_243 VPWR VGND sg13cmos5l_fill_1
XFILLER_16_298 VPWR VGND sg13cmos5l_fill_2
X_7250__487 _7250_/RESET_B VPWR VGND sg13cmos5l_tiehi
XFILLER_8_497 VPWR VGND sg13cmos5l_fill_2
XFILLER_8_486 VPWR VGND sg13cmos5l_fill_2
X_4350_ _7547_/D _3860_/Y _5323_/A2 _4349_/Y VPWR VGND sg13cmos5l_a21oi_1
X_4281_ _4281_/X _4281_/A _4281_/B VPWR VGND sg13cmos5l_and2_1
X_6020_ _6052_/B _6020_/A _6039_/B VPWR VGND sg13cmos5l_nor2_1
Xclkbuf_leaf_3_clk _7332_/CLK clkload0/A VPWR VGND sg13cmos5l_buf_8
X_7359__356 _7359_/RESET_B VPWR VGND sg13cmos5l_tiehi
X_6922_ _6935_/B _7437_/Q _7438_/Q _7436_/Q _7435_/Q VPWR VGND sg13cmos5l_nor4_1
XFILLER_35_541 VPWR VGND sg13cmos5l_decap_4
X_6853_ _6876_/A _7454_/Q _6863_/B _6868_/A VPWR VGND sg13cmos5l_a21o_1
X_5804_ _5833_/A _5832_/B _5832_/C _5832_/A VPWR VGND sg13cmos5l_a21oi_1
XFILLER_23_736 VPWR VGND sg13cmos5l_fill_1
Xfanout28 fanout28/X _4344_/X VPWR VGND sg13cmos5l_buf_1
Xfanout39 _6159_/B _6142_/Y VPWR VGND sg13cmos5l_buf_1
X_3996_ _5297_/B _3996_/A VPWR VGND sg13cmos5l_inv_1
X_6784_ _6784_/Y _7005_/A _7411_/Q _7410_/Q _6737_/A _6783_/Y VPWR VGND sg13cmos5l_a221oi_1
X_5735_ _5735_/Y _7277_/Q _7272_/Q VPWR VGND sg13cmos5l_nor2b_1
X_5666_ _5677_/C _5664_/A _5664_/B _5665_/Y VPWR VGND sg13cmos5l_o21ai_1
XFILLER_13_49 VPWR VGND sg13cmos5l_fill_2
X_7405_ _7405_/Q _7428_/CLK _7405_/D _7405_/RESET_B VPWR VGND sg13cmos5l_dfrbpq_1
X_4617_ _4617_/Y _4617_/A _4617_/B VPWR VGND sg13cmos5l_xnor2_1
X_5597_ _5598_/B _5597_/A _5597_/B VPWR VGND sg13cmos5l_xnor2_1
X_7336_ _7336_/Q clkload7/A _7336_/D _7336_/RESET_B VPWR VGND sg13cmos5l_dfrbpq_1
X_4548_ _4549_/B _7578_/Q _4545_/Y _4547_/Y VPWR VGND sg13cmos5l_o21ai_1
X_4479_ _4479_/Y _7535_/Q _4482_/A VPWR VGND sg13cmos5l_xnor2_1
X_7267_ _7267_/Q _7272_/CLK _7267_/D _7267_/RESET_B VPWR VGND sg13cmos5l_dfrbpq_1
X_6218_ _6222_/C _6218_/A VPWR VGND sg13cmos5l_inv_1
X_7198_ _7198_/Q _7239_/CLK _7198_/D _7198_/RESET_B VPWR VGND sg13cmos5l_dfrbpq_1
Xhold1142 _4635_/A1 _4613_/A VPWR VGND sg13cmos5l_dlygate4sd3_1
Xhold1120 _3993_/A _7180_/Q VPWR VGND sg13cmos5l_dlygate4sd3_1
X_6149_ _6149_/Y _6160_/B _7339_/Q VPWR VGND sg13cmos5l_nor2b_1
X_7295__178 _7295_/D VPWR VGND sg13cmos5l_tielo
Xhold1131 _5316_/B _5315_/X VPWR VGND sg13cmos5l_dlygate4sd3_1
Xhold1153 _5169_/A1 _5147_/Y VPWR VGND sg13cmos5l_dlygate4sd3_1
Xhold1164 _4063_/B _7651_/Q VPWR VGND sg13cmos5l_dlygate4sd3_1
Xhold1175 _7033_/B _7032_/Y VPWR VGND sg13cmos5l_dlygate4sd3_1
Xhold1197 _6596_/B _7376_/Q VPWR VGND sg13cmos5l_dlygate4sd3_1
Xhold1186 _6402_/A _7367_/Q VPWR VGND sg13cmos5l_dlygate4sd3_1
XFILLER_26_574 VPWR VGND sg13cmos5l_fill_1
XFILLER_41_522 VPWR VGND sg13cmos5l_decap_4
XFILLER_13_224 VPWR VGND sg13cmos5l_decap_4
XFILLER_14_747 VPWR VGND sg13cmos5l_decap_8
XFILLER_21_290 VPWR VGND sg13cmos5l_decap_8
XFILLER_5_456 VPWR VGND sg13cmos5l_decap_8
XFILLER_5_478 VPWR VGND sg13cmos5l_decap_8
XFILLER_23_1026 VPWR VGND sg13cmos5l_fill_2
X_7512__441 _7512_/RESET_B VPWR VGND sg13cmos5l_tiehi
XFILLER_45_894 VPWR VGND sg13cmos5l_decap_8
X_5520_ _5520_/Y _5527_/C _5519_/Y _5518_/Y VPWR VGND sg13cmos5l_a21oi_1
XFILLER_9_751 VPWR VGND sg13cmos5l_fill_2
XFILLER_8_261 VPWR VGND sg13cmos5l_decap_8
X_5451_ _5451_/Y _5451_/A _5709_/A VPWR VGND sg13cmos5l_nand2_1
X_4402_ _4403_/B _4402_/A _4402_/B VPWR VGND sg13cmos5l_xnor2_1
X_5382_ _5383_/B _5382_/A _5382_/B VPWR VGND sg13cmos5l_nor2_1
X_7121_ _7121_/Q _7651_/CLK _7121_/D _7121_/RESET_B VPWR VGND sg13cmos5l_dfrbpq_1
X_4333_ _4333_/Y _4316_/A _4336_/S _4332_/Y VPWR VGND sg13cmos5l_a21oi_1
X_4264_ _7528_/D _4357_/B _4394_/A VPWR VGND sg13cmos5l_and2_1
X_7052_ _7054_/A _7052_/A _7052_/B VPWR VGND sg13cmos5l_nor2_1
X_6003_ _6042_/S _5897_/B _6046_/B _6002_/Y VPWR VGND sg13cmos5l_o21ai_1
X_7296__432 _7296_/RESET_B VPWR VGND sg13cmos5l_tiehi
X_4195_ _4195_/Y _4195_/A VPWR VGND sg13cmos5l_inv_1
X_7372__331 _7372_/RESET_B VPWR VGND sg13cmos5l_tiehi
X_7454__653 _7454_/RESET_B VPWR VGND sg13cmos5l_tiehi
XFILLER_28_828 VPWR VGND sg13cmos5l_decap_4
X_6905_ _6906_/A _7465_/Q _6905_/B VPWR VGND sg13cmos5l_xnor2_1
XFILLER_42_308 VPWR VGND sg13cmos5l_fill_1
XFILLER_39_1011 VPWR VGND sg13cmos5l_fill_2
XFILLER_35_360 VPWR VGND sg13cmos5l_fill_2
X_6836_ _6837_/B _6836_/A _6836_/B _6836_/C VPWR VGND sg13cmos5l_nand3_1
XFILLER_23_555 VPWR VGND sg13cmos5l_decap_4
X_6767_ _6768_/B _6767_/A _6773_/B VPWR VGND sg13cmos5l_nor2_1
X_5718_ _7249_/D _5774_/B _5810_/A VPWR VGND sg13cmos5l_and2_1
X_3979_ _6986_/B _7473_/Q VPWR VGND sg13cmos5l_inv_1
X_6698_ _6698_/Y _6698_/A VPWR VGND sg13cmos5l_inv_1
XFILLER_6_209 VPWR VGND sg13cmos5l_decap_8
XFILLER_40_58 VPWR VGND sg13cmos5l_fill_1
X_5649_ _5656_/B _7244_/Q _7243_/Q _7241_/Q _7242_/Q VPWR VGND sg13cmos5l_nor4_1
XFILLER_2_426 VPWR VGND sg13cmos5l_fill_1
X_7319_ _7319_/Q _7344_/CLK _7319_/D _7319_/RESET_B VPWR VGND sg13cmos5l_dfrbpq_1
XFILLER_49_78 VPWR VGND sg13cmos5l_fill_1
XFILLER_49_67 VPWR VGND sg13cmos5l_decap_8
X_7240__497 _7240_/RESET_B VPWR VGND sg13cmos5l_tiehi
XFILLER_46_625 VPWR VGND sg13cmos5l_fill_2
XFILLER_33_308 VPWR VGND sg13cmos5l_fill_2
XFILLER_45_179 VPWR VGND sg13cmos5l_fill_1
XFILLER_42_831 VPWR VGND sg13cmos5l_decap_8
XFILLER_14_511 VPWR VGND sg13cmos5l_fill_2
XFILLER_42_875 VPWR VGND sg13cmos5l_decap_8
XFILLER_41_374 VPWR VGND sg13cmos5l_fill_2
X_7349__366 _7349_/RESET_B VPWR VGND sg13cmos5l_tiehi
XFILLER_10_794 VPWR VGND sg13cmos5l_decap_8
X_7499__322 _7499_/RESET_B VPWR VGND sg13cmos5l_tiehi
XFILLER_6_776 VPWR VGND sg13cmos5l_decap_8
XFILLER_5_286 VPWR VGND sg13cmos5l_fill_1
XFILLER_5_275 VPWR VGND sg13cmos5l_fill_2
X_7356__359 _7356_/RESET_B VPWR VGND sg13cmos5l_tiehi
Xinput7 input7/X ui_in[5] VPWR VGND sg13cmos5l_buf_1
XFILLER_36_146 VPWR VGND sg13cmos5l_fill_1
XFILLER_45_680 VPWR VGND sg13cmos5l_decap_4
X_4951_ _4951_/Y _4982_/A _4949_/Y _4950_/Y _5330_/A VPWR VGND sg13cmos5l_a22oi_1
XFILLER_18_883 VPWR VGND sg13cmos5l_fill_1
X_3902_ _6508_/A _6352_/A VPWR VGND sg13cmos5l_inv_1
X_4882_ _4883_/C input8/X _4862_/C _4863_/B _4901_/A VPWR VGND sg13cmos5l_a22oi_1
X_6621_ _6622_/B _7383_/Q _7428_/Q VPWR VGND sg13cmos5l_nand2_1
XFILLER_32_374 VPWR VGND sg13cmos5l_decap_8
XFILLER_33_886 VPWR VGND sg13cmos5l_fill_2
XFILLER_20_547 VPWR VGND sg13cmos5l_fill_1
X_7543__209 _7543_/D VPWR VGND sg13cmos5l_tielo
X_6552_ _6552_/Y _6552_/A1 _6547_/Y _6551_/Y VPWR VGND sg13cmos5l_a21oi_1
X_6483_ _6483_/Y _7357_/Q _6483_/B VPWR VGND sg13cmos5l_nor2_1
X_5503_ _5503_/Y _5504_/B VPWR VGND sg13cmos5l_inv_1
X_5434_ _5441_/A _5421_/Y _5427_/Y _5429_/X _5432_/Y _5433_/Y VPWR VGND sg13cmos5l_a221oi_1
XFILLER_10_28 VPWR VGND sg13cmos5l_fill_2
X_7104_ _7104_/Y _7104_/A _7075_/Y VPWR VGND sg13cmos5l_nor2b_1
X_5365_ _5365_/X _7196_/Q _5387_/B _5364_/Y VPWR VGND sg13cmos5l_a21o_1
X_5296_ _5296_/Y _7181_/Q _5300_/B VPWR VGND sg13cmos5l_nand2_1
X_7476__152 _7476_/D VPWR VGND sg13cmos5l_tielo
X_4316_ _4316_/Y _4316_/A _4316_/B _4316_/C VPWR VGND sg13cmos5l_nor3_1
X_4247_ _4247_/Y _4269_/B _4247_/B VPWR VGND sg13cmos5l_nor2_1
X_7035_ _7045_/B _7008_/A _7042_/B _7034_/Y VPWR VGND sg13cmos5l_a21oi_1
X_4178_ _4193_/C _7512_/Q _7483_/Q _7517_/Q VPWR VGND sg13cmos5l_nand3_1
X_6819_ _7443_/D _6793_/Y _6794_/Y _6782_/A VPWR VGND sg13cmos5l_a21oi_1
XFILLER_3_735 VPWR VGND sg13cmos5l_decap_8
XFILLER_47_956 VPWR VGND sg13cmos5l_decap_8
XFILLER_19_636 VPWR VGND sg13cmos5l_fill_2
XFILLER_18_135 VPWR VGND sg13cmos5l_fill_2
XFILLER_46_499 VPWR VGND sg13cmos5l_fill_2
XFILLER_15_886 VPWR VGND sg13cmos5l_decap_8
XFILLER_30_845 VPWR VGND sg13cmos5l_fill_2
XFILLER_41_90 VPWR VGND sg13cmos5l_fill_2
X_7362__341 _7362_/RESET_B VPWR VGND sg13cmos5l_tiehi
X_5150_ _5150_/Y _5139_/Y _5173_/B _5144_/Y _5170_/B VPWR VGND sg13cmos5l_a22oi_1
X_4101_ _4102_/C _7523_/Q _7083_/B VPWR VGND sg13cmos5l_xnor2_1
X_5081_ _5082_/B _5068_/B _5293_/B _5083_/S VPWR VGND sg13cmos5l_mux2_1
X_4032_ _4033_/A _7648_/D _7645_/D VPWR VGND sg13cmos5l_nor2_1
XFILLER_49_293 VPWR VGND sg13cmos5l_decap_8
XFILLER_38_956 VPWR VGND sg13cmos5l_decap_8
X_7514__344 _7514_/RESET_B VPWR VGND sg13cmos5l_tiehi
X_5983_ _7298_/D _3877_/Y _6999_/A2 _5982_/Y VPWR VGND sg13cmos5l_a21oi_1
XFILLER_25_639 VPWR VGND sg13cmos5l_fill_2
XFILLER_17_190 VPWR VGND sg13cmos5l_fill_1
X_4934_ _4939_/B input6/X _4936_/B VPWR VGND sg13cmos5l_nand2_1
XFILLER_21_834 VPWR VGND sg13cmos5l_fill_1
X_4865_ _4865_/Y _4871_/C _7644_/Q VPWR VGND sg13cmos5l_nand2_1
X_6604_ _6605_/C _6604_/A _6604_/B VPWR VGND sg13cmos5l_nor2_1
X_7642__642 _7642_/RESET_B VPWR VGND sg13cmos5l_tiehi
X_4796_ _4796_/Y _4692_/Y _4728_/B _4792_/Y _4794_/Y _4795_/Y VPWR VGND sg13cmos5l_a221oi_1
X_7584_ _7584_/Q _7622_/CLK _7584_/D _7584_/RESET_B VPWR VGND sg13cmos5l_dfrbpq_1
X_7508__148 _7508_/D VPWR VGND sg13cmos5l_tielo
X_6535_ _6536_/B _7391_/Q _6541_/B _6519_/Y VPWR VGND sg13cmos5l_a21oi_1
X_6466_ _6517_/A _6352_/Y _6468_/B _6465_/Y VPWR VGND sg13cmos5l_a21oi_1
X_5417_ _5452_/A _7204_/Q _7205_/Q VPWR VGND sg13cmos5l_xnor2_1
X_6397_ _6413_/A _6404_/A _6404_/B VPWR VGND sg13cmos5l_nand2_1
X_5348_ _5348_/X _5348_/A _5391_/B _5391_/C VPWR VGND sg13cmos5l_and3_1
X_5279_ _5279_/Y _5561_/A _7146_/Q VPWR VGND sg13cmos5l_nor2_1
X_7018_ _7018_/Y _7478_/Q _7449_/Q VPWR VGND sg13cmos5l_xnor2_1
X_7339__376 _7339_/RESET_B VPWR VGND sg13cmos5l_tiehi
XFILLER_12_823 VPWR VGND sg13cmos5l_decap_8
XFILLER_8_849 VPWR VGND sg13cmos5l_fill_1
XFILLER_7_348 VPWR VGND sg13cmos5l_decap_4
XFILLER_11_399 VPWR VGND sg13cmos5l_decap_8
X_7346__369 _7346_/RESET_B VPWR VGND sg13cmos5l_tiehi
XFILLER_2_0 VPWR VGND sg13cmos5l_fill_2
XFILLER_3_587 VPWR VGND sg13cmos5l_decap_4
XFILLER_39_709 VPWR VGND sg13cmos5l_fill_2
XFILLER_47_720 VPWR VGND sg13cmos5l_fill_1
XFILLER_16_8 VPWR VGND sg13cmos5l_fill_2
XFILLER_42_491 VPWR VGND sg13cmos5l_fill_1
X_4650_ _4651_/B _4682_/A _4648_/Y _4649_/Y _5098_/A VPWR VGND sg13cmos5l_a22oi_1
X_4581_ _4581_/Y _4473_/Y _4516_/B _4578_/Y _4579_/Y _4580_/Y VPWR VGND sg13cmos5l_a221oi_1
X_6320_ _6322_/B _6323_/A _6323_/C _6231_/Y VPWR VGND sg13cmos5l_a21oi_1
Xhold805 _5574_/B _7191_/Q VPWR VGND sg13cmos5l_dlygate4sd3_1
Xhold816 _5119_/B _7623_/Q VPWR VGND sg13cmos5l_dlygate4sd3_1
Xhold827 hold827/X _7618_/Q VPWR VGND sg13cmos5l_dlygate4sd3_1
Xhold838 _6510_/A _7370_/Q VPWR VGND sg13cmos5l_dlygate4sd3_1
X_6251_ _6251_/X _6244_/Y _6247_/Y _6250_/Y VPWR VGND sg13cmos5l_a21o_1
Xhold849 _7331_/D _6187_/Y VPWR VGND sg13cmos5l_dlygate4sd3_1
X_5202_ _5231_/B _7203_/Q _5203_/B VPWR VGND sg13cmos5l_xnor2_1
X_6182_ _6182_/Y _6137_/Y _6181_/Y _6180_/A VPWR VGND sg13cmos5l_a21oi_1
X_5133_ _5133_/Y _7160_/Q _5151_/B VPWR VGND sg13cmos5l_nor2_1
XFILLER_35_0 VPWR VGND sg13cmos5l_fill_2
X_5064_ _5064_/Y _7144_/Q _5068_/B VPWR VGND sg13cmos5l_nand2_1
X_4015_ _4379_/A _4015_/A VPWR VGND sg13cmos5l_inv_1
XFILLER_37_230 VPWR VGND sg13cmos5l_fill_2
XFILLER_40_406 VPWR VGND sg13cmos5l_decap_4
X_5966_ _5968_/B _7293_/Q _5963_/B _5967_/B _7294_/Q _5964_/Y VPWR VGND sg13cmos5l_a221oi_1
XFILLER_34_970 VPWR VGND sg13cmos5l_fill_1
X_5897_ _7282_/D _5994_/B _5897_/B VPWR VGND sg13cmos5l_nor2_1
X_4917_ _7115_/D _4917_/A _4917_/B VPWR VGND sg13cmos5l_nor2_1
X_7636_ _7636_/Q clkload6/A _7636_/D _7636_/RESET_B VPWR VGND sg13cmos5l_dfrbpq_1
X_4848_ _4850_/B _7629_/Q _4848_/B _4848_/C VPWR VGND sg13cmos5l_nor3_1
X_7567_ _7567_/Q _7571_/CLK _7567_/D _7567_/RESET_B VPWR VGND sg13cmos5l_dfrbpq_1
XFILLER_10_1006 VPWR VGND sg13cmos5l_fill_1
X_4779_ _4779_/Y _3893_/Y _5323_/A2 _4778_/Y VPWR VGND sg13cmos5l_a21oi_1
X_7498_ _7498_/Q _7555_/CLK _7498_/D _7498_/RESET_B VPWR VGND sg13cmos5l_dfrbpq_1
X_6518_ _6518_/Y _6448_/B _6538_/B _6517_/Y VPWR VGND sg13cmos5l_a21oi_1
X_6449_ _6514_/A _6662_/A _6446_/B _6446_/Y _6440_/Y VPWR VGND sg13cmos5l_a22oi_1
XFILLER_44_723 VPWR VGND sg13cmos5l_fill_2
XFILLER_29_786 VPWR VGND sg13cmos5l_fill_2
XFILLER_44_745 VPWR VGND sg13cmos5l_fill_1
XFILLER_43_211 VPWR VGND sg13cmos5l_fill_1
XFILLER_25_981 VPWR VGND sg13cmos5l_fill_1
XFILLER_7_112 VPWR VGND sg13cmos5l_fill_2
XFILLER_11_196 VPWR VGND sg13cmos5l_decap_4
XFILLER_3_395 VPWR VGND sg13cmos5l_fill_1
XFILLER_26_1024 VPWR VGND sg13cmos5l_decap_4
X_5820_ _5820_/Y _5820_/A _5820_/B VPWR VGND sg13cmos5l_nand2_1
X_7190__550 _7190_/RESET_B VPWR VGND sg13cmos5l_tiehi
X_5751_ _5751_/Y _7257_/Q _5749_/Y _5955_/A VPWR VGND sg13cmos5l_o21ai_1
X_4702_ _4702_/Y _7594_/Q _7569_/Q VPWR VGND sg13cmos5l_nand2b_1
X_5682_ _5683_/B _5664_/X _5680_/X _5681_/Y _5677_/C VPWR VGND sg13cmos5l_a22oi_1
X_7481__435 _7481_/RESET_B VPWR VGND sg13cmos5l_tiehi
X_7421_ _7421_/Q clkload8/A _7421_/D _7421_/RESET_B VPWR VGND sg13cmos5l_dfrbpq_1
X_4633_ _7593_/D _4633_/A1 _4630_/X _4632_/Y VPWR VGND sg13cmos5l_a21oi_1
XFILLER_8_72 VPWR VGND sg13cmos5l_decap_8
X_7352_ _7352_/Q _7375_/CLK _7352_/D _7352_/RESET_B VPWR VGND sg13cmos5l_dfrbpq_1
X_4564_ _7582_/D _3894_/Y _5551_/A2 _4563_/Y VPWR VGND sg13cmos5l_a21oi_1
X_7283_ _7283_/Q _7314_/CLK _7283_/D _7283_/RESET_B VPWR VGND sg13cmos5l_dfrbpq_1
X_6303_ _6326_/B _6279_/A _6278_/Y _6303_/S VPWR VGND sg13cmos5l_mux2_1
X_4495_ _4496_/B _4498_/A _4513_/B _4494_/Y VPWR VGND sg13cmos5l_o21ai_1
X_6234_ _6253_/C _7286_/Q _7287_/Q _7284_/Q _7285_/Q VPWR VGND sg13cmos5l_nor4_1
X_6165_ _6165_/Y _6181_/A _6137_/Y _6178_/A _6162_/A VPWR VGND sg13cmos5l_a22oi_1
Xhold1324 _6718_/B1 _7432_/Q VPWR VGND sg13cmos5l_dlygate4sd3_1
X_6096_ _6114_/B _6096_/A _6096_/B VPWR VGND sg13cmos5l_nand2_1
Xhold1302 hold1302/X _7314_/Q VPWR VGND sg13cmos5l_dlygate4sd3_1
X_5116_ _5145_/S _5116_/A _5116_/B VPWR VGND sg13cmos5l_nand2_1
Xhold1313 _6298_/B1 _6218_/A VPWR VGND sg13cmos5l_dlygate4sd3_1
X_5047_ _5047_/Y _7163_/Q _5061_/B _5058_/B _5330_/A VPWR VGND sg13cmos5l_a22oi_1
X_7258__182 _7258_/D VPWR VGND sg13cmos5l_tielo
X_7336__379 _7336_/RESET_B VPWR VGND sg13cmos5l_tiehi
XFILLER_27_59 VPWR VGND sg13cmos5l_fill_1
XFILLER_26_789 VPWR VGND sg13cmos5l_decap_8
X_6998_ _6998_/Y _7448_/Q _6999_/A2 _7111_/B1 VPWR VGND sg13cmos5l_o21ai_1
X_5949_ _5950_/B _5945_/Y _5961_/C _5948_/Y VPWR VGND sg13cmos5l_a21oi_1
X_7619_ _7619_/Q _7622_/CLK _7619_/D _7619_/RESET_B VPWR VGND sg13cmos5l_dfrbpq_1
XFILLER_49_1002 VPWR VGND sg13cmos5l_decap_8
XFILLER_4_159 VPWR VGND sg13cmos5l_fill_2
X_7610__202 _7610_/D VPWR VGND sg13cmos5l_tielo
XFILLER_44_531 VPWR VGND sg13cmos5l_fill_2
XFILLER_44_520 VPWR VGND sg13cmos5l_fill_1
XFILLER_16_211 VPWR VGND sg13cmos5l_fill_1
XFILLER_16_255 VPWR VGND sg13cmos5l_fill_1
XFILLER_17_767 VPWR VGND sg13cmos5l_fill_1
XFILLER_12_450 VPWR VGND sg13cmos5l_fill_2
XFILLER_9_955 VPWR VGND sg13cmos5l_decap_8
X_4280_ _4281_/B _4276_/Y _4278_/Y _4279_/Y VPWR VGND sg13cmos5l_o21ai_1
XFILLER_39_314 VPWR VGND sg13cmos5l_fill_1
X_6921_ _6926_/A _7437_/Q _7436_/Q _7435_/Q VPWR VGND sg13cmos5l_nor3_1
X_6852_ _6868_/A _6867_/B _6867_/C _6867_/A VPWR VGND sg13cmos5l_a21oi_1
X_5803_ _5832_/C _7269_/Q _5823_/B _5824_/A VPWR VGND sg13cmos5l_o21ai_1
Xfanout29 _6500_/A2 _6824_/A2 VPWR VGND sg13cmos5l_buf_1
X_3995_ _5284_/B _7147_/Q VPWR VGND sg13cmos5l_inv_1
XFILLER_22_258 VPWR VGND sg13cmos5l_decap_8
X_6783_ _6783_/Y _7004_/A _4022_/Y _4023_/Y _7457_/Q VPWR VGND sg13cmos5l_a22oi_1
X_5734_ _5734_/Y _7221_/Q _5734_/B VPWR VGND sg13cmos5l_nor2_1
XFILLER_22_269 VPWR VGND sg13cmos5l_fill_2
X_5665_ _5665_/Y _5918_/B _5677_/B VPWR VGND sg13cmos5l_nand2_1
XFILLER_30_280 VPWR VGND sg13cmos5l_decap_8
X_7404_ _7404_/Q _7428_/CLK _7404_/D _7404_/RESET_B VPWR VGND sg13cmos5l_dfrbpq_1
X_4616_ _4617_/B _4616_/A _4616_/B VPWR VGND sg13cmos5l_xnor2_1
X_5596_ _5597_/B _5602_/A _5602_/B _5574_/Y VPWR VGND sg13cmos5l_a21oi_1
X_7335_ _7335_/Q clkload6/A _7335_/D _7335_/RESET_B VPWR VGND sg13cmos5l_dfrbpq_1
X_4547_ _4547_/Y _4753_/B _4542_/X _4546_/Y VPWR VGND sg13cmos5l_o21ai_1
X_4478_ _4490_/B _7535_/Q _7534_/Q _7532_/Q _7533_/Q VPWR VGND sg13cmos5l_nor4_1
X_7266_ _7266_/Q _7272_/CLK _7266_/D _7266_/RESET_B VPWR VGND sg13cmos5l_dfrbpq_1
X_7197_ _7197_/Q _7200_/CLK _7197_/D _7197_/RESET_B VPWR VGND sg13cmos5l_dfrbpq_1
X_6217_ _6218_/A _6217_/A _6217_/B VPWR VGND sg13cmos5l_xnor2_1
X_6148_ _6148_/Y _6148_/A VPWR VGND sg13cmos5l_inv_1
Xhold1110 _7396_/D _6552_/Y VPWR VGND sg13cmos5l_dlygate4sd3_1
Xhold1121 _5312_/B _5311_/X VPWR VGND sg13cmos5l_dlygate4sd3_1
Xhold1132 _3882_/A _7293_/Q VPWR VGND sg13cmos5l_dlygate4sd3_1
Xhold1143 _3884_/A _7291_/Q VPWR VGND sg13cmos5l_dlygate4sd3_1
Xhold1154 _3992_/A _7181_/Q VPWR VGND sg13cmos5l_dlygate4sd3_1
X_6079_ _6081_/C _7340_/Q _6076_/Y _6110_/B VPWR VGND sg13cmos5l_a21o_1
Xhold1176 _5813_/A _7267_/Q VPWR VGND sg13cmos5l_dlygate4sd3_1
Xhold1165 _4074_/C _4072_/A VPWR VGND sg13cmos5l_dlygate4sd3_1
Xhold1198 _5364_/A _7197_/Q VPWR VGND sg13cmos5l_dlygate4sd3_1
Xhold1187 _4190_/A _7516_/Q VPWR VGND sg13cmos5l_dlygate4sd3_1
XFILLER_13_214 VPWR VGND sg13cmos5l_decap_4
XFILLER_41_589 VPWR VGND sg13cmos5l_decap_8
X_7546__752 _7546_/RESET_B VPWR VGND sg13cmos5l_tiehi
XFILLER_49_612 VPWR VGND sg13cmos5l_decap_4
XFILLER_0_162 VPWR VGND sg13cmos5l_decap_8
XFILLER_23_1005 VPWR VGND sg13cmos5l_decap_8
XFILLER_49_656 VPWR VGND sg13cmos5l_decap_8
X_5450_ _5450_/Y _5450_/A _5450_/B VPWR VGND sg13cmos5l_nor2_1
X_4401_ _4401_/Y _4405_/A _4405_/B VPWR VGND sg13cmos5l_nand2_1
X_5381_ _5381_/X _5336_/B _5346_/X _5380_/Y VPWR VGND sg13cmos5l_a21o_1
XFILLER_5_980 VPWR VGND sg13cmos5l_decap_8
X_7120_ _7120_/Q clkload6/A _7120_/D _7120_/RESET_B VPWR VGND sg13cmos5l_dfrbpq_1
X_4332_ _4332_/Y _4316_/B _4336_/S _4357_/B VPWR VGND sg13cmos5l_o21ai_1
X_4263_ _4394_/A _4261_/X _4262_/Y _4263_/S VPWR VGND sg13cmos5l_mux2_1
XFILLER_5_95 VPWR VGND sg13cmos5l_decap_8
X_7051_ _7052_/B _7030_/A _7030_/B _7050_/Y VPWR VGND sg13cmos5l_o21ai_1
X_6002_ _6002_/Y _5998_/Y _6000_/Y _6001_/Y VPWR VGND sg13cmos5l_o21ai_1
X_4194_ _4194_/Y _4194_/A _4194_/B _4194_/C VPWR VGND sg13cmos5l_nor3_1
XFILLER_39_199 VPWR VGND sg13cmos5l_fill_1
XFILLER_36_840 VPWR VGND sg13cmos5l_decap_4
X_6904_ _6910_/B _7465_/Q _6905_/B VPWR VGND sg13cmos5l_nor2b_1
XFILLER_39_1001 VPWR VGND sg13cmos5l_decap_4
X_6835_ _6835_/Y _6835_/A _6873_/B VPWR VGND sg13cmos5l_nor2_1
X_6766_ _6772_/B _6756_/X _6760_/X _6764_/Y VPWR VGND sg13cmos5l_o21ai_1
X_3978_ _6989_/B _3978_/A VPWR VGND sg13cmos5l_inv_1
XFILLER_23_589 VPWR VGND sg13cmos5l_fill_2
X_5717_ _5810_/A _5455_/X _5692_/Y _5719_/S VPWR VGND sg13cmos5l_mux2_1
XFILLER_10_239 VPWR VGND sg13cmos5l_decap_8
X_7229__508 _7229_/RESET_B VPWR VGND sg13cmos5l_tiehi
X_6697_ _6698_/A _6697_/A _6697_/B _6697_/C VPWR VGND sg13cmos5l_or3_1
XFILLER_40_37 VPWR VGND sg13cmos5l_fill_1
X_5648_ _5648_/X _5907_/A _5650_/B _5648_/C VPWR VGND sg13cmos5l_and3_1
XFILLER_3_906 VPWR VGND sg13cmos5l_decap_4
X_5579_ _5579_/Y _7233_/Q _5620_/B VPWR VGND sg13cmos5l_nand2_1
X_7318_ _7318_/Q _7344_/CLK _7318_/D _7318_/RESET_B VPWR VGND sg13cmos5l_dfrbpq_1
X_7249_ _7249_/Q _7307_/CLK _7249_/D _7249_/RESET_B VPWR VGND sg13cmos5l_dfrbpq_1
XFILLER_41_331 VPWR VGND sg13cmos5l_fill_1
XFILLER_42_898 VPWR VGND sg13cmos5l_decap_8
XFILLER_14_82 VPWR VGND sg13cmos5l_decap_8
XFILLER_6_722 VPWR VGND sg13cmos5l_decap_8
XFILLER_5_210 VPWR VGND sg13cmos5l_decap_8
XFILLER_10_784 VPWR VGND sg13cmos5l_fill_2
XFILLER_2_983 VPWR VGND sg13cmos5l_decap_8
XFILLER_1_482 VPWR VGND sg13cmos5l_decap_4
Xinput8 input8/X ui_in[6] VPWR VGND sg13cmos5l_buf_1
XFILLER_49_497 VPWR VGND sg13cmos5l_fill_2
XFILLER_18_862 VPWR VGND sg13cmos5l_decap_4
X_4950_ _4950_/Y _7131_/Q _7130_/Q _7161_/Q VPWR VGND sg13cmos5l_nand3b_1
XFILLER_17_350 VPWR VGND sg13cmos5l_decap_8
X_3901_ _6509_/A _3901_/A VPWR VGND sg13cmos5l_inv_1
X_4881_ _7639_/D _6427_/A _4881_/B VPWR VGND sg13cmos5l_nor2_1
X_7449__712 _7449_/RESET_B VPWR VGND sg13cmos5l_tiehi
XFILLER_32_353 VPWR VGND sg13cmos5l_fill_2
X_6620_ _6620_/Y _7381_/Q _6831_/A _6832_/A _7382_/Q _6619_/Y VPWR VGND sg13cmos5l_a221oi_1
X_6551_ _6551_/Y _6543_/B _6547_/Y _6510_/B VPWR VGND sg13cmos5l_o21ai_1
XFILLER_32_386 VPWR VGND sg13cmos5l_fill_1
X_5502_ _5504_/B _5227_/A _5488_/X _5490_/Y _5501_/Y VPWR VGND sg13cmos5l_a22oi_1
XFILLER_20_559 VPWR VGND sg13cmos5l_fill_1
X_7187__555 _7187_/RESET_B VPWR VGND sg13cmos5l_tiehi
X_6482_ _6486_/B _6478_/Y _6479_/Y _6480_/Y _6481_/Y VPWR VGND sg13cmos5l_a22oi_1
X_5433_ _5433_/Y _5703_/A _5461_/A VPWR VGND sg13cmos5l_nor2_1
X_5364_ _5364_/Y _5364_/A _5387_/B VPWR VGND sg13cmos5l_nor2_1
X_4315_ _4316_/C _7539_/Q _4315_/B VPWR VGND sg13cmos5l_nor2_1
X_7103_ _7506_/D hold969/X _7098_/S _7102_/Y VPWR VGND sg13cmos5l_a21oi_1
X_5295_ _5300_/B _5285_/Y _5293_/Y _5294_/Y _5297_/C VPWR VGND sg13cmos5l_a22oi_1
X_7034_ _7034_/Y _7034_/A _7042_/B VPWR VGND sg13cmos5l_nor2_1
X_4246_ _4266_/B _7531_/Q _4246_/B VPWR VGND sg13cmos5l_xor2_1
X_4177_ _4193_/B _4190_/A _4190_/B VPWR VGND sg13cmos5l_nand2_1
XFILLER_24_821 VPWR VGND sg13cmos5l_fill_2
XFILLER_24_887 VPWR VGND sg13cmos5l_fill_1
X_6818_ _6818_/Y _6804_/Y _6809_/C _6817_/Y VPWR VGND sg13cmos5l_a21oi_1
X_6749_ _6761_/B _6749_/A _6751_/B VPWR VGND sg13cmos5l_xnor2_1
XFILLER_2_213 VPWR VGND sg13cmos5l_fill_2
X_7355__360 _7355_/RESET_B VPWR VGND sg13cmos5l_tiehi
XFILLER_18_147 VPWR VGND sg13cmos5l_fill_1
XFILLER_34_607 VPWR VGND sg13cmos5l_fill_1
XFILLER_46_489 VPWR VGND sg13cmos5l_decap_4
XFILLER_42_662 VPWR VGND sg13cmos5l_decap_4
XFILLER_41_150 VPWR VGND sg13cmos5l_decap_4
XFILLER_10_592 VPWR VGND sg13cmos5l_fill_1
XFILLER_29_1011 VPWR VGND sg13cmos5l_decap_8
XFILLER_37_4 VPWR VGND sg13cmos5l_fill_1
X_4100_ _4102_/B _7495_/Q _7494_/Q _7496_/Q VPWR VGND sg13cmos5l_o21ai_1
X_5080_ _7143_/D _5177_/A _5080_/B VPWR VGND sg13cmos5l_nor2_1
XFILLER_49_250 VPWR VGND sg13cmos5l_fill_2
XFILLER_38_924 VPWR VGND sg13cmos5l_fill_2
X_4031_ _4031_/Y _4031_/A _6107_/A _4031_/C VPWR VGND sg13cmos5l_nor3_1
X_5982_ _5982_/Y hold866/X _6999_/A2 _7000_/A VPWR VGND sg13cmos5l_o21ai_1
X_4933_ _7124_/D _6427_/A _4938_/B VPWR VGND sg13cmos5l_nor2_1
XFILLER_36_1026 VPWR VGND sg13cmos5l_fill_2
XFILLER_36_1004 VPWR VGND sg13cmos5l_fill_2
XFILLER_20_301 VPWR VGND sg13cmos5l_fill_1
X_7652_ _7652_/Q clkload6/A _7652_/D _7652_/RESET_B VPWR VGND sg13cmos5l_dfrbpq_1
X_4864_ _4872_/C _4041_/B _4040_/Y _4863_/Y VPWR VGND sg13cmos5l_o21ai_1
XFILLER_33_684 VPWR VGND sg13cmos5l_fill_1
X_6603_ _6605_/B _6603_/A _6603_/B VPWR VGND sg13cmos5l_nor2_1
X_4795_ _4795_/Y _4795_/A _4725_/B VPWR VGND sg13cmos5l_nor2b_1
X_7583_ _7583_/Q _7617_/CLK _7583_/D _7583_/RESET_B VPWR VGND sg13cmos5l_dfrbpq_1
X_6534_ _6534_/X _6534_/A _6534_/B VPWR VGND sg13cmos5l_and2_1
X_6465_ _6465_/Y _6465_/A _6468_/B VPWR VGND sg13cmos5l_nor2_1
X_5416_ _5456_/A _5426_/B _5415_/Y VPWR VGND sg13cmos5l_nor2b_1
X_6396_ _6396_/X _6396_/A _6396_/B VPWR VGND sg13cmos5l_and2_1
X_5347_ _5347_/Y _5391_/B _5391_/C VPWR VGND sg13cmos5l_nand2_1
XFILLER_43_1019 VPWR VGND sg13cmos5l_fill_1
X_5278_ _7177_/D _5332_/B _5396_/B VPWR VGND sg13cmos5l_and2_1
XFILLER_0_739 VPWR VGND sg13cmos5l_fill_2
X_4229_ _4258_/A _7526_/Q _7527_/Q VPWR VGND sg13cmos5l_xnor2_1
X_7017_ _7017_/Y _7024_/A _7017_/B VPWR VGND sg13cmos5l_nand2_1
XFILLER_44_938 VPWR VGND sg13cmos5l_fill_1
XFILLER_43_415 VPWR VGND sg13cmos5l_decap_8
XFILLER_4_1024 VPWR VGND sg13cmos5l_decap_4
XFILLER_19_401 VPWR VGND sg13cmos5l_decap_8
XFILLER_19_412 VPWR VGND sg13cmos5l_fill_2
XFILLER_47_765 VPWR VGND sg13cmos5l_fill_2
XFILLER_46_286 VPWR VGND sg13cmos5l_fill_1
XFILLER_34_448 VPWR VGND sg13cmos5l_decap_8
XFILLER_34_459 VPWR VGND sg13cmos5l_fill_1
XFILLER_36_80 VPWR VGND sg13cmos5l_decap_4
XFILLER_15_684 VPWR VGND sg13cmos5l_fill_2
X_4580_ _4580_/Y _4580_/A _4580_/B VPWR VGND sg13cmos5l_nor2_1
XFILLER_6_360 VPWR VGND sg13cmos5l_fill_2
Xhold806 _5554_/B _7189_/Q VPWR VGND sg13cmos5l_dlygate4sd3_1
Xhold817 _6844_/B _7420_/Q VPWR VGND sg13cmos5l_dlygate4sd3_1
Xhold828 _4586_/A _7583_/Q VPWR VGND sg13cmos5l_dlygate4sd3_1
X_6250_ _6250_/Y _6249_/A _6249_/B _5887_/A VPWR VGND sg13cmos5l_a21oi_1
Xhold839 _6404_/A _7361_/Q VPWR VGND sg13cmos5l_dlygate4sd3_1
X_5201_ _5208_/A _5201_/A _5201_/B _5201_/C VPWR VGND sg13cmos5l_nor3_1
X_6181_ _6181_/Y _6181_/A _6181_/B VPWR VGND sg13cmos5l_nand2_1
X_5132_ _5137_/A _5136_/B _5136_/C _5136_/A VPWR VGND sg13cmos5l_a21oi_1
X_5063_ _5068_/B _5054_/B _5061_/Y _5062_/Y _5065_/C VPWR VGND sg13cmos5l_a22oi_1
XFILLER_37_220 VPWR VGND sg13cmos5l_fill_1
X_4014_ _4316_/A _4532_/A VPWR VGND sg13cmos5l_inv_1
XFILLER_38_776 VPWR VGND sg13cmos5l_fill_2
X_5965_ _5967_/B _6195_/A _7313_/Q _5955_/A _5761_/B VPWR VGND sg13cmos5l_a22oi_1
X_5896_ _6046_/A _5897_/B VPWR VGND sg13cmos5l_inv_1
X_4916_ _4916_/Y hold888/X _4909_/B _4915_/Y VPWR VGND sg13cmos5l_a21oi_1
X_7635_ _7635_/Q _7635_/CLK _7635_/D _7635_/RESET_B VPWR VGND sg13cmos5l_dfrbpq_1
X_4847_ _4850_/A _4834_/Y _4841_/Y _4849_/A _4849_/B _4842_/Y VPWR VGND sg13cmos5l_a221oi_1
X_7566_ _7566_/Q _7571_/CLK _7566_/D _7566_/RESET_B VPWR VGND sg13cmos5l_dfrbpq_1
X_4778_ _4778_/Y _7620_/Q _5323_/A2 _5087_/A VPWR VGND sg13cmos5l_o21ai_1
X_7497_ _7497_/Q _7555_/CLK _7497_/D _7497_/RESET_B VPWR VGND sg13cmos5l_dfrbpq_1
X_6517_ _6517_/Y _6517_/A _6538_/B VPWR VGND sg13cmos5l_nor2_1
X_7345__370 _7345_/RESET_B VPWR VGND sg13cmos5l_tiehi
X_6448_ _7372_/D _6511_/B _6448_/B VPWR VGND sg13cmos5l_nor2_1
X_6379_ _6379_/Y _7357_/Q _6379_/B _6379_/C VPWR VGND sg13cmos5l_nor3_1
XFILLER_0_547 VPWR VGND sg13cmos5l_fill_2
X_7352__363 _7352_/RESET_B VPWR VGND sg13cmos5l_tiehi
XFILLER_43_223 VPWR VGND sg13cmos5l_decap_4
XFILLER_16_448 VPWR VGND sg13cmos5l_decap_8
XFILLER_17_949 VPWR VGND sg13cmos5l_fill_2
XFILLER_19_1010 VPWR VGND sg13cmos5l_decap_8
XFILLER_19_1021 VPWR VGND sg13cmos5l_decap_8
XFILLER_40_996 VPWR VGND sg13cmos5l_fill_1
XFILLER_12_676 VPWR VGND sg13cmos5l_fill_1
X_7504__311 _7504_/RESET_B VPWR VGND sg13cmos5l_tiehi
XFILLER_4_897 VPWR VGND sg13cmos5l_decap_8
XFILLER_39_507 VPWR VGND sg13cmos5l_fill_2
XFILLER_47_540 VPWR VGND sg13cmos5l_fill_1
XFILLER_34_223 VPWR VGND sg13cmos5l_fill_1
X_5750_ _5750_/Y _7256_/Q _5743_/Y _5749_/Y _7257_/Q VPWR VGND sg13cmos5l_a22oi_1
X_5681_ _5681_/Y _5681_/A _5677_/B VPWR VGND sg13cmos5l_nor2b_1
X_4701_ _4701_/X _4701_/A _4701_/B VPWR VGND sg13cmos5l_xor2_1
X_4632_ _4632_/Y _4585_/X _4630_/X _4575_/B VPWR VGND sg13cmos5l_o21ai_1
X_7420_ _7420_/Q _7510_/CLK _7420_/D _7420_/RESET_B VPWR VGND sg13cmos5l_dfrbpq_1
X_7351_ _7351_/Q _7375_/CLK _7351_/D _7351_/RESET_B VPWR VGND sg13cmos5l_dfrbpq_1
X_4563_ _4563_/Y hold855/X _5551_/A2 _4560_/A VPWR VGND sg13cmos5l_o21ai_1
X_4494_ _4494_/Y _4494_/A _4517_/A VPWR VGND sg13cmos5l_nand2_1
X_7282_ _7282_/Q _7314_/CLK _7282_/D _7282_/RESET_B VPWR VGND sg13cmos5l_dfrbpq_1
X_6302_ _6311_/A _6302_/A _6302_/B VPWR VGND sg13cmos5l_nand2_1
X_6233_ _6249_/A _7286_/Q _7284_/Q _7285_/Q VPWR VGND sg13cmos5l_or3_1
X_6164_ _6164_/Y _6175_/A _6157_/Y _6163_/Y VPWR VGND sg13cmos5l_o21ai_1
Xhold1325 _4097_/A _7497_/Q VPWR VGND sg13cmos5l_dlygate4sd3_1
Xhold1303 _4709_/A _7571_/Q VPWR VGND sg13cmos5l_dlygate4sd3_1
X_6095_ _6096_/B _6095_/A _6160_/B _6095_/C VPWR VGND sg13cmos5l_nand3_1
Xhold1314 _4960_/A _7134_/Q VPWR VGND sg13cmos5l_dlygate4sd3_1
X_5115_ _5116_/B _5108_/Y _5111_/Y _5113_/X VPWR VGND sg13cmos5l_a21o_1
X_5046_ _5046_/Y _7161_/Q _5046_/B _5046_/C VPWR VGND sg13cmos5l_nand3_1
X_6997_ _7479_/D _3863_/Y _6999_/A2 _6996_/Y VPWR VGND sg13cmos5l_a21oi_1
XFILLER_40_226 VPWR VGND sg13cmos5l_fill_2
X_5948_ _5948_/Y _5961_/A _6191_/A _5961_/C VPWR VGND sg13cmos5l_nor3_1
XFILLER_43_48 VPWR VGND sg13cmos5l_fill_2
XFILLER_22_963 VPWR VGND sg13cmos5l_fill_1
X_5879_ _5879_/Y _5879_/A _5879_/B VPWR VGND sg13cmos5l_xnor2_1
X_7618_ _7618_/Q _7622_/CLK _7618_/D _7618_/RESET_B VPWR VGND sg13cmos5l_dfrbpq_1
X_7549_ _7549_/Q _7622_/CLK _7549_/D _7549_/RESET_B VPWR VGND sg13cmos5l_dfrbpq_1
XFILLER_4_127 VPWR VGND sg13cmos5l_fill_1
XFILLER_1_889 VPWR VGND sg13cmos5l_fill_1
XFILLER_0_399 VPWR VGND sg13cmos5l_decap_8
X_7352__171 _7352_/D VPWR VGND sg13cmos5l_tielo
XFILLER_44_576 VPWR VGND sg13cmos5l_decap_8
XFILLER_31_215 VPWR VGND sg13cmos5l_fill_1
XFILLER_12_462 VPWR VGND sg13cmos5l_decap_8
XFILLER_12_473 VPWR VGND sg13cmos5l_fill_2
XFILLER_8_433 VPWR VGND sg13cmos5l_decap_8
X_6920_ _7465_/D _7007_/B _7047_/A VPWR VGND sg13cmos5l_nor2_1
X_7335__380 _7335_/RESET_B VPWR VGND sg13cmos5l_tiehi
X_6851_ _6867_/C _7448_/Q _7420_/Q _7453_/Q VPWR VGND sg13cmos5l_nand3_1
X_5802_ _5824_/A _5802_/A _5809_/C VPWR VGND sg13cmos5l_nand2_1
X_6782_ _7438_/D _6782_/A _6873_/B VPWR VGND sg13cmos5l_nor2_1
X_3994_ _5514_/B _3994_/A VPWR VGND sg13cmos5l_inv_1
XFILLER_22_237 VPWR VGND sg13cmos5l_fill_1
X_5733_ _5733_/Y _5741_/C _5732_/Y _5731_/Y VPWR VGND sg13cmos5l_a21oi_1
X_5664_ _5664_/X _5664_/A _5664_/B VPWR VGND sg13cmos5l_or2_1
X_7403_ _7403_/Q _7428_/CLK _7403_/D _7403_/RESET_B VPWR VGND sg13cmos5l_dfrbpq_1
X_4615_ _4615_/Y _4615_/A _4615_/B _4615_/C VPWR VGND sg13cmos5l_nor3_1
X_5595_ _5595_/Y _5612_/B VPWR VGND sg13cmos5l_inv_1
X_7334_ _7334_/Q clkload7/A _7334_/D _7334_/RESET_B VPWR VGND sg13cmos5l_dfrbpq_1
X_4546_ _4546_/Y _7578_/Q _4545_/Y _4544_/Y VPWR VGND sg13cmos5l_a21oi_1
X_4477_ _4482_/A _7534_/Q _7532_/Q _7533_/Q VPWR VGND sg13cmos5l_nor3_1
X_7342__373 _7342_/RESET_B VPWR VGND sg13cmos5l_tiehi
X_7265_ _7265_/Q _7332_/CLK _7265_/D _7265_/RESET_B VPWR VGND sg13cmos5l_dfrbpq_1
X_7639__648 _7639_/RESET_B VPWR VGND sg13cmos5l_tiehi
X_7196_ _7196_/Q _7610_/CLK _7196_/D _7196_/RESET_B VPWR VGND sg13cmos5l_dfrbpq_1
X_6216_ _6302_/A _6216_/A _6216_/B VPWR VGND sg13cmos5l_xnor2_1
Xhold1100 _4297_/B _4298_/B VPWR VGND sg13cmos5l_dlygate4sd3_1
X_6147_ _6148_/A _6146_/Y _6145_/Y _6159_/B VPWR VGND sg13cmos5l_mux2_1
XFILLER_46_808 VPWR VGND sg13cmos5l_decap_8
Xhold1133 _5976_/B _5975_/X VPWR VGND sg13cmos5l_dlygate4sd3_1
Xhold1122 _3998_/A _7143_/Q VPWR VGND sg13cmos5l_dlygate4sd3_1
Xhold1111 _4020_/A _7440_/Q VPWR VGND sg13cmos5l_dlygate4sd3_1
XFILLER_46_819 VPWR VGND sg13cmos5l_fill_1
Xhold1144 _5972_/B _5971_/X VPWR VGND sg13cmos5l_dlygate4sd3_1
X_6078_ _6110_/B _7315_/Q _7316_/Q VPWR VGND sg13cmos5l_xnor2_1
Xhold1155 _4071_/B2 _7652_/Q VPWR VGND sg13cmos5l_dlygate4sd3_1
Xhold1166 _4925_/B _4080_/B VPWR VGND sg13cmos5l_dlygate4sd3_1
Xhold1188 _4210_/A _4192_/A VPWR VGND sg13cmos5l_dlygate4sd3_1
Xhold1199 _5399_/A _5400_/A VPWR VGND sg13cmos5l_dlygate4sd3_1
X_5029_ _5029_/Y _5035_/A _5029_/B VPWR VGND sg13cmos5l_nor2_1
Xhold1177 _5814_/B _5813_/Y VPWR VGND sg13cmos5l_dlygate4sd3_1
XFILLER_26_543 VPWR VGND sg13cmos5l_fill_2
XFILLER_13_204 VPWR VGND sg13cmos5l_decap_4
XFILLER_10_922 VPWR VGND sg13cmos5l_fill_1
XFILLER_5_425 VPWR VGND sg13cmos5l_decap_4
XFILLER_37_808 VPWR VGND sg13cmos5l_decap_4
XFILLER_0_196 VPWR VGND sg13cmos5l_decap_8
XFILLER_23_1028 VPWR VGND sg13cmos5l_fill_1
XFILLER_49_679 VPWR VGND sg13cmos5l_decap_8
XFILLER_45_830 VPWR VGND sg13cmos5l_fill_1
XFILLER_17_543 VPWR VGND sg13cmos5l_fill_2
X_7389__307 _7389_/RESET_B VPWR VGND sg13cmos5l_tiehi
XFILLER_40_590 VPWR VGND sg13cmos5l_fill_1
XFILLER_8_230 VPWR VGND sg13cmos5l_decap_8
XFILLER_9_753 VPWR VGND sg13cmos5l_fill_1
X_4400_ _4405_/B _4360_/A _4290_/A _4400_/S VPWR VGND sg13cmos5l_mux2_1
X_5380_ _5380_/Y _5391_/B _5391_/C _5336_/A VPWR VGND sg13cmos5l_a21oi_1
X_7209__188 _7209_/D VPWR VGND sg13cmos5l_tielo
X_4331_ _4336_/S _4331_/A _4331_/B VPWR VGND sg13cmos5l_nor2_1
X_4262_ _4262_/Y _4237_/B _4233_/C _4266_/B VPWR VGND sg13cmos5l_a21oi_1
X_7050_ _7050_/Y _7050_/A _7050_/B VPWR VGND sg13cmos5l_xnor2_1
X_6001_ _6001_/Y _5892_/B _5932_/Y _6046_/B _5897_/B VPWR VGND sg13cmos5l_a22oi_1
X_7120__629 _7120_/RESET_B VPWR VGND sg13cmos5l_tiehi
X_4193_ _4194_/C _4193_/A _4193_/B _4193_/C VPWR VGND sg13cmos5l_and3_1
X_6903_ _6903_/Y _4160_/B _6897_/Y _6902_/Y VPWR VGND sg13cmos5l_o21ai_1
XFILLER_39_1013 VPWR VGND sg13cmos5l_fill_1
X_6834_ _7456_/D _6834_/A _6891_/A VPWR VGND sg13cmos5l_and2_1
X_6765_ _6777_/B _6757_/Y _6759_/Y _6773_/B _6767_/A _6761_/Y VPWR VGND sg13cmos5l_a221oi_1
X_3977_ _6968_/B _6969_/B VPWR VGND sg13cmos5l_inv_1
XFILLER_23_568 VPWR VGND sg13cmos5l_decap_8
XFILLER_23_579 VPWR VGND sg13cmos5l_fill_2
X_5716_ _7248_/D _5845_/A _5781_/A VPWR VGND sg13cmos5l_nor2_1
X_6696_ _6697_/C _6696_/A _6696_/B _6696_/C VPWR VGND sg13cmos5l_and3_1
X_5647_ _5647_/Y _5673_/A _5645_/Y _5646_/Y _5672_/A VPWR VGND sg13cmos5l_a22oi_1
X_5578_ _5578_/Y _7234_/Q _5620_/B VPWR VGND sg13cmos5l_nand2_1
X_7317_ _7317_/Q _7344_/CLK _7317_/D _7317_/RESET_B VPWR VGND sg13cmos5l_dfrbpq_1
X_4529_ _4529_/Y _4788_/A _4784_/A VPWR VGND sg13cmos5l_nand2_1
XFILLER_46_1028 VPWR VGND sg13cmos5l_fill_1
X_7248_ _7248_/Q _7307_/CLK _7248_/D _7248_/RESET_B VPWR VGND sg13cmos5l_dfrbpq_1
X_7179_ _7179_/Q _7214_/CLK _7179_/D _7179_/RESET_B VPWR VGND sg13cmos5l_dfrbpq_1
XFILLER_46_605 VPWR VGND sg13cmos5l_decap_8
XFILLER_26_362 VPWR VGND sg13cmos5l_decap_8
XFILLER_14_524 VPWR VGND sg13cmos5l_decap_4
XFILLER_41_376 VPWR VGND sg13cmos5l_fill_1
XFILLER_10_752 VPWR VGND sg13cmos5l_fill_1
XFILLER_5_233 VPWR VGND sg13cmos5l_fill_2
X_7505__280 _7505_/RESET_B VPWR VGND sg13cmos5l_tiehi
XFILLER_2_962 VPWR VGND sg13cmos5l_decap_8
XFILLER_49_410 VPWR VGND sg13cmos5l_fill_2
XFILLER_49_465 VPWR VGND sg13cmos5l_decap_8
XFILLER_49_443 VPWR VGND sg13cmos5l_decap_8
XFILLER_49_487 VPWR VGND sg13cmos5l_decap_4
Xinput9 input9/X ui_in[7] VPWR VGND sg13cmos5l_buf_1
XFILLER_18_874 VPWR VGND sg13cmos5l_decap_8
X_3900_ _6465_/A _6459_/B VPWR VGND sg13cmos5l_inv_1
XFILLER_17_395 VPWR VGND sg13cmos5l_fill_2
X_4880_ _4881_/B _4880_/A _4880_/B VPWR VGND sg13cmos5l_nor2_1
XFILLER_32_321 VPWR VGND sg13cmos5l_fill_1
X_6550_ _7395_/D _6550_/A hold1116/X VPWR VGND sg13cmos5l_nor2b_1
X_5501_ _5501_/Y _5501_/A _5501_/B VPWR VGND sg13cmos5l_nor2_1
XFILLER_9_561 VPWR VGND sg13cmos5l_fill_1
X_6481_ _6481_/Y _7357_/Q _6481_/B VPWR VGND sg13cmos5l_nor2_1
X_5432_ _5432_/Y _5702_/A VPWR VGND sg13cmos5l_inv_1
X_5363_ _5368_/A _5367_/B _5367_/C _5367_/A VPWR VGND sg13cmos5l_a21oi_1
X_4314_ _4315_/B _4312_/Y _4313_/Y _4324_/S VPWR VGND sg13cmos5l_mux2_1
X_7102_ _7102_/Y _7094_/B _7098_/S _4083_/Y VPWR VGND sg13cmos5l_o21ai_1
X_5294_ _5294_/Y _7203_/Q _5559_/A VPWR VGND sg13cmos5l_nor2_1
X_4245_ _4258_/B _7531_/Q _4246_/B VPWR VGND sg13cmos5l_xnor2_1
X_7033_ _7060_/A _7041_/B _7033_/B VPWR VGND sg13cmos5l_nor2_1
X_4176_ _4193_/A _4176_/A _4190_/B VPWR VGND sg13cmos5l_xnor2_1
X_7235__502 _7235_/RESET_B VPWR VGND sg13cmos5l_tiehi
XFILLER_24_855 VPWR VGND sg13cmos5l_fill_1
X_7413__160 _7413_/D VPWR VGND sg13cmos5l_tielo
X_6817_ _6817_/Y _6809_/C _6816_/Y _6711_/Y VPWR VGND sg13cmos5l_o21ai_1
X_6748_ _6748_/X _7407_/Q _6751_/B VPWR VGND sg13cmos5l_xor2_1
X_6679_ _6679_/X _6699_/A _6699_/B VPWR VGND sg13cmos5l_or2_1
XFILLER_3_704 VPWR VGND sg13cmos5l_decap_4
XFILLER_2_225 VPWR VGND sg13cmos5l_decap_4
XFILLER_15_855 VPWR VGND sg13cmos5l_decap_8
XFILLER_42_674 VPWR VGND sg13cmos5l_fill_2
XFILLER_42_641 VPWR VGND sg13cmos5l_decap_8
XFILLER_41_195 VPWR VGND sg13cmos5l_decap_4
X_4030_ _4030_/Y _4031_/A _4031_/C VPWR VGND sg13cmos5l_nor2_1
XFILLER_37_402 VPWR VGND sg13cmos5l_fill_2
X_7119__631 _7119_/RESET_B VPWR VGND sg13cmos5l_tiehi
XFILLER_37_468 VPWR VGND sg13cmos5l_fill_1
X_5981_ _7297_/D _3878_/Y _6994_/A2 _5980_/Y VPWR VGND sg13cmos5l_a21oi_1
XFILLER_18_693 VPWR VGND sg13cmos5l_fill_2
X_4932_ _4938_/B input5/X _4936_/B VPWR VGND sg13cmos5l_nand2_1
X_7651_ _7651_/Q _7651_/CLK _7651_/D _7651_/RESET_B VPWR VGND sg13cmos5l_dfrbpq_1
XFILLER_33_652 VPWR VGND sg13cmos5l_fill_1
X_6602_ _6603_/B _7379_/Q _6602_/B VPWR VGND sg13cmos5l_xor2_1
X_4863_ _4863_/Y _4863_/A _4863_/B VPWR VGND sg13cmos5l_nor2_1
X_4794_ _4794_/Y _4791_/Y _4793_/Y _4790_/Y VPWR VGND sg13cmos5l_o21ai_1
X_7582_ _7582_/Q _7622_/CLK _7582_/D _7582_/RESET_B VPWR VGND sg13cmos5l_dfrbpq_1
X_6533_ _6533_/Y _6533_/A VPWR VGND sg13cmos5l_inv_1
X_6464_ _6468_/B _6461_/Y _6462_/Y _6463_/Y VPWR VGND sg13cmos5l_o21ai_1
X_5415_ _5415_/Y _7204_/Q _7205_/Q _7206_/Q VPWR VGND sg13cmos5l_o21ai_1
X_6395_ _7364_/D _6506_/A _6404_/B VPWR VGND sg13cmos5l_and2_1
X_5346_ _5346_/X _5391_/B _5391_/C VPWR VGND sg13cmos5l_and2_1
X_5277_ _5396_/B _5257_/B _5274_/B _4993_/Y VPWR VGND sg13cmos5l_o21ai_1
X_4228_ _4228_/X _4237_/B _4233_/C _4261_/B VPWR VGND sg13cmos5l_a21o_1
X_7016_ _7039_/B _7016_/A VPWR VGND sg13cmos5l_inv_1
X_4159_ _4159_/X _4160_/A _4160_/B VPWR VGND sg13cmos5l_and2_1
XFILLER_24_641 VPWR VGND sg13cmos5l_fill_2
XFILLER_11_324 VPWR VGND sg13cmos5l_decap_4
XFILLER_12_858 VPWR VGND sg13cmos5l_decap_8
XFILLER_2_2 VPWR VGND sg13cmos5l_fill_1
XFILLER_4_1003 VPWR VGND sg13cmos5l_decap_8
X_7318__407 _7318_/RESET_B VPWR VGND sg13cmos5l_tiehi
X_7177__566 _7177_/RESET_B VPWR VGND sg13cmos5l_tiehi
XFILLER_47_777 VPWR VGND sg13cmos5l_decap_8
XFILLER_34_427 VPWR VGND sg13cmos5l_fill_2
Xclkbuf_leaf_26_clk _7200_/CLK clkload3/A VPWR VGND sg13cmos5l_buf_8
XFILLER_42_482 VPWR VGND sg13cmos5l_fill_1
X_7509__437 _7509_/RESET_B VPWR VGND sg13cmos5l_tiehi
X_7184__559 _7184_/RESET_B VPWR VGND sg13cmos5l_tiehi
Xhold807 _5986_/B _7263_/Q VPWR VGND sg13cmos5l_dlygate4sd3_1
Xhold818 _6411_/A _7128_/Q VPWR VGND sg13cmos5l_dlygate4sd3_1
Xhold829 _7620_/D _4779_/Y VPWR VGND sg13cmos5l_dlygate4sd3_1
X_5200_ _5201_/C _5200_/A _5483_/A VPWR VGND sg13cmos5l_nor2_1
X_6180_ _7326_/D _6180_/A _6180_/B VPWR VGND sg13cmos5l_nor2_1
X_5131_ _5136_/C _7158_/Q _5146_/B _5152_/A VPWR VGND sg13cmos5l_o21ai_1
X_5062_ _5062_/Y _7166_/Q _5331_/A VPWR VGND sg13cmos5l_nor2_1
X_7438__255 _7438_/RESET_B VPWR VGND sg13cmos5l_tiehi
X_4013_ _4013_/Y _4013_/A VPWR VGND sg13cmos5l_inv_1
XFILLER_37_232 VPWR VGND sg13cmos5l_fill_1
XFILLER_26_939 VPWR VGND sg13cmos5l_fill_1
XFILLER_16_18 VPWR VGND sg13cmos5l_decap_4
X_7232__505 _7232_/RESET_B VPWR VGND sg13cmos5l_tiehi
Xclkbuf_leaf_17_clk _7571_/CLK clkload5/A VPWR VGND sg13cmos5l_buf_8
X_5964_ _5964_/Y _6143_/B _5958_/A _5959_/Y _5954_/Y _5963_/Y VPWR VGND sg13cmos5l_a221oi_1
X_5895_ _5897_/B _5961_/A _5877_/B _5872_/Y _5879_/Y _5894_/A VPWR VGND sg13cmos5l_a221oi_1
X_4915_ _4915_/Y hold888/X _4906_/Y _4911_/A VPWR VGND sg13cmos5l_o21ai_1
X_7634_ _7634_/Q _7634_/CLK _7634_/D _7634_/RESET_B VPWR VGND sg13cmos5l_dfrbpq_1
X_4846_ _4846_/Y _4846_/A VPWR VGND sg13cmos5l_inv_1
X_7565_ _7565_/Q _7571_/CLK _7565_/D _7565_/RESET_B VPWR VGND sg13cmos5l_dfrbpq_1
X_7445__248 _7445_/RESET_B VPWR VGND sg13cmos5l_tiehi
X_6516_ _6538_/B _6534_/A _6512_/B _6515_/Y VPWR VGND sg13cmos5l_o21ai_1
X_4777_ _4777_/Y _3894_/Y _5323_/A2 _4776_/Y VPWR VGND sg13cmos5l_a21oi_1
X_7496_ _7496_/Q _7555_/CLK _7496_/D _7496_/RESET_B VPWR VGND sg13cmos5l_dfrbpq_1
X_6447_ _6448_/B _6661_/A _6446_/B _6446_/Y _3899_/Y VPWR VGND sg13cmos5l_a22oi_1
X_6378_ _6379_/C _7356_/Q _6378_/B VPWR VGND sg13cmos5l_nor2_1
X_5329_ _7192_/D _5329_/A _5332_/B VPWR VGND sg13cmos5l_and2_1
XFILLER_29_788 VPWR VGND sg13cmos5l_fill_1
XFILLER_43_202 VPWR VGND sg13cmos5l_fill_2
XFILLER_16_416 VPWR VGND sg13cmos5l_fill_1
XFILLER_25_950 VPWR VGND sg13cmos5l_fill_1
XFILLER_40_953 VPWR VGND sg13cmos5l_decap_8
XFILLER_4_810 VPWR VGND sg13cmos5l_fill_2
XFILLER_35_714 VPWR VGND sg13cmos5l_fill_2
XFILLER_19_298 VPWR VGND sg13cmos5l_decap_8
X_5680_ _5680_/X _5684_/A _5912_/A VPWR VGND sg13cmos5l_and2_1
X_4700_ _4700_/Y _7570_/Q _4701_/B VPWR VGND sg13cmos5l_xnor2_1
X_4631_ _4631_/Y _4631_/A _4631_/B VPWR VGND sg13cmos5l_nand2_1
X_7350_ _7350_/Q _7375_/CLK _7350_/D _7350_/RESET_B VPWR VGND sg13cmos5l_dfrbpq_1
X_4562_ _4562_/Y _3895_/Y _5984_/A2 _4561_/Y VPWR VGND sg13cmos5l_a21oi_1
X_4493_ _4513_/B _7537_/Q _4493_/B VPWR VGND sg13cmos5l_xnor2_1
X_7281_ _7281_/Q _7314_/CLK _7281_/D _7281_/RESET_B VPWR VGND sg13cmos5l_dfrbpq_1
X_6301_ _6301_/Y _6231_/Y _6321_/B _6298_/Y _6323_/B VPWR VGND sg13cmos5l_a22oi_1
X_6232_ _6247_/A _7284_/Q _7285_/Q VPWR VGND sg13cmos5l_or2_1
Xclkbuf_leaf_6_clk _7651_/CLK clkload1/A VPWR VGND sg13cmos5l_buf_8
X_6163_ _6163_/Y _6154_/Y _6158_/Y _6162_/Y VPWR VGND sg13cmos5l_a21oi_1
X_6094_ _6096_/A _6095_/A _6095_/C _6160_/B VPWR VGND sg13cmos5l_a21o_1
Xhold1304 _5491_/A _7173_/Q VPWR VGND sg13cmos5l_dlygate4sd3_1
X_5114_ _5155_/C _5108_/Y _5111_/Y _5113_/X VPWR VGND sg13cmos5l_a21oi_1
Xhold1315 _4806_/A _7629_/Q VPWR VGND sg13cmos5l_dlygate4sd3_1
X_5045_ _5046_/C _5330_/A _7612_/Q VPWR VGND sg13cmos5l_nand2b_1
Xhold1326 _5011_/A _7609_/Q VPWR VGND sg13cmos5l_dlygate4sd3_1
X_6996_ _6996_/Y hold859/X _6999_/A2 _5987_/A VPWR VGND sg13cmos5l_o21ai_1
X_5947_ _5961_/C _5955_/C _5947_/B VPWR VGND sg13cmos5l_and2_1
X_5878_ _5878_/Y _6240_/A _5872_/A _5887_/B VPWR VGND sg13cmos5l_o21ai_1
X_7617_ _7617_/Q _7617_/CLK _7617_/D _7617_/RESET_B VPWR VGND sg13cmos5l_dfrbpq_1
X_4829_ _4829_/Y _4829_/A _4829_/B VPWR VGND sg13cmos5l_nor2_1
XFILLER_4_106 VPWR VGND sg13cmos5l_fill_1
X_7308__417 _7308_/RESET_B VPWR VGND sg13cmos5l_tiehi
X_7548_ _7548_/Q _7622_/CLK _7548_/D _7548_/RESET_B VPWR VGND sg13cmos5l_dfrbpq_1
X_7167__576 _7167_/RESET_B VPWR VGND sg13cmos5l_tiehi
X_7479_ _7479_/Q _7510_/CLK _7479_/D _7479_/RESET_B VPWR VGND sg13cmos5l_dfrbpq_1
XFILLER_1_824 VPWR VGND sg13cmos5l_decap_8
XFILLER_49_839 VPWR VGND sg13cmos5l_decap_8
X_7174__569 _7174_/RESET_B VPWR VGND sg13cmos5l_tiehi
XFILLER_1_1017 VPWR VGND sg13cmos5l_decap_8
XFILLER_1_1028 VPWR VGND sg13cmos5l_fill_1
XFILLER_44_544 VPWR VGND sg13cmos5l_fill_2
XFILLER_17_72 VPWR VGND sg13cmos5l_decap_8
XFILLER_13_942 VPWR VGND sg13cmos5l_decap_8
XFILLER_13_953 VPWR VGND sg13cmos5l_fill_1
XFILLER_40_750 VPWR VGND sg13cmos5l_decap_4
X_7428__265 _7428_/RESET_B VPWR VGND sg13cmos5l_tiehi
XFILLER_4_673 VPWR VGND sg13cmos5l_decap_4
XFILLER_3_183 VPWR VGND sg13cmos5l_decap_8
XFILLER_39_305 VPWR VGND sg13cmos5l_decap_4
XFILLER_12_4 VPWR VGND sg13cmos5l_fill_2
X_7435__258 _7435_/RESET_B VPWR VGND sg13cmos5l_tiehi
XFILLER_35_500 VPWR VGND sg13cmos5l_fill_1
X_6850_ _6867_/B _6863_/A _6875_/B VPWR VGND sg13cmos5l_nand2_1
XFILLER_35_566 VPWR VGND sg13cmos5l_fill_2
X_6781_ _6873_/B _6761_/B _6763_/Y _6575_/X VPWR VGND sg13cmos5l_a21oi_1
X_5801_ _5809_/C _5819_/C _5808_/C _5808_/A VPWR VGND sg13cmos5l_a21o_1
XFILLER_23_717 VPWR VGND sg13cmos5l_fill_2
X_3993_ _5518_/B _3993_/A VPWR VGND sg13cmos5l_inv_1
X_5732_ _5732_/Y _7277_/Q _5672_/A VPWR VGND sg13cmos5l_nor2b_1
XFILLER_22_249 VPWR VGND sg13cmos5l_decap_4
X_5663_ _5664_/B _5918_/B _5677_/B _5662_/Y VPWR VGND sg13cmos5l_o21ai_1
X_7402_ _7402_/Q _7428_/CLK _7402_/D _7402_/RESET_B VPWR VGND sg13cmos5l_dfrbpq_1
X_4614_ _4615_/C _4613_/A _4613_/B _4612_/Y _4585_/X VPWR VGND sg13cmos5l_a22oi_1
X_5594_ _5612_/B _5567_/B _5458_/B _5610_/S VPWR VGND sg13cmos5l_mux2_1
X_7333_ _7333_/Q clkload7/A _7333_/D _7333_/RESET_B VPWR VGND sg13cmos5l_dfrbpq_1
X_4545_ _4545_/Y _4788_/A _3957_/A _4527_/A _4340_/B VPWR VGND sg13cmos5l_a22oi_1
X_4476_ _7566_/D _4516_/A _4623_/A VPWR VGND sg13cmos5l_nor2_1
X_7264_ _7264_/Q _7510_/CLK _7264_/D _7264_/RESET_B VPWR VGND sg13cmos5l_dfrbpq_1
X_7195_ _7195_/Q _7635_/CLK _7195_/D _7195_/RESET_B VPWR VGND sg13cmos5l_dfrbpq_1
X_6215_ _6216_/B _6215_/A _6215_/B VPWR VGND sg13cmos5l_xnor2_1
X_6146_ _6146_/Y _7295_/Q _6146_/B VPWR VGND sg13cmos5l_nor2_1
Xhold1101 _4299_/B _4297_/Y VPWR VGND sg13cmos5l_dlygate4sd3_1
Xhold1112 _3937_/A _7240_/Q VPWR VGND sg13cmos5l_dlygate4sd3_1
Xhold1123 _5080_/B _5079_/X VPWR VGND sg13cmos5l_dlygate4sd3_1
Xhold1145 _4704_/A _7568_/Q VPWR VGND sg13cmos5l_dlygate4sd3_1
X_6077_ _6081_/B _6076_/Y _6145_/A VPWR VGND sg13cmos5l_nand2b_1
Xhold1134 _4002_/A _7613_/Q VPWR VGND sg13cmos5l_dlygate4sd3_1
Xhold1156 _4074_/D _4072_/B VPWR VGND sg13cmos5l_dlygate4sd3_1
Xhold1167 _6863_/A _7452_/Q VPWR VGND sg13cmos5l_dlygate4sd3_1
Xhold1189 _7521_/D _4212_/Y VPWR VGND sg13cmos5l_dlygate4sd3_1
XFILLER_38_371 VPWR VGND sg13cmos5l_decap_4
X_5028_ _5029_/B _5028_/A _5028_/B VPWR VGND sg13cmos5l_nand2_1
Xhold1178 _5839_/A _5820_/A VPWR VGND sg13cmos5l_dlygate4sd3_1
XFILLER_41_558 VPWR VGND sg13cmos5l_fill_2
X_6979_ _6981_/B _7474_/Q _6979_/B VPWR VGND sg13cmos5l_nor2_1
XFILLER_10_901 VPWR VGND sg13cmos5l_fill_1
Xhold990 _4558_/B _7578_/Q VPWR VGND sg13cmos5l_dlygate4sd3_1
XFILLER_1_665 VPWR VGND sg13cmos5l_fill_2
XFILLER_48_168 VPWR VGND sg13cmos5l_decap_8
XFILLER_28_60 VPWR VGND sg13cmos5l_decap_4
XFILLER_45_864 VPWR VGND sg13cmos5l_decap_8
XFILLER_17_533 VPWR VGND sg13cmos5l_fill_1
X_4330_ _4331_/B _7542_/Q _4327_/Y _4527_/A VPWR VGND sg13cmos5l_o21ai_1
X_4261_ _4261_/X _4261_/A _4261_/B VPWR VGND sg13cmos5l_and2_1
X_7597__696 _7597_/RESET_B VPWR VGND sg13cmos5l_tiehi
X_6000_ _6000_/Y _5892_/B _5932_/Y _5999_/Y VPWR VGND sg13cmos5l_o21ai_1
X_4192_ _4192_/Y _4192_/A _4170_/X VPWR VGND sg13cmos5l_nor2b_1
XFILLER_27_308 VPWR VGND sg13cmos5l_decap_4
XFILLER_28_809 VPWR VGND sg13cmos5l_decap_8
X_6902_ _6902_/Y _6898_/Y _6900_/Y _6901_/Y _7490_/Q VPWR VGND sg13cmos5l_a22oi_1
X_7157__586 _7157_/RESET_B VPWR VGND sg13cmos5l_tiehi
X_6833_ _7455_/D _6833_/A _6891_/A VPWR VGND sg13cmos5l_and2_1
X_6764_ _6764_/Y _6575_/A _6748_/X _6773_/B _6767_/A VPWR VGND sg13cmos5l_a22oi_1
X_3976_ _6969_/A _7476_/Q VPWR VGND sg13cmos5l_inv_1
X_6695_ _6695_/Y _6699_/A _6616_/Y _6589_/Y VPWR VGND sg13cmos5l_a21oi_1
X_5715_ _5781_/A _5696_/Y _5719_/S _5714_/Y VPWR VGND sg13cmos5l_a21oi_1
X_5646_ _5646_/Y _7242_/Q _7241_/Q _7272_/Q VPWR VGND sg13cmos5l_nand3b_1
X_5577_ _5577_/Y _5575_/Y _5576_/Y _5574_/Y VPWR VGND sg13cmos5l_a21oi_1
X_7164__579 _7164_/RESET_B VPWR VGND sg13cmos5l_tiehi
X_7316_ _7316_/Q _7344_/CLK _7316_/D _7316_/RESET_B VPWR VGND sg13cmos5l_dfrbpq_1
X_4528_ _4540_/C _7598_/Q _4527_/A _4532_/B VPWR VGND sg13cmos5l_o21ai_1
XFILLER_46_1007 VPWR VGND sg13cmos5l_decap_8
X_4459_ _7562_/D _4519_/A _4578_/A VPWR VGND sg13cmos5l_nor2_1
X_7247_ _7247_/Q _7307_/CLK _7247_/D _7247_/RESET_B VPWR VGND sg13cmos5l_dfrbpq_1
XFILLER_49_48 VPWR VGND sg13cmos5l_decap_8
X_7178_ _7178_/Q _7214_/CLK _7178_/D _7178_/RESET_B VPWR VGND sg13cmos5l_dfrbpq_1
X_6129_ _7320_/D _6331_/A _6299_/A VPWR VGND sg13cmos5l_nor2_1
X_7418__275 _7418_/RESET_B VPWR VGND sg13cmos5l_tiehi
XFILLER_27_886 VPWR VGND sg13cmos5l_decap_8
XFILLER_42_845 VPWR VGND sg13cmos5l_fill_2
XFILLER_41_344 VPWR VGND sg13cmos5l_decap_4
X_7425__268 _7425_/RESET_B VPWR VGND sg13cmos5l_tiehi
XFILLER_5_245 VPWR VGND sg13cmos5l_decap_4
XFILLER_2_941 VPWR VGND sg13cmos5l_decap_8
X_7395__301 _7395_/RESET_B VPWR VGND sg13cmos5l_tiehi
XFILLER_49_422 VPWR VGND sg13cmos5l_decap_8
XFILLER_7_1023 VPWR VGND sg13cmos5l_decap_4
X_7332__384 _7332_/RESET_B VPWR VGND sg13cmos5l_tiehi
X_5500_ _7212_/D _5560_/B _5567_/B VPWR VGND sg13cmos5l_nor2_1
XFILLER_13_591 VPWR VGND sg13cmos5l_fill_1
X_6480_ _6480_/Y _6664_/A _7357_/Q _6478_/Y VPWR VGND sg13cmos5l_o21ai_1
X_5431_ _5702_/A _5777_/A _5431_/B VPWR VGND sg13cmos5l_xnor2_1
X_5362_ _5367_/C _7195_/Q _5382_/B _5388_/A VPWR VGND sg13cmos5l_o21ai_1
X_7101_ _7505_/D hold952/X _7098_/S _7100_/Y VPWR VGND sg13cmos5l_a21oi_1
X_4313_ _4313_/Y _4575_/A _4571_/A VPWR VGND sg13cmos5l_nand2b_1
X_5293_ _5293_/Y _7147_/Q _5293_/B VPWR VGND sg13cmos5l_nor2_1
X_7032_ _7032_/Y _7032_/A _7032_/B VPWR VGND sg13cmos5l_xnor2_1
X_4244_ _4249_/A _4265_/B _4238_/Y _4269_/B _4247_/B _4239_/Y VPWR VGND sg13cmos5l_a221oi_1
X_4175_ _4184_/A _4207_/A _4190_/B VPWR VGND sg13cmos5l_nor2_1
XFILLER_24_823 VPWR VGND sg13cmos5l_fill_1
XFILLER_23_366 VPWR VGND sg13cmos5l_fill_1
X_6816_ _6816_/Y _6816_/A _6816_/B VPWR VGND sg13cmos5l_nor2_1
X_6747_ _6762_/B _7406_/Q _7407_/Q _7405_/Q _7404_/Q VPWR VGND sg13cmos5l_nor4_1
XFILLER_11_517 VPWR VGND sg13cmos5l_decap_8
X_3959_ _4785_/A _3959_/A VPWR VGND sg13cmos5l_inv_1
X_6678_ _6699_/B _6697_/A _6678_/B VPWR VGND sg13cmos5l_and2_1
XFILLER_13_1028 VPWR VGND sg13cmos5l_fill_1
X_5629_ _5630_/B _5595_/Y _5622_/Y _5558_/B VPWR VGND sg13cmos5l_o21ai_1
XFILLER_3_716 VPWR VGND sg13cmos5l_decap_8
XFILLER_3_749 VPWR VGND sg13cmos5l_fill_2
XFILLER_47_904 VPWR VGND sg13cmos5l_fill_2
XFILLER_15_812 VPWR VGND sg13cmos5l_fill_2
XFILLER_41_141 VPWR VGND sg13cmos5l_fill_1
XFILLER_41_130 VPWR VGND sg13cmos5l_fill_1
XFILLER_25_50 VPWR VGND sg13cmos5l_fill_2
XFILLER_14_377 VPWR VGND sg13cmos5l_fill_2
XFILLER_44_7 VPWR VGND sg13cmos5l_fill_2
X_7594__699 _7594_/RESET_B VPWR VGND sg13cmos5l_tiehi
X_7141__195 _7141_/D VPWR VGND sg13cmos5l_tielo
XFILLER_49_263 VPWR VGND sg13cmos5l_decap_8
XFILLER_38_926 VPWR VGND sg13cmos5l_fill_1
X_7293__438 _7293_/RESET_B VPWR VGND sg13cmos5l_tiehi
XFILLER_37_436 VPWR VGND sg13cmos5l_fill_1
XFILLER_18_661 VPWR VGND sg13cmos5l_fill_1
X_5980_ _5980_/Y hold874/X _6999_/A2 _5987_/A VPWR VGND sg13cmos5l_o21ai_1
X_4931_ _7123_/D _3983_/Y _6500_/A2 _4930_/Y VPWR VGND sg13cmos5l_a21oi_1
XFILLER_36_1006 VPWR VGND sg13cmos5l_fill_1
X_7154__589 _7154_/RESET_B VPWR VGND sg13cmos5l_tiehi
X_4862_ _4863_/B _7646_/Q _7644_/Q _4862_/C VPWR VGND sg13cmos5l_nor3_1
X_7650_ _7650_/Q _7651_/CLK _7650_/D _7650_/RESET_B VPWR VGND sg13cmos5l_dfrbpq_1
X_6601_ _6605_/A _6662_/A _7377_/Q _6604_/A _6604_/B _6598_/Y VPWR VGND sg13cmos5l_a221oi_1
XFILLER_36_1028 VPWR VGND sg13cmos5l_fill_1
XFILLER_20_347 VPWR VGND sg13cmos5l_fill_2
X_4793_ _4793_/Y _4793_/A _4684_/B VPWR VGND sg13cmos5l_nor2b_1
X_7581_ _7581_/Q _7622_/CLK _7581_/D _7581_/RESET_B VPWR VGND sg13cmos5l_dfrbpq_1
XFILLER_32_185 VPWR VGND sg13cmos5l_decap_8
XFILLER_9_370 VPWR VGND sg13cmos5l_decap_8
X_6532_ _6532_/Y _6545_/A _6537_/A _6532_/C VPWR VGND sg13cmos5l_nor3_1
X_6463_ _6463_/Y _6463_/A _6463_/B VPWR VGND sg13cmos5l_xnor2_1
X_5414_ _5426_/B _7206_/Q _7204_/Q _7205_/Q VPWR VGND sg13cmos5l_nor3_1
X_6394_ _7363_/D _6506_/A _6394_/B VPWR VGND sg13cmos5l_and2_1
X_5345_ _5391_/C _5339_/Y _5342_/Y _5344_/X VPWR VGND sg13cmos5l_a21o_1
X_5276_ _7176_/D _5334_/B _5391_/A VPWR VGND sg13cmos5l_nor2_1
X_4227_ _4233_/C _7526_/Q _7527_/Q _7528_/Q VPWR VGND sg13cmos5l_o21ai_1
X_7015_ _7016_/A _6946_/B _7009_/B _7042_/B VPWR VGND sg13cmos5l_mux2_1
XFILLER_28_403 VPWR VGND sg13cmos5l_decap_4
X_4158_ _4158_/Y _4158_/A _4158_/B _7071_/B VPWR VGND sg13cmos5l_nor3_1
XFILLER_28_436 VPWR VGND sg13cmos5l_fill_2
X_4089_ _7520_/D _6971_/A _7071_/A VPWR VGND sg13cmos5l_nor2_1
XFILLER_43_428 VPWR VGND sg13cmos5l_decap_4
XFILLER_24_620 VPWR VGND sg13cmos5l_fill_2
XFILLER_11_336 VPWR VGND sg13cmos5l_fill_2
XFILLER_23_196 VPWR VGND sg13cmos5l_decap_8
XFILLER_11_369 VPWR VGND sg13cmos5l_decap_4
X_7392__304 _7392_/RESET_B VPWR VGND sg13cmos5l_tiehi
XFILLER_47_734 VPWR VGND sg13cmos5l_fill_1
XFILLER_35_907 VPWR VGND sg13cmos5l_fill_1
XFILLER_43_940 VPWR VGND sg13cmos5l_decap_4
XFILLER_14_152 VPWR VGND sg13cmos5l_decap_8
X_7466__154 _7466_/D VPWR VGND sg13cmos5l_tielo
XFILLER_7_852 VPWR VGND sg13cmos5l_fill_2
XFILLER_7_841 VPWR VGND sg13cmos5l_fill_2
X_7225__513 _7225_/RESET_B VPWR VGND sg13cmos5l_tiehi
Xhold808 _3864_/A _7510_/Q VPWR VGND sg13cmos5l_dlygate4sd3_1
Xhold819 _7366_/D _6361_/X VPWR VGND sg13cmos5l_dlygate4sd3_1
XFILLER_42_4 VPWR VGND sg13cmos5l_fill_2
X_5130_ _5152_/A _7157_/Q _5146_/B _5139_/A VPWR VGND sg13cmos5l_a21o_1
X_5061_ _5061_/Y _7616_/Q _5061_/B VPWR VGND sg13cmos5l_nor2_1
X_4012_ _4536_/B _4012_/A VPWR VGND sg13cmos5l_inv_1
X_5963_ _5963_/Y _7293_/Q _5963_/B VPWR VGND sg13cmos5l_nor2_1
XFILLER_18_480 VPWR VGND sg13cmos5l_fill_2
XFILLER_25_417 VPWR VGND sg13cmos5l_fill_2
X_4914_ _4914_/Y _4912_/Y hold889/X _4917_/A VPWR VGND sg13cmos5l_a21oi_1
XFILLER_34_940 VPWR VGND sg13cmos5l_fill_2
X_5894_ _5894_/Y _5894_/A VPWR VGND sg13cmos5l_inv_1
XFILLER_20_111 VPWR VGND sg13cmos5l_decap_8
XFILLER_21_656 VPWR VGND sg13cmos5l_fill_1
X_7633_ _7633_/Q _7634_/CLK _7633_/D _7633_/RESET_B VPWR VGND sg13cmos5l_dfrbpq_1
X_4845_ _4849_/B _4845_/A _4845_/B _4845_/C VPWR VGND sg13cmos5l_nor3_1
X_7564_ _7564_/Q _7571_/CLK _7564_/D _7564_/RESET_B VPWR VGND sg13cmos5l_dfrbpq_1
XFILLER_20_155 VPWR VGND sg13cmos5l_fill_2
X_4776_ _4776_/Y _7619_/Q _5323_/A2 _5326_/A VPWR VGND sg13cmos5l_o21ai_1
X_6515_ _6515_/Y _6513_/Y _6514_/Y _6512_/Y VPWR VGND sg13cmos5l_o21ai_1
X_7495_ _7495_/Q _7555_/CLK _7495_/D _7495_/RESET_B VPWR VGND sg13cmos5l_dfrbpq_1
X_6446_ _6446_/Y _6446_/A _6446_/B VPWR VGND sg13cmos5l_nor2_1
X_6377_ _6379_/B _7356_/Q _6378_/B _6374_/Y _6375_/Y _6376_/Y VPWR VGND sg13cmos5l_a221oi_1
XFILLER_0_505 VPWR VGND sg13cmos5l_fill_1
XFILLER_0_527 VPWR VGND sg13cmos5l_decap_8
X_5328_ _7191_/D _5328_/A _5328_/B VPWR VGND sg13cmos5l_and2_1
X_7495__383 _7495_/RESET_B VPWR VGND sg13cmos5l_tiehi
XFILLER_0_549 VPWR VGND sg13cmos5l_fill_1
X_5259_ _5259_/Y _4981_/B _5267_/B _5257_/Y VPWR VGND sg13cmos5l_o21ai_1
XFILLER_12_601 VPWR VGND sg13cmos5l_fill_2
XFILLER_40_943 VPWR VGND sg13cmos5l_fill_2
XFILLER_40_932 VPWR VGND sg13cmos5l_decap_8
XFILLER_7_148 VPWR VGND sg13cmos5l_fill_2
XFILLER_11_166 VPWR VGND sg13cmos5l_fill_2
X_7183__560 _7183_/RESET_B VPWR VGND sg13cmos5l_tiehi
XFILLER_3_343 VPWR VGND sg13cmos5l_fill_2
XFILLER_3_365 VPWR VGND sg13cmos5l_fill_1
XFILLER_39_509 VPWR VGND sg13cmos5l_fill_1
XFILLER_47_81 VPWR VGND sg13cmos5l_fill_2
XFILLER_43_781 VPWR VGND sg13cmos5l_fill_2
XFILLER_15_472 VPWR VGND sg13cmos5l_decap_8
X_4630_ _4630_/X _4631_/A _4631_/B VPWR VGND sg13cmos5l_and2_1
XFILLER_8_97 VPWR VGND sg13cmos5l_decap_8
X_6300_ _6323_/B _6268_/B _6289_/Y _6299_/X VPWR VGND sg13cmos5l_a21o_1
X_7329__389 _7329_/RESET_B VPWR VGND sg13cmos5l_tiehi
X_4561_ _4561_/Y _7545_/Q _5984_/A2 _5555_/A VPWR VGND sg13cmos5l_o21ai_1
X_4492_ _4496_/A _4265_/B _4513_/A _4487_/Y _4488_/Y _4491_/Y VPWR VGND sg13cmos5l_a221oi_1
X_7280_ _7280_/Q _7314_/CLK _7280_/D _7280_/RESET_B VPWR VGND sg13cmos5l_dfrbpq_1
X_6231_ _6231_/Y _6229_/B _6228_/B _6231_/B1 VPWR VGND sg13cmos5l_a21oi_1
X_6162_ _6162_/Y _6162_/A _6178_/A VPWR VGND sg13cmos5l_nor2_1
X_5113_ _5113_/X _5161_/A _5103_/B _5112_/Y VPWR VGND sg13cmos5l_a21o_1
XFILLER_33_0 VPWR VGND sg13cmos5l_fill_1
X_6093_ _6098_/A _6099_/B _6091_/B _6092_/Y VPWR VGND sg13cmos5l_o21ai_1
Xhold1305 _5696_/B _7211_/Q VPWR VGND sg13cmos5l_dlygate4sd3_1
Xhold1316 _4846_/A _4849_/B VPWR VGND sg13cmos5l_dlygate4sd3_1
X_5044_ _7140_/D _5102_/B _5161_/B VPWR VGND sg13cmos5l_nor2_1
Xhold1327 _5581_/A _7232_/Q VPWR VGND sg13cmos5l_dlygate4sd3_1
XFILLER_38_575 VPWR VGND sg13cmos5l_decap_8
X_6995_ _7478_/D _3865_/Y _6999_/A2 _6994_/Y VPWR VGND sg13cmos5l_a21oi_1
X_5946_ _5947_/B _6195_/A _7258_/Q VPWR VGND sg13cmos5l_nand2_1
XFILLER_25_269 VPWR VGND sg13cmos5l_decap_8
XFILLER_40_228 VPWR VGND sg13cmos5l_fill_1
X_5877_ _5887_/B _5961_/A _5877_/B VPWR VGND sg13cmos5l_xnor2_1
X_7616_ _7616_/Q _7635_/CLK _7616_/D _7616_/RESET_B VPWR VGND sg13cmos5l_dfrbpq_1
XFILLER_21_453 VPWR VGND sg13cmos5l_decap_4
X_4828_ _4828_/Y _4829_/B VPWR VGND sg13cmos5l_inv_1
X_4759_ _4759_/Y _7615_/Q _4758_/Y _4757_/Y VPWR VGND sg13cmos5l_a21oi_1
X_7547_ _7547_/Q _7617_/CLK _7547_/D _7547_/RESET_B VPWR VGND sg13cmos5l_dfrbpq_1
XFILLER_49_1016 VPWR VGND sg13cmos5l_decap_8
X_7478_ _7478_/Q _7510_/CLK _7478_/D _7478_/RESET_B VPWR VGND sg13cmos5l_dfrbpq_1
XFILLER_49_1027 VPWR VGND sg13cmos5l_fill_2
X_6429_ _6438_/A _7373_/Q _7372_/Q _7374_/Q VPWR VGND sg13cmos5l_nor3_1
XFILLER_17_704 VPWR VGND sg13cmos5l_fill_2
XFILLER_44_556 VPWR VGND sg13cmos5l_fill_2
XFILLER_24_291 VPWR VGND sg13cmos5l_decap_8
XFILLER_4_685 VPWR VGND sg13cmos5l_decap_4
XFILLER_47_350 VPWR VGND sg13cmos5l_decap_8
XFILLER_35_545 VPWR VGND sg13cmos5l_fill_1
X_6780_ _7437_/D _6782_/A _6838_/B VPWR VGND sg13cmos5l_nor2_1
X_3992_ _5523_/B _3992_/A VPWR VGND sg13cmos5l_inv_1
X_5800_ _5808_/C _5800_/A _5800_/B _5813_/A VPWR VGND sg13cmos5l_nand3_1
X_5731_ _5731_/Y _7221_/Q _5731_/B _5741_/C VPWR VGND sg13cmos5l_nor3_1
XFILLER_15_291 VPWR VGND sg13cmos5l_decap_8
X_5662_ _5662_/Y _5915_/A _5662_/B VPWR VGND sg13cmos5l_nand2_1
XFILLER_31_773 VPWR VGND sg13cmos5l_fill_1
X_7401_ _7401_/Q _7428_/CLK _7401_/D _7401_/RESET_B VPWR VGND sg13cmos5l_dfrbpq_1
X_4613_ _4615_/B _4613_/A _4613_/B VPWR VGND sg13cmos5l_nor2_1
X_5593_ _5612_/A _5593_/A _5616_/B _5593_/C VPWR VGND sg13cmos5l_nor3_1
X_7332_ _7332_/Q _7332_/CLK _7332_/D _7332_/RESET_B VPWR VGND sg13cmos5l_dfrbpq_1
X_4544_ _4544_/Y _4535_/X _4539_/Y _4542_/X _4753_/B _4543_/Y VPWR VGND sg13cmos5l_a221oi_1
XFILLER_7_490 VPWR VGND sg13cmos5l_fill_1
X_7263_ _7263_/Q _7272_/CLK _7263_/D _7263_/RESET_B VPWR VGND sg13cmos5l_dfrbpq_1
X_4475_ _4623_/A _4475_/A1 _4462_/C _4449_/X VPWR VGND sg13cmos5l_a21oi_1
X_6214_ _6309_/A _6230_/B _6214_/B VPWR VGND sg13cmos5l_nand2b_1
X_7194_ _7194_/Q _7635_/CLK _7194_/D _7194_/RESET_B VPWR VGND sg13cmos5l_dfrbpq_1
X_6145_ _6145_/Y _6145_/A _6160_/B VPWR VGND sg13cmos5l_nor2_1
Xhold1113 _6674_/A _7424_/Q VPWR VGND sg13cmos5l_dlygate4sd3_1
Xhold1102 _3942_/A _7203_/Q VPWR VGND sg13cmos5l_dlygate4sd3_1
X_6076_ _6076_/Y _7339_/Q _7315_/Q VPWR VGND sg13cmos5l_nand2_1
Xhold1124 _4008_/A _7575_/Q VPWR VGND sg13cmos5l_dlygate4sd3_1
Xhold1157 hold1157/X _7532_/Q VPWR VGND sg13cmos5l_dlygate4sd3_1
Xhold1146 _6432_/A _7398_/Q VPWR VGND sg13cmos5l_dlygate4sd3_1
X_5027_ _5027_/Y _5013_/Y _5019_/Y _4681_/Y VPWR VGND sg13cmos5l_o21ai_1
Xhold1135 _4768_/B _4767_/X VPWR VGND sg13cmos5l_dlygate4sd3_1
XFILLER_39_884 VPWR VGND sg13cmos5l_fill_1
Xhold1168 _6886_/A _6884_/Y VPWR VGND sg13cmos5l_dlygate4sd3_1
Xhold1179 _7037_/A _7484_/Q VPWR VGND sg13cmos5l_dlygate4sd3_1
X_7314__411 _7314_/RESET_B VPWR VGND sg13cmos5l_tiehi
X_7173__570 _7173_/RESET_B VPWR VGND sg13cmos5l_tiehi
XFILLER_14_718 VPWR VGND sg13cmos5l_fill_2
X_6978_ _6981_/A _7473_/Q _6973_/Y _6979_/B _7474_/Q _6975_/Y VPWR VGND sg13cmos5l_a221oi_1
X_5929_ _7286_/D _5993_/B _5999_/B VPWR VGND sg13cmos5l_nor2_1
XFILLER_6_928 VPWR VGND sg13cmos5l_fill_1
XFILLER_6_906 VPWR VGND sg13cmos5l_fill_2
XFILLER_21_283 VPWR VGND sg13cmos5l_decap_8
X_7321__404 _7321_/RESET_B VPWR VGND sg13cmos5l_tiehi
X_7180__563 _7180_/RESET_B VPWR VGND sg13cmos5l_tiehi
Xhold980 _4771_/B _7615_/Q VPWR VGND sg13cmos5l_dlygate4sd3_1
Xhold991 hold991/X _4558_/Y VPWR VGND sg13cmos5l_dlygate4sd3_1
XFILLER_48_103 VPWR VGND sg13cmos5l_fill_2
XFILLER_23_1019 VPWR VGND sg13cmos5l_decap_8
XFILLER_17_523 VPWR VGND sg13cmos5l_decap_4
XFILLER_9_744 VPWR VGND sg13cmos5l_decap_8
XFILLER_12_250 VPWR VGND sg13cmos5l_decap_4
XFILLER_5_994 VPWR VGND sg13cmos5l_decap_8
XFILLER_4_460 VPWR VGND sg13cmos5l_fill_1
X_7441__252 _7441_/RESET_B VPWR VGND sg13cmos5l_tiehi
X_4260_ _7527_/D _4337_/A _4360_/A VPWR VGND sg13cmos5l_nor2_1
XFILLER_5_76 VPWR VGND sg13cmos5l_decap_4
X_7638__650 _7638_/RESET_B VPWR VGND sg13cmos5l_tiehi
X_4191_ _4192_/A _4194_/B _4191_/B VPWR VGND sg13cmos5l_nor2_1
X_6901_ _6901_/Y _7463_/Q _7462_/Q _7489_/Q VPWR VGND sg13cmos5l_nand3b_1
X_7487__400 _7487_/RESET_B VPWR VGND sg13cmos5l_tiehi
X_6832_ _7454_/D _6832_/A _6889_/A VPWR VGND sg13cmos5l_nor2_1
X_6763_ _6763_/Y _6773_/B VPWR VGND sg13cmos5l_inv_1
X_3975_ _6481_/B _3975_/A VPWR VGND sg13cmos5l_inv_1
X_6694_ _6694_/Y _6692_/Y _6694_/B VPWR VGND sg13cmos5l_nand2b_1
X_5714_ _5714_/Y _5707_/A _5707_/B _5451_/Y VPWR VGND sg13cmos5l_a21oi_1
XFILLER_10_209 VPWR VGND sg13cmos5l_fill_2
X_5645_ _5645_/Y _7272_/Q _7241_/Q VPWR VGND sg13cmos5l_nand2_1
X_7461__639 _7461_/RESET_B VPWR VGND sg13cmos5l_tiehi
X_5576_ _5576_/Y _7224_/Q _7190_/Q VPWR VGND sg13cmos5l_xnor2_1
X_7315_ _7315_/Q _7344_/CLK _7315_/D _7315_/RESET_B VPWR VGND sg13cmos5l_dfrbpq_1
X_4527_ _4527_/Y _4527_/A _7539_/Q VPWR VGND sg13cmos5l_nand2_1
X_4458_ _4458_/Y _4578_/A VPWR VGND sg13cmos5l_inv_1
X_7246_ _7246_/Q _7277_/CLK _7246_/D _7246_/RESET_B VPWR VGND sg13cmos5l_dfrbpq_1
X_7177_ _7177_/Q _7214_/CLK _7177_/D _7177_/RESET_B VPWR VGND sg13cmos5l_dfrbpq_1
X_4389_ _4389_/Y _4390_/A _4390_/B VPWR VGND sg13cmos5l_nand2_1
X_6128_ _6299_/A _6293_/A VPWR VGND sg13cmos5l_inv_1
X_6059_ _6060_/B _6032_/Y _6054_/Y _5990_/B VPWR VGND sg13cmos5l_o21ai_1
XFILLER_27_854 VPWR VGND sg13cmos5l_fill_2
XFILLER_14_504 VPWR VGND sg13cmos5l_decap_8
XFILLER_26_386 VPWR VGND sg13cmos5l_decap_4
XFILLER_6_703 VPWR VGND sg13cmos5l_decap_8
XFILLER_14_96 VPWR VGND sg13cmos5l_decap_8
XFILLER_6_736 VPWR VGND sg13cmos5l_fill_2
XFILLER_6_769 VPWR VGND sg13cmos5l_decap_8
XFILLER_5_224 VPWR VGND sg13cmos5l_fill_1
XFILLER_30_51 VPWR VGND sg13cmos5l_fill_2
XFILLER_49_412 VPWR VGND sg13cmos5l_fill_1
XFILLER_7_1002 VPWR VGND sg13cmos5l_decap_8
XFILLER_2_997 VPWR VGND sg13cmos5l_decap_8
XFILLER_45_673 VPWR VGND sg13cmos5l_decap_8
XFILLER_17_364 VPWR VGND sg13cmos5l_decap_4
XFILLER_45_684 VPWR VGND sg13cmos5l_fill_1
XFILLER_17_397 VPWR VGND sg13cmos5l_fill_1
XFILLER_33_879 VPWR VGND sg13cmos5l_decap_8
XFILLER_20_507 VPWR VGND sg13cmos5l_fill_2
XFILLER_9_541 VPWR VGND sg13cmos5l_fill_1
X_5430_ _5436_/B _5777_/A _5431_/B VPWR VGND sg13cmos5l_and2_1
X_5361_ _5388_/A _7194_/Q _5382_/B _5370_/A VPWR VGND sg13cmos5l_a21o_1
X_5292_ _5292_/Y _5297_/C _5291_/Y _5290_/Y VPWR VGND sg13cmos5l_a21oi_1
X_7304__421 _7304_/RESET_B VPWR VGND sg13cmos5l_tiehi
X_4312_ _4312_/Y _7508_/Q _4312_/B VPWR VGND sg13cmos5l_nand2b_1
X_7100_ _7100_/Y _7085_/A _7098_/S _7072_/A VPWR VGND sg13cmos5l_o21ai_1
X_4243_ _4247_/B _4243_/A _4243_/B VPWR VGND sg13cmos5l_xor2_1
X_7163__580 _7163_/RESET_B VPWR VGND sg13cmos5l_tiehi
X_7031_ _7032_/B _7484_/Q _7037_/B _7017_/Y VPWR VGND sg13cmos5l_a21oi_1
X_4174_ _4207_/B _4172_/Y _4173_/Y _4171_/Y VPWR VGND sg13cmos5l_a21oi_1
X_7311__414 _7311_/RESET_B VPWR VGND sg13cmos5l_tiehi
X_6815_ _6815_/Y _6798_/Y _6809_/C _6815_/B1 VPWR VGND sg13cmos5l_a21oi_1
X_6746_ _6751_/B _7406_/Q _7405_/Q _7404_/Q VPWR VGND sg13cmos5l_or3_1
X_7170__573 _7170_/RESET_B VPWR VGND sg13cmos5l_tiehi
X_3958_ _4786_/A _3958_/A VPWR VGND sg13cmos5l_inv_1
X_3889_ _3889_/Y _5119_/A VPWR VGND sg13cmos5l_inv_1
X_6677_ _6677_/Y _6677_/A _6677_/B VPWR VGND sg13cmos5l_xnor2_1
X_5628_ _5630_/A _5628_/A _5622_/Y VPWR VGND sg13cmos5l_nor2b_1
XFILLER_3_728 VPWR VGND sg13cmos5l_decap_8
X_5559_ _7231_/D _5559_/A _5560_/B VPWR VGND sg13cmos5l_nor2_1
X_7229_ _7229_/Q _7272_/CLK _7229_/D _7229_/RESET_B VPWR VGND sg13cmos5l_dfrbpq_1
XFILLER_47_949 VPWR VGND sg13cmos5l_decap_8
XFILLER_19_629 VPWR VGND sg13cmos5l_decap_8
X_7472__554 _7472_/RESET_B VPWR VGND sg13cmos5l_tiehi
XFILLER_46_448 VPWR VGND sg13cmos5l_fill_2
X_7431__262 _7431_/RESET_B VPWR VGND sg13cmos5l_tiehi
XFILLER_29_1025 VPWR VGND sg13cmos5l_decap_4
X_7477__476 _7477_/RESET_B VPWR VGND sg13cmos5l_tiehi
XFILLER_37_404 VPWR VGND sg13cmos5l_fill_1
XFILLER_49_286 VPWR VGND sg13cmos5l_decap_8
XFILLER_46_993 VPWR VGND sg13cmos5l_decap_8
X_4930_ _4930_/Y hold908/X _6500_/A2 _6391_/B1 VPWR VGND sg13cmos5l_o21ai_1
XFILLER_17_183 VPWR VGND sg13cmos5l_fill_1
X_4861_ _7634_/D _4849_/A _4846_/Y _4788_/B VPWR VGND sg13cmos5l_a21oi_1
X_6600_ _6604_/B _6602_/B _6600_/B VPWR VGND sg13cmos5l_and2_1
X_4792_ _4792_/Y _4725_/B _4795_/A VPWR VGND sg13cmos5l_nand2b_1
X_7580_ _7580_/Q _7617_/CLK _7580_/D _7580_/RESET_B VPWR VGND sg13cmos5l_dfrbpq_1
XFILLER_32_197 VPWR VGND sg13cmos5l_fill_2
X_6531_ _6532_/C _6531_/A _6531_/B _6531_/C VPWR VGND sg13cmos5l_and3_1
X_6462_ _6462_/Y _6348_/A _6458_/A _6355_/B VPWR VGND sg13cmos5l_o21ai_1
X_5413_ _5698_/A _5450_/A _7237_/Q VPWR VGND sg13cmos5l_xnor2_1
X_6393_ _7362_/D _6506_/A _6393_/B VPWR VGND sg13cmos5l_and2_1
X_5344_ _5344_/X _5335_/A _5396_/B _5343_/Y VPWR VGND sg13cmos5l_a21o_1
XFILLER_0_709 VPWR VGND sg13cmos5l_fill_2
X_5275_ _5391_/A _4989_/X _5260_/Y _5262_/X _5274_/Y VPWR VGND sg13cmos5l_a22oi_1
X_4226_ _4237_/B _7528_/Q _7526_/Q _7527_/Q VPWR VGND sg13cmos5l_or3_1
X_7014_ _7042_/B _7047_/A _6957_/Y _7011_/Y _7013_/Y VPWR VGND sg13cmos5l_a22oi_1
X_4157_ _4157_/Y _7071_/B VPWR VGND sg13cmos5l_inv_1
XFILLER_43_407 VPWR VGND sg13cmos5l_decap_4
X_4088_ _7519_/D _4088_/A _7072_/A VPWR VGND sg13cmos5l_and2_1
XFILLER_23_120 VPWR VGND sg13cmos5l_fill_2
XFILLER_24_643 VPWR VGND sg13cmos5l_fill_1
X_7467__623 _7467_/RESET_B VPWR VGND sg13cmos5l_tiehi
XFILLER_12_816 VPWR VGND sg13cmos5l_decap_8
X_6729_ _6729_/Y _6719_/X _6723_/Y _6937_/A _6728_/X _6724_/X VPWR VGND sg13cmos5l_a221oi_1
X_7153__590 _7153_/RESET_B VPWR VGND sg13cmos5l_tiehi
XFILLER_30_613 VPWR VGND sg13cmos5l_fill_1
XFILLER_10_370 VPWR VGND sg13cmos5l_fill_2
XFILLER_7_875 VPWR VGND sg13cmos5l_fill_2
XFILLER_6_330 VPWR VGND sg13cmos5l_fill_1
Xhold809 _7545_/D _4346_/Y VPWR VGND sg13cmos5l_dlygate4sd3_1
X_7301__424 _7301_/RESET_B VPWR VGND sg13cmos5l_tiehi
X_5060_ _5060_/Y _5065_/C _5059_/Y _5058_/Y VPWR VGND sg13cmos5l_a21oi_1
X_7160__583 _7160_/RESET_B VPWR VGND sg13cmos5l_tiehi
X_4011_ _4540_/B _4011_/A VPWR VGND sg13cmos5l_inv_1
X_5962_ _5963_/B _5961_/C _5960_/Y _5961_/Y VPWR VGND sg13cmos5l_a21oi_1
XFILLER_18_470 VPWR VGND sg13cmos5l_fill_1
X_4913_ _4913_/X _4906_/Y _4912_/B hold888/X VPWR VGND sg13cmos5l_a21o_1
X_5893_ _5894_/A _5961_/A _6194_/A _5893_/C VPWR VGND sg13cmos5l_nor3_1
XFILLER_33_451 VPWR VGND sg13cmos5l_fill_2
XFILLER_20_123 VPWR VGND sg13cmos5l_fill_1
X_7632_ _7632_/Q _7634_/CLK _7632_/D _7632_/RESET_B VPWR VGND sg13cmos5l_dfrbpq_1
X_4844_ _4845_/C _4844_/A _4844_/B _4844_/C VPWR VGND sg13cmos5l_and3_1
X_7563_ _7563_/Q _7571_/CLK _7563_/D _7563_/RESET_B VPWR VGND sg13cmos5l_dfrbpq_1
X_4775_ _7618_/D _3895_/Y _5325_/A2 _4774_/Y VPWR VGND sg13cmos5l_a21oi_1
X_6514_ _6514_/Y _6514_/A _6538_/A VPWR VGND sg13cmos5l_nor2_1
X_7494_ _7494_/Q _7555_/CLK _7494_/D _7494_/RESET_B VPWR VGND sg13cmos5l_dfrbpq_1
X_6445_ _6446_/B _6443_/Y _6444_/Y _6603_/A VPWR VGND sg13cmos5l_a21oi_1
X_6376_ _6376_/Y _6483_/B _6376_/B VPWR VGND sg13cmos5l_nor2_1
XFILLER_0_517 VPWR VGND sg13cmos5l_fill_2
X_5327_ _7190_/D _5328_/A _5327_/B VPWR VGND sg13cmos5l_and2_1
X_7421__272 _7421_/RESET_B VPWR VGND sg13cmos5l_tiehi
X_5258_ _5260_/B _5257_/A _5257_/B _5274_/B _4993_/B VPWR VGND sg13cmos5l_a22oi_1
X_4209_ _4209_/Y _4209_/A _4209_/B _4209_/C VPWR VGND sg13cmos5l_nor3_1
X_5189_ _5200_/A _7170_/Q _5189_/B VPWR VGND sg13cmos5l_xor2_1
XFILLER_25_941 VPWR VGND sg13cmos5l_decap_8
XFILLER_7_105 VPWR VGND sg13cmos5l_decap_8
XFILLER_11_189 VPWR VGND sg13cmos5l_decap_8
XFILLER_4_801 VPWR VGND sg13cmos5l_fill_2
X_7508__472 _7508_/RESET_B VPWR VGND sg13cmos5l_tiehi
XFILLER_4_834 VPWR VGND sg13cmos5l_fill_2
XFILLER_4_889 VPWR VGND sg13cmos5l_fill_2
XFILLER_26_1017 VPWR VGND sg13cmos5l_decap_8
XFILLER_26_1028 VPWR VGND sg13cmos5l_fill_1
XFILLER_19_223 VPWR VGND sg13cmos5l_fill_1
XFILLER_35_716 VPWR VGND sg13cmos5l_fill_1
XFILLER_16_930 VPWR VGND sg13cmos5l_decap_8
XFILLER_16_974 VPWR VGND sg13cmos5l_decap_8
X_7116__636 _7116_/RESET_B VPWR VGND sg13cmos5l_tiehi
XFILLER_8_32 VPWR VGND sg13cmos5l_decap_8
XFILLER_31_977 VPWR VGND sg13cmos5l_fill_1
XFILLER_8_65 VPWR VGND sg13cmos5l_decap_8
X_4560_ _7580_/D _4560_/A _4560_/B VPWR VGND sg13cmos5l_and2_1
X_4491_ _4491_/Y _4494_/A _4517_/A VPWR VGND sg13cmos5l_nor2_1
X_6230_ _6323_/A _6299_/A _6230_/B _6230_/C VPWR VGND sg13cmos5l_nand3_1
X_6161_ _6178_/A _6159_/B _6160_/Y _6159_/Y VPWR VGND sg13cmos5l_a21oi_1
X_5112_ _5112_/Y _5155_/A _5110_/A VPWR VGND sg13cmos5l_nor2b_1
Xhold1306 _4106_/A _7495_/Q VPWR VGND sg13cmos5l_dlygate4sd3_1
X_6092_ _6092_/Y _7344_/Q _6095_/C VPWR VGND sg13cmos5l_xnor2_1
Xhold1317 hold1317/X _7522_/Q VPWR VGND sg13cmos5l_dlygate4sd3_1
X_5043_ _5103_/B _5161_/B VPWR VGND sg13cmos5l_inv_1
Xhold1328 _5617_/A _5621_/B VPWR VGND sg13cmos5l_dlygate4sd3_1
XFILLER_25_226 VPWR VGND sg13cmos5l_fill_2
X_6994_ _6994_/Y hold864/X _6994_/A2 _5987_/A VPWR VGND sg13cmos5l_o21ai_1
XFILLER_40_207 VPWR VGND sg13cmos5l_decap_8
X_5945_ _5945_/Y _7258_/Q _5945_/B VPWR VGND sg13cmos5l_nor2_1
X_5876_ _6254_/A _6195_/A _5877_/B VPWR VGND sg13cmos5l_xnor2_1
X_7615_ _7615_/Q _7635_/CLK _7615_/D _7615_/RESET_B VPWR VGND sg13cmos5l_dfrbpq_1
X_4827_ _4829_/B _4793_/A _4684_/B _4838_/S VPWR VGND sg13cmos5l_mux2_1
X_4758_ _4758_/Y _5102_/A _7634_/Q _4739_/A _7578_/Q VPWR VGND sg13cmos5l_a22oi_1
X_7546_ _7546_/Q _7622_/CLK _7546_/D _7546_/RESET_B VPWR VGND sg13cmos5l_dfrbpq_1
X_4689_ _4689_/Y _4689_/A _5021_/A VPWR VGND sg13cmos5l_nor2_1
X_7477_ _7477_/Q _7553_/CLK _7477_/D _7477_/RESET_B VPWR VGND sg13cmos5l_dfrbpq_1
X_6428_ _6495_/A _6651_/B _6506_/A VPWR VGND sg13cmos5l_nand2b_1
X_6359_ _6411_/D _6340_/Y _6359_/A2 _6348_/X VPWR VGND sg13cmos5l_a21oi_1
XFILLER_0_358 VPWR VGND sg13cmos5l_decap_8
XFILLER_16_204 VPWR VGND sg13cmos5l_decap_8
XFILLER_40_741 VPWR VGND sg13cmos5l_decap_4
XFILLER_9_926 VPWR VGND sg13cmos5l_fill_2
XFILLER_12_432 VPWR VGND sg13cmos5l_decap_8
XFILLER_12_443 VPWR VGND sg13cmos5l_fill_2
XFILLER_8_447 VPWR VGND sg13cmos5l_decap_4
XFILLER_12_6 VPWR VGND sg13cmos5l_fill_1
XFILLER_47_395 VPWR VGND sg13cmos5l_fill_2
X_3991_ _5527_/B _3991_/A VPWR VGND sg13cmos5l_inv_1
XFILLER_23_719 VPWR VGND sg13cmos5l_fill_1
X_5730_ _5741_/C _7277_/Q _5728_/B _5729_/Y VPWR VGND sg13cmos5l_o21ai_1
XFILLER_43_590 VPWR VGND sg13cmos5l_fill_1
X_7400_ _7400_/Q _7428_/CLK _7400_/D _7400_/RESET_B VPWR VGND sg13cmos5l_dfrbpq_1
X_5661_ _5677_/B _7246_/Q _5661_/B VPWR VGND sg13cmos5l_xnor2_1
X_5592_ _5593_/C _5592_/A _5603_/C _5592_/C VPWR VGND sg13cmos5l_and3_1
X_4612_ _4612_/Y _4625_/B _4612_/B _4612_/C VPWR VGND sg13cmos5l_nand3b_1
X_7331_ _7331_/Q _7332_/CLK _7331_/D _7331_/RESET_B VPWR VGND sg13cmos5l_dfrbpq_1
X_4543_ _4543_/Y _7576_/Q _4543_/B VPWR VGND sg13cmos5l_nor2_1
X_7262_ _7262_/Q _7272_/CLK _7262_/D _7262_/RESET_B VPWR VGND sg13cmos5l_dfrbpq_1
X_4474_ _7565_/D _4519_/A _4474_/B VPWR VGND sg13cmos5l_nor2_1
X_6213_ _6214_/B _6213_/A _6213_/B _6213_/C VPWR VGND sg13cmos5l_nand3_1
X_7193_ _7193_/Q _7611_/CLK _7193_/D _7193_/RESET_B VPWR VGND sg13cmos5l_dfrbpq_1
X_6144_ _6144_/Y _6140_/Y _6159_/B _6143_/Y VPWR VGND sg13cmos5l_a21oi_1
Xhold1114 _6459_/B _7350_/Q VPWR VGND sg13cmos5l_dlygate4sd3_1
Xhold1103 hold1103/X _7507_/Q VPWR VGND sg13cmos5l_dlygate4sd3_1
X_6075_ _6081_/A _6089_/D _6114_/A _6075_/C VPWR VGND sg13cmos5l_nand3_1
Xhold1158 _4502_/A2 _4501_/B VPWR VGND sg13cmos5l_dlygate4sd3_1
Xhold1147 _3970_/A _7255_/Q VPWR VGND sg13cmos5l_dlygate4sd3_1
X_5026_ _7136_/D _5038_/A _5117_/A VPWR VGND sg13cmos5l_nor2_1
Xhold1136 _3997_/A _7144_/Q VPWR VGND sg13cmos5l_dlygate4sd3_1
Xhold1125 _4553_/B _4552_/X VPWR VGND sg13cmos5l_dlygate4sd3_1
Xhold1169 _5602_/A _7229_/Q VPWR VGND sg13cmos5l_dlygate4sd3_1
X_6977_ _6979_/B _6816_/Y _6970_/B _6971_/C _6976_/Y VPWR VGND sg13cmos5l_a22oi_1
XFILLER_13_218 VPWR VGND sg13cmos5l_fill_2
X_5928_ _5928_/Y _5999_/B VPWR VGND sg13cmos5l_inv_1
X_5859_ _5861_/B _5859_/A _5860_/C VPWR VGND sg13cmos5l_nor2b_1
XFILLER_16_1027 VPWR VGND sg13cmos5l_fill_2
X_7644__346 _7644_/RESET_B VPWR VGND sg13cmos5l_tiehi
X_7529_ _7529_/Q _7560_/CLK _7529_/D _7529_/RESET_B VPWR VGND sg13cmos5l_dfrbpq_1
Xhold981 hold981/X _4771_/Y VPWR VGND sg13cmos5l_dlygate4sd3_1
Xhold970 _4872_/B _7644_/Q VPWR VGND sg13cmos5l_dlygate4sd3_1
Xhold992 _7578_/D _4559_/Y VPWR VGND sg13cmos5l_dlygate4sd3_1
XFILLER_49_649 VPWR VGND sg13cmos5l_decap_8
XFILLER_28_73 VPWR VGND sg13cmos5l_fill_2
XFILLER_29_351 VPWR VGND sg13cmos5l_fill_1
XFILLER_45_844 VPWR VGND sg13cmos5l_decap_4
XFILLER_44_398 VPWR VGND sg13cmos5l_decap_8
XFILLER_44_83 VPWR VGND sg13cmos5l_fill_2
XFILLER_13_752 VPWR VGND sg13cmos5l_fill_2
XFILLER_8_200 VPWR VGND sg13cmos5l_fill_1
XFILLER_9_778 VPWR VGND sg13cmos5l_decap_4
XFILLER_5_973 VPWR VGND sg13cmos5l_decap_8
XFILLER_5_88 VPWR VGND sg13cmos5l_decap_8
XFILLER_4_494 VPWR VGND sg13cmos5l_fill_1
XFILLER_4_483 VPWR VGND sg13cmos5l_fill_2
XFILLER_4_472 VPWR VGND sg13cmos5l_decap_8
X_4190_ _4191_/B _4190_/A _4190_/B VPWR VGND sg13cmos5l_xnor2_1
XFILLER_47_170 VPWR VGND sg13cmos5l_fill_1
X_6900_ _6900_/Y _7463_/Q _7462_/Q VPWR VGND sg13cmos5l_xnor2_1
XFILLER_36_844 VPWR VGND sg13cmos5l_fill_1
XFILLER_36_833 VPWR VGND sg13cmos5l_decap_8
XFILLER_39_1027 VPWR VGND sg13cmos5l_fill_2
XFILLER_36_877 VPWR VGND sg13cmos5l_fill_2
X_6831_ _7453_/D _6831_/A _6889_/A VPWR VGND sg13cmos5l_nor2_1
X_6762_ _6773_/B _7408_/Q _6762_/B VPWR VGND sg13cmos5l_xor2_1
X_3974_ _6483_/B _3974_/A VPWR VGND sg13cmos5l_inv_1
X_6693_ _6693_/Y _6694_/B _6692_/Y VPWR VGND sg13cmos5l_nor2b_1
X_5713_ _7247_/D _5712_/A _5712_/B _5845_/A VPWR VGND sg13cmos5l_a21oi_1
X_5644_ _5673_/A _7241_/Q _7242_/Q VPWR VGND sg13cmos5l_xnor2_1
X_7314_ _7314_/Q _7314_/CLK _7314_/D _7314_/RESET_B VPWR VGND sg13cmos5l_dfrbpq_1
X_5575_ _5575_/Y _7223_/Q _7189_/Q VPWR VGND sg13cmos5l_xnor2_1
X_4526_ _4532_/B _4520_/Y _4524_/Y _4525_/Y VPWR VGND sg13cmos5l_o21ai_1
X_4457_ _4578_/A _4457_/A0 _4456_/Y _4457_/S VPWR VGND sg13cmos5l_mux2_1
X_7245_ _7245_/Q _7307_/CLK _7245_/D _7245_/RESET_B VPWR VGND sg13cmos5l_dfrbpq_1
X_7176_ _7176_/Q _7200_/CLK _7176_/D _7176_/RESET_B VPWR VGND sg13cmos5l_dfrbpq_1
X_4388_ _4390_/B _4403_/A _4388_/B VPWR VGND sg13cmos5l_nor2_1
X_6127_ _6293_/A _6127_/A _6127_/B VPWR VGND sg13cmos5l_or2_1
X_6058_ _6060_/A _6058_/A _6061_/B _6061_/C VPWR VGND sg13cmos5l_nor3_1
X_5009_ _5016_/B _7609_/Q _5011_/B VPWR VGND sg13cmos5l_nor2b_1
XFILLER_10_722 VPWR VGND sg13cmos5l_fill_1
XFILLER_5_203 VPWR VGND sg13cmos5l_decap_8
XFILLER_10_777 VPWR VGND sg13cmos5l_decap_8
XFILLER_2_976 VPWR VGND sg13cmos5l_decap_8
XFILLER_1_486 VPWR VGND sg13cmos5l_fill_1
X_7616__201 _7616_/D VPWR VGND sg13cmos5l_tielo
XFILLER_17_343 VPWR VGND sg13cmos5l_decap_8
XFILLER_18_855 VPWR VGND sg13cmos5l_decap_8
XFILLER_41_891 VPWR VGND sg13cmos5l_decap_8
XFILLER_9_531 VPWR VGND sg13cmos5l_decap_4
X_5360_ _5370_/A _5384_/A _5369_/C _5369_/A VPWR VGND sg13cmos5l_a21oi_1
XFILLER_5_792 VPWR VGND sg13cmos5l_decap_8
X_5291_ _5291_/Y _7203_/Q _5558_/A VPWR VGND sg13cmos5l_nor2b_1
X_4311_ _4316_/B _4324_/S _4309_/Y _4310_/Y VPWR VGND sg13cmos5l_o21ai_1
X_4242_ _4246_/B _7530_/Q _4243_/B VPWR VGND sg13cmos5l_nor2b_1
X_7030_ _7041_/B _7030_/A _7030_/B VPWR VGND sg13cmos5l_nor2_1
X_4173_ _4173_/Y _7511_/Q _7482_/Q VPWR VGND sg13cmos5l_xnor2_1
X_6814_ _6814_/Y _6809_/C _6970_/A _6711_/Y VPWR VGND sg13cmos5l_o21ai_1
X_6745_ _7433_/D _6891_/A _6835_/A VPWR VGND sg13cmos5l_and2_1
X_3957_ _4787_/A _3957_/A VPWR VGND sg13cmos5l_inv_1
X_6676_ _6697_/B _6697_/A _6675_/X _6669_/Y VPWR VGND sg13cmos5l_o21ai_1
X_3888_ _3888_/Y _3888_/A VPWR VGND sg13cmos5l_inv_1
X_5627_ _7236_/D _5627_/A _5627_/B VPWR VGND sg13cmos5l_nor2_1
X_7598__204 _7598_/D VPWR VGND sg13cmos5l_tielo
X_5558_ _7230_/D _5558_/A _5558_/B VPWR VGND sg13cmos5l_and2_1
X_4509_ _4580_/B _4261_/X _4512_/B _4508_/X VPWR VGND sg13cmos5l_a21o_1
X_5489_ _5489_/Y _5501_/B _5489_/B VPWR VGND sg13cmos5l_nand2b_1
XFILLER_4_8 VPWR VGND sg13cmos5l_fill_1
X_7228_ _7228_/Q _7272_/CLK _7228_/D _7228_/RESET_B VPWR VGND sg13cmos5l_dfrbpq_1
X_7159_ _7159_/Q _7634_/CLK _7159_/D _7159_/RESET_B VPWR VGND sg13cmos5l_dfrbpq_1
XFILLER_19_608 VPWR VGND sg13cmos5l_fill_2
XFILLER_39_490 VPWR VGND sg13cmos5l_decap_8
XFILLER_15_814 VPWR VGND sg13cmos5l_fill_1
XFILLER_42_655 VPWR VGND sg13cmos5l_decap_8
XFILLER_41_154 VPWR VGND sg13cmos5l_fill_1
XFILLER_10_541 VPWR VGND sg13cmos5l_decap_4
XFILLER_41_62 VPWR VGND sg13cmos5l_fill_1
XFILLER_6_523 VPWR VGND sg13cmos5l_fill_2
XFILLER_29_1004 VPWR VGND sg13cmos5l_decap_8
XFILLER_2_740 VPWR VGND sg13cmos5l_decap_8
XFILLER_2_34 VPWR VGND sg13cmos5l_fill_1
XFILLER_49_243 VPWR VGND sg13cmos5l_decap_8
XFILLER_38_917 VPWR VGND sg13cmos5l_decap_8
XFILLER_46_972 VPWR VGND sg13cmos5l_decap_8
Xclkbuf_leaf_29_clk _7272_/CLK clkbuf_3_4__f_clk/X VPWR VGND sg13cmos5l_buf_8
X_4860_ _7633_/D _4860_/A1 _4850_/Y _4859_/Y VPWR VGND sg13cmos5l_a21oi_1
XFILLER_33_633 VPWR VGND sg13cmos5l_fill_1
XFILLER_36_1019 VPWR VGND sg13cmos5l_decap_8
XFILLER_33_688 VPWR VGND sg13cmos5l_fill_2
X_4791_ _4791_/Y _4791_/A _4680_/A VPWR VGND sg13cmos5l_nor2b_1
X_6530_ _6537_/A _6545_/A _6529_/X _6523_/Y VPWR VGND sg13cmos5l_o21ai_1
XFILLER_20_349 VPWR VGND sg13cmos5l_fill_1
X_6461_ _6461_/Y _7351_/Q _6509_/A _6348_/A _6458_/A _6460_/Y VPWR VGND sg13cmos5l_a221oi_1
X_5412_ _7202_/D _5400_/B _5399_/Y _5407_/A VPWR VGND sg13cmos5l_a21oi_1
X_6392_ _7361_/D _3871_/Y _6653_/A2 _6391_/Y VPWR VGND sg13cmos5l_a21oi_1
X_5343_ _5343_/Y _5391_/A _5341_/A VPWR VGND sg13cmos5l_nor2b_1
X_5274_ _5274_/Y _5274_/A _5274_/B VPWR VGND sg13cmos5l_nor2_1
X_7013_ _7013_/Y _6919_/Y _7047_/B _7012_/Y VPWR VGND sg13cmos5l_a21oi_1
X_4225_ _4261_/B _7558_/Q _4571_/A VPWR VGND sg13cmos5l_xnor2_1
X_4156_ _7071_/B _4146_/A _4153_/X _4155_/Y _4147_/Y VPWR VGND sg13cmos5l_a22oi_1
XFILLER_29_917 VPWR VGND sg13cmos5l_fill_2
X_4087_ _7518_/D _6976_/B _7071_/A VPWR VGND sg13cmos5l_nor2_1
X_4989_ _4989_/X _5249_/A _4993_/B VPWR VGND sg13cmos5l_and2_1
XFILLER_11_338 VPWR VGND sg13cmos5l_fill_1
X_6728_ _6728_/X _7433_/Q _6728_/B VPWR VGND sg13cmos5l_xor2_1
X_6659_ _7419_/D _6659_/A _6659_/B VPWR VGND sg13cmos5l_and2_1
XFILLER_11_43 VPWR VGND sg13cmos5l_fill_1
XFILLER_11_65 VPWR VGND sg13cmos5l_fill_1
X_7589__704 _7589_/RESET_B VPWR VGND sg13cmos5l_tiehi
XFILLER_4_1028 VPWR VGND sg13cmos5l_fill_1
XFILLER_4_1017 VPWR VGND sg13cmos5l_decap_8
X_7292__440 _7292_/RESET_B VPWR VGND sg13cmos5l_tiehi
X_7218__522 _7218_/RESET_B VPWR VGND sg13cmos5l_tiehi
XFILLER_14_121 VPWR VGND sg13cmos5l_decap_8
XFILLER_15_633 VPWR VGND sg13cmos5l_fill_2
XFILLER_42_463 VPWR VGND sg13cmos5l_decap_4
XFILLER_7_843 VPWR VGND sg13cmos5l_fill_1
XFILLER_6_320 VPWR VGND sg13cmos5l_fill_1
XFILLER_2_570 VPWR VGND sg13cmos5l_decap_8
XFILLER_2_581 VPWR VGND sg13cmos5l_fill_1
XFILLER_28_4 VPWR VGND sg13cmos5l_fill_2
X_4010_ _4527_/A _7543_/Q VPWR VGND sg13cmos5l_inv_1
XFILLER_37_213 VPWR VGND sg13cmos5l_fill_2
XFILLER_37_246 VPWR VGND sg13cmos5l_fill_1
XFILLER_19_961 VPWR VGND sg13cmos5l_fill_1
X_5961_ _5961_/Y _5961_/A _6193_/A _5961_/C VPWR VGND sg13cmos5l_nor3_1
XFILLER_25_419 VPWR VGND sg13cmos5l_fill_1
XFILLER_18_482 VPWR VGND sg13cmos5l_fill_1
XFILLER_34_942 VPWR VGND sg13cmos5l_fill_1
X_4912_ _4912_/Y _6362_/A _4912_/B _4912_/C VPWR VGND sg13cmos5l_nand3_1
X_5892_ _7281_/D _5994_/B _5892_/B VPWR VGND sg13cmos5l_nor2_1
X_7631_ _7631_/Q _7634_/CLK _7631_/D _7631_/RESET_B VPWR VGND sg13cmos5l_dfrbpq_1
XFILLER_33_441 VPWR VGND sg13cmos5l_fill_2
X_4843_ _4849_/A _4843_/A _4843_/B VPWR VGND sg13cmos5l_nor2_1
X_7562_ _7562_/Q _7597_/CLK _7562_/D _7562_/RESET_B VPWR VGND sg13cmos5l_dfrbpq_1
X_4774_ _4774_/Y hold827/X _5325_/A2 _5328_/A VPWR VGND sg13cmos5l_o21ai_1
X_6513_ _6513_/Y _6448_/B _6517_/A _6538_/A _6514_/A VPWR VGND sg13cmos5l_a22oi_1
X_7493_ _7493_/Q _7513_/CLK _7493_/D _7493_/RESET_B VPWR VGND sg13cmos5l_dfrbpq_1
X_6444_ _6444_/Y _6604_/A _6438_/Y _6446_/A VPWR VGND sg13cmos5l_a21oi_1
Xclkbuf_leaf_9_clk _7375_/CLK clkload1/A VPWR VGND sg13cmos5l_buf_8
X_6375_ _6375_/Y _6481_/B _6375_/B VPWR VGND sg13cmos5l_nor2_1
X_5326_ _7189_/D _5326_/A _5326_/B VPWR VGND sg13cmos5l_and2_1
X_5257_ _5257_/Y _5257_/A _5257_/B VPWR VGND sg13cmos5l_nand2_1
X_4208_ _4209_/C _4208_/A _4208_/B VPWR VGND sg13cmos5l_nor2_1
X_5188_ _5198_/B _7170_/Q _7169_/Q _7167_/Q _7168_/Q VPWR VGND sg13cmos5l_nor4_1
X_4139_ _4139_/Y _4136_/Y _4137_/Y _4138_/Y _6971_/B VPWR VGND sg13cmos5l_a22oi_1
XFILLER_43_216 VPWR VGND sg13cmos5l_decap_8
XFILLER_43_227 VPWR VGND sg13cmos5l_fill_1
XFILLER_12_603 VPWR VGND sg13cmos5l_fill_1
XFILLER_12_614 VPWR VGND sg13cmos5l_decap_4
XFILLER_4_868 VPWR VGND sg13cmos5l_fill_2
XFILLER_16_953 VPWR VGND sg13cmos5l_decap_4
XFILLER_15_452 VPWR VGND sg13cmos5l_fill_2
XFILLER_43_783 VPWR VGND sg13cmos5l_fill_1
XFILLER_42_271 VPWR VGND sg13cmos5l_fill_2
Xclkbuf_3_4__f_clk clkbuf_3_4__f_clk/X clkbuf_0_clk/X VPWR VGND sg13cmos5l_buf_8
X_4490_ _4517_/A _7536_/Q _4490_/B VPWR VGND sg13cmos5l_xnor2_1
X_6160_ _6160_/Y _6160_/A _6160_/B VPWR VGND sg13cmos5l_nor2_1
X_5111_ _5111_/Y _5111_/A _5111_/B VPWR VGND sg13cmos5l_nor2_1
X_6091_ _6126_/A _6099_/B _6091_/B VPWR VGND sg13cmos5l_nor2_1
Xhold1307 _4176_/A _7518_/Q VPWR VGND sg13cmos5l_dlygate4sd3_1
Xhold1329 _5690_/A _7213_/Q VPWR VGND sg13cmos5l_dlygate4sd3_1
Xhold1318 _5879_/A _7283_/Q VPWR VGND sg13cmos5l_dlygate4sd3_1
X_5042_ _5161_/B _5011_/X _5028_/B _4694_/Y VPWR VGND sg13cmos5l_a21oi_1
XFILLER_26_706 VPWR VGND sg13cmos5l_decap_4
X_6993_ _7477_/D _7002_/A _6993_/B VPWR VGND sg13cmos5l_and2_1
X_5944_ _5955_/C _5944_/A _5944_/B VPWR VGND sg13cmos5l_nand2_1
XFILLER_18_290 VPWR VGND sg13cmos5l_decap_8
XFILLER_40_219 VPWR VGND sg13cmos5l_decap_8
X_5875_ _6263_/A _6269_/B VPWR VGND sg13cmos5l_inv_1
X_7614_ _7614_/Q _7635_/CLK _7614_/D _7614_/RESET_B VPWR VGND sg13cmos5l_dfrbpq_1
X_4826_ _4829_/A _4845_/B _4826_/B VPWR VGND sg13cmos5l_nor2_1
XFILLER_33_282 VPWR VGND sg13cmos5l_fill_2
XFILLER_22_989 VPWR VGND sg13cmos5l_fill_2
X_7545_ _7545_/Q _7622_/CLK _7545_/D _7545_/RESET_B VPWR VGND sg13cmos5l_dfrbpq_1
X_4757_ _4757_/Y _4748_/Y _4752_/Y _4755_/X _5065_/B _4756_/Y VPWR VGND sg13cmos5l_a221oi_1
X_4688_ _7601_/D _4728_/A _4795_/A VPWR VGND sg13cmos5l_nor2_1
X_7476_ _7476_/Q _7622_/CLK _7476_/D _7476_/RESET_B VPWR VGND sg13cmos5l_dfrbpq_1
X_7208__532 _7208_/RESET_B VPWR VGND sg13cmos5l_tiehi
X_6427_ _6510_/B _6427_/A _6651_/B VPWR VGND sg13cmos5l_nor2_1
X_6358_ _7347_/D _6425_/A _6411_/C VPWR VGND sg13cmos5l_nor2_1
X_5309_ _5309_/X _5289_/Y _5514_/B _5315_/S VPWR VGND sg13cmos5l_mux2_1
X_6289_ _6289_/Y _6299_/A _6299_/C _6299_/D VPWR VGND sg13cmos5l_nand3_1
X_7215__525 _7215_/RESET_B VPWR VGND sg13cmos5l_tiehi
X_7586__707 _7586_/RESET_B VPWR VGND sg13cmos5l_tiehi
XFILLER_44_558 VPWR VGND sg13cmos5l_fill_1
XFILLER_17_86 VPWR VGND sg13cmos5l_decap_4
XFILLER_8_426 VPWR VGND sg13cmos5l_decap_8
XFILLER_13_989 VPWR VGND sg13cmos5l_decap_4
XFILLER_4_643 VPWR VGND sg13cmos5l_fill_1
XFILLER_4_621 VPWR VGND sg13cmos5l_fill_2
XFILLER_3_120 VPWR VGND sg13cmos5l_fill_2
X_7328__391 _7328_/RESET_B VPWR VGND sg13cmos5l_tiehi
X_7222__518 _7222_/RESET_B VPWR VGND sg13cmos5l_tiehi
X_3990_ _5317_/A _7184_/Q VPWR VGND sg13cmos5l_inv_1
X_5660_ _5664_/A _5660_/A _5660_/B _5660_/C VPWR VGND sg13cmos5l_nor3_1
X_4611_ _4612_/B _4611_/A _4611_/B VPWR VGND sg13cmos5l_or2_1
X_5591_ _5616_/B _5616_/A _5590_/Y _5578_/Y VPWR VGND sg13cmos5l_o21ai_1
XFILLER_8_971 VPWR VGND sg13cmos5l_decap_4
XFILLER_8_993 VPWR VGND sg13cmos5l_decap_8
X_7330_ _7330_/Q _7332_/CLK _7330_/D _7330_/RESET_B VPWR VGND sg13cmos5l_dfrbpq_1
X_4542_ _4542_/X _4540_/C _4541_/Y _4540_/Y VPWR VGND sg13cmos5l_a21o_1
X_4473_ _4473_/Y _4473_/A VPWR VGND sg13cmos5l_inv_1
XFILLER_7_470 VPWR VGND sg13cmos5l_fill_2
X_7261_ _7261_/Q _7622_/CLK _7261_/D _7261_/RESET_B VPWR VGND sg13cmos5l_dfrbpq_1
X_6212_ _6229_/B _6230_/B _6230_/C VPWR VGND sg13cmos5l_nand2_1
X_7192_ _7192_/Q _7635_/CLK _7192_/D _7192_/RESET_B VPWR VGND sg13cmos5l_dfrbpq_1
X_6143_ _6143_/Y _7295_/Q _6143_/B _6159_/B VPWR VGND sg13cmos5l_nor3_1
Xhold1104 _7104_/A _4323_/Y VPWR VGND sg13cmos5l_dlygate4sd3_1
X_6074_ _6075_/C _7315_/Q _7316_/Q _7317_/Q VPWR VGND sg13cmos5l_o21ai_1
Xhold1115 _6541_/A _7391_/Q VPWR VGND sg13cmos5l_dlygate4sd3_1
XFILLER_39_842 VPWR VGND sg13cmos5l_fill_1
Xhold1137 _3988_/A _7217_/Q VPWR VGND sg13cmos5l_dlygate4sd3_1
Xhold1148 _3996_/A _7145_/Q VPWR VGND sg13cmos5l_dlygate4sd3_1
X_5025_ _5117_/A _4673_/Y _5020_/Y _5023_/Y _5024_/Y VPWR VGND sg13cmos5l_a22oi_1
Xhold1126 _4007_/A _7576_/Q VPWR VGND sg13cmos5l_dlygate4sd3_1
Xhold1159 _4611_/A _7587_/Q VPWR VGND sg13cmos5l_dlygate4sd3_1
X_6976_ _6976_/Y _6976_/A _6976_/B VPWR VGND sg13cmos5l_nor2_1
XFILLER_13_208 VPWR VGND sg13cmos5l_fill_1
X_5927_ _5999_/B _5676_/X _5917_/X _5919_/Y _5926_/Y VPWR VGND sg13cmos5l_a22oi_1
XFILLER_21_230 VPWR VGND sg13cmos5l_fill_2
XFILLER_22_731 VPWR VGND sg13cmos5l_fill_1
X_5858_ _5860_/C _7278_/Q _7279_/Q _7280_/Q VPWR VGND sg13cmos5l_o21ai_1
XFILLER_10_915 VPWR VGND sg13cmos5l_decap_8
XFILLER_22_764 VPWR VGND sg13cmos5l_fill_2
XFILLER_6_908 VPWR VGND sg13cmos5l_fill_1
X_5789_ _5789_/X _5712_/Y _5671_/A _5827_/S VPWR VGND sg13cmos5l_mux2_1
X_4809_ _4844_/B _4835_/A _4835_/B VPWR VGND sg13cmos5l_nand2_1
X_7528_ _7528_/Q _7560_/CLK _7528_/D _7528_/RESET_B VPWR VGND sg13cmos5l_dfrbpq_1
X_7459_ _7459_/Q _7490_/CLK _7459_/D _7459_/RESET_B VPWR VGND sg13cmos5l_dfrbpq_1
X_7501__318 _7501_/RESET_B VPWR VGND sg13cmos5l_tiehi
Xhold971 _5085_/B _7146_/Q VPWR VGND sg13cmos5l_dlygate4sd3_1
Xhold982 _7615_/D _4772_/Y VPWR VGND sg13cmos5l_dlygate4sd3_1
Xhold960 _6976_/A _7493_/Q VPWR VGND sg13cmos5l_dlygate4sd3_1
Xhold993 _4574_/A _7560_/Q VPWR VGND sg13cmos5l_dlygate4sd3_1
XFILLER_49_639 VPWR VGND sg13cmos5l_decap_4
XFILLER_45_812 VPWR VGND sg13cmos5l_fill_1
Xheichips26_dna_sequencer uio_out[3] VPWR VGND sg13cmos5l_tielo
XFILLER_44_311 VPWR VGND sg13cmos5l_fill_1
XFILLER_17_514 VPWR VGND sg13cmos5l_fill_1
XFILLER_45_878 VPWR VGND sg13cmos5l_decap_4
XFILLER_44_40 VPWR VGND sg13cmos5l_fill_1
X_7289__445 _7289_/RESET_B VPWR VGND sg13cmos5l_tiehi
XFILLER_40_572 VPWR VGND sg13cmos5l_decap_8
XFILLER_8_223 VPWR VGND sg13cmos5l_decap_8
XFILLER_5_952 VPWR VGND sg13cmos5l_decap_8
X_7398__164 _7398_/D VPWR VGND sg13cmos5l_tielo
X_6830_ _7452_/D _6830_/A _6891_/A VPWR VGND sg13cmos5l_and2_1
X_6761_ _6761_/Y _6761_/A _6761_/B VPWR VGND sg13cmos5l_nor2_1
XFILLER_23_539 VPWR VGND sg13cmos5l_fill_2
X_3973_ _3973_/Y _7356_/Q VPWR VGND sg13cmos5l_inv_1
X_5712_ _5712_/Y _5712_/A _5712_/B VPWR VGND sg13cmos5l_nand2_1
X_6692_ _6692_/Y _6682_/A _6691_/B _6691_/Y VPWR VGND sg13cmos5l_o21ai_1
XFILLER_31_561 VPWR VGND sg13cmos5l_fill_2
X_5643_ _5643_/X _5650_/B _5648_/C _5907_/A VPWR VGND sg13cmos5l_a21o_1
X_5574_ _5574_/Y _5584_/A _5574_/B VPWR VGND sg13cmos5l_nand2_1
X_7313_ _7313_/Q clkload7/A _7313_/D _7313_/RESET_B VPWR VGND sg13cmos5l_dfrbpq_1
X_4525_ _4525_/Y _7598_/Q _4527_/A VPWR VGND sg13cmos5l_nand2_1
X_4456_ _4456_/Y _4783_/A _4470_/B VPWR VGND sg13cmos5l_nand2_1
X_7244_ _7244_/Q _7307_/CLK _7244_/D _7244_/RESET_B VPWR VGND sg13cmos5l_dfrbpq_1
X_7205__535 _7205_/RESET_B VPWR VGND sg13cmos5l_tiehi
X_4387_ _4388_/B _4387_/A _4387_/B VPWR VGND sg13cmos5l_xnor2_1
X_7175_ _7175_/Q _7200_/CLK _7175_/D _7175_/RESET_B VPWR VGND sg13cmos5l_dfrbpq_1
X_6126_ _6127_/B _6126_/A _6126_/B VPWR VGND sg13cmos5l_nor2_1
X_6057_ _7309_/D _6057_/A _6057_/B VPWR VGND sg13cmos5l_nor2_1
XFILLER_38_171 VPWR VGND sg13cmos5l_fill_2
X_5008_ _5013_/A _4664_/B _5039_/A _5002_/X _5006_/Y _5007_/X VPWR VGND sg13cmos5l_a221oi_1
XFILLER_27_823 VPWR VGND sg13cmos5l_decap_4
XFILLER_27_856 VPWR VGND sg13cmos5l_fill_1
XFILLER_14_517 VPWR VGND sg13cmos5l_decap_8
XFILLER_14_528 VPWR VGND sg13cmos5l_fill_2
X_7212__528 _7212_/RESET_B VPWR VGND sg13cmos5l_tiehi
X_6959_ _6959_/Y _6971_/B _6813_/B _6810_/B _7489_/Q VPWR VGND sg13cmos5l_a22oi_1
XFILLER_30_31 VPWR VGND sg13cmos5l_fill_2
XFILLER_2_955 VPWR VGND sg13cmos5l_decap_8
Xhold790 _4352_/B _7514_/Q VPWR VGND sg13cmos5l_dlygate4sd3_1
XFILLER_49_436 VPWR VGND sg13cmos5l_fill_2
XFILLER_18_801 VPWR VGND sg13cmos5l_fill_1
XFILLER_17_322 VPWR VGND sg13cmos5l_fill_2
X_7453__670 _7453_/RESET_B VPWR VGND sg13cmos5l_tiehi
XFILLER_45_653 VPWR VGND sg13cmos5l_decap_4
XFILLER_44_163 VPWR VGND sg13cmos5l_fill_1
XFILLER_17_388 VPWR VGND sg13cmos5l_decap_8
XFILLER_32_314 VPWR VGND sg13cmos5l_fill_1
XFILLER_33_826 VPWR VGND sg13cmos5l_fill_1
XFILLER_41_870 VPWR VGND sg13cmos5l_decap_8
XFILLER_9_510 VPWR VGND sg13cmos5l_decap_8
XFILLER_40_380 VPWR VGND sg13cmos5l_decap_4
XFILLER_9_554 VPWR VGND sg13cmos5l_decap_8
X_7460__641 _7460_/RESET_B VPWR VGND sg13cmos5l_tiehi
X_5290_ _5290_/Y _7147_/Q _5290_/B _5297_/C VPWR VGND sg13cmos5l_nor3_1
X_4310_ _4310_/Y _4575_/A _7556_/Q _4324_/S VPWR VGND sg13cmos5l_nand3b_1
X_4241_ _4494_/A _7560_/Q _4241_/B VPWR VGND sg13cmos5l_xor2_1
X_4172_ _4172_/Y _7510_/Q _7481_/Q VPWR VGND sg13cmos5l_xnor2_1
XFILLER_49_981 VPWR VGND sg13cmos5l_decap_8
XFILLER_36_642 VPWR VGND sg13cmos5l_fill_2
X_6813_ _6813_/Y _6816_/A _6813_/B VPWR VGND sg13cmos5l_nor2_1
X_6744_ _6835_/A _6716_/Y _6728_/X _6731_/Y VPWR VGND sg13cmos5l_o21ai_1
XFILLER_11_509 VPWR VGND sg13cmos5l_decap_4
X_3956_ _4788_/A _3956_/A VPWR VGND sg13cmos5l_inv_1
X_6675_ _6675_/X _7423_/Q _6677_/B _6678_/B VPWR VGND sg13cmos5l_a21o_1
X_5626_ _5627_/B _5600_/Y _5622_/Y _5558_/B VPWR VGND sg13cmos5l_o21ai_1
X_3887_ _3887_/Y _3887_/A VPWR VGND sg13cmos5l_inv_1
XFILLER_3_708 VPWR VGND sg13cmos5l_fill_2
X_5557_ _7229_/D _5557_/A _5558_/B VPWR VGND sg13cmos5l_and2_1
X_4508_ _4508_/X _4508_/A _4508_/B VPWR VGND sg13cmos5l_and2_1
X_5488_ _5488_/X _5488_/A _5488_/B VPWR VGND sg13cmos5l_or2_1
XFILLER_2_218 VPWR VGND sg13cmos5l_fill_2
XFILLER_2_229 VPWR VGND sg13cmos5l_fill_1
X_4439_ _4439_/Y _4433_/Y _4438_/Y _4428_/Y VPWR VGND sg13cmos5l_o21ai_1
X_7227_ _7227_/Q _7622_/CLK _7227_/D _7227_/RESET_B VPWR VGND sg13cmos5l_dfrbpq_1
X_7279__455 _7279_/RESET_B VPWR VGND sg13cmos5l_tiehi
X_7158_ _7158_/Q _7634_/CLK _7158_/D _7158_/RESET_B VPWR VGND sg13cmos5l_dfrbpq_1
X_6109_ _7315_/D _6109_/A _6180_/A VPWR VGND sg13cmos5l_nor2_1
X_7089_ _7089_/Y _3866_/Y _7085_/A _7088_/Y VPWR VGND sg13cmos5l_a21oi_1
XFILLER_46_417 VPWR VGND sg13cmos5l_decap_4
XFILLER_18_108 VPWR VGND sg13cmos5l_fill_2
XFILLER_14_358 VPWR VGND sg13cmos5l_fill_2
XFILLER_23_892 VPWR VGND sg13cmos5l_fill_1
X_7628__662 _7628_/RESET_B VPWR VGND sg13cmos5l_tiehi
XFILLER_10_553 VPWR VGND sg13cmos5l_decap_4
X_7286__448 _7286_/RESET_B VPWR VGND sg13cmos5l_tiehi
XFILLER_6_546 VPWR VGND sg13cmos5l_decap_4
X_7147__599 _7147_/RESET_B VPWR VGND sg13cmos5l_tiehi
XFILLER_49_233 VPWR VGND sg13cmos5l_fill_1
XFILLER_49_222 VPWR VGND sg13cmos5l_decap_8
X_7635__655 _7635_/RESET_B VPWR VGND sg13cmos5l_tiehi
XFILLER_46_951 VPWR VGND sg13cmos5l_decap_8
X_4790_ _4790_/Y _4684_/B _4793_/A VPWR VGND sg13cmos5l_nand2b_1
X_6460_ _6460_/Y _6465_/A _6508_/A _6468_/A _7369_/Q VPWR VGND sg13cmos5l_a22oi_1
X_7408__288 _7408_/RESET_B VPWR VGND sg13cmos5l_tiehi
X_5411_ _7201_/D _5393_/X _5401_/Y _5410_/Y VPWR VGND sg13cmos5l_a21oi_1
X_6391_ _6391_/Y hold908/X _6653_/A2 _6391_/B1 VPWR VGND sg13cmos5l_o21ai_1
X_5342_ _5342_/Y _5342_/A _5342_/B VPWR VGND sg13cmos5l_nor2_1
X_7012_ _7012_/Y _7012_/A _7042_/A VPWR VGND sg13cmos5l_nor2_1
X_5273_ _7175_/D _5332_/B _5372_/A VPWR VGND sg13cmos5l_and2_1
X_4224_ _4224_/Y _4570_/A _4261_/A VPWR VGND sg13cmos5l_nand2_1
X_7202__538 _7202_/RESET_B VPWR VGND sg13cmos5l_tiehi
X_4155_ _4155_/Y _4155_/A _4155_/B VPWR VGND sg13cmos5l_nor2_1
XFILLER_37_951 VPWR VGND sg13cmos5l_decap_8
X_4086_ _7517_/D _4144_/A _7071_/A VPWR VGND sg13cmos5l_nor2_1
XFILLER_36_450 VPWR VGND sg13cmos5l_decap_4
XFILLER_23_100 VPWR VGND sg13cmos5l_fill_1
XFILLER_23_122 VPWR VGND sg13cmos5l_fill_1
XFILLER_12_807 VPWR VGND sg13cmos5l_fill_1
X_4988_ _7132_/D _5038_/A _5109_/A VPWR VGND sg13cmos5l_nor2_1
XFILLER_11_306 VPWR VGND sg13cmos5l_decap_4
X_7385__314 _7385_/RESET_B VPWR VGND sg13cmos5l_tiehi
X_3939_ _5776_/A _3939_/A VPWR VGND sg13cmos5l_inv_1
X_6727_ _6937_/A _6730_/B _6727_/B VPWR VGND sg13cmos5l_nand2b_1
X_6658_ _7418_/D _6659_/A _6658_/B VPWR VGND sg13cmos5l_and2_1
X_5609_ _5618_/A _5616_/B _5609_/B VPWR VGND sg13cmos5l_nand2b_1
X_6589_ _6589_/Y _6590_/B VPWR VGND sg13cmos5l_inv_1
XFILLER_3_516 VPWR VGND sg13cmos5l_decap_4
XFILLER_3_538 VPWR VGND sg13cmos5l_decap_8
XFILLER_11_88 VPWR VGND sg13cmos5l_decap_4
XFILLER_36_52 VPWR VGND sg13cmos5l_fill_2
XFILLER_14_177 VPWR VGND sg13cmos5l_fill_2
XFILLER_10_372 VPWR VGND sg13cmos5l_fill_1
X_7403__163 _7403_/D VPWR VGND sg13cmos5l_tielo
X_5960_ _5960_/Y _7258_/Q _5960_/B VPWR VGND sg13cmos5l_nor2_1
X_4911_ _4912_/C _4911_/A _6363_/A VPWR VGND sg13cmos5l_nand2_1
X_5891_ _5892_/B _5867_/B _5888_/S _5890_/Y VPWR VGND sg13cmos5l_o21ai_1
X_7630_ _7630_/Q _7630_/CLK _7630_/D _7630_/RESET_B VPWR VGND sg13cmos5l_dfrbpq_1
XFILLER_20_103 VPWR VGND sg13cmos5l_decap_4
X_4842_ _4842_/Y _4842_/A _4842_/B VPWR VGND sg13cmos5l_nor2_1
X_7269__465 _7269_/RESET_B VPWR VGND sg13cmos5l_tiehi
X_4773_ _7617_/D _5096_/A _4773_/B VPWR VGND sg13cmos5l_and2_1
X_7561_ _7561_/Q _7617_/CLK _7561_/D _7561_/RESET_B VPWR VGND sg13cmos5l_dfrbpq_1
X_6512_ _6512_/Y _6534_/A _6512_/B VPWR VGND sg13cmos5l_nand2_1
X_7492_ _7492_/Q _7555_/CLK _7492_/D _7492_/RESET_B VPWR VGND sg13cmos5l_dfrbpq_1
X_6443_ _6443_/Y _6604_/A _6438_/Y _6442_/Y VPWR VGND sg13cmos5l_o21ai_1
XFILLER_9_192 VPWR VGND sg13cmos5l_decap_4
X_6374_ _6374_/Y _6483_/B _6376_/B VPWR VGND sg13cmos5l_nand2_1
X_5325_ _7188_/D _3889_/Y _5325_/A2 _5324_/Y VPWR VGND sg13cmos5l_a21oi_1
X_5256_ _5260_/A _5256_/A _5256_/B _5256_/C _5256_/D VPWR VGND sg13cmos5l_or4_1
X_4207_ _4209_/B _4207_/A _4207_/B _4207_/C VPWR VGND sg13cmos5l_nor3_1
X_7276__458 _7276_/RESET_B VPWR VGND sg13cmos5l_tiehi
X_5187_ _5187_/X _5221_/A _5189_/B _5187_/C VPWR VGND sg13cmos5l_and3_1
X_4138_ _4138_/Y _7468_/Q _7467_/Q VPWR VGND sg13cmos5l_xnor2_1
XFILLER_16_409 VPWR VGND sg13cmos5l_decap_8
X_4069_ _4070_/B _7647_/Q _4064_/A _7649_/Q VPWR VGND sg13cmos5l_a21oi_1
XFILLER_25_965 VPWR VGND sg13cmos5l_fill_2
XFILLER_12_626 VPWR VGND sg13cmos5l_fill_2
XFILLER_7_118 VPWR VGND sg13cmos5l_fill_2
X_7625__665 _7625_/RESET_B VPWR VGND sg13cmos5l_tiehi
XFILLER_4_803 VPWR VGND sg13cmos5l_fill_1
XFILLER_4_836 VPWR VGND sg13cmos5l_fill_1
XFILLER_3_379 VPWR VGND sg13cmos5l_fill_1
X_7632__658 _7632_/RESET_B VPWR VGND sg13cmos5l_tiehi
XFILLER_47_567 VPWR VGND sg13cmos5l_decap_8
XFILLER_35_707 VPWR VGND sg13cmos5l_decap_8
XFILLER_16_943 VPWR VGND sg13cmos5l_fill_2
XFILLER_34_239 VPWR VGND sg13cmos5l_fill_2
XFILLER_7_685 VPWR VGND sg13cmos5l_decap_4
XFILLER_6_195 VPWR VGND sg13cmos5l_decap_8
X_5110_ _5111_/B _5110_/A _5155_/A VPWR VGND sg13cmos5l_nor2b_1
X_6090_ _6091_/B _3926_/Y _6087_/B _3925_/Y VPWR VGND sg13cmos5l_a21oi_1
X_5041_ _7139_/D _5102_/B _5155_/A VPWR VGND sg13cmos5l_nor2_1
Xhold1308 _4195_/A _4194_/Y VPWR VGND sg13cmos5l_dlygate4sd3_1
Xhold1319 _5429_/A _7208_/Q VPWR VGND sg13cmos5l_dlygate4sd3_1
X_6992_ _6992_/Y _6980_/B hold877/X _6958_/A VPWR VGND sg13cmos5l_a21oi_1
X_5943_ _5944_/B _7314_/Q _5955_/A _7257_/Q _6194_/A VPWR VGND sg13cmos5l_a22oi_1
X_5874_ _6269_/B _5961_/A _5877_/B VPWR VGND sg13cmos5l_nor2_1
XFILLER_33_250 VPWR VGND sg13cmos5l_fill_1
XFILLER_34_784 VPWR VGND sg13cmos5l_fill_1
X_7613_ _7613_/Q _7635_/CLK _7613_/D _7613_/RESET_B VPWR VGND sg13cmos5l_dfrbpq_1
X_4825_ _4825_/Y _4825_/A _4825_/B VPWR VGND sg13cmos5l_xnor2_1
XFILLER_33_294 VPWR VGND sg13cmos5l_fill_1
XFILLER_21_489 VPWR VGND sg13cmos5l_fill_2
X_7544_ _7544_/Q _7617_/CLK _7544_/D _7544_/RESET_B VPWR VGND sg13cmos5l_dfrbpq_1
X_4756_ _4756_/Y _7613_/Q _4756_/B VPWR VGND sg13cmos5l_nor2_1
X_7475_ _7475_/Q _7555_/CLK _7475_/D _7475_/RESET_B VPWR VGND sg13cmos5l_dfrbpq_1
X_4687_ _4795_/A _4672_/X _4685_/X _4686_/Y _4675_/Y VPWR VGND sg13cmos5l_a22oi_1
X_6426_ _7370_/D _6396_/B _6426_/A2 _7348_/D VPWR VGND sg13cmos5l_a21o_1
X_6357_ _6411_/C _6341_/Y _6356_/A _6356_/Y VPWR VGND sg13cmos5l_o21ai_1
XFILLER_0_316 VPWR VGND sg13cmos5l_decap_4
X_5308_ _5315_/S _5304_/Y _5306_/Y _5307_/Y VPWR VGND sg13cmos5l_a21oi_1
X_6288_ _6303_/S _6293_/A _6293_/C _6293_/D VPWR VGND sg13cmos5l_nor3_1
X_5239_ _5245_/C _7137_/Q _7136_/Q _7138_/Q VPWR VGND sg13cmos5l_o21ai_1
XFILLER_16_239 VPWR VGND sg13cmos5l_decap_4
XFILLER_40_721 VPWR VGND sg13cmos5l_fill_1
XFILLER_13_913 VPWR VGND sg13cmos5l_decap_4
X_7150__595 _7150_/RESET_B VPWR VGND sg13cmos5l_tiehi
XFILLER_4_677 VPWR VGND sg13cmos5l_fill_2
XFILLER_4_666 VPWR VGND sg13cmos5l_decap_8
XFILLER_3_176 VPWR VGND sg13cmos5l_decap_8
XFILLER_39_309 VPWR VGND sg13cmos5l_fill_2
XFILLER_47_364 VPWR VGND sg13cmos5l_decap_4
XFILLER_47_397 VPWR VGND sg13cmos5l_fill_1
XFILLER_15_250 VPWR VGND sg13cmos5l_fill_1
X_4610_ _4613_/B _4505_/Y _4464_/Y _4619_/S VPWR VGND sg13cmos5l_mux2_1
XFILLER_8_950 VPWR VGND sg13cmos5l_decap_8
XFILLER_12_990 VPWR VGND sg13cmos5l_fill_1
X_5590_ _5590_/Y _7234_/Q _5620_/B _5579_/Y VPWR VGND sg13cmos5l_o21ai_1
X_7266__468 _7266_/RESET_B VPWR VGND sg13cmos5l_tiehi
X_4541_ _4541_/Y _7598_/Q _4786_/A VPWR VGND sg13cmos5l_nor2_1
X_4472_ _4473_/A _4446_/B _4457_/S _4471_/Y VPWR VGND sg13cmos5l_o21ai_1
X_7260_ _7260_/Q _7272_/CLK _7260_/D _7260_/RESET_B VPWR VGND sg13cmos5l_dfrbpq_1
X_6211_ _6230_/C _6224_/A _6224_/B VPWR VGND sg13cmos5l_nor2_1
X_7191_ _7191_/Q _7611_/CLK _7191_/D _7191_/RESET_B VPWR VGND sg13cmos5l_dfrbpq_1
X_6142_ _6142_/Y _6160_/B _6141_/Y _6139_/Y VPWR VGND sg13cmos5l_a21oi_1
Xhold1105 _7105_/B _7104_/Y VPWR VGND sg13cmos5l_dlygate4sd3_1
X_6073_ _6114_/A _7341_/Q _7340_/Q VPWR VGND sg13cmos5l_xnor2_1
Xhold1138 _3969_/A _7256_/Q VPWR VGND sg13cmos5l_dlygate4sd3_1
Xhold1149 _5084_/B _5083_/X VPWR VGND sg13cmos5l_dlygate4sd3_1
X_5024_ _5024_/Y _5024_/A _5039_/B VPWR VGND sg13cmos5l_nor2_1
Xhold1127 _4555_/B _4554_/X VPWR VGND sg13cmos5l_dlygate4sd3_1
Xhold1116 hold1116/X _6548_/Y VPWR VGND sg13cmos5l_dlygate4sd3_1
XFILLER_38_375 VPWR VGND sg13cmos5l_fill_2
X_6975_ _6975_/Y _6986_/B _6973_/A _6974_/Y VPWR VGND sg13cmos5l_a21oi_1
X_5926_ _5926_/Y _5907_/B _5907_/C _5930_/B VPWR VGND sg13cmos5l_a21oi_1
X_5857_ _5887_/A _7310_/Q _7311_/Q VPWR VGND sg13cmos5l_xnor2_1
XFILLER_10_927 VPWR VGND sg13cmos5l_decap_8
XFILLER_10_938 VPWR VGND sg13cmos5l_fill_1
X_5788_ _5827_/S _5687_/B _5831_/B _5787_/Y VPWR VGND sg13cmos5l_o21ai_1
X_4808_ _4844_/A _7628_/Q _4835_/B VPWR VGND sg13cmos5l_xnor2_1
X_7527_ _7527_/Q _7571_/CLK _7527_/D _7527_/RESET_B VPWR VGND sg13cmos5l_dfrbpq_1
X_4739_ _4739_/Y _4739_/A _7575_/Q VPWR VGND sg13cmos5l_nand2_1
X_7622__668 _7622_/RESET_B VPWR VGND sg13cmos5l_tiehi
X_7458_ _7458_/Q _7513_/CLK _7458_/D _7458_/RESET_B VPWR VGND sg13cmos5l_dfrbpq_1
X_6409_ _6410_/B _6409_/A _6409_/B VPWR VGND sg13cmos5l_nor2_1
Xhold961 _4024_/A _7371_/Q VPWR VGND sg13cmos5l_dlygate4sd3_1
X_7592__701 _7592_/RESET_B VPWR VGND sg13cmos5l_tiehi
Xhold972 hold972/X _5085_/Y VPWR VGND sg13cmos5l_dlygate4sd3_1
Xhold950 _3948_/A _7165_/Q VPWR VGND sg13cmos5l_dlygate4sd3_1
X_7389_ _7389_/Q clkload8/A _7389_/D _7389_/RESET_B VPWR VGND sg13cmos5l_dfrbpq_1
Xhold994 _5317_/B _7183_/Q VPWR VGND sg13cmos5l_dlygate4sd3_1
Xhold983 _5547_/B _7185_/Q VPWR VGND sg13cmos5l_dlygate4sd3_1
XFILLER_0_157 VPWR VGND sg13cmos5l_fill_1
XFILLER_28_64 VPWR VGND sg13cmos5l_fill_1
XFILLER_44_85 VPWR VGND sg13cmos5l_fill_1
XFILLER_8_268 VPWR VGND sg13cmos5l_decap_4
XFILLER_5_920 VPWR VGND sg13cmos5l_fill_1
XFILLER_0_680 VPWR VGND sg13cmos5l_decap_8
XFILLER_0_691 VPWR VGND sg13cmos5l_fill_1
XFILLER_36_879 VPWR VGND sg13cmos5l_fill_1
XFILLER_35_356 VPWR VGND sg13cmos5l_decap_4
X_6760_ _6760_/X _6761_/A _6761_/B _6758_/Y VPWR VGND sg13cmos5l_a21o_1
XFILLER_35_389 VPWR VGND sg13cmos5l_fill_2
X_5711_ _5712_/B _5696_/A _5719_/S VPWR VGND sg13cmos5l_nand2b_1
X_3972_ _5951_/B _3972_/A VPWR VGND sg13cmos5l_inv_1
XFILLER_16_581 VPWR VGND sg13cmos5l_decap_8
X_6691_ _6691_/Y _6691_/A _6691_/B VPWR VGND sg13cmos5l_nand2_1
X_5642_ _5677_/A _5650_/B _5648_/C VPWR VGND sg13cmos5l_nand2_1
X_5573_ _5573_/Y _5604_/A VPWR VGND sg13cmos5l_inv_1
X_7312_ _7312_/Q clkload7/A _7312_/D _7312_/RESET_B VPWR VGND sg13cmos5l_dfrbpq_1
X_4524_ _4524_/Y _4787_/A _7542_/Q _7541_/Q _4786_/A _4523_/Y VPWR VGND sg13cmos5l_a221oi_1
X_4455_ _4457_/S _4462_/B _4462_/C VPWR VGND sg13cmos5l_nand2_1
X_7243_ _7243_/Q _7307_/CLK _7243_/D _7243_/RESET_B VPWR VGND sg13cmos5l_dfrbpq_1
X_4386_ _4387_/B _7554_/Q _4386_/B VPWR VGND sg13cmos5l_xor2_1
X_7174_ _7174_/Q _7200_/CLK _7174_/D _7174_/RESET_B VPWR VGND sg13cmos5l_dfrbpq_1
X_6125_ _7319_/D _6331_/A _6286_/A VPWR VGND sg13cmos5l_nor2_1
X_6056_ _6057_/B _6005_/Y _6054_/Y _5990_/B VPWR VGND sg13cmos5l_o21ai_1
X_7650__352 _7650_/RESET_B VPWR VGND sg13cmos5l_tiehi
X_5007_ _5007_/X _5007_/A _5007_/B _5007_/C VPWR VGND sg13cmos5l_and3_1
XFILLER_42_838 VPWR VGND sg13cmos5l_decap_8
X_6958_ _7470_/D _6958_/A _7047_/B VPWR VGND sg13cmos5l_nor2_1
XFILLER_41_337 VPWR VGND sg13cmos5l_decap_8
X_5909_ _5914_/B _7251_/Q _5910_/B VPWR VGND sg13cmos5l_nand2b_1
X_6889_ _6889_/Y _6889_/A _6889_/B _6889_/C VPWR VGND sg13cmos5l_nor3_1
XFILLER_5_238 VPWR VGND sg13cmos5l_decap_8
XFILLER_2_934 VPWR VGND sg13cmos5l_decap_8
Xhold791 _6396_/A _7129_/Q VPWR VGND sg13cmos5l_dlygate4sd3_1
Xhold780 _6505_/B _7362_/Q VPWR VGND sg13cmos5l_dlygate4sd3_1
XFILLER_7_1016 VPWR VGND sg13cmos5l_decap_8
XFILLER_7_1027 VPWR VGND sg13cmos5l_fill_2
XFILLER_32_304 VPWR VGND sg13cmos5l_decap_4
XFILLER_33_805 VPWR VGND sg13cmos5l_fill_2
XFILLER_13_584 VPWR VGND sg13cmos5l_decap_8
XFILLER_40_392 VPWR VGND sg13cmos5l_decap_8
X_4240_ _4269_/B _7560_/Q _4241_/B VPWR VGND sg13cmos5l_xnor2_1
X_4171_ _4171_/Y _4171_/A _4171_/B VPWR VGND sg13cmos5l_nand2_1
XFILLER_49_960 VPWR VGND sg13cmos5l_decap_8
XFILLER_27_109 VPWR VGND sg13cmos5l_fill_1
X_6812_ _7440_/D _6812_/A _6809_/Y VPWR VGND sg13cmos5l_nor2b_1
XFILLER_17_890 VPWR VGND sg13cmos5l_fill_1
XFILLER_35_186 VPWR VGND sg13cmos5l_fill_1
X_6743_ _7432_/D _6891_/A _6870_/A VPWR VGND sg13cmos5l_and2_1
X_3955_ _5097_/A _3955_/A VPWR VGND sg13cmos5l_inv_1
X_6674_ _6678_/B _6674_/A _6677_/B VPWR VGND sg13cmos5l_nor2_1
X_5625_ _5627_/A _5625_/A _5622_/Y VPWR VGND sg13cmos5l_nor2b_1
X_3886_ _3886_/Y _5584_/A VPWR VGND sg13cmos5l_inv_1
X_5556_ _7228_/D _7113_/A _5574_/B VPWR VGND sg13cmos5l_and2_1
X_4507_ _4508_/B _4507_/A _4513_/B VPWR VGND sg13cmos5l_nor2b_1
X_5487_ _5488_/B _5231_/B _5501_/B _5485_/X VPWR VGND sg13cmos5l_a21o_1
X_4438_ _4438_/Y _4433_/A _4433_/B _4435_/Y _4437_/X VPWR VGND sg13cmos5l_a22oi_1
X_7226_ _7226_/Q _7272_/CLK _7226_/D _7226_/RESET_B VPWR VGND sg13cmos5l_dfrbpq_1
X_7157_ _7157_/Q _7635_/CLK _7157_/D _7157_/RESET_B VPWR VGND sg13cmos5l_dfrbpq_1
X_4369_ _4369_/Y _7545_/Q _7513_/Q VPWR VGND sg13cmos5l_xnor2_1
X_6108_ _6108_/Y _6107_/B _6108_/B VPWR VGND sg13cmos5l_nand2b_1
X_7088_ _7088_/Y _7504_/Q _7088_/B VPWR VGND sg13cmos5l_nand2_1
X_6039_ _6040_/B _6039_/A _6039_/B VPWR VGND sg13cmos5l_xnor2_1
XFILLER_22_370 VPWR VGND sg13cmos5l_fill_1
XFILLER_23_871 VPWR VGND sg13cmos5l_fill_1
XFILLER_41_31 VPWR VGND sg13cmos5l_fill_2
XFILLER_6_536 VPWR VGND sg13cmos5l_fill_1
XFILLER_9_0 VPWR VGND sg13cmos5l_fill_2
XFILLER_49_201 VPWR VGND sg13cmos5l_decap_8
XFILLER_49_256 VPWR VGND sg13cmos5l_decap_8
XFILLER_37_429 VPWR VGND sg13cmos5l_fill_2
XFILLER_46_930 VPWR VGND sg13cmos5l_decap_8
XFILLER_18_632 VPWR VGND sg13cmos5l_fill_2
XFILLER_14_882 VPWR VGND sg13cmos5l_decap_8
XFILLER_20_307 VPWR VGND sg13cmos5l_fill_2
X_7484__428 _7484_/RESET_B VPWR VGND sg13cmos5l_tiehi
XFILLER_32_178 VPWR VGND sg13cmos5l_decap_8
XFILLER_9_352 VPWR VGND sg13cmos5l_fill_2
XFILLER_12_1021 VPWR VGND sg13cmos5l_decap_8
X_5410_ _5410_/Y _5390_/Y _5401_/Y _5332_/B VPWR VGND sg13cmos5l_o21ai_1
X_6390_ _7360_/D _3872_/Y _6653_/A2 _6389_/Y VPWR VGND sg13cmos5l_a21oi_1
X_5341_ _5342_/B _5341_/A _5391_/A VPWR VGND sg13cmos5l_nor2b_1
X_7011_ _7011_/Y _7008_/Y _7009_/Y _7010_/Y VPWR VGND sg13cmos5l_o21ai_1
X_5272_ _5372_/A _5261_/Y _5271_/X _5270_/Y VPWR VGND sg13cmos5l_o21ai_1
X_4223_ _4498_/A _7561_/Q _4223_/B VPWR VGND sg13cmos5l_xor2_1
X_4154_ _4154_/Y _4154_/A _4160_/A VPWR VGND sg13cmos5l_nand2_1
XFILLER_29_919 VPWR VGND sg13cmos5l_fill_1
XFILLER_28_407 VPWR VGND sg13cmos5l_fill_2
X_4085_ _7516_/D _4154_/A _7072_/A VPWR VGND sg13cmos5l_and2_1
XFILLER_37_985 VPWR VGND sg13cmos5l_decap_4
X_6726_ _6727_/B _7459_/Q _7004_/A _7460_/Q VPWR VGND sg13cmos5l_o21ai_1
X_4987_ _5109_/A _4972_/X _4985_/X _4986_/Y _4975_/Y VPWR VGND sg13cmos5l_a22oi_1
X_3938_ _5777_/A _3938_/A VPWR VGND sg13cmos5l_inv_1
X_3869_ _3869_/Y _3869_/A VPWR VGND sg13cmos5l_inv_1
X_6657_ _6657_/Y _3868_/Y _6657_/A2 _6656_/Y VPWR VGND sg13cmos5l_a21oi_1
X_6588_ _6590_/B _6571_/B _6777_/A _6588_/S VPWR VGND sg13cmos5l_mux2_1
X_5608_ _5608_/Y _5608_/A _5608_/B VPWR VGND sg13cmos5l_xnor2_1
X_5539_ _5540_/B _5520_/Y _5731_/B _5541_/S VPWR VGND sg13cmos5l_mux2_1
X_7209_ _7209_/Q _7277_/CLK _7209_/D _7209_/RESET_B VPWR VGND sg13cmos5l_dfrbpq_1
XFILLER_46_248 VPWR VGND sg13cmos5l_decap_4
XFILLER_43_944 VPWR VGND sg13cmos5l_fill_1
XFILLER_43_933 VPWR VGND sg13cmos5l_decap_8
XFILLER_15_635 VPWR VGND sg13cmos5l_fill_1
XFILLER_42_487 VPWR VGND sg13cmos5l_decap_4
XFILLER_35_1021 VPWR VGND sg13cmos5l_decap_8
XFILLER_7_812 VPWR VGND sg13cmos5l_decap_8
XFILLER_6_311 VPWR VGND sg13cmos5l_decap_8
XFILLER_10_351 VPWR VGND sg13cmos5l_fill_2
XFILLER_11_896 VPWR VGND sg13cmos5l_fill_1
XFILLER_28_6 VPWR VGND sg13cmos5l_fill_1
XFILLER_37_215 VPWR VGND sg13cmos5l_fill_1
X_4910_ _6363_/A _6396_/A _6411_/A VPWR VGND sg13cmos5l_nand2b_1
X_5890_ _5890_/Y _5867_/A _6254_/A _5888_/S VPWR VGND sg13cmos5l_o21ai_1
XFILLER_34_933 VPWR VGND sg13cmos5l_fill_2
X_4841_ _4841_/Y _4842_/A _4842_/B _4840_/Y VPWR VGND sg13cmos5l_a21oi_1
X_7414__282 _7414_/RESET_B VPWR VGND sg13cmos5l_tiehi
X_7560_ _7560_/Q _7560_/CLK _7560_/D _7560_/RESET_B VPWR VGND sg13cmos5l_dfrbpq_1
X_4772_ _4772_/Y _4758_/Y hold981/X _4768_/A VPWR VGND sg13cmos5l_a21oi_1
X_7491_ _7491_/Q _7555_/CLK _7491_/D _7491_/RESET_B VPWR VGND sg13cmos5l_dfrbpq_1
X_6511_ _7394_/D _6511_/A _6511_/B VPWR VGND sg13cmos5l_nor2_1
X_6442_ _6442_/Y _7396_/Q _7373_/Q _6439_/Y _6441_/Y VPWR VGND sg13cmos5l_a22oi_1
X_6373_ _6376_/B _4921_/Y _6372_/C _6372_/Y VPWR VGND sg13cmos5l_o21ai_1
X_5324_ _5324_/Y hold862/X _5324_/A2 _5087_/A VPWR VGND sg13cmos5l_o21ai_1
X_5255_ _5255_/Y _5256_/A _5256_/B _5256_/C _5256_/D VPWR VGND sg13cmos5l_nor4_1
X_4206_ _4209_/A _4194_/Y _4198_/Y _4208_/A _4208_/B _4200_/Y VPWR VGND sg13cmos5l_a221oi_1
X_5186_ _5186_/Y _5218_/A _5184_/Y _5185_/Y _5558_/A VPWR VGND sg13cmos5l_a22oi_1
XFILLER_29_738 VPWR VGND sg13cmos5l_fill_2
X_4137_ _4137_/Y _6971_/B _7468_/Q VPWR VGND sg13cmos5l_nand2b_1
XFILLER_44_719 VPWR VGND sg13cmos5l_decap_4
X_4068_ _4072_/A _4068_/A _4068_/B _4068_/C VPWR VGND sg13cmos5l_nand3_1
XFILLER_40_903 VPWR VGND sg13cmos5l_decap_8
X_6709_ _7427_/D _6709_/A _6709_/B VPWR VGND sg13cmos5l_nor2_1
XFILLER_11_159 VPWR VGND sg13cmos5l_decap_8
XFILLER_47_524 VPWR VGND sg13cmos5l_fill_2
XFILLER_43_774 VPWR VGND sg13cmos5l_decap_8
XFILLER_8_79 VPWR VGND sg13cmos5l_fill_2
XFILLER_7_642 VPWR VGND sg13cmos5l_decap_8
XFILLER_6_141 VPWR VGND sg13cmos5l_decap_4
XFILLER_10_192 VPWR VGND sg13cmos5l_decap_8
XFILLER_6_185 VPWR VGND sg13cmos5l_fill_2
X_7147__194 _7147_/D VPWR VGND sg13cmos5l_tielo
XFILLER_2_391 VPWR VGND sg13cmos5l_fill_1
X_5040_ _5155_/A _4689_/Y _5020_/Y _5023_/Y _5039_/Y VPWR VGND sg13cmos5l_a22oi_1
X_7457__647 _7457_/RESET_B VPWR VGND sg13cmos5l_tiehi
Xhold1309 _6559_/B1 _7401_/Q VPWR VGND sg13cmos5l_dlygate4sd3_1
X_6991_ _6991_/Y _6979_/B _6982_/Y _6990_/Y VPWR VGND sg13cmos5l_a21oi_1
X_5942_ _5944_/A _6194_/A _7257_/Q _5941_/Y VPWR VGND sg13cmos5l_o21ai_1
X_5873_ _5873_/Y _5861_/X _5866_/Y _6240_/A _5872_/A _5867_/Y VPWR VGND sg13cmos5l_a221oi_1
XFILLER_22_936 VPWR VGND sg13cmos5l_decap_4
X_7612_ _7612_/Q _7635_/CLK _7612_/D _7612_/RESET_B VPWR VGND sg13cmos5l_dfrbpq_1
XFILLER_21_424 VPWR VGND sg13cmos5l_fill_2
X_4824_ _4825_/B _7624_/Q _4805_/Y _4802_/Y VPWR VGND sg13cmos5l_a21oi_1
XFILLER_33_284 VPWR VGND sg13cmos5l_fill_1
X_4755_ _4755_/X _4754_/C _4753_/Y _4754_/Y VPWR VGND sg13cmos5l_a21o_1
XFILLER_21_457 VPWR VGND sg13cmos5l_fill_1
X_7543_ _7543_/Q _7630_/CLK _7543_/D _7543_/RESET_B VPWR VGND sg13cmos5l_dfrbpq_1
XFILLER_30_980 VPWR VGND sg13cmos5l_fill_1
X_4686_ _4686_/Y _4654_/B _4652_/C _4690_/B VPWR VGND sg13cmos5l_a21oi_1
X_7474_ _7474_/Q _7553_/CLK _7474_/D _7474_/RESET_B VPWR VGND sg13cmos5l_dfrbpq_1
XFILLER_49_1009 VPWR VGND sg13cmos5l_decap_8
X_6425_ _7369_/D _6425_/A _6425_/B _6425_/C VPWR VGND sg13cmos5l_nor3_1
X_7282__452 _7282_/RESET_B VPWR VGND sg13cmos5l_tiehi
X_6356_ _6356_/Y _6356_/A _6356_/B VPWR VGND sg13cmos5l_nand2_1
XFILLER_0_306 VPWR VGND sg13cmos5l_fill_2
X_5307_ _5307_/Y _7183_/Q _5305_/Y _5317_/A VPWR VGND sg13cmos5l_o21ai_1
X_6287_ _6299_/D _6293_/D VPWR VGND sg13cmos5l_inv_1
X_5238_ _5274_/A _7139_/Q _5245_/B VPWR VGND sg13cmos5l_xor2_1
X_5169_ _7161_/D _5169_/A1 _5176_/S _5168_/Y VPWR VGND sg13cmos5l_a21oi_1
XFILLER_17_66 VPWR VGND sg13cmos5l_fill_2
XFILLER_24_262 VPWR VGND sg13cmos5l_decap_8
XFILLER_25_763 VPWR VGND sg13cmos5l_fill_2
XFILLER_21_980 VPWR VGND sg13cmos5l_fill_2
X_7404__292 _7404_/RESET_B VPWR VGND sg13cmos5l_tiehi
XFILLER_0_862 VPWR VGND sg13cmos5l_fill_1
XFILLER_47_343 VPWR VGND sg13cmos5l_decap_8
X_7411__285 _7411_/RESET_B VPWR VGND sg13cmos5l_tiehi
XFILLER_30_287 VPWR VGND sg13cmos5l_fill_1
Xclkbuf_leaf_10_clk _7428_/CLK clkload2/A VPWR VGND sg13cmos5l_buf_8
X_4540_ _4540_/Y _7543_/Q _4540_/B _4540_/C VPWR VGND sg13cmos5l_nor3_1
X_4471_ _4471_/Y _4451_/Y _4454_/X _4470_/Y VPWR VGND sg13cmos5l_o21ai_1
XFILLER_7_472 VPWR VGND sg13cmos5l_fill_1
X_6210_ _6230_/B _6213_/B _6213_/C _6213_/A VPWR VGND sg13cmos5l_a21oi_1
X_7190_ _7190_/Q _7611_/CLK _7190_/D _7190_/RESET_B VPWR VGND sg13cmos5l_dfrbpq_1
X_6141_ _6141_/Y _7295_/Q _7344_/Q VPWR VGND sg13cmos5l_nand2_1
X_6072_ _6119_/B _7318_/Q _6089_/D VPWR VGND sg13cmos5l_xnor2_1
Xhold1106 _5863_/A _7278_/Q VPWR VGND sg13cmos5l_dlygate4sd3_1
Xhold1139 _5760_/B _5759_/X VPWR VGND sg13cmos5l_dlygate4sd3_1
X_5023_ _5023_/Y _5013_/Y _5019_/Y _5021_/Y VPWR VGND sg13cmos5l_o21ai_1
Xhold1128 _6107_/B _8274_/A VPWR VGND sg13cmos5l_dlygate4sd3_1
Xhold1117 _4003_/A _7612_/Q VPWR VGND sg13cmos5l_dlygate4sd3_1
XFILLER_39_877 VPWR VGND sg13cmos5l_fill_2
X_6974_ _6974_/Y _7472_/Q _6974_/B VPWR VGND sg13cmos5l_nand2_1
X_5925_ _7285_/D _5976_/A _5997_/A VPWR VGND sg13cmos5l_nor2_1
XFILLER_22_700 VPWR VGND sg13cmos5l_fill_2
XFILLER_34_571 VPWR VGND sg13cmos5l_fill_2
X_5856_ _5867_/B _7281_/Q _5859_/A VPWR VGND sg13cmos5l_xor2_1
X_4807_ _4807_/Y _7628_/Q _4835_/B VPWR VGND sg13cmos5l_nand2_1
X_5787_ _5787_/Y _5782_/Y _5784_/Y _5786_/Y VPWR VGND sg13cmos5l_o21ai_1
X_7526_ _7526_/Q _7571_/CLK _7526_/D _7526_/RESET_B VPWR VGND sg13cmos5l_dfrbpq_1
X_4738_ _4745_/B _4732_/Y _4736_/Y _4737_/Y VPWR VGND sg13cmos5l_o21ai_1
X_4669_ _4690_/B _7604_/Q _4669_/B VPWR VGND sg13cmos5l_xor2_1
X_7457_ _7457_/Q _7510_/CLK _7457_/D _7457_/RESET_B VPWR VGND sg13cmos5l_dfrbpq_1
Xhold940 _3938_/A _7239_/Q VPWR VGND sg13cmos5l_dlygate4sd3_1
X_6408_ _6408_/Y _6413_/B _6415_/A _6408_/C VPWR VGND sg13cmos5l_nor3_1
Xhold973 _7146_/D _5086_/Y VPWR VGND sg13cmos5l_dlygate4sd3_1
X_7388_ _7388_/Q _7651_/CLK _7388_/D _7388_/RESET_B VPWR VGND sg13cmos5l_dfrbpq_1
Xhold962 _6834_/A _7429_/Q VPWR VGND sg13cmos5l_dlygate4sd3_1
Xhold951 _4312_/B _7505_/Q VPWR VGND sg13cmos5l_dlygate4sd3_1
X_6339_ _6340_/A _6350_/B _6338_/Y VPWR VGND sg13cmos5l_nor2b_1
Xhold995 hold995/X _5317_/Y VPWR VGND sg13cmos5l_dlygate4sd3_1
Xhold984 _5329_/A _7161_/Q VPWR VGND sg13cmos5l_dlygate4sd3_1
XFILLER_17_527 VPWR VGND sg13cmos5l_fill_2
XFILLER_44_324 VPWR VGND sg13cmos5l_fill_2
XFILLER_25_560 VPWR VGND sg13cmos5l_fill_1
XFILLER_40_563 VPWR VGND sg13cmos5l_decap_4
XFILLER_12_254 VPWR VGND sg13cmos5l_fill_1
XFILLER_5_932 VPWR VGND sg13cmos5l_fill_2
XFILLER_5_987 VPWR VGND sg13cmos5l_decap_8
X_7272__462 _7272_/RESET_B VPWR VGND sg13cmos5l_tiehi
X_3971_ _5945_/B _3971_/A VPWR VGND sg13cmos5l_inv_1
XFILLER_44_880 VPWR VGND sg13cmos5l_fill_2
X_5710_ _5719_/S _5707_/A _5707_/B _5709_/Y VPWR VGND sg13cmos5l_a21o_1
X_6690_ _6694_/B _6697_/B _6690_/B VPWR VGND sg13cmos5l_or2_1
XFILLER_31_563 VPWR VGND sg13cmos5l_fill_1
X_5641_ _5648_/C _7241_/Q _7242_/Q _7243_/Q VPWR VGND sg13cmos5l_o21ai_1
X_5572_ _5604_/A _5564_/A _5449_/A _5610_/S VPWR VGND sg13cmos5l_mux2_1
X_7311_ _7311_/Q clkload7/A _7311_/D _7311_/RESET_B VPWR VGND sg13cmos5l_dfrbpq_1
X_4523_ _4523_/Y _7596_/Q _4540_/B _4536_/B _7595_/Q _4522_/Y VPWR VGND sg13cmos5l_a221oi_1
X_7242_ _7242_/Q _7307_/CLK _7242_/D _7242_/RESET_B VPWR VGND sg13cmos5l_dfrbpq_1
X_7500__320 _7500_/RESET_B VPWR VGND sg13cmos5l_tiehi
X_4454_ _4454_/X _7567_/Q _4454_/B VPWR VGND sg13cmos5l_xor2_1
X_4385_ _4403_/A _4379_/A _4379_/C _4384_/Y VPWR VGND sg13cmos5l_a21oi_1
X_7173_ _7173_/Q _7200_/CLK _7173_/D _7173_/RESET_B VPWR VGND sg13cmos5l_dfrbpq_1
X_6124_ _6286_/A _6124_/A VPWR VGND sg13cmos5l_inv_1
X_6055_ _6057_/A _6055_/A _6061_/B _6061_/C VPWR VGND sg13cmos5l_nor3_1
X_5006_ _5006_/Y _5003_/Y _5004_/Y _5028_/A _7631_/Q VPWR VGND sg13cmos5l_a22oi_1
XFILLER_22_1001 VPWR VGND sg13cmos5l_fill_1
XFILLER_38_173 VPWR VGND sg13cmos5l_fill_1
X_7513__714 _7513_/RESET_B VPWR VGND sg13cmos5l_tiehi
X_6957_ _6957_/Y _7047_/B VPWR VGND sg13cmos5l_inv_1
XFILLER_26_379 VPWR VGND sg13cmos5l_fill_2
XFILLER_35_880 VPWR VGND sg13cmos5l_fill_1
X_5908_ _5913_/A _5900_/X _5904_/Y _5930_/A _5912_/A _5907_/X VPWR VGND sg13cmos5l_a221oi_1
X_6888_ _6889_/C _6883_/A _6883_/B _6862_/X VPWR VGND sg13cmos5l_a21oi_1
X_5839_ _5841_/A _5839_/A _5844_/S VPWR VGND sg13cmos5l_nor2b_1
XFILLER_14_89 VPWR VGND sg13cmos5l_decap_8
XFILLER_6_729 VPWR VGND sg13cmos5l_fill_2
XFILLER_5_217 VPWR VGND sg13cmos5l_decap_8
X_7509_ _7509_/Q _7553_/CLK _7509_/D _7509_/RESET_B VPWR VGND sg13cmos5l_dfrbpq_1
XFILLER_30_33 VPWR VGND sg13cmos5l_fill_1
Xhold781 _7000_/B _7449_/Q VPWR VGND sg13cmos5l_dlygate4sd3_1
Xhold770 _4568_/B _7549_/Q VPWR VGND sg13cmos5l_dlygate4sd3_1
Xhold792 _7367_/D _6396_/X VPWR VGND sg13cmos5l_dlygate4sd3_1
XFILLER_49_438 VPWR VGND sg13cmos5l_fill_1
X_7401__295 _7401_/RESET_B VPWR VGND sg13cmos5l_tiehi
XFILLER_45_622 VPWR VGND sg13cmos5l_fill_1
XFILLER_44_110 VPWR VGND sg13cmos5l_decap_8
XFILLER_17_324 VPWR VGND sg13cmos5l_fill_1
XFILLER_45_666 VPWR VGND sg13cmos5l_decap_8
XFILLER_44_143 VPWR VGND sg13cmos5l_fill_2
XFILLER_17_357 VPWR VGND sg13cmos5l_decap_8
XFILLER_17_368 VPWR VGND sg13cmos5l_fill_2
XFILLER_33_817 VPWR VGND sg13cmos5l_decap_4
X_7215__187 _7215_/D VPWR VGND sg13cmos5l_tielo
XFILLER_9_589 VPWR VGND sg13cmos5l_fill_2
XFILLER_5_740 VPWR VGND sg13cmos5l_decap_4
XFILLER_5_751 VPWR VGND sg13cmos5l_decap_4
XFILLER_45_1023 VPWR VGND sg13cmos5l_decap_4
X_4170_ _4170_/X _4158_/A _4157_/Y _4196_/B VPWR VGND sg13cmos5l_mux2_1
XFILLER_35_110 VPWR VGND sg13cmos5l_fill_1
X_6811_ _6812_/A _6809_/C _6810_/Y _6891_/A VPWR VGND sg13cmos5l_o21ai_1
X_6742_ _6870_/A _6738_/S _6741_/X _6740_/Y VPWR VGND sg13cmos5l_a21o_1
XFILLER_16_390 VPWR VGND sg13cmos5l_decap_4
X_3954_ _3954_/Y _5098_/A VPWR VGND sg13cmos5l_inv_1
X_3885_ _6150_/B _3885_/A VPWR VGND sg13cmos5l_inv_1
X_6673_ _6697_/A _6696_/B _6696_/C _6696_/A VPWR VGND sg13cmos5l_a21oi_1
X_5624_ _7235_/D _5624_/A1 _5622_/Y _5623_/Y VPWR VGND sg13cmos5l_a21oi_1
X_5555_ _7227_/D _5555_/A _5555_/B VPWR VGND sg13cmos5l_and2_1
X_4506_ _7569_/D _4519_/A _4577_/C VPWR VGND sg13cmos5l_nor2_1
X_5486_ _5501_/B _7178_/Q _5486_/B VPWR VGND sg13cmos5l_xnor2_1
X_8274_ _8274_/X _8274_/A VPWR VGND sg13cmos5l_buf_1
X_4437_ _4437_/X _7594_/Q _4434_/Y _4436_/Y VPWR VGND sg13cmos5l_a21o_1
X_7225_ _7225_/Q _7611_/CLK _7225_/D _7225_/RESET_B VPWR VGND sg13cmos5l_dfrbpq_1
X_7156_ _7156_/Q _7635_/CLK _7156_/D _7156_/RESET_B VPWR VGND sg13cmos5l_dfrbpq_1
X_6107_ _6192_/B _6107_/A _6107_/B VPWR VGND sg13cmos5l_nor2_1
X_4368_ _4368_/Y _7547_/Q _7515_/Q VPWR VGND sg13cmos5l_nand2_1
X_4299_ _7535_/D _4358_/B _4299_/B VPWR VGND sg13cmos5l_nor2_1
X_7087_ _7088_/B _6983_/Y _7081_/B _7091_/S _7086_/Y VPWR VGND sg13cmos5l_a22oi_1
X_7277__181 _7277_/D VPWR VGND sg13cmos5l_tielo
X_6038_ _6038_/Y _6033_/Y _6037_/Y _6027_/Y VPWR VGND sg13cmos5l_o21ai_1
XFILLER_42_636 VPWR VGND sg13cmos5l_fill_1
XFILLER_25_66 VPWR VGND sg13cmos5l_decap_4
XFILLER_29_1018 VPWR VGND sg13cmos5l_decap_8
XFILLER_2_776 VPWR VGND sg13cmos5l_decap_8
XFILLER_46_986 VPWR VGND sg13cmos5l_decap_8
X_5340_ _5342_/A _5340_/A _5372_/A VPWR VGND sg13cmos5l_nor2_1
X_5271_ _5271_/X _5245_/B _5245_/C _5274_/B VPWR VGND sg13cmos5l_a21o_1
X_7010_ _7010_/Y _7008_/A _7034_/A _7042_/A _7012_/A VPWR VGND sg13cmos5l_a22oi_1
X_4222_ _4261_/A _4575_/A _4223_/B VPWR VGND sg13cmos5l_xnor2_1
X_4153_ _4153_/X _4154_/A _4160_/A VPWR VGND sg13cmos5l_and2_1
X_4084_ _4084_/Y _4342_/B _7106_/A VPWR VGND sg13cmos5l_nand2b_1
X_4986_ _4986_/Y _4957_/B _4952_/C _4994_/B VPWR VGND sg13cmos5l_a21oi_1
XFILLER_23_146 VPWR VGND sg13cmos5l_fill_1
X_3937_ _5778_/A _3937_/A VPWR VGND sg13cmos5l_inv_1
XFILLER_11_319 VPWR VGND sg13cmos5l_fill_1
X_6725_ _6730_/B _7459_/Q _7004_/A _7460_/Q VPWR VGND sg13cmos5l_nor3_1
X_3868_ _3868_/Y _3868_/A VPWR VGND sg13cmos5l_inv_1
X_6656_ _6656_/Y _7387_/Q _6657_/A2 _6505_/A VPWR VGND sg13cmos5l_o21ai_1
X_6587_ _6777_/A _6751_/A _6767_/A VPWR VGND sg13cmos5l_nand2_1
X_5607_ _5608_/B _5607_/A _5620_/B VPWR VGND sg13cmos5l_xnor2_1
XFILLER_20_897 VPWR VGND sg13cmos5l_fill_2
X_5538_ _7216_/D _5542_/A _5538_/B VPWR VGND sg13cmos5l_nor2_1
XFILLER_11_35 VPWR VGND sg13cmos5l_decap_4
X_7208_ _7208_/Q _7277_/CLK _7208_/D _7208_/RESET_B VPWR VGND sg13cmos5l_dfrbpq_1
X_5469_ _5481_/B _7176_/Q _7175_/Q _7173_/Q _7174_/Q VPWR VGND sg13cmos5l_nor4_1
X_7139_ _7139_/Q _7610_/CLK _7139_/D _7139_/RESET_B VPWR VGND sg13cmos5l_dfrbpq_1
XFILLER_19_408 VPWR VGND sg13cmos5l_decap_4
XFILLER_46_238 VPWR VGND sg13cmos5l_fill_1
XFILLER_28_942 VPWR VGND sg13cmos5l_fill_2
XFILLER_28_953 VPWR VGND sg13cmos5l_fill_2
XFILLER_14_135 VPWR VGND sg13cmos5l_fill_1
XFILLER_10_341 VPWR VGND sg13cmos5l_fill_1
XFILLER_7_868 VPWR VGND sg13cmos5l_decap_8
XFILLER_10_363 VPWR VGND sg13cmos5l_decap_8
XFILLER_6_356 VPWR VGND sg13cmos5l_decap_4
XFILLER_38_739 VPWR VGND sg13cmos5l_fill_1
XFILLER_37_238 VPWR VGND sg13cmos5l_fill_2
XFILLER_46_794 VPWR VGND sg13cmos5l_decap_8
XFILLER_46_783 VPWR VGND sg13cmos5l_decap_8
XFILLER_19_997 VPWR VGND sg13cmos5l_fill_1
X_4840_ _4840_/Y _4840_/A _4840_/B VPWR VGND sg13cmos5l_nor2_1
XFILLER_34_989 VPWR VGND sg13cmos5l_fill_1
X_6510_ _7393_/D _6510_/A _6510_/B VPWR VGND sg13cmos5l_and2_1
X_4771_ _4771_/Y _4771_/A _4771_/B VPWR VGND sg13cmos5l_nand2_1
X_7490_ _7490_/Q _7490_/CLK _7490_/D _7490_/RESET_B VPWR VGND sg13cmos5l_dfrbpq_1
XFILLER_13_190 VPWR VGND sg13cmos5l_decap_8
X_6441_ _6441_/Y _6440_/Y _6662_/A VPWR VGND sg13cmos5l_nand2b_1
X_6372_ _6372_/Y _7369_/Q _6511_/A _6372_/C VPWR VGND sg13cmos5l_nand3_1
X_5323_ _7187_/D _3890_/Y _5323_/A2 _5322_/Y VPWR VGND sg13cmos5l_a21oi_1
X_5254_ _5256_/D _5253_/A _5253_/B _4993_/B VPWR VGND sg13cmos5l_a21oi_1
X_4205_ _4208_/B _4205_/A VPWR VGND sg13cmos5l_inv_1
X_5185_ _5185_/Y _7168_/Q _7167_/Q _7198_/Q VPWR VGND sg13cmos5l_nand3b_1
X_4136_ _4136_/Y _7489_/Q _7467_/Q VPWR VGND sg13cmos5l_nor2_1
X_4067_ _4068_/C input9/X _7646_/Q _4067_/C VPWR VGND sg13cmos5l_nand3_1
XFILLER_25_934 VPWR VGND sg13cmos5l_decap_8
XFILLER_25_967 VPWR VGND sg13cmos5l_fill_1
XFILLER_19_1028 VPWR VGND sg13cmos5l_fill_1
X_4969_ _4994_/B _7135_/Q _4969_/B VPWR VGND sg13cmos5l_xor2_1
X_6708_ _6709_/B _6695_/Y _6698_/A _6708_/S VPWR VGND sg13cmos5l_mux2_1
X_6639_ _6639_/Y _7411_/Q _6631_/Y _6638_/Y _6649_/B VPWR VGND sg13cmos5l_a22oi_1
XFILLER_22_89 VPWR VGND sg13cmos5l_fill_2
XFILLER_4_827 VPWR VGND sg13cmos5l_decap_8
XFILLER_3_337 VPWR VGND sg13cmos5l_fill_1
Xfanout140 _5087_/A _4569_/A VPWR VGND sg13cmos5l_buf_1
XFILLER_16_967 VPWR VGND sg13cmos5l_decap_8
XFILLER_43_764 VPWR VGND sg13cmos5l_fill_2
XFILLER_42_296 VPWR VGND sg13cmos5l_decap_4
X_7299__427 _7299_/RESET_B VPWR VGND sg13cmos5l_tiehi
XFILLER_26_4 VPWR VGND sg13cmos5l_decap_8
X_6990_ _6990_/Y _6982_/Y _6989_/Y _6893_/Y VPWR VGND sg13cmos5l_o21ai_1
X_5941_ _5941_/Y _7312_/Q _5960_/B _5939_/Y _5940_/Y VPWR VGND sg13cmos5l_a22oi_1
X_5872_ _5872_/Y _5872_/A VPWR VGND sg13cmos5l_inv_1
XFILLER_22_926 VPWR VGND sg13cmos5l_fill_1
X_7611_ _7611_/Q _7611_/CLK _7611_/D _7611_/RESET_B VPWR VGND sg13cmos5l_dfrbpq_1
X_4823_ _4823_/Y _4840_/B VPWR VGND sg13cmos5l_inv_1
X_4754_ _4754_/Y _7635_/Q _5100_/A _4754_/C VPWR VGND sg13cmos5l_nor3_1
X_7542_ _7542_/Q _7617_/CLK _7542_/D _7542_/RESET_B VPWR VGND sg13cmos5l_dfrbpq_1
XFILLER_30_992 VPWR VGND sg13cmos5l_decap_8
X_7382__319 _7382_/RESET_B VPWR VGND sg13cmos5l_tiehi
X_7473_ _7473_/Q _7553_/CLK _7473_/D _7473_/RESET_B VPWR VGND sg13cmos5l_dfrbpq_1
X_4685_ _4685_/X _5007_/A _4685_/B VPWR VGND sg13cmos5l_and2_1
X_6424_ _6425_/C _6424_/A _6423_/A VPWR VGND sg13cmos5l_nor2b_1
X_7345__174 _7345_/D VPWR VGND sg13cmos5l_tielo
X_7579__717 _7579_/RESET_B VPWR VGND sg13cmos5l_tiehi
X_6355_ _6356_/B _6509_/A _6355_/B VPWR VGND sg13cmos5l_nand2_1
X_5306_ _5306_/Y _7182_/Q _5299_/Y _5305_/Y _7183_/Q VPWR VGND sg13cmos5l_a22oi_1
X_6286_ _6293_/D _6286_/A _6286_/B VPWR VGND sg13cmos5l_nor2_1
X_5237_ _5251_/C _7138_/Q _7139_/Q _7137_/Q _7136_/Q VPWR VGND sg13cmos5l_nor4_1
X_7139__607 _7139_/RESET_B VPWR VGND sg13cmos5l_tiehi
X_5168_ _5168_/Y _5175_/A _5168_/B VPWR VGND sg13cmos5l_nand2_1
XFILLER_29_536 VPWR VGND sg13cmos5l_decap_4
X_4119_ _7070_/B _4120_/A _4120_/B _4298_/A VPWR VGND sg13cmos5l_nor3_1
X_5099_ _7157_/D _5099_/A _5102_/B VPWR VGND sg13cmos5l_nor2_1
Xheichips26_dna_sequencer_760 uio_oe[7] VPWR VGND sg13cmos5l_tiehi
XFILLER_12_403 VPWR VGND sg13cmos5l_fill_2
XFILLER_24_252 VPWR VGND sg13cmos5l_fill_2
XFILLER_40_745 VPWR VGND sg13cmos5l_fill_2
XFILLER_12_469 VPWR VGND sg13cmos5l_decap_4
XFILLER_32_1025 VPWR VGND sg13cmos5l_decap_4
XFILLER_33_88 VPWR VGND sg13cmos5l_decap_4
XFILLER_16_742 VPWR VGND sg13cmos5l_decap_4
XFILLER_31_701 VPWR VGND sg13cmos5l_fill_1
XFILLER_43_583 VPWR VGND sg13cmos5l_decap_8
XFILLER_31_745 VPWR VGND sg13cmos5l_fill_2
XFILLER_12_981 VPWR VGND sg13cmos5l_decap_8
X_4470_ _4470_/Y _4714_/A _4470_/B VPWR VGND sg13cmos5l_nand2b_1
XFILLER_48_1010 VPWR VGND sg13cmos5l_decap_8
X_6140_ _6140_/Y _6140_/A _7345_/Q VPWR VGND sg13cmos5l_nor2_1
XFILLER_39_801 VPWR VGND sg13cmos5l_fill_1
X_6071_ _6087_/B _7315_/Q _7316_/Q _7317_/Q _7318_/Q VPWR VGND sg13cmos5l_nor4_1
X_5022_ _5035_/A _5021_/A _5028_/B _5020_/B _5020_/A VPWR VGND sg13cmos5l_a22oi_1
Xhold1118 _4766_/B _4765_/X VPWR VGND sg13cmos5l_dlygate4sd3_1
Xhold1129 _4013_/A _7539_/Q VPWR VGND sg13cmos5l_dlygate4sd3_1
Xhold1107 _6536_/A _7392_/Q VPWR VGND sg13cmos5l_dlygate4sd3_1
X_7375__167 _7375_/D VPWR VGND sg13cmos5l_tielo
XFILLER_17_0 VPWR VGND sg13cmos5l_decap_4
XFILLER_26_506 VPWR VGND sg13cmos5l_fill_2
XFILLER_0_1012 VPWR VGND sg13cmos5l_decap_8
X_6973_ _6973_/Y _6973_/A VPWR VGND sg13cmos5l_inv_1
X_5924_ _5997_/A _5672_/Y _5917_/X _5919_/Y _5923_/Y VPWR VGND sg13cmos5l_a22oi_1
X_5855_ _5871_/B _7281_/Q _5859_/A VPWR VGND sg13cmos5l_nor2b_1
X_4806_ _4806_/Y _4806_/A _4835_/B VPWR VGND sg13cmos5l_nand2_1
X_7468__596 _7468_/RESET_B VPWR VGND sg13cmos5l_tiehi
X_5786_ _5786_/Y _5687_/B _5831_/B _5785_/Y VPWR VGND sg13cmos5l_a21oi_1
X_7525_ _7525_/Q _7553_/CLK _7525_/D _7525_/RESET_B VPWR VGND sg13cmos5l_dfrbpq_1
X_4737_ _4737_/Y _7635_/Q _4739_/A VPWR VGND sg13cmos5l_nand2_1
X_4668_ _4682_/B _7604_/Q _4669_/B VPWR VGND sg13cmos5l_xnor2_1
X_7456_ _7456_/Q _7510_/CLK _7456_/D _7456_/RESET_B VPWR VGND sg13cmos5l_dfrbpq_1
Xhold930 _4875_/A _7638_/Q VPWR VGND sg13cmos5l_dlygate4sd3_1
X_6407_ _6408_/C _6407_/A _6407_/B VPWR VGND sg13cmos5l_nor2_1
Xhold963 _4570_/A _7556_/Q VPWR VGND sg13cmos5l_dlygate4sd3_1
X_4599_ _4625_/A _4624_/B _4624_/C _4624_/A VPWR VGND sg13cmos5l_a21oi_1
Xhold941 _3911_/A _7491_/Q VPWR VGND sg13cmos5l_dlygate4sd3_1
X_7387_ _7387_/Q clkload8/A _7387_/D _7387_/RESET_B VPWR VGND sg13cmos5l_dfrbpq_1
Xhold952 hold952/X _4312_/Y VPWR VGND sg13cmos5l_dlygate4sd3_1
X_6338_ _6338_/Y _7346_/Q _7347_/Q _7348_/Q VPWR VGND sg13cmos5l_o21ai_1
XFILLER_0_126 VPWR VGND sg13cmos5l_decap_4
Xhold996 _5761_/B _7257_/Q VPWR VGND sg13cmos5l_dlygate4sd3_1
X_7538__222 _7538_/RESET_B VPWR VGND sg13cmos5l_tiehi
Xhold985 _4340_/B _7542_/Q VPWR VGND sg13cmos5l_dlygate4sd3_1
Xhold974 _6833_/A _7428_/Q VPWR VGND sg13cmos5l_dlygate4sd3_1
X_6269_ _6269_/Y _6263_/B _6269_/B _7309_/Q VPWR VGND sg13cmos5l_nand3b_1
XFILLER_28_55 VPWR VGND sg13cmos5l_fill_1
XFILLER_44_76 VPWR VGND sg13cmos5l_decap_8
XFILLER_44_65 VPWR VGND sg13cmos5l_decap_8
XFILLER_40_553 VPWR VGND sg13cmos5l_fill_1
XFILLER_13_745 VPWR VGND sg13cmos5l_decap_8
X_7545__215 _7545_/RESET_B VPWR VGND sg13cmos5l_tiehi
XFILLER_40_586 VPWR VGND sg13cmos5l_decap_4
XFILLER_8_237 VPWR VGND sg13cmos5l_decap_8
XFILLER_5_911 VPWR VGND sg13cmos5l_fill_2
XFILLER_5_966 VPWR VGND sg13cmos5l_decap_8
XFILLER_0_660 VPWR VGND sg13cmos5l_decap_8
XFILLER_36_826 VPWR VGND sg13cmos5l_decap_8
X_7569__727 _7569_/RESET_B VPWR VGND sg13cmos5l_tiehi
X_3970_ _3970_/Y _3970_/A VPWR VGND sg13cmos5l_inv_1
XFILLER_31_542 VPWR VGND sg13cmos5l_fill_2
X_5640_ _5650_/B _7243_/Q _7241_/Q _7242_/Q VPWR VGND sg13cmos5l_or3_1
X_5571_ _5610_/S _5467_/B _5614_/B _5570_/Y VPWR VGND sg13cmos5l_o21ai_1
X_7129__617 _7129_/RESET_B VPWR VGND sg13cmos5l_tiehi
XFILLER_8_771 VPWR VGND sg13cmos5l_fill_1
X_7310_ _7310_/Q clkload7/A _7310_/D _7310_/RESET_B VPWR VGND sg13cmos5l_dfrbpq_1
X_4522_ _4522_/Y _4785_/A _7540_/Q _7539_/Q _4460_/A _4521_/Y VPWR VGND sg13cmos5l_a221oi_1
X_4453_ _4462_/C _7567_/Q _4454_/B VPWR VGND sg13cmos5l_xnor2_1
X_7241_ _7241_/Q _7307_/CLK _7241_/D _7241_/RESET_B VPWR VGND sg13cmos5l_dfrbpq_1
X_4384_ _4384_/Y _7555_/Q _4402_/B _4378_/Y _4383_/Y VPWR VGND sg13cmos5l_a22oi_1
X_7172_ _7172_/Q _7214_/CLK _7172_/D _7172_/RESET_B VPWR VGND sg13cmos5l_dfrbpq_1
X_6123_ _6124_/A _6097_/B _6104_/Y _6122_/X VPWR VGND sg13cmos5l_o21ai_1
X_6054_ _6054_/Y _6061_/B _6061_/C VPWR VGND sg13cmos5l_nor2_1
X_5005_ _5028_/A _7605_/Q _7606_/Q VPWR VGND sg13cmos5l_xnor2_1
XFILLER_26_303 VPWR VGND sg13cmos5l_decap_8
X_6956_ _7047_/B _6937_/A _6941_/A _6955_/Y VPWR VGND sg13cmos5l_a21oi_1
XFILLER_26_369 VPWR VGND sg13cmos5l_fill_1
X_5907_ _5907_/X _5907_/A _5907_/B _5907_/C VPWR VGND sg13cmos5l_and3_1
XFILLER_22_531 VPWR VGND sg13cmos5l_fill_1
X_6887_ _6889_/B _6890_/S _6861_/X VPWR VGND sg13cmos5l_nor2b_1
X_5838_ _7272_/D _5838_/A1 _5844_/S _5837_/Y VPWR VGND sg13cmos5l_a21oi_1
XFILLER_22_586 VPWR VGND sg13cmos5l_fill_2
XFILLER_10_748 VPWR VGND sg13cmos5l_decap_4
X_5769_ _5769_/Y _3886_/Y _5769_/A2 _5768_/Y VPWR VGND sg13cmos5l_a21oi_1
XFILLER_22_597 VPWR VGND sg13cmos5l_fill_1
XFILLER_30_23 VPWR VGND sg13cmos5l_fill_1
X_7508_ _7508_/Q _7617_/CLK _7508_/D _7508_/RESET_B VPWR VGND sg13cmos5l_dfrbpq_1
X_7439_ _7439_/Q _7489_/CLK _7439_/D _7439_/RESET_B VPWR VGND sg13cmos5l_dfrbpq_1
X_7325__397 _7325_/RESET_B VPWR VGND sg13cmos5l_tiehi
Xhold771 _5987_/B _7264_/Q VPWR VGND sg13cmos5l_dlygate4sd3_1
Xhold782 _4081_/B _7482_/Q VPWR VGND sg13cmos5l_dlygate4sd3_1
XFILLER_2_969 VPWR VGND sg13cmos5l_decap_8
Xhold793 _7017_/B _7451_/Q VPWR VGND sg13cmos5l_dlygate4sd3_1
XFILLER_49_417 VPWR VGND sg13cmos5l_fill_1
XFILLER_39_54 VPWR VGND sg13cmos5l_fill_2
XFILLER_18_826 VPWR VGND sg13cmos5l_fill_2
XFILLER_33_807 VPWR VGND sg13cmos5l_fill_1
XFILLER_13_553 VPWR VGND sg13cmos5l_decap_4
XFILLER_41_884 VPWR VGND sg13cmos5l_decap_8
XFILLER_5_774 VPWR VGND sg13cmos5l_fill_2
XFILLER_5_785 VPWR VGND sg13cmos5l_decap_8
XFILLER_49_995 VPWR VGND sg13cmos5l_decap_8
XFILLER_48_461 VPWR VGND sg13cmos5l_decap_4
X_6810_ _6810_/Y _6816_/A _6810_/B VPWR VGND sg13cmos5l_nor2_1
X_6741_ _6741_/X _6927_/A _6941_/A VPWR VGND sg13cmos5l_and2_1
X_3953_ _5099_/A _3953_/A VPWR VGND sg13cmos5l_inv_1
X_7582__713 _7582_/RESET_B VPWR VGND sg13cmos5l_tiehi
X_7528__232 _7528_/RESET_B VPWR VGND sg13cmos5l_tiehi
X_3884_ _6146_/B _3884_/A VPWR VGND sg13cmos5l_inv_1
XFILLER_32_884 VPWR VGND sg13cmos5l_decap_4
X_6672_ _6696_/C _7421_/Q _6677_/B VPWR VGND sg13cmos5l_nand2_1
X_5623_ _5623_/Y _5573_/Y _5622_/Y _5558_/B VPWR VGND sg13cmos5l_o21ai_1
X_5554_ _7226_/D _7113_/A _5554_/B VPWR VGND sg13cmos5l_and2_1
X_4505_ _4505_/Y _4577_/C VPWR VGND sg13cmos5l_inv_1
X_5485_ _5485_/X _5485_/A _5485_/B VPWR VGND sg13cmos5l_and2_1
X_8273_ _8273_/X _8273_/A VPWR VGND sg13cmos5l_buf_1
X_7498__342 _7498_/RESET_B VPWR VGND sg13cmos5l_tiehi
X_4436_ _4436_/Y _7562_/Q _7563_/Q VPWR VGND sg13cmos5l_xnor2_1
X_7224_ _7224_/Q _7622_/CLK _7224_/D _7224_/RESET_B VPWR VGND sg13cmos5l_dfrbpq_1
X_4367_ _4404_/A _4256_/A _4287_/B _4400_/S VPWR VGND sg13cmos5l_mux2_1
X_7155_ _7155_/Q _7635_/CLK _7155_/D _7155_/RESET_B VPWR VGND sg13cmos5l_dfrbpq_1
X_6106_ _6295_/A _6106_/A _6105_/Y VPWR VGND sg13cmos5l_nor2b_1
X_7535__225 _7535_/RESET_B VPWR VGND sg13cmos5l_tiehi
X_4298_ _4298_/X _4298_/A _4298_/B VPWR VGND sg13cmos5l_or2_1
X_7086_ _7086_/Y _7090_/A _7086_/B VPWR VGND sg13cmos5l_nor2_1
X_6037_ _6037_/Y _6058_/A _6033_/B _6036_/B _6036_/A _6005_/A VPWR VGND sg13cmos5l_a221oi_1
XFILLER_42_626 VPWR VGND sg13cmos5l_fill_1
XFILLER_27_689 VPWR VGND sg13cmos5l_fill_2
X_6939_ _6939_/Y _6939_/A _6939_/B VPWR VGND sg13cmos5l_nand2_1
XFILLER_42_648 VPWR VGND sg13cmos5l_decap_8
XFILLER_41_136 VPWR VGND sg13cmos5l_fill_2
XFILLER_14_339 VPWR VGND sg13cmos5l_fill_2
XFILLER_41_33 VPWR VGND sg13cmos5l_fill_1
XFILLER_6_516 VPWR VGND sg13cmos5l_decap_8
X_7542__218 _7542_/RESET_B VPWR VGND sg13cmos5l_tiehi
X_7559__737 _7559_/RESET_B VPWR VGND sg13cmos5l_tiehi
XFILLER_2_733 VPWR VGND sg13cmos5l_fill_2
XFILLER_9_2 VPWR VGND sg13cmos5l_fill_1
X_7262__473 _7262_/RESET_B VPWR VGND sg13cmos5l_tiehi
XFILLER_46_910 VPWR VGND sg13cmos5l_fill_2
XFILLER_17_100 VPWR VGND sg13cmos5l_decap_4
XFILLER_46_965 VPWR VGND sg13cmos5l_decap_8
Xhold1290 _6860_/A _7453_/Q VPWR VGND sg13cmos5l_dlygate4sd3_1
XFILLER_17_188 VPWR VGND sg13cmos5l_fill_2
XFILLER_32_114 VPWR VGND sg13cmos5l_fill_2
XFILLER_20_309 VPWR VGND sg13cmos5l_fill_1
XFILLER_9_343 VPWR VGND sg13cmos5l_fill_1
XFILLER_9_387 VPWR VGND sg13cmos5l_fill_1
X_5270_ _5270_/Y _5255_/Y _5259_/Y _4985_/X VPWR VGND sg13cmos5l_o21ai_1
X_4221_ _4223_/B _7560_/Q _4241_/B VPWR VGND sg13cmos5l_nor2b_1
X_4152_ _4158_/B _7072_/B _7068_/B VPWR VGND sg13cmos5l_nor2_1
X_4083_ _4083_/Y _6711_/A _4342_/B VPWR VGND sg13cmos5l_nor2_1
X_4985_ _4985_/X _5245_/A _4993_/B VPWR VGND sg13cmos5l_and2_1
X_6724_ _6724_/X _6728_/B _6927_/A _6724_/C VPWR VGND sg13cmos5l_and3_1
X_3936_ _3936_/Y _5672_/A VPWR VGND sg13cmos5l_inv_1
X_6655_ _7416_/D _3869_/Y _6657_/A2 _6654_/Y VPWR VGND sg13cmos5l_a21oi_1
X_3867_ _3867_/Y _7504_/Q VPWR VGND sg13cmos5l_inv_1
X_6586_ _7400_/D _6661_/B _6682_/A VPWR VGND sg13cmos5l_and2_1
X_5606_ _5606_/Y _5601_/Y _5604_/Y _5605_/Y VPWR VGND sg13cmos5l_o21ai_1
X_5537_ _5538_/B _5521_/B _5734_/B _5541_/S VPWR VGND sg13cmos5l_mux2_1
XFILLER_11_58 VPWR VGND sg13cmos5l_decap_8
X_7498__150 _7498_/D VPWR VGND sg13cmos5l_tielo
X_7207_ _7207_/Q _7277_/CLK _7207_/D _7207_/RESET_B VPWR VGND sg13cmos5l_dfrbpq_1
X_5468_ _5472_/A _7175_/Q _7173_/Q _7174_/Q VPWR VGND sg13cmos5l_or3_1
X_4419_ _4419_/Y _4272_/B _4380_/B _4358_/B VPWR VGND sg13cmos5l_a21oi_1
X_5399_ _5399_/Y _5399_/A _5406_/B VPWR VGND sg13cmos5l_nand2_1
X_7138_ _7138_/Q _7610_/CLK _7138_/D _7138_/RESET_B VPWR VGND sg13cmos5l_dfrbpq_1
X_7069_ _7496_/D _7072_/A _7069_/B VPWR VGND sg13cmos5l_and2_1
XFILLER_39_280 VPWR VGND sg13cmos5l_fill_1
XFILLER_28_932 VPWR VGND sg13cmos5l_fill_1
XFILLER_43_913 VPWR VGND sg13cmos5l_fill_1
XFILLER_14_114 VPWR VGND sg13cmos5l_decap_8
XFILLER_42_478 VPWR VGND sg13cmos5l_decap_4
XFILLER_42_467 VPWR VGND sg13cmos5l_fill_1
XFILLER_42_456 VPWR VGND sg13cmos5l_decap_8
X_7483__430 _7483_/RESET_B VPWR VGND sg13cmos5l_tiehi
XFILLER_10_353 VPWR VGND sg13cmos5l_fill_1
XFILLER_11_865 VPWR VGND sg13cmos5l_fill_1
XFILLER_6_335 VPWR VGND sg13cmos5l_fill_2
XFILLER_10_397 VPWR VGND sg13cmos5l_decap_4
XFILLER_2_541 VPWR VGND sg13cmos5l_fill_2
X_7518__242 _7518_/RESET_B VPWR VGND sg13cmos5l_tiehi
XFILLER_19_910 VPWR VGND sg13cmos5l_decap_4
XFILLER_19_965 VPWR VGND sg13cmos5l_fill_2
XFILLER_34_957 VPWR VGND sg13cmos5l_fill_2
XFILLER_34_968 VPWR VGND sg13cmos5l_fill_2
X_4770_ _4770_/Y _5065_/B _4767_/S _4769_/Y VPWR VGND sg13cmos5l_a21oi_1
X_7525__235 _7525_/RESET_B VPWR VGND sg13cmos5l_tiehi
X_7525__213 _7525_/D VPWR VGND sg13cmos5l_tielo
XFILLER_13_180 VPWR VGND sg13cmos5l_fill_1
X_6440_ _6440_/Y _6440_/A _6440_/B VPWR VGND sg13cmos5l_xnor2_1
X_6371_ _6375_/B _4918_/Y _6370_/Y _6372_/C VPWR VGND sg13cmos5l_mux2_1
X_5322_ _5322_/Y hold845/X _5323_/A2 _5096_/A VPWR VGND sg13cmos5l_o21ai_1
XFILLER_47_0 VPWR VGND sg13cmos5l_decap_8
X_5253_ _5274_/B _5253_/A _5253_/B VPWR VGND sg13cmos5l_and2_1
X_4204_ _4205_/A _4184_/A _4184_/B _4203_/Y VPWR VGND sg13cmos5l_o21ai_1
X_5184_ _5184_/Y _7198_/Q _7167_/Q VPWR VGND sg13cmos5l_nand2_1
X_4135_ _4135_/X _4140_/A _4140_/B _4160_/B VPWR VGND sg13cmos5l_a21o_1
X_7618__675 _7618_/RESET_B VPWR VGND sg13cmos5l_tiehi
X_7532__228 _7532_/RESET_B VPWR VGND sg13cmos5l_tiehi
XFILLER_3_1021 VPWR VGND sg13cmos5l_decap_8
XFILLER_37_740 VPWR VGND sg13cmos5l_fill_1
X_4066_ _4068_/B _4066_/A _4066_/B VPWR VGND sg13cmos5l_nand2_1
XFILLER_25_979 VPWR VGND sg13cmos5l_fill_2
X_7549__747 _7549_/RESET_B VPWR VGND sg13cmos5l_tiehi
X_4968_ _4982_/B _7135_/Q _4969_/B VPWR VGND sg13cmos5l_xnor2_1
X_6707_ _7426_/D _6707_/A _6707_/B VPWR VGND sg13cmos5l_nor2_1
X_4899_ _4899_/Y _4026_/A _4897_/Y _4898_/Y VPWR VGND sg13cmos5l_a21oi_1
X_3919_ _4871_/C _7646_/Q VPWR VGND sg13cmos5l_inv_1
X_6638_ _6638_/Y _6834_/A _6833_/A VPWR VGND sg13cmos5l_nand2b_1
X_6569_ _6578_/B _7402_/Q _6570_/B VPWR VGND sg13cmos5l_nor2_1
XFILLER_3_349 VPWR VGND sg13cmos5l_fill_2
Xfanout130 _7000_/A _7111_/B1 VPWR VGND sg13cmos5l_buf_1
Xfanout141 _4569_/A fanout142/X VPWR VGND sg13cmos5l_buf_1
XFILLER_47_526 VPWR VGND sg13cmos5l_fill_1
XFILLER_34_209 VPWR VGND sg13cmos5l_fill_1
XFILLER_16_957 VPWR VGND sg13cmos5l_fill_2
XFILLER_42_264 VPWR VGND sg13cmos5l_fill_2
XFILLER_31_916 VPWR VGND sg13cmos5l_fill_1
XFILLER_11_640 VPWR VGND sg13cmos5l_fill_2
XFILLER_6_187 VPWR VGND sg13cmos5l_fill_1
XFILLER_19_4 VPWR VGND sg13cmos5l_decap_4
X_5940_ _5940_/Y _6193_/A _7256_/Q _5937_/Y _5938_/Y VPWR VGND sg13cmos5l_a22oi_1
X_5871_ _5872_/A _7282_/Q _5871_/B VPWR VGND sg13cmos5l_xnor2_1
X_7610_ _7610_/Q _7610_/CLK _7610_/D _7610_/RESET_B VPWR VGND sg13cmos5l_dfrbpq_1
XFILLER_22_949 VPWR VGND sg13cmos5l_fill_1
X_4822_ _4840_/B _4725_/B _4795_/A _4838_/S VPWR VGND sg13cmos5l_mux2_1
X_4753_ _4753_/Y _7579_/Q _4753_/B VPWR VGND sg13cmos5l_nor2_1
X_7541_ _7541_/Q _7617_/CLK _7541_/D _7541_/RESET_B VPWR VGND sg13cmos5l_dfrbpq_1
XFILLER_30_971 VPWR VGND sg13cmos5l_decap_8
X_7472_ _7472_/Q _7553_/CLK _7472_/D _7472_/RESET_B VPWR VGND sg13cmos5l_dfrbpq_1
X_6423_ _6425_/B _6423_/A _6411_/C VPWR VGND sg13cmos5l_nor2b_1
X_4684_ _7600_/D _4728_/A _4684_/B VPWR VGND sg13cmos5l_nor2_1
X_6354_ _7346_/D _6425_/A _6354_/B VPWR VGND sg13cmos5l_nor2_1
X_5305_ _5305_/Y _5562_/A _3943_/A _5284_/B _5085_/B VPWR VGND sg13cmos5l_a22oi_1
X_6285_ _6285_/Y _6293_/A _6293_/C VPWR VGND sg13cmos5l_nor2_1
X_5236_ _5245_/B _7138_/Q _7137_/Q _7136_/Q VPWR VGND sg13cmos5l_or3_1
X_5167_ _5168_/B _5167_/A _5167_/B _5176_/S VPWR VGND sg13cmos5l_or3_1
X_4118_ _4298_/A _7090_/A _4118_/B VPWR VGND sg13cmos5l_nor2_1
X_5098_ _7156_/D _5098_/A _5175_/A VPWR VGND sg13cmos5l_and2_1
X_4049_ _7651_/D _7646_/D _4049_/B VPWR VGND sg13cmos5l_nand2b_1
XFILLER_17_79 VPWR VGND sg13cmos5l_decap_8
XFILLER_24_242 VPWR VGND sg13cmos5l_fill_1
XFILLER_40_713 VPWR VGND sg13cmos5l_fill_2
XFILLER_13_949 VPWR VGND sg13cmos5l_decap_4
XFILLER_8_419 VPWR VGND sg13cmos5l_decap_8
XFILLER_0_842 VPWR VGND sg13cmos5l_decap_8
X_7259__478 _7259_/RESET_B VPWR VGND sg13cmos5l_tiehi
X_7515__245 _7515_/RESET_B VPWR VGND sg13cmos5l_tiehi
XFILLER_15_264 VPWR VGND sg13cmos5l_fill_2
XFILLER_15_286 VPWR VGND sg13cmos5l_fill_2
XFILLER_31_735 VPWR VGND sg13cmos5l_decap_4
XFILLER_8_964 VPWR VGND sg13cmos5l_decap_8
X_7608__685 _7608_/RESET_B VPWR VGND sg13cmos5l_tiehi
X_7522__238 _7522_/RESET_B VPWR VGND sg13cmos5l_tiehi
XFILLER_8_986 VPWR VGND sg13cmos5l_decap_8
X_6070_ _6089_/D _7315_/Q _7316_/Q _7317_/Q VPWR VGND sg13cmos5l_or3_1
Xhold1119 _3987_/A _7218_/Q VPWR VGND sg13cmos5l_dlygate4sd3_1
X_5021_ _5021_/Y _5021_/A _5028_/B VPWR VGND sg13cmos5l_nand2_1
Xhold1108 _6537_/B _6536_/Y VPWR VGND sg13cmos5l_dlygate4sd3_1
XFILLER_38_323 VPWR VGND sg13cmos5l_fill_2
X_7615__678 _7615_/RESET_B VPWR VGND sg13cmos5l_tiehi
X_6972_ _6973_/A _6972_/A _6972_/B VPWR VGND sg13cmos5l_nand2_1
XFILLER_0_93 VPWR VGND sg13cmos5l_fill_1
X_5923_ _5923_/Y _5930_/B _5903_/Y VPWR VGND sg13cmos5l_nor2b_1
XFILLER_34_551 VPWR VGND sg13cmos5l_fill_1
X_5854_ _5859_/A _7280_/Q _7278_/Q _7279_/Q VPWR VGND sg13cmos5l_nor3_1
XFILLER_34_584 VPWR VGND sg13cmos5l_decap_4
X_4805_ _4805_/Y _4803_/Y _4804_/Y _4802_/Y VPWR VGND sg13cmos5l_a21oi_1
X_7524_ _7524_/Q _7553_/CLK _7524_/D _7524_/RESET_B VPWR VGND sg13cmos5l_dfrbpq_1
X_5785_ _5785_/Y _5785_/A _5683_/B VPWR VGND sg13cmos5l_nor2b_1
XFILLER_21_267 VPWR VGND sg13cmos5l_decap_4
X_4736_ _4736_/Y _5101_/A _7578_/Q _7577_/Q _5100_/A _4735_/Y VPWR VGND sg13cmos5l_a221oi_1
X_7145__601 _7145_/RESET_B VPWR VGND sg13cmos5l_tiehi
X_4667_ _4694_/B _5102_/A _4667_/B VPWR VGND sg13cmos5l_xnor2_1
X_7455_ _7455_/Q _7510_/CLK _7455_/D _7455_/RESET_B VPWR VGND sg13cmos5l_dfrbpq_1
Xhold920 _3892_/A _7640_/Q VPWR VGND sg13cmos5l_dlygate4sd3_1
Xhold931 _4878_/B _4877_/Y VPWR VGND sg13cmos5l_dlygate4sd3_1
X_7386_ _7386_/Q clkload8/A _7386_/D _7386_/RESET_B VPWR VGND sg13cmos5l_dfrbpq_1
X_6406_ _6415_/A _6413_/B _6405_/Y _6402_/Y VPWR VGND sg13cmos5l_o21ai_1
X_6337_ _6350_/B _7346_/Q _7347_/Q _7348_/Q VPWR VGND sg13cmos5l_nor3_1
X_4598_ _4624_/C _7590_/Q _4616_/B _4617_/A VPWR VGND sg13cmos5l_o21ai_1
Xhold942 _3943_/A _7202_/Q VPWR VGND sg13cmos5l_dlygate4sd3_1
Xhold953 _4783_/A _7593_/Q VPWR VGND sg13cmos5l_dlygate4sd3_1
Xhold964 _6629_/B _7427_/Q VPWR VGND sg13cmos5l_dlygate4sd3_1
Xhold975 _5545_/B _7220_/Q VPWR VGND sg13cmos5l_dlygate4sd3_1
XFILLER_0_105 VPWR VGND sg13cmos5l_fill_2
Xhold997 hold997/X _5761_/Y VPWR VGND sg13cmos5l_dlygate4sd3_1
Xhold986 hold986/X _4340_/Y VPWR VGND sg13cmos5l_dlygate4sd3_1
X_6268_ _6268_/Y _6299_/B _6268_/B VPWR VGND sg13cmos5l_nand2b_1
X_5219_ _5336_/A _5208_/X _5217_/Y _5218_/X _5229_/S VPWR VGND sg13cmos5l_a22oi_1
X_6199_ _6199_/Y _7330_/Q _7300_/Q VPWR VGND sg13cmos5l_xnor2_1
XFILLER_25_540 VPWR VGND sg13cmos5l_fill_2
XFILLER_25_573 VPWR VGND sg13cmos5l_decap_4
XFILLER_9_728 VPWR VGND sg13cmos5l_fill_2
XFILLER_5_945 VPWR VGND sg13cmos5l_decap_8
XFILLER_4_488 VPWR VGND sg13cmos5l_fill_1
XFILLER_10_8 VPWR VGND sg13cmos5l_fill_1
X_7491__392 _7491_/RESET_B VPWR VGND sg13cmos5l_tiehi
XFILLER_36_849 VPWR VGND sg13cmos5l_fill_1
XFILLER_16_595 VPWR VGND sg13cmos5l_decap_4
X_5570_ _5570_/Y _5566_/Y _5568_/Y _5569_/Y VPWR VGND sg13cmos5l_o21ai_1
X_4521_ _4521_/Y _4784_/A _4013_/Y _4316_/A _7593_/Q VPWR VGND sg13cmos5l_a22oi_1
X_4452_ _4462_/B _4439_/Y _4447_/Y _4450_/Y VPWR VGND sg13cmos5l_a21o_1
X_7240_ _7240_/Q _7277_/CLK _7240_/D _7240_/RESET_B VPWR VGND sg13cmos5l_dfrbpq_1
XFILLER_7_293 VPWR VGND sg13cmos5l_decap_4
X_4383_ _4383_/Y _7554_/Q _4402_/B VPWR VGND sg13cmos5l_nand2_1
X_7171_ _7171_/Q _7214_/CLK _7171_/D _7171_/RESET_B VPWR VGND sg13cmos5l_dfrbpq_1
X_6122_ _6122_/X _6122_/A _6122_/B VPWR VGND sg13cmos5l_or2_1
X_6053_ _6061_/C _6046_/Y _6049_/A _6052_/Y VPWR VGND sg13cmos5l_o21ai_1
X_5004_ _5004_/Y _7630_/Q _7605_/Q VPWR VGND sg13cmos5l_nor2_1
XFILLER_26_337 VPWR VGND sg13cmos5l_fill_2
X_6955_ _6955_/Y _6955_/A _6955_/B VPWR VGND sg13cmos5l_nor2_1
XFILLER_41_329 VPWR VGND sg13cmos5l_fill_2
X_5906_ _5930_/A _7250_/Q _5907_/B VPWR VGND sg13cmos5l_xor2_1
XFILLER_22_510 VPWR VGND sg13cmos5l_fill_2
XFILLER_22_543 VPWR VGND sg13cmos5l_fill_2
X_6886_ _7457_/D _6886_/A _6885_/Y VPWR VGND sg13cmos5l_nor2b_1
X_5837_ _5837_/Y _5789_/X _5844_/S _5774_/B VPWR VGND sg13cmos5l_o21ai_1
XFILLER_10_738 VPWR VGND sg13cmos5l_fill_1
X_5768_ _5768_/Y _7262_/Q _5769_/A2 _5555_/A VPWR VGND sg13cmos5l_o21ai_1
X_7507_ _7507_/Q _7560_/CLK _7507_/D _7507_/RESET_B VPWR VGND sg13cmos5l_dfrbpq_1
X_7249__488 _7249_/RESET_B VPWR VGND sg13cmos5l_tiehi
X_4719_ _4791_/A _4704_/A _4456_/Y _4726_/S VPWR VGND sg13cmos5l_mux2_1
X_7438_ _7438_/Q _7489_/CLK _7438_/D _7438_/RESET_B VPWR VGND sg13cmos5l_dfrbpq_1
X_5699_ _5704_/A _5703_/A _5703_/B _5693_/X _5697_/Y _5698_/X VPWR VGND sg13cmos5l_a221oi_1
XFILLER_2_915 VPWR VGND sg13cmos5l_decap_4
X_7369_ _7369_/Q _7375_/CLK _7369_/D _7369_/RESET_B VPWR VGND sg13cmos5l_dfrbpq_1
XFILLER_2_948 VPWR VGND sg13cmos5l_decap_8
Xhold761 _5094_/B _7621_/Q VPWR VGND sg13cmos5l_dlygate4sd3_1
Xhold772 _6659_/B _7389_/Q VPWR VGND sg13cmos5l_dlygate4sd3_1
Xhold794 _5326_/B _7152_/Q VPWR VGND sg13cmos5l_dlygate4sd3_1
Xhold783 _4342_/B _7509_/Q VPWR VGND sg13cmos5l_dlygate4sd3_1
XFILLER_49_429 VPWR VGND sg13cmos5l_decap_8
XFILLER_18_816 VPWR VGND sg13cmos5l_fill_1
XFILLER_45_646 VPWR VGND sg13cmos5l_decap_8
XFILLER_17_337 VPWR VGND sg13cmos5l_fill_1
XFILLER_45_657 VPWR VGND sg13cmos5l_fill_1
XFILLER_44_167 VPWR VGND sg13cmos5l_fill_2
XFILLER_41_852 VPWR VGND sg13cmos5l_fill_1
XFILLER_41_841 VPWR VGND sg13cmos5l_decap_8
XFILLER_9_503 VPWR VGND sg13cmos5l_decap_8
XFILLER_40_373 VPWR VGND sg13cmos5l_decap_8
X_7605__688 _7605_/RESET_B VPWR VGND sg13cmos5l_tiehi
X_7575__721 _7575_/RESET_B VPWR VGND sg13cmos5l_tiehi
XFILLER_0_491 VPWR VGND sg13cmos5l_fill_2
XFILLER_49_974 VPWR VGND sg13cmos5l_decap_8
X_7135__611 _7135_/RESET_B VPWR VGND sg13cmos5l_tiehi
XFILLER_36_679 VPWR VGND sg13cmos5l_fill_2
X_6740_ _6740_/Y _6728_/B _6724_/C _6738_/S VPWR VGND sg13cmos5l_a21oi_1
XFILLER_23_329 VPWR VGND sg13cmos5l_fill_1
X_3952_ _5100_/A _3952_/A VPWR VGND sg13cmos5l_inv_1
X_3883_ _6143_/B _3883_/A VPWR VGND sg13cmos5l_inv_1
X_6671_ _6696_/B _7417_/Q _7390_/Q _7422_/Q VPWR VGND sg13cmos5l_nand3_1
X_5622_ _5622_/Y _5622_/A _5622_/B _5622_/C VPWR VGND sg13cmos5l_nor3_1
X_5553_ _7225_/D _3886_/Y _5984_/A2 _5552_/Y VPWR VGND sg13cmos5l_a21oi_1
X_4504_ _4577_/C _4257_/Y _4512_/B _4508_/A _4503_/X VPWR VGND sg13cmos5l_a22oi_1
X_5484_ _5488_/A _5478_/X _5479_/Y _5482_/Y _5196_/Y _5483_/Y VPWR VGND sg13cmos5l_a221oi_1
X_8272_ _8272_/X _8272_/A VPWR VGND sg13cmos5l_buf_1
X_4435_ _4435_/Y _4434_/Y _4460_/A VPWR VGND sg13cmos5l_nand2b_1
X_7142__604 _7142_/RESET_B VPWR VGND sg13cmos5l_tiehi
X_7223_ _7223_/Q _7611_/CLK _7223_/D _7223_/RESET_B VPWR VGND sg13cmos5l_dfrbpq_1
X_4366_ _4400_/S _4362_/X _4364_/Y _4365_/Y VPWR VGND sg13cmos5l_a21oi_1
X_7154_ _7154_/Q _7611_/CLK _7154_/D _7154_/RESET_B VPWR VGND sg13cmos5l_dfrbpq_1
X_6105_ _6105_/Y _7339_/Q _6114_/B _6122_/B VPWR VGND sg13cmos5l_nand3_1
X_4297_ _4297_/Y _4298_/A _4297_/B VPWR VGND sg13cmos5l_nor2_1
X_7085_ _7085_/Y _7085_/A VPWR VGND sg13cmos5l_inv_1
XFILLER_39_451 VPWR VGND sg13cmos5l_decap_4
X_6036_ _6055_/A _6036_/A _6036_/B VPWR VGND sg13cmos5l_and2_1
XFILLER_39_484 VPWR VGND sg13cmos5l_fill_2
X_6938_ _6938_/X _6939_/A _6939_/B VPWR VGND sg13cmos5l_and2_1
XFILLER_41_115 VPWR VGND sg13cmos5l_decap_4
XFILLER_23_841 VPWR VGND sg13cmos5l_fill_2
XFILLER_25_46 VPWR VGND sg13cmos5l_decap_4
X_6869_ _6869_/Y _6879_/A VPWR VGND sg13cmos5l_inv_1
XFILLER_10_513 VPWR VGND sg13cmos5l_decap_4
XFILLER_10_557 VPWR VGND sg13cmos5l_fill_1
XFILLER_2_756 VPWR VGND sg13cmos5l_fill_2
XFILLER_49_215 VPWR VGND sg13cmos5l_fill_2
XFILLER_46_944 VPWR VGND sg13cmos5l_decap_8
XFILLER_45_454 VPWR VGND sg13cmos5l_decap_4
Xhold1280 _4243_/A _7530_/Q VPWR VGND sg13cmos5l_dlygate4sd3_1
Xhold1291 _7458_/D _6889_/Y VPWR VGND sg13cmos5l_dlygate4sd3_1
XFILLER_17_156 VPWR VGND sg13cmos5l_fill_2
XFILLER_14_830 VPWR VGND sg13cmos5l_fill_2
XFILLER_32_126 VPWR VGND sg13cmos5l_fill_2
XFILLER_32_137 VPWR VGND sg13cmos5l_decap_4
XFILLER_13_362 VPWR VGND sg13cmos5l_decap_4
XFILLER_14_896 VPWR VGND sg13cmos5l_decap_8
XFILLER_9_377 VPWR VGND sg13cmos5l_fill_2
X_7378__325 _7378_/RESET_B VPWR VGND sg13cmos5l_tiehi
XFILLER_49_4 VPWR VGND sg13cmos5l_decap_4
X_4220_ _4241_/B _7559_/Q _7558_/Q _4571_/A VPWR VGND sg13cmos5l_nor3_1
XFILLER_5_594 VPWR VGND sg13cmos5l_decap_4
X_4151_ _4151_/Y _7068_/B VPWR VGND sg13cmos5l_inv_1
X_4082_ _7515_/D _7106_/A _4171_/B VPWR VGND sg13cmos5l_and2_1
XFILLER_49_793 VPWR VGND sg13cmos5l_fill_2
XFILLER_37_944 VPWR VGND sg13cmos5l_fill_2
X_7239__498 _7239_/RESET_B VPWR VGND sg13cmos5l_tiehi
XFILLER_36_443 VPWR VGND sg13cmos5l_fill_2
XFILLER_36_454 VPWR VGND sg13cmos5l_fill_1
X_4984_ _7131_/D _5038_/A _5105_/A VPWR VGND sg13cmos5l_nor2_1
X_6723_ _6723_/Y _6720_/Y _6721_/Y _6722_/Y _7004_/A VPWR VGND sg13cmos5l_a22oi_1
X_3935_ _5991_/A _3935_/A VPWR VGND sg13cmos5l_inv_1
XFILLER_23_159 VPWR VGND sg13cmos5l_fill_1
X_6654_ _6654_/Y hold898/X _6657_/A2 _6507_/A VPWR VGND sg13cmos5l_o21ai_1
X_5605_ _5605_/Y _5612_/A _5612_/B _5601_/A _5601_/B VPWR VGND sg13cmos5l_a22oi_1
X_3866_ _3866_/Y _7505_/Q VPWR VGND sg13cmos5l_inv_1
X_6585_ _6682_/A _6561_/Y _6772_/A _6588_/S VPWR VGND sg13cmos5l_mux2_1
XFILLER_20_899 VPWR VGND sg13cmos5l_fill_1
X_5536_ _5541_/S _5536_/A _5536_/B VPWR VGND sg13cmos5l_nor2_1
XFILLER_3_509 VPWR VGND sg13cmos5l_decap_8
X_5467_ _7208_/D _5542_/A _5467_/B VPWR VGND sg13cmos5l_nor2_1
X_4418_ _7559_/D _4390_/A _4409_/Y _4417_/Y VPWR VGND sg13cmos5l_a21oi_1
X_7206_ _7206_/Q _7277_/CLK _7206_/D _7206_/RESET_B VPWR VGND sg13cmos5l_dfrbpq_1
X_5398_ _5406_/B _5368_/A _5364_/Y _5395_/Y _5397_/Y VPWR VGND sg13cmos5l_a22oi_1
X_7137_ _7137_/Q _7610_/CLK _7137_/D _7137_/RESET_B VPWR VGND sg13cmos5l_dfrbpq_1
X_4349_ _4349_/Y _4375_/A _5323_/A2 _4569_/A VPWR VGND sg13cmos5l_o21ai_1
X_7068_ _7495_/D _7071_/A _7068_/B VPWR VGND sg13cmos5l_nor2_1
X_6019_ _6052_/A _6047_/B _6047_/C _6047_/A VPWR VGND sg13cmos5l_a21oi_1
XFILLER_28_944 VPWR VGND sg13cmos5l_fill_1
X_7565__731 _7565_/RESET_B VPWR VGND sg13cmos5l_tiehi
XFILLER_14_159 VPWR VGND sg13cmos5l_decap_8
XFILLER_7_826 VPWR VGND sg13cmos5l_decap_8
XFILLER_6_303 VPWR VGND sg13cmos5l_decap_4
XFILLER_2_520 VPWR VGND sg13cmos5l_decap_8
X_7125__621 _7125_/RESET_B VPWR VGND sg13cmos5l_tiehi
XFILLER_2_553 VPWR VGND sg13cmos5l_fill_1
X_7572__724 _7572_/RESET_B VPWR VGND sg13cmos5l_tiehi
X_7132__614 _7132_/RESET_B VPWR VGND sg13cmos5l_tiehi
XFILLER_9_163 VPWR VGND sg13cmos5l_fill_2
X_6370_ _6370_/Y _6508_/A _7371_/Q VPWR VGND sg13cmos5l_nor2_1
XFILLER_9_196 VPWR VGND sg13cmos5l_fill_2
X_5321_ _5321_/Y _3891_/Y _5325_/A2 _5320_/Y VPWR VGND sg13cmos5l_a21oi_1
XFILLER_6_892 VPWR VGND sg13cmos5l_decap_8
X_5252_ _5267_/B _5253_/A _5253_/B VPWR VGND sg13cmos5l_nand2_1
X_4203_ _4203_/Y _4203_/A _4203_/B VPWR VGND sg13cmos5l_xnor2_1
X_5183_ _5218_/A _7167_/Q _7168_/Q VPWR VGND sg13cmos5l_xnor2_1
X_4134_ _4160_/B _6971_/B _7491_/Q VPWR VGND sg13cmos5l_xnor2_1
XFILLER_3_1000 VPWR VGND sg13cmos5l_decap_8
X_4065_ _4066_/B input8/X input9/X _4058_/B VPWR VGND sg13cmos5l_a21oi_1
XFILLER_12_608 VPWR VGND sg13cmos5l_fill_2
X_7647__349 _7647_/RESET_B VPWR VGND sg13cmos5l_tiehi
XFILLER_40_939 VPWR VGND sg13cmos5l_decap_4
X_4967_ _4981_/B _5334_/A _4967_/B VPWR VGND sg13cmos5l_xnor2_1
X_6706_ _6707_/B _6692_/Y _6694_/B _6708_/S VPWR VGND sg13cmos5l_mux2_1
Xclkbuf_leaf_31_clk _7277_/CLK clkload0/A VPWR VGND sg13cmos5l_buf_8
X_4898_ _4898_/Y _4031_/C _4888_/B _4889_/A VPWR VGND sg13cmos5l_a21oi_1
X_3918_ _4041_/B input9/X VPWR VGND sg13cmos5l_inv_1
X_6637_ _6637_/Y _7410_/Q _6635_/Y _6632_/Y VPWR VGND sg13cmos5l_o21ai_1
X_6568_ _6575_/A _7428_/Q _6568_/B VPWR VGND sg13cmos5l_xor2_1
X_5519_ _5519_/Y _7240_/Q _5774_/A VPWR VGND sg13cmos5l_nor2b_1
X_6499_ _6499_/Y hold863/X _6500_/A2 _6505_/A VPWR VGND sg13cmos5l_o21ai_1
Xfanout131 _7111_/B1 fanout142/X VPWR VGND sg13cmos5l_buf_1
Xfanout120 _6108_/B _6507_/A VPWR VGND sg13cmos5l_buf_1
Xfanout142 fanout142/X input1/X VPWR VGND sg13cmos5l_buf_1
XFILLER_47_538 VPWR VGND sg13cmos5l_fill_2
XFILLER_19_229 VPWR VGND sg13cmos5l_fill_2
XFILLER_47_549 VPWR VGND sg13cmos5l_fill_2
XFILLER_43_711 VPWR VGND sg13cmos5l_decap_8
XFILLER_15_424 VPWR VGND sg13cmos5l_fill_1
X_7368__335 _7368_/RESET_B VPWR VGND sg13cmos5l_tiehi
XFILLER_15_479 VPWR VGND sg13cmos5l_fill_1
XFILLER_24_991 VPWR VGND sg13cmos5l_fill_2
Xclkbuf_leaf_22_clk _7611_/CLK clkbuf_3_4__f_clk/X VPWR VGND sg13cmos5l_buf_8
XFILLER_6_100 VPWR VGND sg13cmos5l_decap_8
XFILLER_7_667 VPWR VGND sg13cmos5l_decap_4
XFILLER_7_689 VPWR VGND sg13cmos5l_fill_1
X_7199__541 _7199_/RESET_B VPWR VGND sg13cmos5l_tiehi
X_7375__328 _7375_/RESET_B VPWR VGND sg13cmos5l_tiehi
XFILLER_38_538 VPWR VGND sg13cmos5l_fill_1
XFILLER_38_505 VPWR VGND sg13cmos5l_decap_4
XFILLER_46_593 VPWR VGND sg13cmos5l_fill_1
X_5870_ _5879_/B _7282_/Q _5871_/B VPWR VGND sg13cmos5l_nor2b_1
XFILLER_33_210 VPWR VGND sg13cmos5l_fill_1
X_4821_ _4840_/A _4821_/A _4845_/B _4821_/C VPWR VGND sg13cmos5l_nor3_1
XFILLER_15_980 VPWR VGND sg13cmos5l_fill_2
X_4752_ _4752_/Y _7612_/Q _4744_/B _4756_/B _7613_/Q VPWR VGND sg13cmos5l_a22oi_1
Xclkbuf_leaf_13_clk _7513_/CLK clkload4/A VPWR VGND sg13cmos5l_buf_8
X_7540_ _7540_/Q _7617_/CLK _7540_/D _7540_/RESET_B VPWR VGND sg13cmos5l_dfrbpq_1
X_7471_ _7471_/Q _7555_/CLK _7471_/D _7471_/RESET_B VPWR VGND sg13cmos5l_dfrbpq_1
X_4683_ _4684_/B _4672_/X _4681_/Y _4682_/X _4675_/Y VPWR VGND sg13cmos5l_a22oi_1
X_6422_ _7368_/D _6422_/A _6422_/B VPWR VGND sg13cmos5l_nor2_1
X_6353_ _6412_/A _6353_/A0 _6352_/Y _6356_/A VPWR VGND sg13cmos5l_mux2_1
X_6284_ _6299_/C _6276_/Y _6279_/Y _6282_/Y VPWR VGND sg13cmos5l_a21o_1
X_5304_ _5304_/Y _7182_/Q _5299_/Y _5303_/Y VPWR VGND sg13cmos5l_o21ai_1
X_5235_ _7171_/D _5314_/A _5335_/A VPWR VGND sg13cmos5l_nor2_1
X_7555__741 _7555_/RESET_B VPWR VGND sg13cmos5l_tiehi
X_5166_ _5176_/S _5160_/X _5164_/Y _5165_/X _5163_/A VPWR VGND sg13cmos5l_a22oi_1
X_4117_ _4158_/A _4117_/A _4117_/B VPWR VGND sg13cmos5l_nand2_1
X_5097_ _7155_/D _5097_/A _5102_/B VPWR VGND sg13cmos5l_nor2_1
XFILLER_17_36 VPWR VGND sg13cmos5l_fill_2
X_4048_ _7649_/D _4049_/B VPWR VGND sg13cmos5l_inv_1
XFILLER_13_906 VPWR VGND sg13cmos5l_decap_8
XFILLER_13_917 VPWR VGND sg13cmos5l_fill_1
X_5999_ _5999_/Y _5889_/B _5999_/B VPWR VGND sg13cmos5l_nand2b_1
XFILLER_40_758 VPWR VGND sg13cmos5l_decap_4
XFILLER_24_298 VPWR VGND sg13cmos5l_decap_8
X_7562__734 _7562_/RESET_B VPWR VGND sg13cmos5l_tiehi
XFILLER_4_659 VPWR VGND sg13cmos5l_decap_8
XFILLER_4_648 VPWR VGND sg13cmos5l_fill_1
XFILLER_0_810 VPWR VGND sg13cmos5l_fill_1
XFILLER_47_357 VPWR VGND sg13cmos5l_decap_8
XFILLER_43_552 VPWR VGND sg13cmos5l_fill_2
XFILLER_15_298 VPWR VGND sg13cmos5l_fill_2
XFILLER_31_747 VPWR VGND sg13cmos5l_fill_1
X_7463__632 _7463_/RESET_B VPWR VGND sg13cmos5l_tiehi
XFILLER_30_268 VPWR VGND sg13cmos5l_decap_4
XFILLER_8_943 VPWR VGND sg13cmos5l_decap_8
X_7381__321 _7381_/RESET_B VPWR VGND sg13cmos5l_tiehi
X_5020_ _5020_/Y _5020_/A _5020_/B VPWR VGND sg13cmos5l_nand2_1
Xhold1109 _6552_/A1 _6543_/A VPWR VGND sg13cmos5l_dlygate4sd3_1
Xclkbuf_leaf_2_clk clkload7/A clkbuf_leaf_5_clk/A VPWR VGND sg13cmos5l_buf_8
X_6971_ _6972_/B _6971_/A _6971_/B _6971_/C VPWR VGND sg13cmos5l_nand3_1
X_5922_ _7284_/D _5976_/A _5996_/A VPWR VGND sg13cmos5l_nor2_1
X_5853_ _5853_/Y _6193_/A _5853_/B VPWR VGND sg13cmos5l_xnor2_1
X_5784_ _5784_/Y _5679_/B _5810_/A _5783_/Y VPWR VGND sg13cmos5l_o21ai_1
X_4804_ _4804_/Y _7619_/Q _7585_/Q VPWR VGND sg13cmos5l_xnor2_1
X_7523_ _7523_/Q _7555_/CLK _7523_/D _7523_/RESET_B VPWR VGND sg13cmos5l_dfrbpq_1
X_4735_ _4735_/Y _7633_/Q _4753_/B _4749_/B _7632_/Q _4734_/Y VPWR VGND sg13cmos5l_a221oi_1
X_4666_ _4685_/B _7635_/Q _4667_/B VPWR VGND sg13cmos5l_xnor2_1
X_7454_ _7454_/Q _7510_/CLK _7454_/D _7454_/RESET_B VPWR VGND sg13cmos5l_dfrbpq_1
X_4597_ _4617_/A _7589_/Q _4611_/B _4604_/A VPWR VGND sg13cmos5l_a21o_1
Xhold921 hold921/X _4893_/Y VPWR VGND sg13cmos5l_dlygate4sd3_1
Xhold910 _4869_/B _4868_/Y VPWR VGND sg13cmos5l_dlygate4sd3_1
X_7385_ _7385_/Q _7651_/CLK _7385_/D _7385_/RESET_B VPWR VGND sg13cmos5l_dfrbpq_1
X_6405_ _6405_/Y _6409_/A _6409_/B VPWR VGND sg13cmos5l_nand2_1
X_6336_ _6348_/A _7369_/Q _7370_/Q VPWR VGND sg13cmos5l_xnor2_1
Xhold943 _6352_/A _7368_/Q VPWR VGND sg13cmos5l_dlygate4sd3_1
Xhold932 _7638_/D _4878_/Y VPWR VGND sg13cmos5l_dlygate4sd3_1
Xhold954 _6820_/B _7414_/Q VPWR VGND sg13cmos5l_dlygate4sd3_1
Xhold976 hold976/X _5545_/Y VPWR VGND sg13cmos5l_dlygate4sd3_1
Xhold998 _3986_/A _7219_/Q VPWR VGND sg13cmos5l_dlygate4sd3_1
Xhold965 _3883_/A _7292_/Q VPWR VGND sg13cmos5l_dlygate4sd3_1
Xhold987 _7542_/D _4341_/Y VPWR VGND sg13cmos5l_dlygate4sd3_1
X_7475__514 _7475_/RESET_B VPWR VGND sg13cmos5l_tiehi
X_6267_ _6299_/B _5887_/A _6263_/Y _6266_/Y VPWR VGND sg13cmos5l_a21oi_1
X_5218_ _5218_/X _5218_/A _5228_/B VPWR VGND sg13cmos5l_and2_1
X_6198_ _6198_/Y _7331_/Q _7301_/Q VPWR VGND sg13cmos5l_xnor2_1
XFILLER_28_13 VPWR VGND sg13cmos5l_fill_1
X_5149_ _5149_/Y _5144_/Y _5170_/B _5148_/Y VPWR VGND sg13cmos5l_o21ai_1
XFILLER_45_828 VPWR VGND sg13cmos5l_fill_2
X_7189__551 _7189_/RESET_B VPWR VGND sg13cmos5l_tiehi
X_7365__338 _7365_/RESET_B VPWR VGND sg13cmos5l_tiehi
XFILLER_4_467 VPWR VGND sg13cmos5l_fill_1
XFILLER_0_640 VPWR VGND sg13cmos5l_decap_8
X_7196__544 _7196_/RESET_B VPWR VGND sg13cmos5l_tiehi
XFILLER_48_666 VPWR VGND sg13cmos5l_decap_4
XFILLER_47_198 VPWR VGND sg13cmos5l_fill_1
XFILLER_35_327 VPWR VGND sg13cmos5l_fill_1
XFILLER_18_90 VPWR VGND sg13cmos5l_decap_8
XFILLER_31_500 VPWR VGND sg13cmos5l_fill_1
XFILLER_43_393 VPWR VGND sg13cmos5l_decap_8
XFILLER_31_544 VPWR VGND sg13cmos5l_fill_1
XFILLER_8_751 VPWR VGND sg13cmos5l_fill_2
X_4520_ _4520_/Y _4787_/A _7542_/Q VPWR VGND sg13cmos5l_nor2_1
X_4451_ _4451_/Y _4439_/Y _4447_/Y _4450_/Y VPWR VGND sg13cmos5l_a21oi_1
X_7170_ _7170_/Q _7214_/CLK _7170_/D _7170_/RESET_B VPWR VGND sg13cmos5l_dfrbpq_1
X_4382_ _4390_/A _4382_/A VPWR VGND sg13cmos5l_inv_1
X_6121_ _7318_/D _6192_/B _6279_/A VPWR VGND sg13cmos5l_and2_1
X_6052_ _6052_/Y _6052_/A _6052_/B VPWR VGND sg13cmos5l_nand2_1
X_5003_ _5003_/Y _7631_/Q _7606_/Q VPWR VGND sg13cmos5l_nand2b_1
X_7552__744 _7552_/RESET_B VPWR VGND sg13cmos5l_tiehi
XFILLER_38_165 VPWR VGND sg13cmos5l_fill_1
XFILLER_42_809 VPWR VGND sg13cmos5l_fill_1
X_6954_ _7469_/D _7006_/B _7042_/A VPWR VGND sg13cmos5l_and2_1
X_5905_ _5910_/B _7250_/Q _7249_/Q _7247_/Q _7248_/Q VPWR VGND sg13cmos5l_nor4_1
X_6885_ _6885_/Y _6843_/X _6890_/S _6889_/A VPWR VGND sg13cmos5l_a21oi_1
XFILLER_34_371 VPWR VGND sg13cmos5l_fill_2
X_5836_ _5844_/S _5833_/A _5805_/Y _5830_/Y _5834_/Y _5835_/Y VPWR VGND sg13cmos5l_a221oi_1
XFILLER_10_728 VPWR VGND sg13cmos5l_fill_1
XFILLER_22_588 VPWR VGND sg13cmos5l_fill_1
X_5767_ _7261_/D _3887_/Y _5769_/A2 _5766_/Y VPWR VGND sg13cmos5l_a21oi_1
X_5698_ _5698_/X _5698_/A _5698_/B _5698_/C VPWR VGND sg13cmos5l_and3_1
X_4718_ _4726_/S _4715_/Y _4716_/Y _4729_/B VPWR VGND sg13cmos5l_o21ai_1
X_7506_ _7506_/Q _7553_/CLK _7506_/D _7506_/RESET_B VPWR VGND sg13cmos5l_dfrbpq_1
X_7437_ _7437_/Q _7489_/CLK _7437_/D _7437_/RESET_B VPWR VGND sg13cmos5l_dfrbpq_1
X_4649_ _4649_/Y _7600_/Q _7599_/Q _7630_/Q VPWR VGND sg13cmos5l_nand3b_1
X_7368_ _7368_/Q _7375_/CLK _7368_/D _7368_/RESET_B VPWR VGND sg13cmos5l_dfrbpq_1
XFILLER_2_927 VPWR VGND sg13cmos5l_decap_8
Xhold762 _5095_/B _7622_/Q VPWR VGND sg13cmos5l_dlygate4sd3_1
Xhold773 _4781_/B _7585_/Q VPWR VGND sg13cmos5l_dlygate4sd3_1
XFILLER_1_437 VPWR VGND sg13cmos5l_fill_1
X_6319_ _7339_/D _6325_/A _6319_/B _6319_/C VPWR VGND sg13cmos5l_nor3_1
X_7299_ _7299_/Q _7332_/CLK _7299_/D _7299_/RESET_B VPWR VGND sg13cmos5l_dfrbpq_1
Xhold784 _7001_/B _7450_/Q VPWR VGND sg13cmos5l_dlygate4sd3_1
Xhold795 _4375_/B _7515_/Q VPWR VGND sg13cmos5l_dlygate4sd3_1
XFILLER_7_1009 VPWR VGND sg13cmos5l_decap_8
XFILLER_29_143 VPWR VGND sg13cmos5l_fill_1
XFILLER_32_308 VPWR VGND sg13cmos5l_fill_2
XFILLER_32_319 VPWR VGND sg13cmos5l_fill_2
XFILLER_26_894 VPWR VGND sg13cmos5l_fill_2
XFILLER_45_1004 VPWR VGND sg13cmos5l_fill_1
XFILLER_49_953 VPWR VGND sg13cmos5l_decap_8
XFILLER_1_982 VPWR VGND sg13cmos5l_decap_8
XFILLER_36_614 VPWR VGND sg13cmos5l_decap_8
XFILLER_17_883 VPWR VGND sg13cmos5l_decap_8
X_3951_ _5101_/A _3951_/A VPWR VGND sg13cmos5l_inv_1
XFILLER_35_179 VPWR VGND sg13cmos5l_decap_8
XFILLER_44_680 VPWR VGND sg13cmos5l_decap_4
X_3882_ _6156_/B _3882_/A VPWR VGND sg13cmos5l_inv_1
X_6670_ _6696_/A _7423_/Q _6677_/B VPWR VGND sg13cmos5l_xnor2_1
X_5621_ _5622_/C _5621_/A _5621_/B VPWR VGND sg13cmos5l_nor2_1
X_5552_ _5552_/Y hold862/X _5984_/A2 _5555_/A VPWR VGND sg13cmos5l_o21ai_1
X_4503_ _4503_/X _4503_/A _4513_/B VPWR VGND sg13cmos5l_and2_1
X_5483_ _5483_/Y _5483_/A _5501_/A VPWR VGND sg13cmos5l_nor2_1
X_7222_ _7222_/Q _7332_/CLK _7222_/D _7222_/RESET_B VPWR VGND sg13cmos5l_dfrbpq_1
X_4434_ _4434_/Y _7593_/Q _7562_/Q VPWR VGND sg13cmos5l_nand2_1
X_4365_ _4365_/Y _4268_/B _4298_/X _4272_/B VPWR VGND sg13cmos5l_o21ai_1
X_7153_ _7153_/Q _7611_/CLK _7153_/D _7153_/RESET_B VPWR VGND sg13cmos5l_dfrbpq_1
X_6104_ _6104_/Y _6114_/B _6122_/B VPWR VGND sg13cmos5l_nand2_1
X_7084_ _7085_/A _7084_/A _7084_/B VPWR VGND sg13cmos5l_nand2_1
X_4296_ _4298_/B _4296_/A _4296_/B _4296_/C VPWR VGND sg13cmos5l_nor3_1
X_6035_ _6036_/B _6048_/B _6035_/B VPWR VGND sg13cmos5l_nor2_1
XFILLER_39_430 VPWR VGND sg13cmos5l_decap_8
XFILLER_42_617 VPWR VGND sg13cmos5l_fill_2
X_7255__482 _7255_/RESET_B VPWR VGND sg13cmos5l_tiehi
X_6937_ _6939_/B _6937_/A _6955_/A VPWR VGND sg13cmos5l_nand2_1
X_6868_ _6879_/A _6868_/A _6868_/B _6868_/C VPWR VGND sg13cmos5l_or3_1
X_5819_ _5819_/Y _5833_/B _5819_/B _5819_/C VPWR VGND sg13cmos5l_nand3b_1
XFILLER_22_363 VPWR VGND sg13cmos5l_fill_2
XFILLER_41_24 VPWR VGND sg13cmos5l_decap_8
X_6799_ _6800_/D _6813_/B _6799_/B VPWR VGND sg13cmos5l_nand2_1
XFILLER_2_724 VPWR VGND sg13cmos5l_fill_1
X_7399__297 _7399_/RESET_B VPWR VGND sg13cmos5l_tiehi
XFILLER_49_238 VPWR VGND sg13cmos5l_fill_1
XFILLER_18_614 VPWR VGND sg13cmos5l_fill_1
X_7193__547 _7193_/RESET_B VPWR VGND sg13cmos5l_tiehi
Xhold1270 _6523_/A _7394_/Q VPWR VGND sg13cmos5l_dlygate4sd3_1
Xhold1281 _6749_/A _7407_/Q VPWR VGND sg13cmos5l_dlygate4sd3_1
Xhold1292 _4704_/B _7569_/Q VPWR VGND sg13cmos5l_dlygate4sd3_1
X_7611__682 _7611_/RESET_B VPWR VGND sg13cmos5l_tiehi
XFILLER_25_190 VPWR VGND sg13cmos5l_decap_8
XFILLER_12_1014 VPWR VGND sg13cmos5l_decap_8
X_4150_ _7068_/B _4355_/A _4116_/B _4115_/B _4106_/Y VPWR VGND sg13cmos5l_a22oi_1
X_4081_ _7514_/D _7002_/A _4081_/B VPWR VGND sg13cmos5l_and2_1
XFILLER_37_934 VPWR VGND sg13cmos5l_decap_4
XFILLER_37_989 VPWR VGND sg13cmos5l_fill_1
X_4983_ _5105_/A _4972_/X _4981_/Y _4982_/X _4975_/Y VPWR VGND sg13cmos5l_a22oi_1
X_6722_ _6722_/Y _7431_/Q _7430_/Q _7457_/Q VPWR VGND sg13cmos5l_nand3b_1
X_3934_ _5992_/A _3934_/A VPWR VGND sg13cmos5l_inv_1
X_6653_ _7415_/D _3870_/Y _6653_/A2 _6652_/Y VPWR VGND sg13cmos5l_a21oi_1
X_3865_ _3865_/Y _3865_/A VPWR VGND sg13cmos5l_inv_1
X_5604_ _5604_/Y _5604_/A _5603_/Y VPWR VGND sg13cmos5l_nor2b_1
X_6584_ _6772_/A _6831_/A _6767_/A VPWR VGND sg13cmos5l_and2_1
X_5535_ _5536_/B _5545_/B _5533_/Y _5728_/B VPWR VGND sg13cmos5l_o21ai_1
XFILLER_11_49 VPWR VGND sg13cmos5l_decap_4
X_5466_ _5614_/A _5467_/B VPWR VGND sg13cmos5l_inv_1
X_4417_ _4417_/Y _4390_/B _4409_/Y _4357_/B VPWR VGND sg13cmos5l_o21ai_1
X_7205_ _7205_/Q _7277_/CLK _7205_/D _7205_/RESET_B VPWR VGND sg13cmos5l_dfrbpq_1
X_5397_ _5397_/Y _5390_/Y _5393_/X _5400_/B _5400_/A VPWR VGND sg13cmos5l_a22oi_1
X_7136_ _7136_/Q _7610_/CLK _7136_/D _7136_/RESET_B VPWR VGND sg13cmos5l_dfrbpq_1
X_4348_ _7546_/D _3862_/Y _5325_/A2 _4347_/Y VPWR VGND sg13cmos5l_a21oi_1
X_4279_ _4279_/Y _7524_/Q _4296_/B _7503_/Q VPWR VGND sg13cmos5l_a21oi_1
X_7067_ _7494_/D _7067_/A1 _4117_/B _7071_/A VPWR VGND sg13cmos5l_a21oi_1
X_6018_ _6047_/C _7306_/Q _6039_/B _6040_/A VPWR VGND sg13cmos5l_o21ai_1
XFILLER_36_46 VPWR VGND sg13cmos5l_fill_1
XFILLER_43_926 VPWR VGND sg13cmos5l_decap_8
XFILLER_10_300 VPWR VGND sg13cmos5l_decap_8
XFILLER_35_1014 VPWR VGND sg13cmos5l_decap_8
XFILLER_11_889 VPWR VGND sg13cmos5l_decap_8
XFILLER_6_337 VPWR VGND sg13cmos5l_fill_1
XFILLER_2_543 VPWR VGND sg13cmos5l_fill_1
XFILLER_18_444 VPWR VGND sg13cmos5l_fill_1
XFILLER_34_959 VPWR VGND sg13cmos5l_fill_1
XFILLER_33_447 VPWR VGND sg13cmos5l_decap_4
XFILLER_42_970 VPWR VGND sg13cmos5l_fill_1
X_7488__398 _7488_/RESET_B VPWR VGND sg13cmos5l_tiehi
XFILLER_13_171 VPWR VGND sg13cmos5l_decap_8
XFILLER_6_882 VPWR VGND sg13cmos5l_decap_4
X_5320_ _5320_/Y _7186_/Q _5325_/A2 _5326_/A VPWR VGND sg13cmos5l_o21ai_1
X_7245__492 _7245_/RESET_B VPWR VGND sg13cmos5l_tiehi
X_5251_ _5253_/B _5251_/A _7141_/Q _5251_/C VPWR VGND sg13cmos5l_nand3_1
X_4202_ _4203_/B _7519_/Q _4207_/B VPWR VGND sg13cmos5l_xnor2_1
X_5182_ _5182_/X _5189_/B _5187_/C _5221_/A VPWR VGND sg13cmos5l_a21o_1
X_4133_ _4140_/B _7468_/Q _7467_/Q _7469_/Q VPWR VGND sg13cmos5l_o21ai_1
XFILLER_29_709 VPWR VGND sg13cmos5l_fill_1
X_4064_ _4066_/A _4064_/A _4064_/B VPWR VGND sg13cmos5l_nand2_1
XFILLER_28_219 VPWR VGND sg13cmos5l_fill_1
XFILLER_37_764 VPWR VGND sg13cmos5l_fill_1
XFILLER_25_948 VPWR VGND sg13cmos5l_fill_2
X_7252__485 _7252_/RESET_B VPWR VGND sg13cmos5l_tiehi
X_6705_ _7425_/D _6705_/A _6703_/Y VPWR VGND sg13cmos5l_nor2b_1
X_4966_ _4993_/B _7166_/Q _4967_/B VPWR VGND sg13cmos5l_xnor2_1
XFILLER_11_119 VPWR VGND sg13cmos5l_fill_2
X_4897_ _4897_/Y _4885_/X _4897_/B VPWR VGND sg13cmos5l_nand2b_1
X_3917_ _4901_/A _7649_/Q VPWR VGND sg13cmos5l_inv_1
X_6636_ _6636_/Y _6789_/B _6628_/Y _6635_/Y _7410_/Q VPWR VGND sg13cmos5l_a22oi_1
X_6567_ _6761_/A _7428_/Q _6568_/B VPWR VGND sg13cmos5l_xnor2_1
X_5518_ _5518_/Y _7184_/Q _5518_/B _5527_/C VPWR VGND sg13cmos5l_nor3_1
X_6498_ _7384_/D _6505_/A _6498_/B VPWR VGND sg13cmos5l_and2_1
X_5449_ _7204_/D _5449_/A _5560_/B VPWR VGND sg13cmos5l_nor2_1
X_7601__692 _7601_/RESET_B VPWR VGND sg13cmos5l_tiehi
Xfanout110 _5672_/A _7273_/Q VPWR VGND sg13cmos5l_buf_1
Xfanout121 _6391_/B1 _6507_/A VPWR VGND sg13cmos5l_buf_1
X_7119_ _7119_/Q _7424_/CLK _7119_/D _7119_/RESET_B VPWR VGND sg13cmos5l_dfrbpq_1
Xfanout132 _7113_/A _7002_/A VPWR VGND sg13cmos5l_buf_1
XFILLER_19_219 VPWR VGND sg13cmos5l_decap_4
XFILLER_16_937 VPWR VGND sg13cmos5l_fill_1
XFILLER_27_263 VPWR VGND sg13cmos5l_fill_2
XFILLER_42_255 VPWR VGND sg13cmos5l_decap_4
XFILLER_42_277 VPWR VGND sg13cmos5l_fill_2
XFILLER_42_266 VPWR VGND sg13cmos5l_fill_1
XFILLER_8_39 VPWR VGND sg13cmos5l_decap_8
XFILLER_11_631 VPWR VGND sg13cmos5l_decap_4
XFILLER_11_642 VPWR VGND sg13cmos5l_fill_1
XFILLER_10_130 VPWR VGND sg13cmos5l_decap_4
XFILLER_10_152 VPWR VGND sg13cmos5l_decap_8
XFILLER_7_635 VPWR VGND sg13cmos5l_decap_8
XFILLER_10_185 VPWR VGND sg13cmos5l_decap_8
XFILLER_6_145 VPWR VGND sg13cmos5l_fill_1
XFILLER_6_178 VPWR VGND sg13cmos5l_decap_8
XFILLER_3_863 VPWR VGND sg13cmos5l_fill_2
XFILLER_3_852 VPWR VGND sg13cmos5l_decap_8
XFILLER_46_561 VPWR VGND sg13cmos5l_decap_8
XFILLER_18_263 VPWR VGND sg13cmos5l_decap_4
X_4820_ _4821_/C _4820_/A _4831_/C _4820_/C VPWR VGND sg13cmos5l_and3_1
X_4751_ _4756_/B _4745_/B _4749_/Y _4750_/Y VPWR VGND sg13cmos5l_a21oi_1
X_7470_ _7470_/Q _7489_/CLK _7470_/D _7470_/RESET_B VPWR VGND sg13cmos5l_dfrbpq_1
X_4682_ _4682_/X _4682_/A _4682_/B VPWR VGND sg13cmos5l_and2_1
X_6421_ _6422_/B _6412_/Y _6423_/A _6396_/B VPWR VGND sg13cmos5l_o21ai_1
X_6352_ _6352_/Y _6352_/A _6355_/B VPWR VGND sg13cmos5l_nand2_1
X_6283_ _6293_/C _6276_/Y _6279_/Y _6282_/Y VPWR VGND sg13cmos5l_a21oi_1
X_5303_ _5303_/Y _5301_/Y _5302_/Y _5296_/Y VPWR VGND sg13cmos5l_o21ai_1
X_5234_ _5396_/A _5335_/A VPWR VGND sg13cmos5l_inv_1
X_5165_ _5165_/X _5137_/A _5133_/Y _5163_/B VPWR VGND sg13cmos5l_a21o_1
X_4116_ _4117_/B _4116_/A _4116_/B VPWR VGND sg13cmos5l_nand2_1
X_5096_ _7154_/D _5096_/A _5119_/B VPWR VGND sg13cmos5l_and2_1
X_4047_ _4049_/B _4046_/Y _6108_/B VPWR VGND sg13cmos5l_nand2b_1
X_5998_ _5998_/Y _5889_/B _5928_/Y _5995_/Y _5996_/Y _5997_/Y VPWR VGND sg13cmos5l_a221oi_1
X_4949_ _4949_/Y _7161_/Q _7130_/Q VPWR VGND sg13cmos5l_nand2_1
XFILLER_12_439 VPWR VGND sg13cmos5l_decap_4
XFILLER_20_450 VPWR VGND sg13cmos5l_decap_4
XFILLER_32_1006 VPWR VGND sg13cmos5l_fill_2
X_6619_ _6619_/Y _6633_/B _7426_/Q _7425_/Q _6626_/B VPWR VGND sg13cmos5l_a22oi_1
X_7599_ _7599_/Q _7634_/CLK _7599_/D _7599_/RESET_B VPWR VGND sg13cmos5l_dfrbpq_1
XFILLER_47_303 VPWR VGND sg13cmos5l_fill_2
XFILLER_47_325 VPWR VGND sg13cmos5l_fill_2
XFILLER_47_336 VPWR VGND sg13cmos5l_fill_2
XFILLER_28_550 VPWR VGND sg13cmos5l_fill_2
XFILLER_12_995 VPWR VGND sg13cmos5l_fill_1
XFILLER_48_1024 VPWR VGND sg13cmos5l_decap_4
XFILLER_3_671 VPWR VGND sg13cmos5l_fill_2
X_7242__495 _7242_/RESET_B VPWR VGND sg13cmos5l_tiehi
XFILLER_24_4 VPWR VGND sg13cmos5l_decap_8
X_6970_ _6972_/A _6970_/A _6970_/B VPWR VGND sg13cmos5l_nand2_1
XFILLER_0_1026 VPWR VGND sg13cmos5l_fill_2
X_5921_ _5996_/A _5638_/X _5917_/X _5919_/Y _5920_/Y VPWR VGND sg13cmos5l_a22oi_1
X_5852_ _5867_/A _7312_/Q _5853_/B VPWR VGND sg13cmos5l_xnor2_1
XFILLER_22_726 VPWR VGND sg13cmos5l_fill_1
XFILLER_34_564 VPWR VGND sg13cmos5l_decap_8
X_5783_ _5783_/Y _5683_/B _5785_/A VPWR VGND sg13cmos5l_nand2b_1
X_4803_ _4803_/Y _7618_/Q _7584_/Q VPWR VGND sg13cmos5l_xnor2_1
X_7522_ _7522_/Q _7555_/CLK _7522_/D _7522_/RESET_B VPWR VGND sg13cmos5l_dfrbpq_1
X_4734_ _4734_/Y _5099_/A _7576_/Q _7575_/Q _3954_/Y _4733_/Y VPWR VGND sg13cmos5l_a221oi_1
X_4665_ _4672_/A _4651_/Y _4658_/Y _4694_/A _4663_/X _4664_/Y VPWR VGND sg13cmos5l_a221oi_1
X_7453_ _7453_/Q clkload8/A _7453_/D _7453_/RESET_B VPWR VGND sg13cmos5l_dfrbpq_1
Xhold922 _3944_/A _7201_/Q VPWR VGND sg13cmos5l_dlygate4sd3_1
Xhold911 _7636_/D _4869_/Y VPWR VGND sg13cmos5l_dlygate4sd3_1
X_7384_ _7384_/Q _7651_/CLK _7384_/D _7384_/RESET_B VPWR VGND sg13cmos5l_dfrbpq_1
Xhold900 hold900/X _7620_/Q VPWR VGND sg13cmos5l_dlygate4sd3_1
X_6404_ _6409_/B _6404_/A _6404_/B _6414_/A VPWR VGND sg13cmos5l_nand3_1
X_4596_ _4604_/A _4612_/C _4603_/C _4603_/A VPWR VGND sg13cmos5l_a21oi_1
X_6335_ _6347_/B _7369_/Q _7370_/Q VPWR VGND sg13cmos5l_nor2_1
Xhold944 _6451_/A _7397_/Q VPWR VGND sg13cmos5l_dlygate4sd3_1
Xhold933 _3934_/A _7275_/Q VPWR VGND sg13cmos5l_dlygate4sd3_1
Xhold955 _6386_/B _7120_/Q VPWR VGND sg13cmos5l_dlygate4sd3_1
Xhold966 _7292_/D _5974_/Y VPWR VGND sg13cmos5l_dlygate4sd3_1
Xhold977 _7220_/D _5546_/Y VPWR VGND sg13cmos5l_dlygate4sd3_1
XFILLER_0_107 VPWR VGND sg13cmos5l_fill_1
Xhold988 _6649_/B _7412_/Q VPWR VGND sg13cmos5l_dlygate4sd3_1
Xhold999 _7219_/D _5544_/Y VPWR VGND sg13cmos5l_dlygate4sd3_1
X_6266_ _6266_/Y _6249_/A _6249_/B _6259_/X _6269_/B _6261_/B VPWR VGND sg13cmos5l_a221oi_1
X_5217_ _5217_/Y _5558_/A _5489_/B VPWR VGND sg13cmos5l_nor2_1
X_7358__357 _7358_/RESET_B VPWR VGND sg13cmos5l_tiehi
X_6197_ _6197_/Y _6197_/A _7302_/Q VPWR VGND sg13cmos5l_nand2_1
X_5148_ _5148_/Y _5167_/A _5167_/B _5147_/Y VPWR VGND sg13cmos5l_o21ai_1
X_5079_ _5079_/X _5060_/Y _5290_/B _5083_/S VPWR VGND sg13cmos5l_mux2_1
XFILLER_28_69 VPWR VGND sg13cmos5l_decap_4
XFILLER_29_358 VPWR VGND sg13cmos5l_fill_1
XFILLER_44_317 VPWR VGND sg13cmos5l_decap_8
XFILLER_38_881 VPWR VGND sg13cmos5l_decap_4
XFILLER_44_24 VPWR VGND sg13cmos5l_decap_4
XFILLER_9_708 VPWR VGND sg13cmos5l_fill_2
XFILLER_5_925 VPWR VGND sg13cmos5l_decap_8
XFILLER_4_479 VPWR VGND sg13cmos5l_decap_4
XFILLER_0_674 VPWR VGND sg13cmos5l_fill_2
XFILLER_0_696 VPWR VGND sg13cmos5l_decap_8
XFILLER_36_818 VPWR VGND sg13cmos5l_decap_4
XFILLER_44_840 VPWR VGND sg13cmos5l_fill_2
XFILLER_16_520 VPWR VGND sg13cmos5l_decap_4
XFILLER_44_873 VPWR VGND sg13cmos5l_decap_8
XFILLER_16_575 VPWR VGND sg13cmos5l_fill_1
XFILLER_43_383 VPWR VGND sg13cmos5l_fill_2
XFILLER_43_372 VPWR VGND sg13cmos5l_decap_8
XFILLER_8_741 VPWR VGND sg13cmos5l_decap_4
X_4450_ _4450_/Y _4449_/A _4445_/Y _4470_/B VPWR VGND sg13cmos5l_o21ai_1
X_4381_ _4382_/A _4380_/A _4297_/Y _4268_/B VPWR VGND sg13cmos5l_o21ai_1
X_6120_ _6279_/A _6083_/A _6104_/Y _6119_/Y VPWR VGND sg13cmos5l_o21ai_1
X_6051_ _6061_/B _6038_/Y _6045_/Y _6046_/Y _6049_/A _6050_/Y VPWR VGND sg13cmos5l_a221oi_1
X_5002_ _5002_/X _5007_/B _5007_/C _5007_/A VPWR VGND sg13cmos5l_a21o_1
XFILLER_38_122 VPWR VGND sg13cmos5l_fill_2
X_6953_ _7042_/A _6942_/Y _6952_/X _6951_/Y VPWR VGND sg13cmos5l_o21ai_1
XFILLER_19_391 VPWR VGND sg13cmos5l_fill_2
XFILLER_26_339 VPWR VGND sg13cmos5l_fill_1
XFILLER_35_840 VPWR VGND sg13cmos5l_fill_1
X_5904_ _5904_/Y _5901_/Y _5902_/Y _5903_/Y _7273_/Q VPWR VGND sg13cmos5l_a22oi_1
Xclkbuf_3_5__f_clk clkload3/A clkbuf_0_clk/X VPWR VGND sg13cmos5l_buf_8
X_6884_ _6884_/Y _6867_/B _6864_/Y _6890_/S VPWR VGND sg13cmos5l_a21oi_1
XFILLER_34_361 VPWR VGND sg13cmos5l_fill_1
XFILLER_35_884 VPWR VGND sg13cmos5l_fill_1
X_5835_ _5835_/Y _5835_/A _5846_/A VPWR VGND sg13cmos5l_nor2_1
X_5766_ _5766_/Y hold866/X _5769_/A2 _7113_/A VPWR VGND sg13cmos5l_o21ai_1
X_5697_ _5697_/Y _5694_/Y _5695_/Y _5696_/Y _5774_/A VPWR VGND sg13cmos5l_a22oi_1
X_4717_ _4729_/B _7573_/Q _4717_/B VPWR VGND sg13cmos5l_xnor2_1
X_7505_ _7505_/Q _7617_/CLK _7505_/D _7505_/RESET_B VPWR VGND sg13cmos5l_dfrbpq_1
X_7436_ _7436_/Q _7489_/CLK _7436_/D _7436_/RESET_B VPWR VGND sg13cmos5l_dfrbpq_1
X_4648_ _4648_/Y _7630_/Q _7599_/Q VPWR VGND sg13cmos5l_nand2_1
X_4579_ _4579_/Y _4465_/B _4505_/Y _4580_/B _4580_/A VPWR VGND sg13cmos5l_a22oi_1
Xhold763 _6506_/B _7363_/Q VPWR VGND sg13cmos5l_dlygate4sd3_1
X_7367_ _7367_/Q _7394_/CLK _7367_/D _7367_/RESET_B VPWR VGND sg13cmos5l_dfrbpq_1
X_6318_ _6319_/C _6329_/A _6318_/B _6318_/C _6329_/C VPWR VGND sg13cmos5l_nor4_1
X_7298_ _7298_/Q _7332_/CLK _7298_/D _7298_/RESET_B VPWR VGND sg13cmos5l_dfrbpq_1
Xhold785 _5771_/B _7227_/Q VPWR VGND sg13cmos5l_dlygate4sd3_1
Xhold774 _4567_/B _7548_/Q VPWR VGND sg13cmos5l_dlygate4sd3_1
Xhold796 _6404_/B _7126_/Q VPWR VGND sg13cmos5l_dlygate4sd3_1
X_6249_ _6249_/X _6249_/A _6249_/B VPWR VGND sg13cmos5l_and2_1
X_7371__332 _7371_/RESET_B VPWR VGND sg13cmos5l_tiehi
XFILLER_44_169 VPWR VGND sg13cmos5l_fill_1
XFILLER_38_1023 VPWR VGND sg13cmos5l_decap_4
XFILLER_25_383 VPWR VGND sg13cmos5l_fill_2
XFILLER_41_898 VPWR VGND sg13cmos5l_decap_8
XFILLER_5_711 VPWR VGND sg13cmos5l_decap_8
XFILLER_5_744 VPWR VGND sg13cmos5l_fill_2
XFILLER_4_210 VPWR VGND sg13cmos5l_decap_4
XFILLER_5_799 VPWR VGND sg13cmos5l_fill_2
XFILLER_45_1016 VPWR VGND sg13cmos5l_decap_8
XFILLER_45_1027 VPWR VGND sg13cmos5l_fill_2
XFILLER_1_961 VPWR VGND sg13cmos5l_decap_8
XFILLER_49_932 VPWR VGND sg13cmos5l_decap_8
X_3950_ _5102_/A _3950_/A VPWR VGND sg13cmos5l_inv_1
XFILLER_16_361 VPWR VGND sg13cmos5l_decap_8
XFILLER_16_383 VPWR VGND sg13cmos5l_decap_8
XFILLER_16_394 VPWR VGND sg13cmos5l_fill_1
X_3881_ _3881_/Y _3881_/A VPWR VGND sg13cmos5l_inv_1
X_5620_ _5622_/B _7234_/Q _5620_/B _5620_/C VPWR VGND sg13cmos5l_nor3_1
X_7348__367 _7348_/RESET_B VPWR VGND sg13cmos5l_tiehi
X_5551_ _7224_/D _3887_/Y _5551_/A2 _5550_/Y VPWR VGND sg13cmos5l_a21oi_1
X_4502_ _7568_/D _4501_/A _4502_/A2 _4519_/A VPWR VGND sg13cmos5l_a21oi_1
X_5482_ _5482_/Y _5485_/B VPWR VGND sg13cmos5l_inv_1
X_7221_ _7221_/Q _7277_/CLK _7221_/D _7221_/RESET_B VPWR VGND sg13cmos5l_dfrbpq_1
X_4433_ _4433_/Y _4433_/A _4433_/B VPWR VGND sg13cmos5l_nor2_1
XFILLER_6_83 VPWR VGND sg13cmos5l_fill_2
X_4364_ _4364_/Y _4268_/B _4298_/X _4363_/Y VPWR VGND sg13cmos5l_a21oi_1
X_7152_ _7152_/Q _7611_/CLK _7152_/D _7152_/RESET_B VPWR VGND sg13cmos5l_dfrbpq_1
X_4295_ _7534_/D _4358_/B _4363_/B VPWR VGND sg13cmos5l_nor2_1
X_6103_ _6106_/A _6103_/A _6122_/B VPWR VGND sg13cmos5l_nor2_1
X_7083_ _7084_/B _7083_/A _7083_/B _7091_/S VPWR VGND sg13cmos5l_nand3_1
X_6034_ _6035_/B _6034_/A _6034_/B VPWR VGND sg13cmos5l_nor2_1
XFILLER_39_497 VPWR VGND sg13cmos5l_decap_4
X_6936_ _6939_/A _6941_/A _6955_/B VPWR VGND sg13cmos5l_nand2_1
XFILLER_23_843 VPWR VGND sg13cmos5l_fill_1
X_6867_ _6868_/C _6867_/A _6867_/B _6867_/C VPWR VGND sg13cmos5l_and3_1
X_5818_ _5819_/B _5818_/A _5818_/B VPWR VGND sg13cmos5l_or2_1
X_6798_ _6798_/Y _6799_/B VPWR VGND sg13cmos5l_inv_1
X_5749_ _5749_/Y _5994_/A _3933_/A _5728_/B _5545_/B VPWR VGND sg13cmos5l_a22oi_1
X_7419_ _7419_/Q _7510_/CLK _7419_/D _7419_/RESET_B VPWR VGND sg13cmos5l_dfrbpq_1
XFILLER_2_758 VPWR VGND sg13cmos5l_fill_1
XFILLER_2_747 VPWR VGND sg13cmos5l_decap_4
XFILLER_45_412 VPWR VGND sg13cmos5l_decap_8
Xhold1260 _7066_/A2 _7052_/B VPWR VGND sg13cmos5l_dlygate4sd3_1
XFILLER_18_604 VPWR VGND sg13cmos5l_fill_2
Xhold1282 _4976_/A _7130_/Q VPWR VGND sg13cmos5l_dlygate4sd3_1
Xhold1293 _5920_/A _7247_/Q VPWR VGND sg13cmos5l_dlygate4sd3_1
XFILLER_17_136 VPWR VGND sg13cmos5l_fill_1
Xhold1271 _6533_/A _6532_/Y VPWR VGND sg13cmos5l_dlygate4sd3_1
XFILLER_46_979 VPWR VGND sg13cmos5l_decap_8
XFILLER_33_618 VPWR VGND sg13cmos5l_fill_1
XFILLER_32_128 VPWR VGND sg13cmos5l_fill_1
XFILLER_12_1004 VPWR VGND sg13cmos5l_fill_1
X_4080_ _8272_/A _4936_/B _4080_/B _4080_/C VPWR VGND sg13cmos5l_nor3_1
XFILLER_37_946 VPWR VGND sg13cmos5l_fill_1
XFILLER_36_445 VPWR VGND sg13cmos5l_fill_1
XFILLER_45_990 VPWR VGND sg13cmos5l_decap_8
X_4982_ _4982_/X _4982_/A _4982_/B VPWR VGND sg13cmos5l_and2_1
XFILLER_36_489 VPWR VGND sg13cmos5l_decap_4
X_6721_ _6721_/Y _7431_/Q _7430_/Q VPWR VGND sg13cmos5l_xnor2_1
X_3933_ _5993_/A _3933_/A VPWR VGND sg13cmos5l_inv_1
X_6652_ _6652_/Y hold863/X _6653_/A2 _6505_/A VPWR VGND sg13cmos5l_o21ai_1
X_3864_ _3864_/Y _3864_/A VPWR VGND sg13cmos5l_inv_1
X_5603_ _5603_/Y _5616_/B _5603_/B _5603_/C VPWR VGND sg13cmos5l_nand3b_1
X_6583_ _7399_/D _6661_/B _6583_/B VPWR VGND sg13cmos5l_and2_1
X_5534_ _5536_/A _7219_/Q _5530_/Y _5533_/Y _7220_/Q _5532_/Y VPWR VGND sg13cmos5l_a221oi_1
XFILLER_11_39 VPWR VGND sg13cmos5l_fill_1
X_5465_ _5467_/B _5702_/A _5709_/A _5452_/B _5429_/X VPWR VGND sg13cmos5l_a22oi_1
X_4416_ _7558_/D _4416_/A _4416_/B VPWR VGND sg13cmos5l_nor2_1
X_7204_ _7204_/Q _7214_/CLK _7204_/D _7204_/RESET_B VPWR VGND sg13cmos5l_dfrbpq_1
X_5396_ _5400_/B _5396_/A _5396_/B VPWR VGND sg13cmos5l_nor2_1
X_7135_ _7135_/Q _7200_/CLK _7135_/D _7135_/RESET_B VPWR VGND sg13cmos5l_dfrbpq_1
X_4347_ _4347_/Y hold855/X _5325_/A2 _7106_/A VPWR VGND sg13cmos5l_o21ai_1
X_4278_ _4278_/Y _7523_/Q _3965_/Y _4277_/Y VPWR VGND sg13cmos5l_o21ai_1
X_7066_ _7492_/D _7048_/Y _7066_/A2 _7007_/B VPWR VGND sg13cmos5l_a21oi_1
X_6017_ _6040_/A _7305_/Q _6039_/B _6024_/A VPWR VGND sg13cmos5l_a21o_1
XFILLER_27_401 VPWR VGND sg13cmos5l_fill_1
XFILLER_43_949 VPWR VGND sg13cmos5l_decap_8
XFILLER_14_128 VPWR VGND sg13cmos5l_decap_8
X_6919_ _6919_/Y _7047_/A VPWR VGND sg13cmos5l_inv_1
XFILLER_22_183 VPWR VGND sg13cmos5l_decap_4
XFILLER_6_349 VPWR VGND sg13cmos5l_decap_4
XFILLER_2_577 VPWR VGND sg13cmos5l_decap_4
X_7338__377 _7338_/RESET_B VPWR VGND sg13cmos5l_tiehi
XFILLER_19_935 VPWR VGND sg13cmos5l_fill_2
XFILLER_19_957 VPWR VGND sg13cmos5l_decap_4
XFILLER_46_776 VPWR VGND sg13cmos5l_decap_8
Xhold1090 _7472_/D _6985_/Y VPWR VGND sg13cmos5l_dlygate4sd3_1
XFILLER_13_150 VPWR VGND sg13cmos5l_decap_8
XFILLER_14_651 VPWR VGND sg13cmos5l_decap_8
XFILLER_6_861 VPWR VGND sg13cmos5l_decap_4
XFILLER_5_360 VPWR VGND sg13cmos5l_fill_2
X_5250_ _5253_/A _5251_/A _5251_/C _7141_/Q VPWR VGND sg13cmos5l_a21o_1
X_4201_ _4208_/A _7070_/B _7074_/B VPWR VGND sg13cmos5l_and2_1
X_5181_ _5187_/C _7167_/Q _7168_/Q _7169_/Q VPWR VGND sg13cmos5l_o21ai_1
X_4132_ _4132_/Y _4132_/A _4132_/B VPWR VGND sg13cmos5l_nor2_1
XFILLER_3_73 VPWR VGND sg13cmos5l_fill_2
XFILLER_3_95 VPWR VGND sg13cmos5l_decap_4
X_4063_ _4064_/B _7647_/Q _4063_/B VPWR VGND sg13cmos5l_nand2_1
XFILLER_36_220 VPWR VGND sg13cmos5l_fill_1
X_4965_ _4972_/A _4965_/A _4965_/B _4965_/C VPWR VGND sg13cmos5l_nor3_1
X_6704_ _6705_/A _6686_/X _6708_/S _6661_/B VPWR VGND sg13cmos5l_o21ai_1
X_3916_ _6893_/A _5326_/A VPWR VGND sg13cmos5l_inv_1
X_4896_ _4897_/B _7641_/Q _7640_/Q _7649_/Q VPWR VGND sg13cmos5l_o21ai_1
XFILLER_20_632 VPWR VGND sg13cmos5l_fill_2
X_6635_ _6635_/Y _6633_/C _6634_/Y _6633_/Y VPWR VGND sg13cmos5l_a21oi_1
X_6566_ _6574_/B _7426_/Q _7427_/Q _7428_/Q VPWR VGND sg13cmos5l_nor3_1
X_5517_ _5521_/B _5513_/Y _5514_/Y _5527_/C _5516_/Y VPWR VGND sg13cmos5l_a22oi_1
X_6497_ _6497_/Y _6487_/X _6630_/A1 _6495_/A VPWR VGND sg13cmos5l_a21oi_1
X_5448_ _5562_/B _5763_/B _6827_/A VPWR VGND sg13cmos5l_nand2b_1
Xfanout122 _6506_/A _6505_/A VPWR VGND sg13cmos5l_buf_1
Xfanout111 _5450_/A _5774_/A VPWR VGND sg13cmos5l_buf_1
X_5379_ _5406_/A _5383_/A _5379_/B VPWR VGND sg13cmos5l_nand2b_1
Xfanout100 _5098_/A _4681_/A VPWR VGND sg13cmos5l_buf_1
X_7118_ _7118_/Q _7424_/CLK _7118_/D _7118_/RESET_B VPWR VGND sg13cmos5l_dfrbpq_1
Xfanout133 _5555_/A _7002_/A VPWR VGND sg13cmos5l_buf_1
X_7049_ _7050_/B _7487_/Q _7055_/B VPWR VGND sg13cmos5l_xnor2_1
XFILLER_28_754 VPWR VGND sg13cmos5l_fill_1
XFILLER_43_746 VPWR VGND sg13cmos5l_fill_2
XFILLER_24_960 VPWR VGND sg13cmos5l_fill_1
XFILLER_23_481 VPWR VGND sg13cmos5l_fill_1
XFILLER_24_993 VPWR VGND sg13cmos5l_fill_1
XFILLER_11_654 VPWR VGND sg13cmos5l_fill_2
XFILLER_11_665 VPWR VGND sg13cmos5l_fill_2
XFILLER_2_352 VPWR VGND sg13cmos5l_fill_2
X_7635__200 _7635_/D VPWR VGND sg13cmos5l_tielo
XFILLER_18_231 VPWR VGND sg13cmos5l_fill_1
XFILLER_46_584 VPWR VGND sg13cmos5l_fill_1
XFILLER_18_297 VPWR VGND sg13cmos5l_decap_4
X_4750_ _4750_/Y _7635_/Q _5099_/A _4754_/C VPWR VGND sg13cmos5l_nor3_1
X_4681_ _4681_/Y _4681_/A _5021_/A VPWR VGND sg13cmos5l_nor2_1
X_6420_ _6422_/A _6420_/A _6423_/A VPWR VGND sg13cmos5l_nor2b_1
XFILLER_30_985 VPWR VGND sg13cmos5l_decap_8
X_6351_ _6356_/A _6345_/Y _6349_/Y _6350_/Y VPWR VGND sg13cmos5l_o21ai_1
X_5302_ _5302_/Y _7180_/Q _5292_/Y _5300_/X VPWR VGND sg13cmos5l_o21ai_1
XFILLER_45_0 VPWR VGND sg13cmos5l_fill_2
X_6282_ _6282_/Y _6279_/A _6279_/B _6281_/Y VPWR VGND sg13cmos5l_o21ai_1
X_5233_ _5335_/A _5485_/A _5231_/B _5232_/Y VPWR VGND sg13cmos5l_a21oi_1
X_5164_ _5164_/Y _5154_/Y _5157_/Y _5163_/Y VPWR VGND sg13cmos5l_a21oi_1
X_4115_ _4117_/A _4106_/B _4115_/B VPWR VGND sg13cmos5l_nand2b_1
Xheichips26_dna_sequencer_753 uio_oe[0] VPWR VGND sg13cmos5l_tiehi
X_5095_ _7153_/D _5096_/A _5095_/B VPWR VGND sg13cmos5l_and2_1
X_4046_ _4046_/Y input9/X _4863_/A _4043_/Y VPWR VGND sg13cmos5l_a21oi_1
XFILLER_25_757 VPWR VGND sg13cmos5l_fill_2
X_5997_ _5997_/Y _5997_/A _5886_/B VPWR VGND sg13cmos5l_nor2b_1
X_4948_ _4982_/A _7130_/Q _7131_/Q VPWR VGND sg13cmos5l_xnor2_1
X_4879_ _4880_/B _4879_/A hold948/X VPWR VGND sg13cmos5l_nor2b_1
XFILLER_32_1018 VPWR VGND sg13cmos5l_decap_8
X_6618_ _6618_/Y _7382_/Q _6832_/A VPWR VGND sg13cmos5l_nor2_1
X_7598_ _7598_/Q _7630_/CLK _7598_/D _7598_/RESET_B VPWR VGND sg13cmos5l_dfrbpq_1
XFILLER_4_639 VPWR VGND sg13cmos5l_decap_4
X_6549_ _6550_/A _6518_/Y _6547_/Y _6510_/B VPWR VGND sg13cmos5l_o21ai_1
XFILLER_0_856 VPWR VGND sg13cmos5l_fill_2
X_7122__626 _7122_/RESET_B VPWR VGND sg13cmos5l_tiehi
XFILLER_0_867 VPWR VGND sg13cmos5l_fill_2
XFILLER_43_521 VPWR VGND sg13cmos5l_fill_1
XFILLER_16_735 VPWR VGND sg13cmos5l_decap_8
XFILLER_16_746 VPWR VGND sg13cmos5l_fill_2
XFILLER_43_576 VPWR VGND sg13cmos5l_decap_8
XFILLER_43_554 VPWR VGND sg13cmos5l_fill_1
XFILLER_7_400 VPWR VGND sg13cmos5l_fill_2
XFILLER_7_488 VPWR VGND sg13cmos5l_fill_2
XFILLER_48_1003 VPWR VGND sg13cmos5l_decap_8
XFILLER_2_193 VPWR VGND sg13cmos5l_decap_8
XFILLER_47_882 VPWR VGND sg13cmos5l_decap_4
XFILLER_0_52 VPWR VGND sg13cmos5l_fill_2
XFILLER_0_1005 VPWR VGND sg13cmos5l_decap_8
X_5920_ _5920_/Y _5920_/A _5930_/B VPWR VGND sg13cmos5l_nor2_1
X_5851_ _5893_/C _7312_/Q _7310_/Q _7311_/Q VPWR VGND sg13cmos5l_nor3_1
X_5782_ _5782_/Y _5679_/B _5810_/A _5779_/Y _5780_/Y _5781_/Y VPWR VGND sg13cmos5l_a221oi_1
X_4802_ _4802_/Y _7620_/Q _7586_/Q VPWR VGND sg13cmos5l_nand2_1
X_7521_ _7521_/Q _7553_/CLK _7521_/D _7521_/RESET_B VPWR VGND sg13cmos5l_dfrbpq_1
X_4733_ _4733_/Y _5098_/A _4008_/Y _4535_/A _7630_/Q VPWR VGND sg13cmos5l_a22oi_1
XFILLER_30_793 VPWR VGND sg13cmos5l_fill_2
X_7452_ _7452_/Q clkload8/A _7452_/D _7452_/RESET_B VPWR VGND sg13cmos5l_dfrbpq_1
X_4664_ _4664_/Y _4690_/A _4664_/B VPWR VGND sg13cmos5l_nor2_1
X_6403_ _6413_/B _6407_/A _6407_/B VPWR VGND sg13cmos5l_and2_1
Xhold901 _6181_/A _7327_/Q VPWR VGND sg13cmos5l_dlygate4sd3_1
Xhold912 _3888_/A _7223_/Q VPWR VGND sg13cmos5l_dlygate4sd3_1
X_4595_ _4603_/C _7583_/Q _7550_/Q _7588_/Q VPWR VGND sg13cmos5l_nand3_1
X_7383_ _7383_/Q clkload8/A _7383_/D _7383_/RESET_B VPWR VGND sg13cmos5l_dfrbpq_1
Xhold945 _4357_/A _7524_/Q VPWR VGND sg13cmos5l_dlygate4sd3_1
X_6334_ _6425_/A _6498_/B _6506_/A VPWR VGND sg13cmos5l_nand2b_1
Xhold934 _4908_/A _7116_/Q VPWR VGND sg13cmos5l_dlygate4sd3_1
Xhold923 _6830_/A _7425_/Q VPWR VGND sg13cmos5l_dlygate4sd3_1
Xhold978 _3974_/A _7355_/Q VPWR VGND sg13cmos5l_dlygate4sd3_1
X_6265_ _6265_/Y _6263_/A _6263_/B _6260_/B VPWR VGND sg13cmos5l_o21ai_1
Xhold967 _3946_/A _7200_/Q VPWR VGND sg13cmos5l_dlygate4sd3_1
Xhold956 _3953_/A _7632_/Q VPWR VGND sg13cmos5l_dlygate4sd3_1
Xhold989 hold989/X _6649_/Y VPWR VGND sg13cmos5l_dlygate4sd3_1
X_5216_ _7167_/D _5337_/B _5314_/A VPWR VGND sg13cmos5l_nor2_1
X_6196_ _6196_/X _7332_/Q _7302_/Q VPWR VGND sg13cmos5l_and2_1
X_5147_ _5147_/Y _5153_/A _5147_/B _5147_/C VPWR VGND sg13cmos5l_nand3b_1
X_5078_ _7142_/D _5177_/A _5078_/B VPWR VGND sg13cmos5l_nor2_1
X_4029_ _4031_/C _7649_/Q _4029_/B VPWR VGND sg13cmos5l_nand2_1
XFILLER_40_579 VPWR VGND sg13cmos5l_decap_8
XFILLER_5_904 VPWR VGND sg13cmos5l_decap_8
XFILLER_5_959 VPWR VGND sg13cmos5l_decap_8
XFILLER_4_458 VPWR VGND sg13cmos5l_fill_2
XFILLER_4_447 VPWR VGND sg13cmos5l_fill_2
X_7439__157 _7439_/D VPWR VGND sg13cmos5l_tielo
XFILLER_0_653 VPWR VGND sg13cmos5l_decap_8
XFILLER_28_392 VPWR VGND sg13cmos5l_fill_1
XFILLER_44_863 VPWR VGND sg13cmos5l_fill_1
XFILLER_16_565 VPWR VGND sg13cmos5l_decap_4
X_4380_ _4414_/A _4380_/A _4380_/B VPWR VGND sg13cmos5l_nor2_1
X_6050_ _6050_/Y _6050_/A _6050_/B VPWR VGND sg13cmos5l_nor2_1
XFILLER_38_101 VPWR VGND sg13cmos5l_fill_2
X_5001_ _5007_/C _7605_/Q _7606_/Q _5001_/B1 VPWR VGND sg13cmos5l_o21ai_1
XFILLER_39_668 VPWR VGND sg13cmos5l_fill_1
X_6952_ _6952_/X _6952_/A _6955_/B VPWR VGND sg13cmos5l_or2_1
X_5903_ _5903_/Y _7247_/Q _7248_/Q VPWR VGND sg13cmos5l_xnor2_1
X_6883_ _6890_/S _6883_/A _6883_/B VPWR VGND sg13cmos5l_nand2_1
X_5834_ _5834_/Y _5828_/A _5828_/B _5835_/A _5846_/A VPWR VGND sg13cmos5l_a22oi_1
XFILLER_34_373 VPWR VGND sg13cmos5l_fill_1
X_5765_ _7260_/D _3888_/Y _5769_/A2 _5764_/Y VPWR VGND sg13cmos5l_a21oi_1
X_5696_ _5696_/Y _5696_/A _5696_/B VPWR VGND sg13cmos5l_xnor2_1
X_7504_ _7504_/Q _7617_/CLK _7504_/D _7504_/RESET_B VPWR VGND sg13cmos5l_dfrbpq_1
X_4716_ _4716_/Y _4449_/A _4713_/Y _4470_/B VPWR VGND sg13cmos5l_o21ai_1
X_7435_ _7435_/Q _7489_/CLK _7435_/D _7435_/RESET_B VPWR VGND sg13cmos5l_dfrbpq_1
X_4647_ _4682_/A _7599_/Q _7600_/Q VPWR VGND sg13cmos5l_xnor2_1
X_7366_ _7366_/Q _7394_/CLK _7366_/D _7366_/RESET_B VPWR VGND sg13cmos5l_dfrbpq_1
X_4578_ _4578_/Y _4578_/A _4578_/B _4578_/C VPWR VGND sg13cmos5l_nand3_1
X_6317_ _6319_/B _6222_/A _6302_/B _6323_/A _6323_/C VPWR VGND sg13cmos5l_a22oi_1
Xhold764 _4351_/B _7513_/Q VPWR VGND sg13cmos5l_dlygate4sd3_1
Xhold786 _6362_/A _7127_/Q VPWR VGND sg13cmos5l_dlygate4sd3_1
X_7297_ _7297_/Q _7332_/CLK _7297_/D _7297_/RESET_B VPWR VGND sg13cmos5l_dfrbpq_1
Xhold775 _4780_/B _7584_/Q VPWR VGND sg13cmos5l_dlygate4sd3_1
Xhold797 _7106_/B _7477_/Q VPWR VGND sg13cmos5l_dlygate4sd3_1
X_6248_ _6249_/B _7284_/Q _7285_/Q _7286_/Q VPWR VGND sg13cmos5l_o21ai_1
X_6179_ _6180_/B _6162_/A _6181_/B _6178_/Y VPWR VGND sg13cmos5l_a21oi_1
X_7295__434 _7295_/RESET_B VPWR VGND sg13cmos5l_tiehi
XFILLER_29_123 VPWR VGND sg13cmos5l_decap_4
XFILLER_41_877 VPWR VGND sg13cmos5l_decap_8
XFILLER_40_332 VPWR VGND sg13cmos5l_decap_8
XFILLER_9_517 VPWR VGND sg13cmos5l_decap_4
XFILLER_13_557 VPWR VGND sg13cmos5l_fill_2
XFILLER_9_539 VPWR VGND sg13cmos5l_fill_2
X_7228__509 _7228_/RESET_B VPWR VGND sg13cmos5l_tiehi
XFILLER_4_255 VPWR VGND sg13cmos5l_fill_2
XFILLER_20_60 VPWR VGND sg13cmos5l_fill_1
XFILLER_1_940 VPWR VGND sg13cmos5l_decap_8
XFILLER_49_911 VPWR VGND sg13cmos5l_fill_2
XFILLER_48_454 VPWR VGND sg13cmos5l_decap_8
XFILLER_49_988 VPWR VGND sg13cmos5l_decap_8
XFILLER_17_830 VPWR VGND sg13cmos5l_fill_2
X_3880_ _3880_/Y _3880_/A VPWR VGND sg13cmos5l_inv_1
XFILLER_32_877 VPWR VGND sg13cmos5l_decap_8
X_5550_ _5550_/Y hold845/X _5550_/A2 _5096_/A VPWR VGND sg13cmos5l_o21ai_1
X_4501_ _4578_/B _4501_/A _4501_/B VPWR VGND sg13cmos5l_nand2_1
X_5481_ _5485_/B _7177_/Q _5481_/B VPWR VGND sg13cmos5l_xnor2_1
X_7220_ _7220_/Q _7314_/CLK _7220_/D _7220_/RESET_B VPWR VGND sg13cmos5l_dfrbpq_1
X_4432_ _4466_/A _7595_/Q _4784_/A VPWR VGND sg13cmos5l_xnor2_1
X_4363_ _4363_/Y _4394_/A _4363_/B VPWR VGND sg13cmos5l_nor2_1
X_7151_ _7151_/Q _7635_/CLK _7151_/D _7151_/RESET_B VPWR VGND sg13cmos5l_dfrbpq_1
X_4294_ _4363_/B _4102_/C _4281_/X _4284_/Y _4293_/Y VPWR VGND sg13cmos5l_a22oi_1
X_6102_ _6102_/Y _6088_/Y _6098_/Y _6101_/Y VPWR VGND sg13cmos5l_o21ai_1
X_7082_ _7091_/S _7090_/A _6969_/A _7081_/B VPWR VGND sg13cmos5l_o21ai_1
X_6033_ _6033_/Y _6058_/A _6033_/B VPWR VGND sg13cmos5l_nor2_1
XFILLER_39_476 VPWR VGND sg13cmos5l_fill_2
X_6935_ _6955_/B _7439_/Q _6935_/B VPWR VGND sg13cmos5l_xor2_1
X_6866_ _6866_/Y _6861_/X _6862_/X _6865_/Y VPWR VGND sg13cmos5l_o21ai_1
XFILLER_34_181 VPWR VGND sg13cmos5l_fill_1
X_5817_ _5817_/Y _5820_/A _5820_/B VPWR VGND sg13cmos5l_nor2_1
X_6797_ _6799_/B _7413_/Q _6795_/Y _6796_/Y VPWR VGND sg13cmos5l_o21ai_1
X_5748_ _5748_/Y _7256_/Q _5743_/Y _5747_/Y VPWR VGND sg13cmos5l_o21ai_1
X_5679_ _7243_/D _5845_/A _5679_/B VPWR VGND sg13cmos5l_nor2_1
X_7418_ _7418_/Q _7510_/CLK _7418_/D _7418_/RESET_B VPWR VGND sg13cmos5l_dfrbpq_1
X_7349_ _7349_/Q _7375_/CLK _7349_/D _7349_/RESET_B VPWR VGND sg13cmos5l_dfrbpq_1
XFILLER_49_229 VPWR VGND sg13cmos5l_decap_4
Xhold1261 _5263_/A _7136_/Q VPWR VGND sg13cmos5l_dlygate4sd3_1
Xhold1250 _4835_/A _7627_/Q VPWR VGND sg13cmos5l_dlygate4sd3_1
Xhold1294 _6440_/A _7373_/Q VPWR VGND sg13cmos5l_dlygate4sd3_1
XFILLER_46_958 VPWR VGND sg13cmos5l_decap_8
Xhold1283 _4444_/A _7566_/Q VPWR VGND sg13cmos5l_dlygate4sd3_1
Xhold1272 _6103_/A _7315_/Q VPWR VGND sg13cmos5l_dlygate4sd3_1
XFILLER_41_630 VPWR VGND sg13cmos5l_fill_2
XFILLER_15_71 VPWR VGND sg13cmos5l_decap_8
XFILLER_5_520 VPWR VGND sg13cmos5l_decap_4
XFILLER_31_92 VPWR VGND sg13cmos5l_fill_2
XFILLER_49_763 VPWR VGND sg13cmos5l_decap_4
X_7354__361 _7354_/RESET_B VPWR VGND sg13cmos5l_tiehi
XFILLER_37_958 VPWR VGND sg13cmos5l_decap_4
X_4981_ _4981_/Y _4981_/A _4981_/B VPWR VGND sg13cmos5l_nor2_1
X_6720_ _6720_/Y _7457_/Q _7430_/Q VPWR VGND sg13cmos5l_nand2_1
X_3932_ _5994_/A _3932_/A VPWR VGND sg13cmos5l_inv_1
X_3863_ _3863_/Y _3863_/A VPWR VGND sg13cmos5l_inv_1
X_6651_ _7414_/D _6660_/A _6651_/B VPWR VGND sg13cmos5l_and2_1
X_6582_ _6583_/B _6582_/A1 _6588_/S _6581_/Y VPWR VGND sg13cmos5l_o21ai_1
X_5602_ _5603_/B _5602_/A _5602_/B VPWR VGND sg13cmos5l_or2_1
X_5533_ _5533_/Y _5778_/A _3938_/A _5317_/A _7183_/Q VPWR VGND sg13cmos5l_a22oi_1
X_5464_ _5464_/Y _5702_/A _5709_/A VPWR VGND sg13cmos5l_nand2_1
X_7361__343 _7361_/RESET_B VPWR VGND sg13cmos5l_tiehi
X_4415_ _4416_/B _4393_/Y _4409_/Y _4357_/B VPWR VGND sg13cmos5l_o21ai_1
X_5395_ _5395_/Y _5385_/Y _5386_/Y _5394_/Y VPWR VGND sg13cmos5l_o21ai_1
X_7203_ _7203_/Q _7239_/CLK _7203_/D _7203_/RESET_B VPWR VGND sg13cmos5l_dfrbpq_1
XFILLER_28_1001 VPWR VGND sg13cmos5l_decap_8
X_7134_ _7134_/Q _7200_/CLK _7134_/D _7134_/RESET_B VPWR VGND sg13cmos5l_dfrbpq_1
X_4346_ _4346_/Y _3864_/Y _7112_/A2 _4345_/Y VPWR VGND sg13cmos5l_a21oi_1
XFILLER_28_1012 VPWR VGND sg13cmos5l_decap_8
X_4277_ _4277_/Y _7524_/Q _7502_/Q VPWR VGND sg13cmos5l_nand2b_1
X_7065_ _7491_/D _7065_/A _7065_/B VPWR VGND sg13cmos5l_nor2_1
X_6016_ _6024_/A _6036_/A _6023_/C _6023_/A VPWR VGND sg13cmos5l_a21oi_1
XFILLER_39_273 VPWR VGND sg13cmos5l_fill_1
XFILLER_43_906 VPWR VGND sg13cmos5l_decap_8
XFILLER_28_969 VPWR VGND sg13cmos5l_fill_2
X_6918_ _7047_/A _6906_/Y _6918_/A2 _4131_/A VPWR VGND sg13cmos5l_a21oi_1
XFILLER_42_449 VPWR VGND sg13cmos5l_decap_8
X_6849_ _6867_/A _7454_/Q _6875_/B VPWR VGND sg13cmos5l_xnor2_1
XFILLER_11_858 VPWR VGND sg13cmos5l_decap_8
XFILLER_22_173 VPWR VGND sg13cmos5l_decap_4
X_7641__644 _7641_/RESET_B VPWR VGND sg13cmos5l_tiehi
XFILLER_2_534 VPWR VGND sg13cmos5l_decap_8
XFILLER_19_914 VPWR VGND sg13cmos5l_fill_2
XFILLER_46_722 VPWR VGND sg13cmos5l_decap_8
Xhold1091 _6407_/A _7365_/Q VPWR VGND sg13cmos5l_dlygate4sd3_1
Xhold1080 _3972_/A _7253_/Q VPWR VGND sg13cmos5l_dlygate4sd3_1
XFILLER_34_917 VPWR VGND sg13cmos5l_decap_8
Xclkbuf_leaf_25_clk _7610_/CLK clkload3/A VPWR VGND sg13cmos5l_buf_8
XFILLER_6_851 VPWR VGND sg13cmos5l_fill_2
X_4200_ _4200_/Y _4189_/Y _4192_/Y _4195_/Y _4198_/A _4199_/Y VPWR VGND sg13cmos5l_a221oi_1
X_5180_ _5189_/B _7169_/Q _7167_/Q _7168_/Q VPWR VGND sg13cmos5l_or3_1
X_4131_ _7074_/B _4131_/A _4131_/B VPWR VGND sg13cmos5l_nor2_1
XFILLER_3_63 VPWR VGND sg13cmos5l_fill_1
X_4062_ _4064_/A input8/X input9/X VPWR VGND sg13cmos5l_nor2_1
XFILLER_3_1014 VPWR VGND sg13cmos5l_decap_8
XFILLER_25_906 VPWR VGND sg13cmos5l_fill_2
XFILLER_18_991 VPWR VGND sg13cmos5l_fill_2
Xclkbuf_leaf_16_clk _7560_/CLK clkload5/A VPWR VGND sg13cmos5l_buf_8
X_4964_ _4965_/C _5249_/A _4990_/A VPWR VGND sg13cmos5l_nor2_1
X_6703_ _6703_/Y _6697_/B _6677_/Y _6708_/S VPWR VGND sg13cmos5l_o21ai_1
X_3915_ _7086_/B _4116_/A VPWR VGND sg13cmos5l_inv_1
X_4895_ _7641_/D _4895_/A _4895_/B VPWR VGND sg13cmos5l_nor2_1
X_6634_ _6634_/Y _6834_/A _6831_/A VPWR VGND sg13cmos5l_nor2_1
X_6565_ _6565_/Y _6751_/A _6571_/B _6564_/Y VPWR VGND sg13cmos5l_o21ai_1
X_5516_ _5516_/Y _7240_/Q _7235_/Q VPWR VGND sg13cmos5l_nor2b_1
X_6496_ _6496_/Y _7383_/Q _6496_/B VPWR VGND sg13cmos5l_nand2b_1
X_5447_ _5558_/B _6554_/A _5763_/B VPWR VGND sg13cmos5l_nor2_1
Xfanout112 _5774_/A hold1062/X VPWR VGND sg13cmos5l_buf_1
X_5378_ _5379_/B _5378_/A _5378_/B VPWR VGND sg13cmos5l_xor2_1
Xfanout101 _4784_/A hold1262/X VPWR VGND sg13cmos5l_buf_1
X_7117_ _7117_/Q _7424_/CLK _7117_/D _7117_/RESET_B VPWR VGND sg13cmos5l_dfrbpq_1
Xfanout123 _6505_/A _6507_/A VPWR VGND sg13cmos5l_buf_1
Xfanout134 _7002_/A fanout142/X VPWR VGND sg13cmos5l_buf_1
X_4329_ _4331_/A _4340_/B _4327_/Y _4328_/Y VPWR VGND sg13cmos5l_a21oi_1
XFILLER_47_36 VPWR VGND sg13cmos5l_fill_2
X_7048_ _7048_/Y _7052_/A VPWR VGND sg13cmos5l_inv_1
XFILLER_47_47 VPWR VGND sg13cmos5l_decap_8
XFILLER_43_725 VPWR VGND sg13cmos5l_fill_1
XFILLER_10_121 VPWR VGND sg13cmos5l_decap_4
XFILLER_11_677 VPWR VGND sg13cmos5l_fill_1
XFILLER_6_136 VPWR VGND sg13cmos5l_fill_2
X_7344__371 _7344_/RESET_B VPWR VGND sg13cmos5l_tiehi
XFILLER_3_810 VPWR VGND sg13cmos5l_fill_1
XFILLER_19_8 VPWR VGND sg13cmos5l_fill_1
XFILLER_18_221 VPWR VGND sg13cmos5l_decap_4
XFILLER_34_725 VPWR VGND sg13cmos5l_fill_1
X_7351__364 _7351_/RESET_B VPWR VGND sg13cmos5l_tiehi
XFILLER_15_994 VPWR VGND sg13cmos5l_fill_2
XFILLER_30_920 VPWR VGND sg13cmos5l_fill_1
X_4680_ _7599_/D _4680_/A _4728_/A VPWR VGND sg13cmos5l_nor2_1
X_6350_ _6350_/Y _6350_/A _6350_/B VPWR VGND sg13cmos5l_xnor2_1
X_5301_ _5301_/Y _7179_/Q _5289_/Y _5292_/Y _7180_/Q VPWR VGND sg13cmos5l_a22oi_1
XFILLER_6_692 VPWR VGND sg13cmos5l_decap_4
XFILLER_5_191 VPWR VGND sg13cmos5l_fill_2
X_6281_ _6281_/Y _6124_/A _6286_/B VPWR VGND sg13cmos5l_nand2b_1
X_5232_ _5232_/Y _5232_/A _5232_/B VPWR VGND sg13cmos5l_nor2_1
Xclkbuf_leaf_5_clk clkload8/A clkbuf_leaf_5_clk/A VPWR VGND sg13cmos5l_buf_8
X_5163_ _5163_/Y _5163_/A _5163_/B VPWR VGND sg13cmos5l_nor2_1
X_4114_ _4115_/B _4113_/A _4113_/B _4110_/A VPWR VGND sg13cmos5l_a21oi_1
XFILLER_25_1026 VPWR VGND sg13cmos5l_fill_2
X_5094_ _7152_/D _5326_/A _5094_/B VPWR VGND sg13cmos5l_and2_1
Xheichips26_dna_sequencer_754 uio_oe[1] VPWR VGND sg13cmos5l_tiehi
X_4045_ _4863_/A input8/X _4058_/B _4060_/A VPWR VGND sg13cmos5l_o21ai_1
XFILLER_40_728 VPWR VGND sg13cmos5l_fill_2
X_5996_ _5996_/Y _5996_/A _5883_/B VPWR VGND sg13cmos5l_nor2b_1
X_4947_ _4947_/X _4957_/B _4952_/C _5245_/A VPWR VGND sg13cmos5l_a21o_1
XFILLER_20_441 VPWR VGND sg13cmos5l_decap_4
X_4878_ _4878_/Y _4878_/A _4878_/B VPWR VGND sg13cmos5l_nor2_1
X_6617_ _7406_/D _6661_/B _6617_/B VPWR VGND sg13cmos5l_and2_1
X_7597_ _7597_/Q _7597_/CLK _7597_/D _7597_/RESET_B VPWR VGND sg13cmos5l_dfrbpq_1
XFILLER_3_106 VPWR VGND sg13cmos5l_decap_4
X_6548_ _6548_/Y _6537_/A _6541_/Y _6547_/Y VPWR VGND sg13cmos5l_o21ai_1
X_6479_ _6479_/Y _7398_/Q _7395_/Q VPWR VGND sg13cmos5l_nor2b_1
XFILLER_47_327 VPWR VGND sg13cmos5l_fill_1
XFILLER_28_563 VPWR VGND sg13cmos5l_decap_4
XFILLER_15_246 VPWR VGND sg13cmos5l_decap_4
XFILLER_31_706 VPWR VGND sg13cmos5l_fill_2
XFILLER_24_780 VPWR VGND sg13cmos5l_decap_8
XFILLER_31_739 VPWR VGND sg13cmos5l_fill_2
XFILLER_8_957 VPWR VGND sg13cmos5l_decap_8
XFILLER_7_456 VPWR VGND sg13cmos5l_decap_4
XFILLER_8_979 VPWR VGND sg13cmos5l_decap_8
XFILLER_11_496 VPWR VGND sg13cmos5l_fill_1
XFILLER_3_695 VPWR VGND sg13cmos5l_decap_4
XFILLER_46_393 VPWR VGND sg13cmos5l_decap_8
XFILLER_46_371 VPWR VGND sg13cmos5l_decap_8
XFILLER_0_1028 VPWR VGND sg13cmos5l_fill_1
XFILLER_34_544 VPWR VGND sg13cmos5l_fill_2
X_7351__172 _7351_/D VPWR VGND sg13cmos5l_tielo
X_5850_ _5853_/B _7310_/Q _7311_/Q VPWR VGND sg13cmos5l_nor2_1
XFILLER_34_577 VPWR VGND sg13cmos5l_decap_8
X_5781_ _5781_/Y _5781_/A _5675_/B VPWR VGND sg13cmos5l_nor2b_1
X_4801_ _4801_/Y _4832_/A VPWR VGND sg13cmos5l_inv_1
X_7520_ _7520_/Q _7555_/CLK _7520_/D _7520_/RESET_B VPWR VGND sg13cmos5l_dfrbpq_1
XFILLER_9_40 VPWR VGND sg13cmos5l_fill_1
XFILLER_9_51 VPWR VGND sg13cmos5l_fill_1
X_4732_ _4732_/Y _5101_/A _7578_/Q VPWR VGND sg13cmos5l_nor2_1
X_4663_ _4663_/X _4663_/A _4663_/B VPWR VGND sg13cmos5l_xor2_1
X_7451_ _7451_/Q _7510_/CLK _7451_/D _7451_/RESET_B VPWR VGND sg13cmos5l_dfrbpq_1
X_6402_ _6402_/Y _6402_/A _6407_/B VPWR VGND sg13cmos5l_nand2_1
X_4594_ _4612_/C _4611_/A _4611_/B VPWR VGND sg13cmos5l_nand2_1
Xhold902 _7327_/D _6182_/Y VPWR VGND sg13cmos5l_dlygate4sd3_1
Xhold913 _6172_/A _7324_/Q VPWR VGND sg13cmos5l_dlygate4sd3_1
X_7382_ _7382_/Q clkload8/A _7382_/D _7382_/RESET_B VPWR VGND sg13cmos5l_dfrbpq_1
Xhold946 _4154_/A _7489_/Q VPWR VGND sg13cmos5l_dlygate4sd3_1
Xhold924 _5332_/A _7164_/Q VPWR VGND sg13cmos5l_dlygate4sd3_1
Xhold935 _4909_/B _4908_/Y VPWR VGND sg13cmos5l_dlygate4sd3_1
X_6333_ _6396_/B _6427_/A _6498_/B VPWR VGND sg13cmos5l_nor2_1
Xhold979 _7355_/D _6383_/Y VPWR VGND sg13cmos5l_dlygate4sd3_1
X_6264_ _6264_/Y _6269_/B _6259_/X _6261_/B VPWR VGND sg13cmos5l_a21oi_1
Xhold957 _4006_/A _7577_/Q VPWR VGND sg13cmos5l_dlygate4sd3_1
Xhold968 _4317_/B _7506_/Q VPWR VGND sg13cmos5l_dlygate4sd3_1
X_5215_ _5407_/A _5547_/B _5326_/A VPWR VGND sg13cmos5l_nand2b_1
X_6195_ _7338_/D _6195_/A _6325_/A VPWR VGND sg13cmos5l_nor2_1
X_5146_ _5147_/B _5146_/A _5146_/B VPWR VGND sg13cmos5l_or2_1
X_5077_ _5077_/X _5057_/Y _5286_/B _5083_/S VPWR VGND sg13cmos5l_mux2_1
X_4028_ _4074_/A _4043_/B VPWR VGND sg13cmos5l_inv_1
X_7334__381 _7334_/RESET_B VPWR VGND sg13cmos5l_tiehi
XFILLER_25_566 VPWR VGND sg13cmos5l_decap_8
XFILLER_25_577 VPWR VGND sg13cmos5l_fill_2
XFILLER_40_525 VPWR VGND sg13cmos5l_decap_4
X_5979_ _7296_/D _6659_/A _5979_/B VPWR VGND sg13cmos5l_and2_1
X_7649_ _7649_/Q _7651_/CLK _7649_/D _7649_/RESET_B VPWR VGND sg13cmos5l_dfrbpq_1
XFILLER_5_938 VPWR VGND sg13cmos5l_decap_8
XFILLER_0_621 VPWR VGND sg13cmos5l_decap_4
X_7341__374 _7341_/RESET_B VPWR VGND sg13cmos5l_tiehi
XFILLER_0_687 VPWR VGND sg13cmos5l_decap_4
XFILLER_47_146 VPWR VGND sg13cmos5l_fill_2
X_7237__500 _7237_/RESET_B VPWR VGND sg13cmos5l_tiehi
XFILLER_28_371 VPWR VGND sg13cmos5l_fill_2
XFILLER_16_588 VPWR VGND sg13cmos5l_decap_8
XFILLER_16_599 VPWR VGND sg13cmos5l_fill_1
XFILLER_12_783 VPWR VGND sg13cmos5l_fill_2
XFILLER_7_297 VPWR VGND sg13cmos5l_fill_1
XFILLER_4_982 VPWR VGND sg13cmos5l_decap_8
XFILLER_3_492 VPWR VGND sg13cmos5l_fill_2
X_5000_ _5000_/Y _7608_/Q _5007_/B VPWR VGND sg13cmos5l_xnor2_1
X_6951_ _6951_/Y _6933_/Y _6939_/Y _6741_/X VPWR VGND sg13cmos5l_o21ai_1
X_5902_ _5902_/Y _7272_/Q _7247_/Q VPWR VGND sg13cmos5l_nor2_1
X_7388__308 _7388_/RESET_B VPWR VGND sg13cmos5l_tiehi
X_6882_ _6883_/B _6858_/A _6855_/Y _6878_/X _6880_/Y VPWR VGND sg13cmos5l_a22oi_1
X_5833_ _5846_/A _5833_/A _5833_/B _5833_/C VPWR VGND sg13cmos5l_nor3_1
XFILLER_34_385 VPWR VGND sg13cmos5l_decap_4
XFILLER_22_536 VPWR VGND sg13cmos5l_decap_8
X_7503_ _7503_/Q _7560_/CLK _7503_/D _7503_/RESET_B VPWR VGND sg13cmos5l_dfrbpq_1
X_5764_ _5764_/Y hold874/X _7112_/A2 _7113_/A VPWR VGND sg13cmos5l_o21ai_1
X_5695_ _5695_/Y _7235_/Q _7210_/Q VPWR VGND sg13cmos5l_nor2_1
X_4715_ _4715_/Y _4707_/X _4711_/Y _4713_/Y _4449_/A _4714_/Y VPWR VGND sg13cmos5l_a221oi_1
X_7434_ _7434_/Q _7489_/CLK _7434_/D _7434_/RESET_B VPWR VGND sg13cmos5l_dfrbpq_1
X_4646_ _4646_/Y _4654_/B _4652_/C _5007_/A VPWR VGND sg13cmos5l_a21oi_1
X_4577_ _4578_/C _4577_/A _4577_/B _4577_/C VPWR VGND sg13cmos5l_nand3_1
X_7365_ _7365_/Q _7424_/CLK _7365_/D _7365_/RESET_B VPWR VGND sg13cmos5l_dfrbpq_1
XFILLER_2_919 VPWR VGND sg13cmos5l_fill_1
XFILLER_2_908 VPWR VGND sg13cmos5l_decap_8
X_6316_ _6323_/C _6306_/X _6312_/Y _6314_/Y VPWR VGND sg13cmos5l_a21o_1
Xhold787 _7365_/D _6362_/X VPWR VGND sg13cmos5l_dlygate4sd3_1
X_7296_ _7296_/Q clkload7/A _7296_/D _7296_/RESET_B VPWR VGND sg13cmos5l_dfrbpq_1
Xhold776 _6393_/B _7124_/Q VPWR VGND sg13cmos5l_dlygate4sd3_1
Xhold765 _6525_/B _7364_/Q VPWR VGND sg13cmos5l_dlygate4sd3_1
X_6247_ _6247_/Y _6247_/A _6247_/B _6247_/C VPWR VGND sg13cmos5l_nand3_1
Xhold798 _6828_/B _7419_/Q VPWR VGND sg13cmos5l_dlygate4sd3_1
X_6178_ _6178_/Y _6178_/A _6181_/B VPWR VGND sg13cmos5l_nor2_1
X_5129_ _5139_/A _5147_/C _5138_/C _5138_/A VPWR VGND sg13cmos5l_a21oi_1
XFILLER_13_525 VPWR VGND sg13cmos5l_fill_1
XFILLER_40_366 VPWR VGND sg13cmos5l_decap_8
XFILLER_40_399 VPWR VGND sg13cmos5l_decap_8
XFILLER_1_996 VPWR VGND sg13cmos5l_decap_8
XFILLER_49_967 VPWR VGND sg13cmos5l_decap_8
XFILLER_0_484 VPWR VGND sg13cmos5l_decap_8
XFILLER_16_341 VPWR VGND sg13cmos5l_fill_2
XFILLER_28_190 VPWR VGND sg13cmos5l_fill_2
XFILLER_44_694 VPWR VGND sg13cmos5l_fill_2
XFILLER_16_352 VPWR VGND sg13cmos5l_fill_1
XFILLER_43_171 VPWR VGND sg13cmos5l_decap_4
X_4500_ _4501_/B hold1157/X _4513_/B _4508_/A VPWR VGND sg13cmos5l_nand3b_1
X_5480_ _5486_/B _7177_/Q _5481_/B VPWR VGND sg13cmos5l_nand2b_1
X_4431_ _4433_/B _7595_/Q _4784_/A VPWR VGND sg13cmos5l_xor2_1
XFILLER_6_85 VPWR VGND sg13cmos5l_fill_1
X_4362_ _4362_/X _4362_/A _4362_/B _4362_/C VPWR VGND sg13cmos5l_or3_1
X_7150_ _7150_/Q _7611_/CLK _7150_/D _7150_/RESET_B VPWR VGND sg13cmos5l_dfrbpq_1
X_4293_ _4293_/Y _4296_/C _4293_/B VPWR VGND sg13cmos5l_nand2b_1
X_6101_ _6101_/Y _6126_/A _6127_/A _6126_/B VPWR VGND sg13cmos5l_a21oi_1
X_7081_ _7084_/A _7081_/A _7081_/B VPWR VGND sg13cmos5l_nand2_1
XFILLER_6_1012 VPWR VGND sg13cmos5l_decap_8
X_6032_ _6032_/Y _6033_/B VPWR VGND sg13cmos5l_inv_1
XFILLER_39_444 VPWR VGND sg13cmos5l_decap_8
X_7179__564 _7179_/RESET_B VPWR VGND sg13cmos5l_tiehi
XFILLER_39_455 VPWR VGND sg13cmos5l_fill_1
X_6934_ _6934_/X _6934_/A _6934_/B _6934_/C VPWR VGND sg13cmos5l_or3_1
XFILLER_41_119 VPWR VGND sg13cmos5l_fill_1
XFILLER_23_801 VPWR VGND sg13cmos5l_fill_1
X_6865_ _6865_/Y _6867_/B _6864_/Y _6843_/X VPWR VGND sg13cmos5l_a21oi_1
X_5816_ _5816_/Y _5820_/B VPWR VGND sg13cmos5l_inv_1
X_6796_ _6796_/Y _7007_/A _7004_/A _6802_/C VPWR VGND sg13cmos5l_nand3_1
XFILLER_41_38 VPWR VGND sg13cmos5l_fill_1
X_5747_ _5747_/Y _5745_/Y _5746_/Y _5740_/Y VPWR VGND sg13cmos5l_o21ai_1
XFILLER_22_388 VPWR VGND sg13cmos5l_fill_2
X_7186__557 _7186_/RESET_B VPWR VGND sg13cmos5l_tiehi
X_5678_ _5679_/B _5664_/X _5676_/X _5677_/X VPWR VGND sg13cmos5l_a21oi_1
X_7227__510 _7227_/RESET_B VPWR VGND sg13cmos5l_tiehi
X_7417_ _7417_/Q clkload8/A _7417_/D _7417_/RESET_B VPWR VGND sg13cmos5l_dfrbpq_1
X_4629_ _4631_/B _4625_/A _4600_/Y _4628_/Y VPWR VGND sg13cmos5l_a21oi_1
X_7348_ _7348_/Q _7375_/CLK _7348_/D _7348_/RESET_B VPWR VGND sg13cmos5l_dfrbpq_1
X_7279_ _7279_/Q _7307_/CLK _7279_/D _7279_/RESET_B VPWR VGND sg13cmos5l_dfrbpq_1
XFILLER_49_208 VPWR VGND sg13cmos5l_decap_8
X_7221__186 _7221_/D VPWR VGND sg13cmos5l_tielo
Xhold1240 _6616_/A1 _7379_/Q VPWR VGND sg13cmos5l_dlygate4sd3_1
XFILLER_18_606 VPWR VGND sg13cmos5l_fill_1
Xhold1251 _4837_/B _4836_/Y VPWR VGND sg13cmos5l_dlygate4sd3_1
XFILLER_46_937 VPWR VGND sg13cmos5l_decap_8
Xhold1284 _4475_/A1 _4445_/A VPWR VGND sg13cmos5l_dlygate4sd3_1
X_7234__503 _7234_/RESET_B VPWR VGND sg13cmos5l_tiehi
Xhold1273 _6109_/A _6295_/A VPWR VGND sg13cmos5l_dlygate4sd3_1
XFILLER_17_116 VPWR VGND sg13cmos5l_fill_2
XFILLER_18_628 VPWR VGND sg13cmos5l_decap_4
Xhold1262 hold1262/X _7594_/Q VPWR VGND sg13cmos5l_dlygate4sd3_1
XFILLER_45_458 VPWR VGND sg13cmos5l_fill_1
XFILLER_45_447 VPWR VGND sg13cmos5l_decap_8
Xhold1295 _5445_/A _7204_/Q VPWR VGND sg13cmos5l_dlygate4sd3_1
XFILLER_14_801 VPWR VGND sg13cmos5l_fill_2
XFILLER_13_344 VPWR VGND sg13cmos5l_fill_2
XFILLER_13_355 VPWR VGND sg13cmos5l_decap_8
XFILLER_13_366 VPWR VGND sg13cmos5l_fill_2
XFILLER_14_889 VPWR VGND sg13cmos5l_decap_8
XFILLER_12_1028 VPWR VGND sg13cmos5l_fill_1
XFILLER_31_71 VPWR VGND sg13cmos5l_decap_8
XFILLER_49_8 VPWR VGND sg13cmos5l_fill_1
XFILLER_5_587 VPWR VGND sg13cmos5l_decap_8
XFILLER_49_720 VPWR VGND sg13cmos5l_decap_4
XFILLER_49_775 VPWR VGND sg13cmos5l_decap_4
XFILLER_48_274 VPWR VGND sg13cmos5l_fill_1
XFILLER_36_436 VPWR VGND sg13cmos5l_decap_8
X_4980_ _7130_/D _5106_/B _5038_/A VPWR VGND sg13cmos5l_nor2_1
X_3931_ _6190_/A _5881_/A VPWR VGND sg13cmos5l_inv_1
X_3862_ _3862_/Y _3862_/A VPWR VGND sg13cmos5l_inv_1
X_6650_ _7412_/D _6638_/Y hold989/X _6707_/A VPWR VGND sg13cmos5l_a21oi_1
X_6581_ _6581_/Y _6588_/S _6581_/B VPWR VGND sg13cmos5l_nand2_1
X_5601_ _5601_/Y _5601_/A _5601_/B VPWR VGND sg13cmos5l_nor2_1
X_5532_ _5532_/Y _5522_/Y _5526_/Y _5530_/A _5741_/B _5531_/Y VPWR VGND sg13cmos5l_a221oi_1
X_7283__180 _7283_/D VPWR VGND sg13cmos5l_tielo
X_5463_ _7207_/D _5542_/A _5463_/B VPWR VGND sg13cmos5l_nor2_1
X_4414_ _4416_/A _4414_/A _4414_/B _4414_/C VPWR VGND sg13cmos5l_nor3_1
X_5394_ _5394_/Y _5371_/Y _5374_/Y _5390_/A _5392_/Y VPWR VGND sg13cmos5l_a22oi_1
X_7202_ _7202_/Q _7239_/CLK _7202_/D _7202_/RESET_B VPWR VGND sg13cmos5l_dfrbpq_1
X_7133_ _7133_/Q _7200_/CLK _7133_/D _7133_/RESET_B VPWR VGND sg13cmos5l_dfrbpq_1
X_4345_ _4345_/Y _7545_/Q _7112_/A2 _7113_/A VPWR VGND sg13cmos5l_o21ai_1
X_4276_ _4276_/Y _7523_/Q _3965_/Y _4273_/Y _4274_/Y _4275_/Y VPWR VGND sg13cmos5l_a221oi_1
X_7064_ _7065_/B _7053_/A _7056_/Y _7006_/B VPWR VGND sg13cmos5l_o21ai_1
XFILLER_39_252 VPWR VGND sg13cmos5l_decap_8
X_6015_ _6023_/C _7299_/Q _7265_/Q _7304_/Q VPWR VGND sg13cmos5l_nand3_1
XFILLER_39_285 VPWR VGND sg13cmos5l_fill_1
XFILLER_39_263 VPWR VGND sg13cmos5l_fill_2
XFILLER_36_27 VPWR VGND sg13cmos5l_fill_2
X_6917_ _7464_/D _7007_/B _7012_/A VPWR VGND sg13cmos5l_nor2_1
X_6848_ _6858_/A _6848_/A _6875_/B VPWR VGND sg13cmos5l_nor2_1
XFILLER_35_1028 VPWR VGND sg13cmos5l_fill_1
XFILLER_10_314 VPWR VGND sg13cmos5l_decap_4
X_6779_ _6838_/B _6768_/X _6778_/Y _6777_/Y VPWR VGND sg13cmos5l_a21oi_1
XFILLER_7_819 VPWR VGND sg13cmos5l_decap_8
XFILLER_6_318 VPWR VGND sg13cmos5l_fill_2
XFILLER_7_4 VPWR VGND sg13cmos5l_fill_2
XFILLER_19_904 VPWR VGND sg13cmos5l_fill_2
XFILLER_19_926 VPWR VGND sg13cmos5l_fill_1
XFILLER_45_222 VPWR VGND sg13cmos5l_fill_2
Xhold1092 _6420_/A _6408_/Y VPWR VGND sg13cmos5l_dlygate4sd3_1
Xhold1081 _5754_/B _5753_/X VPWR VGND sg13cmos5l_dlygate4sd3_1
Xhold1070 _3874_/A _7381_/Q VPWR VGND sg13cmos5l_dlygate4sd3_1
XFILLER_45_288 VPWR VGND sg13cmos5l_fill_1
XFILLER_9_123 VPWR VGND sg13cmos5l_fill_2
XFILLER_9_156 VPWR VGND sg13cmos5l_decap_8
X_7169__574 _7169_/RESET_B VPWR VGND sg13cmos5l_tiehi
XFILLER_5_362 VPWR VGND sg13cmos5l_fill_1
X_4130_ _4131_/B _4132_/B _4155_/B VPWR VGND sg13cmos5l_nor2_1
XFILLER_37_701 VPWR VGND sg13cmos5l_fill_1
XFILLER_3_75 VPWR VGND sg13cmos5l_fill_1
X_4061_ _4068_/A _4036_/Y _4043_/Y _4063_/B VPWR VGND sg13cmos5l_o21ai_1
X_7317__408 _7317_/RESET_B VPWR VGND sg13cmos5l_tiehi
X_7176__567 _7176_/RESET_B VPWR VGND sg13cmos5l_tiehi
X_4963_ _4965_/B _4994_/A _5257_/A VPWR VGND sg13cmos5l_nor2_1
X_6702_ _6708_/S _6700_/Y _6701_/Y _6699_/Y VPWR VGND sg13cmos5l_o21ai_1
X_3914_ _4355_/A _7083_/B VPWR VGND sg13cmos5l_inv_1
X_6633_ _6633_/Y _7383_/Q _6633_/B _6633_/C VPWR VGND sg13cmos5l_nor3_1
X_4894_ _4895_/B _4885_/X hold921/X _6108_/B VPWR VGND sg13cmos5l_o21ai_1
X_6564_ _6564_/Y _7426_/Q _6561_/Y _6563_/Y VPWR VGND sg13cmos5l_o21ai_1
X_5515_ _5527_/C _7240_/Q _5317_/A _5513_/Y VPWR VGND sg13cmos5l_o21ai_1
X_6495_ _7381_/D _6495_/A _6495_/B VPWR VGND sg13cmos5l_nor2_1
X_5446_ _5449_/A _5441_/X _5708_/A _5444_/Y _5445_/Y VPWR VGND sg13cmos5l_a22oi_1
Xfanout113 _5558_/A hold1255/X VPWR VGND sg13cmos5l_buf_1
X_5377_ _5378_/B _7192_/Q _5387_/B _5350_/Y VPWR VGND sg13cmos5l_a21oi_1
Xfanout102 _4575_/A hold1238/X VPWR VGND sg13cmos5l_buf_1
Xfanout135 _5326_/A _5328_/A VPWR VGND sg13cmos5l_buf_1
Xfanout124 _6507_/A input1/X VPWR VGND sg13cmos5l_buf_1
X_4328_ _4328_/Y _4540_/B _4324_/X _4326_/Y VPWR VGND sg13cmos5l_o21ai_1
X_7116_ _7116_/Q _7394_/CLK _7116_/D _7116_/RESET_B VPWR VGND sg13cmos5l_dfrbpq_1
X_4259_ _4360_/A _4249_/X _4257_/Y _4258_/X _4263_/S VPWR VGND sg13cmos5l_a22oi_1
X_7047_ _7052_/A _7047_/A _7047_/B VPWR VGND sg13cmos5l_nand2_1
X_7437__256 _7437_/RESET_B VPWR VGND sg13cmos5l_tiehi
XFILLER_15_417 VPWR VGND sg13cmos5l_decap_8
X_7231__506 _7231_/RESET_B VPWR VGND sg13cmos5l_tiehi
XFILLER_11_667 VPWR VGND sg13cmos5l_fill_1
XFILLER_7_649 VPWR VGND sg13cmos5l_fill_2
XFILLER_10_166 VPWR VGND sg13cmos5l_fill_1
X_7444__249 _7444_/RESET_B VPWR VGND sg13cmos5l_tiehi
XFILLER_10_199 VPWR VGND sg13cmos5l_decap_4
XFILLER_2_343 VPWR VGND sg13cmos5l_fill_1
XFILLER_38_509 VPWR VGND sg13cmos5l_fill_2
XFILLER_19_701 VPWR VGND sg13cmos5l_fill_1
XFILLER_46_575 VPWR VGND sg13cmos5l_decap_4
XFILLER_15_940 VPWR VGND sg13cmos5l_decap_4
XFILLER_14_450 VPWR VGND sg13cmos5l_fill_1
XFILLER_15_973 VPWR VGND sg13cmos5l_decap_8
XFILLER_30_943 VPWR VGND sg13cmos5l_fill_1
X_7503__313 _7503_/RESET_B VPWR VGND sg13cmos5l_tiehi
XFILLER_6_671 VPWR VGND sg13cmos5l_decap_8
X_7323__401 _7323_/RESET_B VPWR VGND sg13cmos5l_tiehi
X_5300_ _5300_/X _7181_/Q _5300_/B VPWR VGND sg13cmos5l_or2_1
X_6280_ _6286_/B _7289_/Q _6240_/C _5894_/Y VPWR VGND sg13cmos5l_o21ai_1
XFILLER_45_2 VPWR VGND sg13cmos5l_fill_1
X_5231_ _5231_/Y _5485_/A _5231_/B VPWR VGND sg13cmos5l_nand2_1
X_5162_ _5162_/Y _5163_/B VPWR VGND sg13cmos5l_inv_1
X_4113_ _4116_/B _4113_/A _4113_/B VPWR VGND sg13cmos5l_and2_1
X_5093_ _7151_/D _3889_/Y _5550_/A2 _5092_/Y VPWR VGND sg13cmos5l_a21oi_1
Xheichips26_dna_sequencer_755 uio_oe[2] VPWR VGND sg13cmos5l_tiehi
XFILLER_37_520 VPWR VGND sg13cmos5l_decap_4
X_4044_ _4060_/A _7646_/Q _4067_/C VPWR VGND sg13cmos5l_nand2_1
X_5995_ _5995_/Y _5886_/B _5997_/A VPWR VGND sg13cmos5l_nand2b_1
X_4946_ _4952_/C _7130_/Q _7131_/Q _7132_/Q VPWR VGND sg13cmos5l_o21ai_1
XFILLER_21_910 VPWR VGND sg13cmos5l_decap_8
X_4877_ _4877_/Y _4875_/A _4879_/A _4875_/Y VPWR VGND sg13cmos5l_o21ai_1
X_6616_ _6616_/Y _6616_/A1 _6600_/B _6451_/Y VPWR VGND sg13cmos5l_o21ai_1
X_7596_ _7596_/Q _7597_/CLK _7596_/D _7596_/RESET_B VPWR VGND sg13cmos5l_dfrbpq_1
X_6547_ _6547_/Y _6547_/A _6547_/B VPWR VGND sg13cmos5l_nor2_1
X_6478_ _6478_/Y _6475_/Y _6476_/Y _6477_/Y VPWR VGND sg13cmos5l_o21ai_1
X_7599__694 _7599_/RESET_B VPWR VGND sg13cmos5l_tiehi
X_5429_ _5429_/X _5429_/A _5429_/B VPWR VGND sg13cmos5l_xor2_1
XFILLER_0_803 VPWR VGND sg13cmos5l_decap_8
X_7159__584 _7159_/RESET_B VPWR VGND sg13cmos5l_tiehi
XFILLER_43_512 VPWR VGND sg13cmos5l_decap_8
XFILLER_16_726 VPWR VGND sg13cmos5l_fill_1
X_7307__418 _7307_/RESET_B VPWR VGND sg13cmos5l_tiehi
X_7166__577 _7166_/RESET_B VPWR VGND sg13cmos5l_tiehi
XFILLER_3_685 VPWR VGND sg13cmos5l_decap_4
XFILLER_46_350 VPWR VGND sg13cmos5l_decap_8
XFILLER_0_98 VPWR VGND sg13cmos5l_decap_8
XFILLER_22_707 VPWR VGND sg13cmos5l_fill_2
X_4800_ _4832_/A _4791_/A _4680_/A _4838_/S VPWR VGND sg13cmos5l_mux2_1
X_5780_ _5780_/Y _5712_/A _5712_/B _5671_/A VPWR VGND sg13cmos5l_a21oi_1
X_4731_ _7609_/D _4784_/B _4843_/B VPWR VGND sg13cmos5l_and2_1
X_4662_ _4669_/B _7603_/Q _4663_/B VPWR VGND sg13cmos5l_nor2b_1
X_7450_ _7450_/Q _7510_/CLK _7450_/D _7450_/RESET_B VPWR VGND sg13cmos5l_dfrbpq_1
X_7427__266 _7427_/RESET_B VPWR VGND sg13cmos5l_tiehi
XFILLER_30_795 VPWR VGND sg13cmos5l_fill_1
X_6401_ _6409_/A _7367_/Q _6407_/B VPWR VGND sg13cmos5l_or2_1
X_4593_ _4603_/A _7589_/Q _4611_/B VPWR VGND sg13cmos5l_xnor2_1
Xhold903 _3880_/A _7323_/Q VPWR VGND sg13cmos5l_dlygate4sd3_1
X_7381_ _7381_/Q clkload8/A _7381_/D _7381_/RESET_B VPWR VGND sg13cmos5l_dfrbpq_1
Xhold936 _4917_/B _4916_/Y VPWR VGND sg13cmos5l_dlygate4sd3_1
Xhold914 _7324_/D _6174_/Y VPWR VGND sg13cmos5l_dlygate4sd3_1
X_6332_ _7344_/D _6299_/A _6229_/B _6331_/A VPWR VGND sg13cmos5l_a21oi_1
Xhold925 _7195_/D _5332_/X VPWR VGND sg13cmos5l_dlygate4sd3_1
X_6263_ _6263_/Y _6263_/A _6263_/B VPWR VGND sg13cmos5l_nor2_1
Xhold958 _7577_/D _4557_/Y VPWR VGND sg13cmos5l_dlygate4sd3_1
Xhold947 _6802_/B _7459_/Q VPWR VGND sg13cmos5l_dlygate4sd3_1
Xhold969 hold969/X _4318_/B VPWR VGND sg13cmos5l_dlygate4sd3_1
X_5214_ _5332_/B _6711_/A _5547_/B VPWR VGND sg13cmos5l_nor2_1
X_6194_ _7337_/D _6194_/A _6325_/A VPWR VGND sg13cmos5l_nor2_1
X_5145_ _5170_/B _5030_/Y _5105_/A _5145_/S VPWR VGND sg13cmos5l_mux2_1
X_5076_ _5083_/S _5072_/Y _5074_/Y _5075_/Y VPWR VGND sg13cmos5l_a21oi_1
X_7434__259 _7434_/RESET_B VPWR VGND sg13cmos5l_tiehi
X_4027_ _4043_/B _4031_/A _4901_/B VPWR VGND sg13cmos5l_nor2b_1
XFILLER_37_383 VPWR VGND sg13cmos5l_fill_2
XFILLER_44_38 VPWR VGND sg13cmos5l_fill_2
X_5978_ _5978_/Y _5967_/B _5978_/A2 _5976_/A VPWR VGND sg13cmos5l_a21oi_1
X_4929_ _7122_/D _3982_/Y _6500_/A2 _4928_/Y VPWR VGND sg13cmos5l_a21oi_1
XFILLER_21_762 VPWR VGND sg13cmos5l_fill_2
X_7648_ _7648_/Q clkload6/A _7648_/D _7648_/RESET_B VPWR VGND sg13cmos5l_dfrbpq_1
X_7328__175 _7328_/D VPWR VGND sg13cmos5l_tielo
X_7579_ _7579_/Q _7635_/CLK _7579_/D _7579_/RESET_B VPWR VGND sg13cmos5l_dfrbpq_1
XFILLER_0_633 VPWR VGND sg13cmos5l_decap_8
XFILLER_48_659 VPWR VGND sg13cmos5l_decap_8
XFILLER_44_821 VPWR VGND sg13cmos5l_decap_4
XFILLER_18_72 VPWR VGND sg13cmos5l_decap_8
XFILLER_43_353 VPWR VGND sg13cmos5l_decap_8
XFILLER_44_898 VPWR VGND sg13cmos5l_decap_4
XFILLER_31_537 VPWR VGND sg13cmos5l_fill_1
X_7643__345 _7643_/RESET_B VPWR VGND sg13cmos5l_tiehi
XFILLER_8_733 VPWR VGND sg13cmos5l_fill_2
XFILLER_4_961 VPWR VGND sg13cmos5l_decap_8
XFILLER_22_4 VPWR VGND sg13cmos5l_fill_2
X_6950_ _7468_/D _7006_/B _7034_/A VPWR VGND sg13cmos5l_and2_1
X_5901_ _5901_/Y _7273_/Q _7248_/Q VPWR VGND sg13cmos5l_nand2b_1
X_6881_ _6883_/A _6881_/A _6881_/B VPWR VGND sg13cmos5l_nand2_1
XFILLER_34_331 VPWR VGND sg13cmos5l_decap_8
X_5832_ _5833_/C _5832_/A _5832_/B _5832_/C VPWR VGND sg13cmos5l_and3_1
XFILLER_22_526 VPWR VGND sg13cmos5l_fill_1
X_5763_ _7259_/D _6827_/A _5763_/B VPWR VGND sg13cmos5l_and2_1
X_7502_ _7502_/Q _7560_/CLK _7502_/D _7502_/RESET_B VPWR VGND sg13cmos5l_dfrbpq_1
X_4714_ _4714_/Y _4714_/A _4714_/B VPWR VGND sg13cmos5l_nor2_1
X_5694_ _5694_/Y _5450_/A _7211_/Q VPWR VGND sg13cmos5l_nand2b_1
X_7433_ _7433_/Q _7490_/CLK _7433_/D _7433_/RESET_B VPWR VGND sg13cmos5l_dfrbpq_1
X_4645_ _4652_/C _7599_/Q _7600_/Q _4645_/B1 VPWR VGND sg13cmos5l_o21ai_1
X_4576_ _4576_/Y _4623_/A _4623_/B VPWR VGND sg13cmos5l_nand2b_1
X_7364_ _7364_/Q _7394_/CLK _7364_/D _7364_/RESET_B VPWR VGND sg13cmos5l_dfrbpq_1
X_6315_ _6329_/C _6306_/X _6312_/Y _6314_/Y VPWR VGND sg13cmos5l_a21oi_1
X_7295_ _7295_/Q clkload9/A _7295_/D _7295_/RESET_B VPWR VGND sg13cmos5l_dfrbpq_1
Xhold777 _5770_/B _7226_/Q VPWR VGND sg13cmos5l_dlygate4sd3_1
Xhold788 _5555_/B _7190_/Q VPWR VGND sg13cmos5l_dlygate4sd3_1
Xhold766 _4782_/B _7586_/Q VPWR VGND sg13cmos5l_dlygate4sd3_1
XFILLER_39_38 VPWR VGND sg13cmos5l_fill_2
X_6246_ _6247_/C _7309_/Q _7284_/Q VPWR VGND sg13cmos5l_or2_1
Xhold799 _5800_/B _7228_/Q VPWR VGND sg13cmos5l_dlygate4sd3_1
X_7596__697 _7596_/RESET_B VPWR VGND sg13cmos5l_tiehi
X_6177_ _6177_/Y _6180_/A _6177_/B _6177_/C VPWR VGND sg13cmos5l_nor3_1
X_5128_ _5138_/C _7151_/Q _7623_/Q _7156_/Q VPWR VGND sg13cmos5l_nand3_1
XFILLER_29_136 VPWR VGND sg13cmos5l_decap_8
XFILLER_44_117 VPWR VGND sg13cmos5l_decap_8
X_5059_ _5059_/Y _7166_/Q _5330_/A VPWR VGND sg13cmos5l_nor2b_1
XFILLER_44_139 VPWR VGND sg13cmos5l_decap_4
XFILLER_37_191 VPWR VGND sg13cmos5l_fill_2
XFILLER_37_180 VPWR VGND sg13cmos5l_fill_2
X_7156__587 _7156_/RESET_B VPWR VGND sg13cmos5l_tiehi
XFILLER_25_342 VPWR VGND sg13cmos5l_fill_1
XFILLER_40_301 VPWR VGND sg13cmos5l_decap_8
XFILLER_5_725 VPWR VGND sg13cmos5l_fill_2
XFILLER_4_257 VPWR VGND sg13cmos5l_fill_1
XFILLER_0_463 VPWR VGND sg13cmos5l_fill_2
XFILLER_1_975 VPWR VGND sg13cmos5l_decap_8
XFILLER_49_946 VPWR VGND sg13cmos5l_decap_8
XFILLER_16_331 VPWR VGND sg13cmos5l_fill_1
XFILLER_17_854 VPWR VGND sg13cmos5l_decap_4
XFILLER_31_389 VPWR VGND sg13cmos5l_decap_8
X_4430_ _4433_/A _4427_/B _4430_/B VPWR VGND sg13cmos5l_nand2b_1
X_7424__269 _7424_/RESET_B VPWR VGND sg13cmos5l_tiehi
X_7166__193 _7166_/D VPWR VGND sg13cmos5l_tielo
X_4361_ _4362_/C _4256_/A _4286_/Y _4360_/B _4360_/A VPWR VGND sg13cmos5l_a22oi_1
X_6100_ _6127_/A _6096_/A _6096_/B _6092_/Y VPWR VGND sg13cmos5l_a21oi_1
X_4292_ _4293_/B _7499_/Q _7500_/Q _4292_/B1 VPWR VGND sg13cmos5l_o21ai_1
X_7080_ _7081_/B _7524_/Q _6968_/B _7079_/Y VPWR VGND sg13cmos5l_o21ai_1
X_7394__302 _7394_/RESET_B VPWR VGND sg13cmos5l_tiehi
X_6031_ _6033_/B _5997_/A _5886_/B _6042_/S VPWR VGND sg13cmos5l_mux2_1
XFILLER_39_478 VPWR VGND sg13cmos5l_fill_1
XFILLER_13_0 VPWR VGND sg13cmos5l_fill_1
X_6933_ _6933_/Y _6934_/A _6934_/B _6934_/C VPWR VGND sg13cmos5l_nor3_1
XFILLER_25_18 VPWR VGND sg13cmos5l_fill_1
X_6864_ _6864_/Y _6868_/B _6864_/B VPWR VGND sg13cmos5l_nor2_1
X_5815_ _5820_/B _5781_/A _5675_/B _5827_/S VPWR VGND sg13cmos5l_mux2_1
X_6795_ _6795_/Y _7410_/Q _6801_/B VPWR VGND sg13cmos5l_nand2_1
X_5746_ _5746_/Y _7254_/Q _5733_/Y _5744_/X VPWR VGND sg13cmos5l_o21ai_1
X_5677_ _5677_/X _5677_/A _5677_/B _5677_/C VPWR VGND sg13cmos5l_and3_1
X_4628_ _4628_/Y _4628_/A _4628_/B VPWR VGND sg13cmos5l_nor2_1
X_7416_ _7416_/Q clkload8/A _7416_/D _7416_/RESET_B VPWR VGND sg13cmos5l_dfrbpq_1
XFILLER_2_706 VPWR VGND sg13cmos5l_fill_1
X_7347_ _7347_/Q _7375_/CLK _7347_/D _7347_/RESET_B VPWR VGND sg13cmos5l_dfrbpq_1
X_4559_ _4559_/Y _4545_/Y hold991/X _4516_/A VPWR VGND sg13cmos5l_a21oi_1
X_7278_ _7278_/Q _7307_/CLK _7278_/D _7278_/RESET_B VPWR VGND sg13cmos5l_dfrbpq_1
X_6229_ _6329_/A _6293_/A _6229_/B VPWR VGND sg13cmos5l_nor2_1
Xhold1230 _6463_/A _7353_/Q VPWR VGND sg13cmos5l_dlygate4sd3_1
Xhold1241 _6617_/B _6616_/Y VPWR VGND sg13cmos5l_dlygate4sd3_1
Xhold1252 _4860_/A1 _4842_/A VPWR VGND sg13cmos5l_dlygate4sd3_1
Xhold1263 _4600_/A _7592_/Q VPWR VGND sg13cmos5l_dlygate4sd3_1
Xhold1285 _4616_/A _7590_/Q VPWR VGND sg13cmos5l_dlygate4sd3_1
Xhold1274 _6201_/A _7333_/Q VPWR VGND sg13cmos5l_dlygate4sd3_1
Xhold1296 _6899_/A _7463_/Q VPWR VGND sg13cmos5l_dlygate4sd3_1
XFILLER_40_120 VPWR VGND sg13cmos5l_fill_1
X_7447__214 _7447_/RESET_B VPWR VGND sg13cmos5l_tiehi
XFILLER_13_378 VPWR VGND sg13cmos5l_decap_8
XFILLER_31_50 VPWR VGND sg13cmos5l_fill_1
XFILLER_37_938 VPWR VGND sg13cmos5l_fill_2
XFILLER_37_927 VPWR VGND sg13cmos5l_decap_8
X_3930_ _6191_/A _3930_/A VPWR VGND sg13cmos5l_inv_1
X_7649__351 _7649_/RESET_B VPWR VGND sg13cmos5l_tiehi
X_3861_ _3861_/Y _7024_/A VPWR VGND sg13cmos5l_inv_1
X_6580_ _6581_/B _6830_/A _6767_/A VPWR VGND sg13cmos5l_and2_1
X_5600_ _5600_/Y _5601_/B VPWR VGND sg13cmos5l_inv_1
X_5531_ _5531_/Y _7218_/Q _5531_/B VPWR VGND sg13cmos5l_nor2_1
XFILLER_9_850 VPWR VGND sg13cmos5l_decap_8
X_7201_ _7201_/Q _7214_/CLK _7201_/D _7201_/RESET_B VPWR VGND sg13cmos5l_dfrbpq_1
X_5462_ _5463_/B _5441_/X _5460_/A _5461_/Y _5444_/Y VPWR VGND sg13cmos5l_a22oi_1
X_4413_ _7557_/D _4405_/B _4409_/Y _4412_/Y VPWR VGND sg13cmos5l_a21oi_1
X_5393_ _5393_/X _5341_/A _5347_/Y _5391_/X VPWR VGND sg13cmos5l_a21o_1
X_7132_ _7132_/Q _7200_/CLK _7132_/D _7132_/RESET_B VPWR VGND sg13cmos5l_dfrbpq_1
X_4344_ _4344_/X _4344_/A _4344_/B VPWR VGND sg13cmos5l_or2_1
X_7063_ _7065_/A _7063_/A _7056_/Y VPWR VGND sg13cmos5l_nor2b_1
X_4275_ _4275_/Y _7500_/Q _7522_/Q VPWR VGND sg13cmos5l_nor2b_1
X_6014_ _6036_/A _6034_/A _6034_/B VPWR VGND sg13cmos5l_nand2_1
XFILLER_39_220 VPWR VGND sg13cmos5l_fill_1
XFILLER_27_415 VPWR VGND sg13cmos5l_fill_1
XFILLER_39_297 VPWR VGND sg13cmos5l_decap_4
X_7118__633 _7118_/RESET_B VPWR VGND sg13cmos5l_tiehi
X_6916_ _7012_/A _6897_/Y _4160_/Y _6916_/S VPWR VGND sg13cmos5l_mux2_1
XFILLER_36_993 VPWR VGND sg13cmos5l_fill_1
X_6847_ _6863_/B _6845_/Y _6846_/Y _6844_/Y VPWR VGND sg13cmos5l_a21oi_1
X_6778_ _6778_/Y _6751_/B _6751_/C _6773_/B VPWR VGND sg13cmos5l_a21oi_1
X_5729_ _5729_/Y _5723_/Y _5727_/Y _5728_/Y VPWR VGND sg13cmos5l_o21ai_1
XFILLER_46_735 VPWR VGND sg13cmos5l_fill_1
Xhold1060 _4004_/A _7611_/Q VPWR VGND sg13cmos5l_dlygate4sd3_1
Xhold1082 _3950_/A _7635_/Q VPWR VGND sg13cmos5l_dlygate4sd3_1
Xhold1071 _6495_/B _6494_/X VPWR VGND sg13cmos5l_dlygate4sd3_1
Xhold1093 _3978_/A _7474_/Q VPWR VGND sg13cmos5l_dlygate4sd3_1
XFILLER_26_83 VPWR VGND sg13cmos5l_decap_4
XFILLER_42_963 VPWR VGND sg13cmos5l_decap_8
XFILLER_13_164 VPWR VGND sg13cmos5l_decap_8
XFILLER_14_676 VPWR VGND sg13cmos5l_decap_4
XFILLER_13_197 VPWR VGND sg13cmos5l_decap_8
XFILLER_6_853 VPWR VGND sg13cmos5l_fill_1
XFILLER_6_886 VPWR VGND sg13cmos5l_fill_1
XFILLER_6_875 VPWR VGND sg13cmos5l_decap_8
XFILLER_49_540 VPWR VGND sg13cmos5l_fill_1
X_4060_ _4344_/A _4060_/A _4060_/B _4060_/C VPWR VGND sg13cmos5l_nand3_1
X_7391__305 _7391_/RESET_B VPWR VGND sg13cmos5l_tiehi
XFILLER_49_584 VPWR VGND sg13cmos5l_fill_1
XFILLER_49_573 VPWR VGND sg13cmos5l_fill_2
XFILLER_37_713 VPWR VGND sg13cmos5l_fill_2
X_4962_ _5257_/A _5333_/A _4962_/B VPWR VGND sg13cmos5l_xnor2_1
XFILLER_18_993 VPWR VGND sg13cmos5l_fill_1
X_6701_ _6701_/Y _6695_/Y _6698_/Y _6679_/X VPWR VGND sg13cmos5l_o21ai_1
X_3913_ _7090_/B _3913_/A VPWR VGND sg13cmos5l_inv_1
X_4893_ _4893_/Y _3892_/Y _4901_/A _4892_/A VPWR VGND sg13cmos5l_o21ai_1
X_6632_ _6632_/Y _7411_/Q _6632_/B VPWR VGND sg13cmos5l_nand2b_1
X_6563_ _6563_/Y _7425_/Q _7399_/Q _6563_/C VPWR VGND sg13cmos5l_nand3_1
X_5514_ _5514_/Y _7184_/Q _5514_/B VPWR VGND sg13cmos5l_nor2_1
X_6494_ _6494_/X _6485_/B _6633_/B _6494_/S VPWR VGND sg13cmos5l_mux2_1
X_5445_ _5445_/Y _5445_/A _5461_/B VPWR VGND sg13cmos5l_nor2_1
Xfanout103 _4571_/A _4257_/A VPWR VGND sg13cmos5l_buf_1
X_5376_ _5376_/Y _5376_/A _5376_/B _5376_/C VPWR VGND sg13cmos5l_nand3_1
X_7115_ _7115_/Q _7394_/CLK _7115_/D _7115_/RESET_B VPWR VGND sg13cmos5l_dfrbpq_1
Xfanout114 _5330_/A hold1232/X VPWR VGND sg13cmos5l_buf_1
Xfanout125 _6659_/A _6660_/A VPWR VGND sg13cmos5l_buf_1
Xfanout136 _5328_/A _4560_/A VPWR VGND sg13cmos5l_buf_1
X_4327_ _4327_/Y _7561_/Q _7560_/Q VPWR VGND sg13cmos5l_nand2b_1
X_4258_ _4258_/X _4258_/A _4258_/B VPWR VGND sg13cmos5l_and2_1
XFILLER_41_1011 VPWR VGND sg13cmos5l_fill_2
X_7046_ _7046_/Y _7046_/A _7046_/B _7046_/C VPWR VGND sg13cmos5l_nand3_1
XFILLER_27_201 VPWR VGND sg13cmos5l_fill_2
X_4189_ _4189_/Y _4188_/X _4213_/A VPWR VGND sg13cmos5l_nand2b_1
XFILLER_27_245 VPWR VGND sg13cmos5l_fill_1
XFILLER_42_226 VPWR VGND sg13cmos5l_decap_4
XFILLER_42_204 VPWR VGND sg13cmos5l_fill_2
XFILLER_42_259 VPWR VGND sg13cmos5l_fill_1
XFILLER_11_624 VPWR VGND sg13cmos5l_decap_4
XFILLER_11_635 VPWR VGND sg13cmos5l_fill_1
XFILLER_10_145 VPWR VGND sg13cmos5l_decap_8
XFILLER_12_96 VPWR VGND sg13cmos5l_decap_4
XFILLER_3_889 VPWR VGND sg13cmos5l_fill_1
XFILLER_3_878 VPWR VGND sg13cmos5l_fill_2
X_7531__212 _7531_/D VPWR VGND sg13cmos5l_tielo
XFILLER_46_598 VPWR VGND sg13cmos5l_fill_2
XFILLER_14_473 VPWR VGND sg13cmos5l_decap_8
XFILLER_30_911 VPWR VGND sg13cmos5l_fill_2
XFILLER_14_484 VPWR VGND sg13cmos5l_decap_4
XFILLER_14_495 VPWR VGND sg13cmos5l_fill_1
XFILLER_30_999 VPWR VGND sg13cmos5l_decap_4
XFILLER_6_650 VPWR VGND sg13cmos5l_fill_2
X_5230_ _7170_/D _5314_/A _5341_/A VPWR VGND sg13cmos5l_nor2_1
X_7182__561 _7182_/RESET_B VPWR VGND sg13cmos5l_tiehi
X_5161_ _5163_/B _5161_/A _5161_/B VPWR VGND sg13cmos5l_nand2_1
X_4112_ _4113_/B _4108_/Y _4109_/Y _4111_/Y VPWR VGND sg13cmos5l_o21ai_1
X_5092_ _5092_/Y hold900/X _5550_/A2 _5087_/A VPWR VGND sg13cmos5l_o21ai_1
XFILLER_25_1028 VPWR VGND sg13cmos5l_fill_1
Xheichips26_dna_sequencer_756 uio_oe[3] VPWR VGND sg13cmos5l_tiehi
X_4043_ _4043_/Y _4901_/A _4043_/B VPWR VGND sg13cmos5l_nor2_1
XFILLER_37_554 VPWR VGND sg13cmos5l_fill_2
X_5994_ _7308_/D _5994_/A _5994_/B VPWR VGND sg13cmos5l_nor2_1
X_4945_ _4957_/B _7132_/Q _7130_/Q _7131_/Q VPWR VGND sg13cmos5l_or3_1
X_4876_ _4879_/A _4872_/A _4035_/B _4872_/C VPWR VGND sg13cmos5l_a21oi_1
X_6615_ _7405_/D _6707_/A _6691_/A VPWR VGND sg13cmos5l_nor2_1
XFILLER_20_454 VPWR VGND sg13cmos5l_fill_1
X_7595_ _7595_/Q _7597_/CLK _7595_/D _7595_/RESET_B VPWR VGND sg13cmos5l_dfrbpq_1
XFILLER_20_487 VPWR VGND sg13cmos5l_fill_2
X_7480__439 _7480_/RESET_B VPWR VGND sg13cmos5l_tiehi
X_6546_ _6547_/B _6532_/Y _6534_/X _6545_/Y VPWR VGND sg13cmos5l_o21ai_1
X_7443__250 _7443_/RESET_B VPWR VGND sg13cmos5l_tiehi
X_6477_ _6477_/Y _6664_/A _7357_/Q _3973_/Y _7397_/Q VPWR VGND sg13cmos5l_a22oi_1
X_5428_ _5438_/B _7208_/Q _5429_/B VPWR VGND sg13cmos5l_nor2b_1
X_5359_ _5369_/C _7188_/Q _7154_/Q _7193_/Q VPWR VGND sg13cmos5l_nand3_1
X_7029_ _7030_/B _7055_/A _7055_/B _7055_/C _7028_/Y VPWR VGND sg13cmos5l_a22oi_1
XFILLER_16_705 VPWR VGND sg13cmos5l_fill_1
XFILLER_28_598 VPWR VGND sg13cmos5l_fill_2
XFILLER_12_988 VPWR VGND sg13cmos5l_fill_2
XFILLER_23_40 VPWR VGND sg13cmos5l_fill_2
XFILLER_23_51 VPWR VGND sg13cmos5l_fill_2
XFILLER_48_1017 VPWR VGND sg13cmos5l_decap_8
XFILLER_48_1028 VPWR VGND sg13cmos5l_fill_1
XFILLER_2_185 VPWR VGND sg13cmos5l_decap_4
XFILLER_46_340 VPWR VGND sg13cmos5l_fill_2
XFILLER_0_1019 VPWR VGND sg13cmos5l_decap_8
XFILLER_34_535 VPWR VGND sg13cmos5l_fill_1
XFILLER_34_546 VPWR VGND sg13cmos5l_fill_1
X_4730_ _4843_/B _4449_/X _4730_/B VPWR VGND sg13cmos5l_nand2b_1
X_4661_ _5017_/A _5101_/A _4661_/B VPWR VGND sg13cmos5l_xnor2_1
XFILLER_30_763 VPWR VGND sg13cmos5l_fill_1
X_6400_ _6407_/B _6398_/Y _6399_/Y _6413_/A VPWR VGND sg13cmos5l_a21oi_1
X_7380_ _7380_/Q clkload8/A _7380_/D _7380_/RESET_B VPWR VGND sg13cmos5l_dfrbpq_1
X_4592_ _4624_/B _7590_/Q _4611_/B VPWR VGND sg13cmos5l_nand2_1
Xhold904 _7323_/D _6171_/Y VPWR VGND sg13cmos5l_dlygate4sd3_1
X_6331_ _7343_/D _6331_/A _6331_/B _6331_/C VPWR VGND sg13cmos5l_nor3_1
Xhold937 _7127_/D _4942_/Y VPWR VGND sg13cmos5l_dlygate4sd3_1
XFILLER_7_981 VPWR VGND sg13cmos5l_decap_8
Xhold926 _3933_/A _7276_/Q VPWR VGND sg13cmos5l_dlygate4sd3_1
Xhold915 hold915/X _7186_/Q VPWR VGND sg13cmos5l_dlygate4sd3_1
XFILLER_43_0 VPWR VGND sg13cmos5l_decap_4
Xhold959 _3962_/A _7558_/Q VPWR VGND sg13cmos5l_dlygate4sd3_1
X_6262_ _6263_/B _6255_/Y _6256_/Y _6260_/Y _6261_/Y _6258_/Y VPWR VGND sg13cmos5l_a221oi_1
Xhold948 hold948/X _7639_/Q VPWR VGND sg13cmos5l_dlygate4sd3_1
X_5213_ _5337_/B _5208_/X _5209_/X _5229_/S _5212_/Y VPWR VGND sg13cmos5l_a22oi_1
X_6193_ _7336_/D _6193_/A _6325_/A VPWR VGND sg13cmos5l_nor2_1
X_5144_ _5144_/Y _5144_/A VPWR VGND sg13cmos5l_inv_1
X_5075_ _5075_/Y _7146_/Q _5073_/Y _5284_/B VPWR VGND sg13cmos5l_o21ai_1
X_4026_ _4029_/B _4026_/A _4892_/A _7640_/Q VPWR VGND sg13cmos5l_nor3_1
XFILLER_44_17 VPWR VGND sg13cmos5l_decap_8
XFILLER_38_885 VPWR VGND sg13cmos5l_fill_2
XFILLER_44_28 VPWR VGND sg13cmos5l_fill_1
XFILLER_25_535 VPWR VGND sg13cmos5l_fill_1
X_5977_ _6159_/A _7295_/Q _5977_/B VPWR VGND sg13cmos5l_nand2b_1
X_4928_ _4928_/Y _4939_/A _6500_/A2 _6391_/B1 VPWR VGND sg13cmos5l_o21ai_1
X_7647_ _7647_/Q _7651_/CLK _7647_/D _7647_/RESET_B VPWR VGND sg13cmos5l_dfrbpq_1
X_4859_ _4859_/Y _4842_/B _4850_/Y _4784_/B VPWR VGND sg13cmos5l_o21ai_1
Xclkbuf_3_0__f_clk clkbuf_leaf_5_clk/A clkbuf_0_clk/X VPWR VGND sg13cmos5l_buf_8
X_7578_ _7578_/Q _7630_/CLK _7578_/D _7578_/RESET_B VPWR VGND sg13cmos5l_dfrbpq_1
X_6529_ _6529_/X _7393_/Q _6541_/B _6545_/B VPWR VGND sg13cmos5l_a21o_1
XFILLER_0_667 VPWR VGND sg13cmos5l_decap_8
XFILLER_47_148 VPWR VGND sg13cmos5l_fill_1
XFILLER_44_833 VPWR VGND sg13cmos5l_decap_8
XFILLER_16_513 VPWR VGND sg13cmos5l_fill_2
X_7313__412 _7313_/RESET_B VPWR VGND sg13cmos5l_tiehi
XFILLER_43_365 VPWR VGND sg13cmos5l_decap_8
X_7172__571 _7172_/RESET_B VPWR VGND sg13cmos5l_tiehi
XFILLER_31_549 VPWR VGND sg13cmos5l_decap_8
XFILLER_8_745 VPWR VGND sg13cmos5l_fill_1
XFILLER_8_767 VPWR VGND sg13cmos5l_decap_4
XFILLER_7_266 VPWR VGND sg13cmos5l_decap_8
XFILLER_4_940 VPWR VGND sg13cmos5l_decap_8
X_7320__405 _7320_/RESET_B VPWR VGND sg13cmos5l_tiehi
XFILLER_15_4 VPWR VGND sg13cmos5l_fill_2
X_5900_ _5900_/X _5907_/B _5907_/C _5907_/A VPWR VGND sg13cmos5l_a21o_1
X_7433__260 _7433_/RESET_B VPWR VGND sg13cmos5l_tiehi
X_6880_ _6880_/Y _6866_/Y _6872_/Y _6879_/Y VPWR VGND sg13cmos5l_a21oi_1
X_5831_ _5835_/A _5831_/A _5831_/B VPWR VGND sg13cmos5l_nor2_1
XFILLER_22_516 VPWR VGND sg13cmos5l_fill_1
XFILLER_35_899 VPWR VGND sg13cmos5l_fill_2
X_5762_ _7257_/D _5749_/Y hold997/X _5847_/A VPWR VGND sg13cmos5l_a21oi_1
X_7501_ _7501_/Q _7560_/CLK _7501_/D _7501_/RESET_B VPWR VGND sg13cmos5l_dfrbpq_1
X_4713_ _4713_/Y _7572_/Q _4713_/B VPWR VGND sg13cmos5l_xnor2_1
X_5693_ _5693_/X _5698_/B _5698_/C _5698_/A VPWR VGND sg13cmos5l_a21o_1
X_7432_ _7432_/Q _7490_/CLK _7432_/D _7432_/RESET_B VPWR VGND sg13cmos5l_dfrbpq_1
X_4644_ _4654_/B _7601_/Q _7599_/Q _7600_/Q VPWR VGND sg13cmos5l_or3_1
X_4575_ _7592_/D _4575_/A _4575_/B VPWR VGND sg13cmos5l_and2_1
X_7363_ _7363_/Q _7651_/CLK _7363_/D _7363_/RESET_B VPWR VGND sg13cmos5l_dfrbpq_1
X_7294_ _7294_/Q clkload9/A _7294_/D _7294_/RESET_B VPWR VGND sg13cmos5l_dfrbpq_1
X_6314_ _6314_/Y _6314_/A VPWR VGND sg13cmos5l_inv_1
X_7440__253 _7440_/RESET_B VPWR VGND sg13cmos5l_tiehi
X_6245_ _6247_/B _7284_/Q _7285_/Q VPWR VGND sg13cmos5l_nand2_1
Xhold778 _7113_/B _7481_/Q VPWR VGND sg13cmos5l_dlygate4sd3_1
Xhold767 _4586_/B _7550_/Q VPWR VGND sg13cmos5l_dlygate4sd3_1
Xhold789 _4171_/B _7483_/Q VPWR VGND sg13cmos5l_dlygate4sd3_1
X_6176_ _6177_/C _6181_/B _6157_/Y VPWR VGND sg13cmos5l_nor2b_1
X_5127_ _5147_/C _5146_/A _5146_/B VPWR VGND sg13cmos5l_nand2_1
X_5058_ _5058_/Y _7616_/Q _5058_/B _5065_/C VPWR VGND sg13cmos5l_nor3_1
X_4009_ _4535_/A _4745_/A VPWR VGND sg13cmos5l_inv_1
XFILLER_38_1027 VPWR VGND sg13cmos5l_fill_2
XFILLER_40_346 VPWR VGND sg13cmos5l_decap_4
XFILLER_21_560 VPWR VGND sg13cmos5l_decap_4
XFILLER_45_1009 VPWR VGND sg13cmos5l_decap_8
XFILLER_1_954 VPWR VGND sg13cmos5l_decap_8
XFILLER_49_925 VPWR VGND sg13cmos5l_decap_8
XFILLER_29_50 VPWR VGND sg13cmos5l_fill_1
X_7417__277 _7417_/RESET_B VPWR VGND sg13cmos5l_tiehi
XFILLER_35_129 VPWR VGND sg13cmos5l_fill_1
XFILLER_28_192 VPWR VGND sg13cmos5l_fill_1
XFILLER_44_652 VPWR VGND sg13cmos5l_fill_1
X_7387__310 _7387_/RESET_B VPWR VGND sg13cmos5l_tiehi
X_4360_ _4362_/B _4360_/A _4360_/B VPWR VGND sg13cmos5l_nor2_1
X_4291_ _7533_/D _4291_/A _4291_/B VPWR VGND sg13cmos5l_nor2_1
X_6030_ _6058_/A _6048_/B _6030_/B VPWR VGND sg13cmos5l_nor2_1
X_6932_ _6934_/C _6927_/A _6952_/A _6930_/Y _6931_/Y VPWR VGND sg13cmos5l_a22oi_1
X_6863_ _6864_/B _6863_/A _6863_/B VPWR VGND sg13cmos5l_nor2_1
X_5814_ _5820_/A _5833_/B _5814_/B VPWR VGND sg13cmos5l_nor2_1
X_7331__386 _7331_/RESET_B VPWR VGND sg13cmos5l_tiehi
X_7448__749 _7448_/RESET_B VPWR VGND sg13cmos5l_tiehi
X_6794_ _6794_/Y _7007_/A _7006_/A _6789_/A _6649_/B VPWR VGND sg13cmos5l_a22oi_1
X_5745_ _5745_/Y _7254_/Q _5733_/Y _5736_/Y _7253_/Q VPWR VGND sg13cmos5l_a22oi_1
X_7429__159 _7429_/D VPWR VGND sg13cmos5l_tielo
X_5676_ _5676_/X _5684_/A _5907_/A VPWR VGND sg13cmos5l_and2_1
X_4627_ _4631_/A _4615_/Y _4621_/Y _4626_/Y VPWR VGND sg13cmos5l_o21ai_1
X_7415_ _7415_/Q _7651_/CLK _7415_/D _7415_/RESET_B VPWR VGND sg13cmos5l_dfrbpq_1
X_7346_ _7346_/Q _7375_/CLK _7346_/D _7346_/RESET_B VPWR VGND sg13cmos5l_dfrbpq_1
X_7303__422 _7303_/RESET_B VPWR VGND sg13cmos5l_tiehi
X_4558_ _4558_/Y _4739_/A _4558_/B VPWR VGND sg13cmos5l_nand2_1
X_4489_ _4493_/B _7536_/Q _4490_/B VPWR VGND sg13cmos5l_nor2b_1
X_7277_ _7277_/Q _7277_/CLK _7277_/D _7277_/RESET_B VPWR VGND sg13cmos5l_dfrbpq_1
X_7162__581 _7162_/RESET_B VPWR VGND sg13cmos5l_tiehi
X_6228_ _6302_/B _6229_/B _6228_/B VPWR VGND sg13cmos5l_nand2_1
X_6159_ _6159_/Y _6159_/A _6159_/B VPWR VGND sg13cmos5l_nor2_1
Xhold1231 _6471_/A2 _6463_/Y VPWR VGND sg13cmos5l_dlygate4sd3_1
Xhold1242 hold1242/X _7490_/Q VPWR VGND sg13cmos5l_dlygate4sd3_1
Xhold1220 _6220_/A _7334_/Q VPWR VGND sg13cmos5l_dlygate4sd3_1
Xhold1264 _4257_/A _7557_/Q VPWR VGND sg13cmos5l_dlygate4sd3_1
XFILLER_17_118 VPWR VGND sg13cmos5l_fill_1
Xhold1275 _6215_/A _7336_/Q VPWR VGND sg13cmos5l_dlygate4sd3_1
Xhold1253 _4810_/A _7626_/Q VPWR VGND sg13cmos5l_dlygate4sd3_1
Xhold1286 _4618_/B _4617_/Y VPWR VGND sg13cmos5l_dlygate4sd3_1
XFILLER_38_490 VPWR VGND sg13cmos5l_fill_1
XFILLER_17_129 VPWR VGND sg13cmos5l_decap_8
Xhold1297 _7022_/A _7486_/Q VPWR VGND sg13cmos5l_dlygate4sd3_1
XFILLER_26_652 VPWR VGND sg13cmos5l_fill_2
XFILLER_41_622 VPWR VGND sg13cmos5l_fill_2
XFILLER_40_110 VPWR VGND sg13cmos5l_fill_1
X_7310__415 _7310_/RESET_B VPWR VGND sg13cmos5l_tiehi
XFILLER_41_688 VPWR VGND sg13cmos5l_fill_1
XFILLER_5_556 VPWR VGND sg13cmos5l_fill_1
X_7423__270 _7423_/RESET_B VPWR VGND sg13cmos5l_tiehi
XFILLER_49_700 VPWR VGND sg13cmos5l_fill_1
Xclkbuf_leaf_28_clk _7239_/CLK clkbuf_3_4__f_clk/X VPWR VGND sg13cmos5l_buf_8
XFILLER_45_983 VPWR VGND sg13cmos5l_decap_8
X_7430__263 _7430_/RESET_B VPWR VGND sg13cmos5l_tiehi
XFILLER_32_611 VPWR VGND sg13cmos5l_fill_2
XFILLER_32_633 VPWR VGND sg13cmos5l_fill_2
X_3860_ _3860_/Y _3860_/A VPWR VGND sg13cmos5l_inv_1
X_5530_ _5530_/Y _5530_/A VPWR VGND sg13cmos5l_inv_1
XFILLER_9_840 VPWR VGND sg13cmos5l_fill_2
X_5461_ _5461_/Y _5461_/A _5461_/B VPWR VGND sg13cmos5l_nor2_1
X_4412_ _4412_/Y _4405_/A _4409_/Y _4357_/B VPWR VGND sg13cmos5l_o21ai_1
X_7200_ _7200_/Q _7200_/CLK _7200_/D _7200_/RESET_B VPWR VGND sg13cmos5l_dfrbpq_1
X_5392_ _5392_/Y _5341_/A _5347_/Y _5391_/X VPWR VGND sg13cmos5l_a21oi_1
X_7131_ _7131_/Q _7610_/CLK _7131_/D _7131_/RESET_B VPWR VGND sg13cmos5l_dfrbpq_1
X_4343_ _4343_/Y _4344_/A _4344_/B VPWR VGND sg13cmos5l_nor2_1
XFILLER_28_1026 VPWR VGND sg13cmos5l_fill_2
X_4274_ _4274_/Y _7499_/Q _7521_/Q VPWR VGND sg13cmos5l_nor2b_1
X_7062_ _7490_/D _7062_/A _7062_/B VPWR VGND sg13cmos5l_nor2_1
X_6013_ _6023_/A _7305_/Q _6034_/B VPWR VGND sg13cmos5l_xnor2_1
Xclkbuf_leaf_19_clk _7630_/CLK clkload5/A VPWR VGND sg13cmos5l_buf_8
X_6915_ _7463_/D _7007_/B _7008_/A VPWR VGND sg13cmos5l_nor2_1
X_6846_ _6846_/Y _7447_/Q _7419_/Q VPWR VGND sg13cmos5l_xnor2_1
XFILLER_35_1008 VPWR VGND sg13cmos5l_fill_1
X_6777_ _6777_/Y _6777_/A _6777_/B VPWR VGND sg13cmos5l_nor2_1
XFILLER_11_839 VPWR VGND sg13cmos5l_fill_2
XFILLER_23_688 VPWR VGND sg13cmos5l_fill_2
X_5728_ _5728_/Y _7277_/Q _5728_/B VPWR VGND sg13cmos5l_nand2_1
X_3989_ _5734_/B _3989_/A VPWR VGND sg13cmos5l_inv_1
X_5659_ _5660_/C _5681_/A _5912_/A VPWR VGND sg13cmos5l_nor2_1
X_7329_ _8274_/A clkload7/A _7329_/D _7329_/RESET_B VPWR VGND sg13cmos5l_dfrbpq_1
XFILLER_19_906 VPWR VGND sg13cmos5l_fill_1
Xhold1050 _6645_/A1 _7410_/Q VPWR VGND sg13cmos5l_dlygate4sd3_1
XFILLER_45_224 VPWR VGND sg13cmos5l_fill_1
Xhold1072 _3932_/A _7277_/Q VPWR VGND sg13cmos5l_dlygate4sd3_1
Xhold1061 _4764_/B _4763_/X VPWR VGND sg13cmos5l_dlygate4sd3_1
Xhold1083 _6989_/A _7476_/Q VPWR VGND sg13cmos5l_dlygate4sd3_1
XFILLER_34_909 VPWR VGND sg13cmos5l_decap_4
Xhold1094 _7474_/D _6991_/Y VPWR VGND sg13cmos5l_dlygate4sd3_1
XFILLER_27_950 VPWR VGND sg13cmos5l_fill_2
XFILLER_41_485 VPWR VGND sg13cmos5l_fill_1
XFILLER_41_463 VPWR VGND sg13cmos5l_fill_2
XFILLER_41_452 VPWR VGND sg13cmos5l_decap_8
XFILLER_10_894 VPWR VGND sg13cmos5l_fill_2
XFILLER_6_865 VPWR VGND sg13cmos5l_fill_1
XFILLER_47_7 VPWR VGND sg13cmos5l_fill_2
XFILLER_49_530 VPWR VGND sg13cmos5l_fill_1
XFILLER_3_99 VPWR VGND sg13cmos5l_fill_2
XFILLER_37_736 VPWR VGND sg13cmos5l_decap_4
XFILLER_3_1028 VPWR VGND sg13cmos5l_fill_1
XFILLER_45_780 VPWR VGND sg13cmos5l_fill_1
X_4961_ _4967_/B _7165_/Q _7164_/Q _7163_/Q _5330_/A VPWR VGND sg13cmos5l_nor4_1
XFILLER_44_290 VPWR VGND sg13cmos5l_fill_1
X_6700_ _6700_/Y _6687_/Y _6694_/Y _6695_/Y _6698_/Y _6693_/Y VPWR VGND sg13cmos5l_a221oi_1
X_4892_ _4895_/A _4892_/A _4892_/B VPWR VGND sg13cmos5l_nor2_1
XFILLER_33_964 VPWR VGND sg13cmos5l_fill_1
X_3912_ _7083_/A _7090_/A VPWR VGND sg13cmos5l_inv_1
X_7152__591 _7152_/RESET_B VPWR VGND sg13cmos5l_tiehi
XFILLER_20_625 VPWR VGND sg13cmos5l_decap_8
X_6631_ _6631_/Y _6632_/B VPWR VGND sg13cmos5l_inv_1
X_6562_ _6563_/C _7426_/Q _7400_/Q VPWR VGND sg13cmos5l_nand2_1
XFILLER_20_669 VPWR VGND sg13cmos5l_fill_2
X_5513_ _5513_/Y _5778_/A _7184_/Q _5512_/Y VPWR VGND sg13cmos5l_o21ai_1
X_6493_ _7380_/D _6495_/A _6493_/B VPWR VGND sg13cmos5l_nor2_1
Xclkbuf_leaf_8_clk _7424_/CLK clkload1/A VPWR VGND sg13cmos5l_buf_8
X_5444_ _5444_/Y _5441_/A _5441_/B _5443_/Y VPWR VGND sg13cmos5l_o21ai_1
X_7224__515 _7224_/RESET_B VPWR VGND sg13cmos5l_tiehi
Xfanout104 _7090_/A _4283_/B VPWR VGND sg13cmos5l_buf_1
X_5375_ _5375_/X _5376_/B _5376_/C VPWR VGND sg13cmos5l_and2_1
X_7114_ _7114_/Q _7394_/CLK _7114_/D _7114_/RESET_B VPWR VGND sg13cmos5l_dfrbpq_1
Xfanout115 _4981_/A _7162_/Q VPWR VGND sg13cmos5l_buf_1
X_7300__425 _7300_/RESET_B VPWR VGND sg13cmos5l_tiehi
Xfanout126 _6660_/A _6829_/A VPWR VGND sg13cmos5l_buf_1
X_4326_ _4326_/Y _7540_/Q _4320_/Y _4325_/Y VPWR VGND sg13cmos5l_o21ai_1
Xfanout137 _7106_/A _4560_/A VPWR VGND sg13cmos5l_buf_1
X_4257_ _4257_/Y _4257_/A _4498_/A VPWR VGND sg13cmos5l_nor2_1
XFILLER_41_1001 VPWR VGND sg13cmos5l_fill_1
X_7045_ _7046_/C _7060_/A _7045_/B VPWR VGND sg13cmos5l_nand2b_1
X_4188_ _4188_/X _4151_/Y _7072_/B _4196_/B VPWR VGND sg13cmos5l_mux2_1
XFILLER_27_235 VPWR VGND sg13cmos5l_fill_1
X_6829_ _7451_/D _6829_/A _6844_/B VPWR VGND sg13cmos5l_and2_1
XFILLER_10_113 VPWR VGND sg13cmos5l_fill_2
X_7420__273 _7420_/RESET_B VPWR VGND sg13cmos5l_tiehi
X_7494__385 _7494_/RESET_B VPWR VGND sg13cmos5l_tiehi
XFILLER_15_920 VPWR VGND sg13cmos5l_decap_8
XFILLER_15_931 VPWR VGND sg13cmos5l_fill_1
XFILLER_42_750 VPWR VGND sg13cmos5l_fill_2
XFILLER_30_978 VPWR VGND sg13cmos5l_fill_2
XFILLER_6_640 VPWR VGND sg13cmos5l_fill_2
X_5160_ _5160_/X _5149_/Y _5150_/Y _5159_/Y VPWR VGND sg13cmos5l_a21o_1
X_4111_ _4111_/Y _4110_/B _4099_/Y _4110_/A VPWR VGND sg13cmos5l_a21oi_1
X_5091_ _5091_/Y _3890_/Y _5550_/A2 _5090_/Y VPWR VGND sg13cmos5l_a21oi_1
X_4042_ _7646_/D hold949/X _4041_/Y _6107_/A VPWR VGND sg13cmos5l_a21oi_1
Xheichips26_dna_sequencer_757 uio_oe[4] VPWR VGND sg13cmos5l_tiehi
XFILLER_37_544 VPWR VGND sg13cmos5l_fill_1
XFILLER_37_588 VPWR VGND sg13cmos5l_fill_2
X_5993_ _7307_/D _5993_/A _5993_/B VPWR VGND sg13cmos5l_nor2_1
XFILLER_24_205 VPWR VGND sg13cmos5l_fill_1
X_4944_ _5245_/A _7163_/Q _5330_/A VPWR VGND sg13cmos5l_xnor2_1
X_7115__637 _7115_/RESET_B VPWR VGND sg13cmos5l_tiehi
X_4875_ _4875_/Y _4875_/A _4875_/B VPWR VGND sg13cmos5l_nand2_1
X_6614_ _6691_/A _6596_/Y _6609_/A _6613_/Y _6610_/C VPWR VGND sg13cmos5l_a22oi_1
X_7594_ _7594_/Q _7597_/CLK _7594_/D _7594_/RESET_B VPWR VGND sg13cmos5l_dfrbpq_1
X_6545_ _6545_/Y _6545_/A _6545_/B VPWR VGND sg13cmos5l_nand2_1
X_6476_ _6476_/Y _7396_/Q _6483_/B _6474_/Y VPWR VGND sg13cmos5l_o21ai_1
X_5427_ _5427_/Y _5698_/A _5456_/A _5703_/A _5461_/A VPWR VGND sg13cmos5l_a22oi_1
X_5358_ _5384_/A _5382_/A _5382_/B VPWR VGND sg13cmos5l_nand2_1
XFILLER_0_849 VPWR VGND sg13cmos5l_decap_8
X_4309_ _4309_/Y _7508_/Q _4309_/B VPWR VGND sg13cmos5l_nand2b_1
X_5289_ _5289_/Y _5285_/Y _5286_/Y _5297_/C _5288_/Y VPWR VGND sg13cmos5l_a22oi_1
X_7028_ _7028_/Y _7487_/Q _7037_/B VPWR VGND sg13cmos5l_nand2_1
XFILLER_11_488 VPWR VGND sg13cmos5l_decap_4
XFILLER_3_610 VPWR VGND sg13cmos5l_fill_2
XFILLER_3_0 VPWR VGND sg13cmos5l_fill_2
XFILLER_47_820 VPWR VGND sg13cmos5l_decap_4
XFILLER_47_853 VPWR VGND sg13cmos5l_fill_2
XFILLER_47_886 VPWR VGND sg13cmos5l_fill_1
XFILLER_15_750 VPWR VGND sg13cmos5l_fill_2
XFILLER_42_591 VPWR VGND sg13cmos5l_fill_1
X_4660_ _4694_/A _7634_/Q _4661_/B VPWR VGND sg13cmos5l_xnor2_1
XFILLER_30_786 VPWR VGND sg13cmos5l_decap_8
X_4591_ _4624_/A _7591_/Q _4611_/B VPWR VGND sg13cmos5l_xnor2_1
XFILLER_7_960 VPWR VGND sg13cmos5l_decap_8
X_6330_ _6331_/C _6323_/A _6323_/C _6310_/A VPWR VGND sg13cmos5l_a21oi_1
Xhold927 _4116_/A _7521_/Q VPWR VGND sg13cmos5l_dlygate4sd3_1
Xhold916 _4892_/A _7641_/Q VPWR VGND sg13cmos5l_dlygate4sd3_1
Xhold905 _4171_/A _7512_/Q VPWR VGND sg13cmos5l_dlygate4sd3_1
X_6261_ _6261_/Y _6263_/A _6261_/B VPWR VGND sg13cmos5l_nand2_1
Xhold949 hold949/X _4883_/B VPWR VGND sg13cmos5l_dlygate4sd3_1
Xhold938 _3957_/A _7597_/Q VPWR VGND sg13cmos5l_dlygate4sd3_1
X_5212_ _5212_/Y _7167_/Q _5232_/B VPWR VGND sg13cmos5l_nor2_1
XFILLER_9_1012 VPWR VGND sg13cmos5l_decap_8
X_6192_ _6192_/X _6192_/A _6192_/B VPWR VGND sg13cmos5l_and2_1
X_5143_ _5144_/A _5153_/A _5143_/B VPWR VGND sg13cmos5l_nand2b_1
X_5074_ _5074_/Y _7145_/Q _5067_/Y _5073_/Y _7146_/Q VPWR VGND sg13cmos5l_a22oi_1
X_4025_ _7648_/D _4059_/A _6108_/B VPWR VGND sg13cmos5l_and2_1
XFILLER_25_503 VPWR VGND sg13cmos5l_fill_1
X_5976_ _7293_/D _5976_/A _5976_/B VPWR VGND sg13cmos5l_nor2_1
XFILLER_12_219 VPWR VGND sg13cmos5l_decap_4
X_4927_ _7121_/D _3981_/Y _6500_/A2 _4926_/Y VPWR VGND sg13cmos5l_a21oi_1
X_4858_ _7632_/D _4858_/A _4858_/B VPWR VGND sg13cmos5l_nor2_1
X_7646_ _7646_/Q _7651_/CLK _7646_/D _7646_/RESET_B VPWR VGND sg13cmos5l_dfrbpq_1
XFILLER_20_285 VPWR VGND sg13cmos5l_fill_1
X_4789_ _4789_/Y _4843_/B _4843_/A VPWR VGND sg13cmos5l_nand2b_1
X_7577_ _7577_/Q _7634_/CLK _7577_/D _7577_/RESET_B VPWR VGND sg13cmos5l_dfrbpq_1
X_6528_ _6545_/B _7394_/Q _6541_/B VPWR VGND sg13cmos5l_nor2_1
X_6459_ _6468_/A _7351_/Q _6459_/B VPWR VGND sg13cmos5l_xnor2_1
XFILLER_48_628 VPWR VGND sg13cmos5l_fill_2
XFILLER_29_853 VPWR VGND sg13cmos5l_fill_1
XFILLER_44_812 VPWR VGND sg13cmos5l_fill_2
XFILLER_29_886 VPWR VGND sg13cmos5l_fill_1
XFILLER_28_385 VPWR VGND sg13cmos5l_decap_8
XFILLER_16_569 VPWR VGND sg13cmos5l_fill_2
XFILLER_12_742 VPWR VGND sg13cmos5l_decap_8
XFILLER_12_753 VPWR VGND sg13cmos5l_fill_2
XFILLER_15_1028 VPWR VGND sg13cmos5l_fill_1
XFILLER_34_95 VPWR VGND sg13cmos5l_fill_1
XFILLER_4_996 VPWR VGND sg13cmos5l_decap_8
XFILLER_3_440 VPWR VGND sg13cmos5l_decap_4
XFILLER_47_661 VPWR VGND sg13cmos5l_fill_1
XFILLER_19_385 VPWR VGND sg13cmos5l_fill_1
X_5830_ _5830_/Y _5821_/Y _5822_/Y _5829_/Y VPWR VGND sg13cmos5l_o21ai_1
XFILLER_35_878 VPWR VGND sg13cmos5l_fill_2
XFILLER_35_889 VPWR VGND sg13cmos5l_fill_1
X_5761_ _5761_/Y _5955_/A _5761_/B VPWR VGND sg13cmos5l_nand2_1
X_7500_ _7500_/Q _7560_/CLK _7500_/D _7500_/RESET_B VPWR VGND sg13cmos5l_dfrbpq_1
X_4712_ _4717_/B _7572_/Q _4713_/B VPWR VGND sg13cmos5l_nor2b_1
X_7431_ _7431_/Q _7490_/CLK _7431_/D _7431_/RESET_B VPWR VGND sg13cmos5l_dfrbpq_1
X_5692_ _5692_/Y _5698_/B _5698_/C VPWR VGND sg13cmos5l_nand2_1
X_4643_ _5007_/A _7632_/Q _5098_/A VPWR VGND sg13cmos5l_xnor2_1
X_4574_ _7591_/D _4574_/A _4575_/B VPWR VGND sg13cmos5l_and2_1
X_7362_ _7362_/Q _7651_/CLK _7362_/D _7362_/RESET_B VPWR VGND sg13cmos5l_dfrbpq_1
X_7293_ _7293_/Q clkload9/A _7293_/D _7293_/RESET_B VPWR VGND sg13cmos5l_dfrbpq_1
X_6313_ _6314_/A _6293_/A _6229_/B _6329_/B _6310_/Y VPWR VGND sg13cmos5l_a22oi_1
X_6244_ _6244_/Y _7309_/Q _6247_/A _6191_/A VPWR VGND sg13cmos5l_o21ai_1
Xhold768 _6658_/B _7388_/Q VPWR VGND sg13cmos5l_dlygate4sd3_1
Xhold779 _6660_/B _7390_/Q VPWR VGND sg13cmos5l_dlygate4sd3_1
X_6175_ _6177_/B _6175_/A _6181_/B VPWR VGND sg13cmos5l_nor2b_1
X_7637__652 _7637_/RESET_B VPWR VGND sg13cmos5l_tiehi
X_5126_ _5138_/A _7157_/Q _5146_/B VPWR VGND sg13cmos5l_xnor2_1
XFILLER_29_127 VPWR VGND sg13cmos5l_fill_1
X_5057_ _5057_/Y _4771_/A _5054_/X _5065_/C _5056_/Y VPWR VGND sg13cmos5l_a22oi_1
X_4008_ _4008_/Y _4008_/A VPWR VGND sg13cmos5l_inv_1
XFILLER_26_812 VPWR VGND sg13cmos5l_fill_2
XFILLER_37_182 VPWR VGND sg13cmos5l_fill_1
XFILLER_25_355 VPWR VGND sg13cmos5l_fill_2
X_7486__402 _7486_/RESET_B VPWR VGND sg13cmos5l_tiehi
XFILLER_41_848 VPWR VGND sg13cmos5l_decap_4
X_5959_ _5959_/Y _7291_/Q _5950_/B _5958_/Y _7292_/Q VPWR VGND sg13cmos5l_a22oi_1
X_7629_ _7629_/Q _7630_/CLK _7629_/D _7629_/RESET_B VPWR VGND sg13cmos5l_dfrbpq_1
XFILLER_5_727 VPWR VGND sg13cmos5l_fill_1
XFILLER_4_237 VPWR VGND sg13cmos5l_fill_2
XFILLER_1_933 VPWR VGND sg13cmos5l_decap_8
XFILLER_0_465 VPWR VGND sg13cmos5l_fill_1
XFILLER_48_447 VPWR VGND sg13cmos5l_decap_8
XFILLER_29_650 VPWR VGND sg13cmos5l_fill_2
XFILLER_35_108 VPWR VGND sg13cmos5l_fill_2
XFILLER_35_119 VPWR VGND sg13cmos5l_fill_2
XFILLER_40_881 VPWR VGND sg13cmos5l_fill_2
XFILLER_8_554 VPWR VGND sg13cmos5l_decap_8
XFILLER_8_543 VPWR VGND sg13cmos5l_fill_1
X_4290_ _4360_/B _4290_/A VPWR VGND sg13cmos5l_inv_1
XFILLER_6_1026 VPWR VGND sg13cmos5l_fill_2
X_6931_ _6931_/Y _7458_/Q _6930_/B _6948_/B VPWR VGND sg13cmos5l_o21ai_1
XFILLER_35_642 VPWR VGND sg13cmos5l_fill_2
X_6862_ _6862_/X _6836_/A _6839_/B _6870_/B VPWR VGND sg13cmos5l_mux2_1
X_5813_ _5813_/Y _5813_/A _5813_/B VPWR VGND sg13cmos5l_xnor2_1
XFILLER_34_174 VPWR VGND sg13cmos5l_decap_8
X_6793_ _6793_/Y _6793_/A VPWR VGND sg13cmos5l_inv_1
X_5744_ _5744_/X _7255_/Q _5744_/B VPWR VGND sg13cmos5l_or2_1
X_5675_ _7242_/D _5845_/A _5675_/B VPWR VGND sg13cmos5l_nor2_1
X_4626_ _4626_/Y _4628_/A _4628_/B _4622_/Y VPWR VGND sg13cmos5l_a21oi_1
X_7414_ _7414_/Q clkload8/A _7414_/D _7414_/RESET_B VPWR VGND sg13cmos5l_dfrbpq_1
X_7345_ _7345_/Q clkload9/A _7345_/D _7345_/RESET_B VPWR VGND sg13cmos5l_dfrbpq_1
X_4557_ _4557_/Y _4753_/B _4554_/S _4556_/Y VPWR VGND sg13cmos5l_a21oi_1
X_4488_ _4488_/Y _4235_/Y _4479_/Y _4507_/A _4261_/B VPWR VGND sg13cmos5l_a22oi_1
X_7276_ _7276_/Q _7314_/CLK _7276_/D _7276_/RESET_B VPWR VGND sg13cmos5l_dfrbpq_1
X_6227_ _6228_/B _6227_/A VPWR VGND sg13cmos5l_inv_1
X_6158_ _6158_/Y _7324_/Q _6144_/Y _6157_/Y _7325_/Q VPWR VGND sg13cmos5l_a22oi_1
Xhold1243 _6769_/A _7404_/Q VPWR VGND sg13cmos5l_dlygate4sd3_1
X_5109_ _5111_/A _5109_/A _5109_/B VPWR VGND sg13cmos5l_nor2_1
Xhold1232 hold1232/X _7162_/Q VPWR VGND sg13cmos5l_dlygate4sd3_1
Xhold1210 _5809_/B _5808_/Y VPWR VGND sg13cmos5l_dlygate4sd3_1
Xhold1221 _6231_/B1 _6221_/A VPWR VGND sg13cmos5l_dlygate4sd3_1
Xhold1265 _4155_/A _7467_/Q VPWR VGND sg13cmos5l_dlygate4sd3_1
X_6089_ _6099_/B _7318_/Q _7320_/Q _7319_/Q _6089_/D VPWR VGND sg13cmos5l_nor4_1
Xhold1276 _5024_/A _7605_/Q VPWR VGND sg13cmos5l_dlygate4sd3_1
Xhold1254 _4856_/A _4840_/A VPWR VGND sg13cmos5l_dlygate4sd3_1
Xhold1287 _6689_/A _7422_/Q VPWR VGND sg13cmos5l_dlygate4sd3_1
Xhold1298 _7063_/A _7041_/Y VPWR VGND sg13cmos5l_dlygate4sd3_1
XFILLER_13_303 VPWR VGND sg13cmos5l_fill_2
XFILLER_14_837 VPWR VGND sg13cmos5l_fill_2
XFILLER_41_667 VPWR VGND sg13cmos5l_fill_2
XFILLER_22_881 VPWR VGND sg13cmos5l_decap_4
XFILLER_5_513 VPWR VGND sg13cmos5l_decap_8
XFILLER_5_524 VPWR VGND sg13cmos5l_fill_1
XFILLER_31_85 VPWR VGND sg13cmos5l_fill_2
XFILLER_1_763 VPWR VGND sg13cmos5l_fill_2
XFILLER_49_734 VPWR VGND sg13cmos5l_decap_4
XFILLER_0_273 VPWR VGND sg13cmos5l_decap_4
XFILLER_49_756 VPWR VGND sg13cmos5l_decap_8
X_7471__556 _7471_/RESET_B VPWR VGND sg13cmos5l_tiehi
XFILLER_45_962 VPWR VGND sg13cmos5l_decap_8
XFILLER_16_130 VPWR VGND sg13cmos5l_decap_4
XFILLER_16_152 VPWR VGND sg13cmos5l_decap_8
XFILLER_32_623 VPWR VGND sg13cmos5l_fill_2
XFILLER_16_196 VPWR VGND sg13cmos5l_decap_4
XFILLER_13_892 VPWR VGND sg13cmos5l_decap_8
X_5460_ _5460_/Y _5460_/A VPWR VGND sg13cmos5l_inv_1
X_4411_ _7556_/D _4404_/A _4409_/Y _4410_/Y VPWR VGND sg13cmos5l_a21oi_1
X_5391_ _5391_/X _5391_/A _5391_/B _5391_/C VPWR VGND sg13cmos5l_and3_1
X_7130_ _7130_/Q _7610_/CLK _7130_/D _7130_/RESET_B VPWR VGND sg13cmos5l_dfrbpq_1
X_4342_ _7544_/D _7106_/A _4342_/B VPWR VGND sg13cmos5l_and2_1
X_4273_ _4273_/Y _7522_/Q _7500_/Q VPWR VGND sg13cmos5l_nand2b_1
X_7061_ _7062_/B _7045_/B _7056_/Y _7006_/B VPWR VGND sg13cmos5l_o21ai_1
X_6012_ _6047_/B _6039_/A _6039_/B VPWR VGND sg13cmos5l_nand2_1
.ends
