* NGSPICE file created from heichips26_dna_sequencer.ext - technology: ihp-sg13cmos5l

* Black-box entry subcircuit for sg13cmos5l_and3_1 abstract view
.subckt sg13cmos5l_and3_1 X A B C VDD VSS
.ends

* Black-box entry subcircuit for sg13cmos5l_nand2_1 abstract view
.subckt sg13cmos5l_nand2_1 Y A B VDD VSS
.ends

* Black-box entry subcircuit for sg13cmos5l_nand3b_1 abstract view
.subckt sg13cmos5l_nand3b_1 Y A_N B C VDD VSS
.ends

* Black-box entry subcircuit for sg13cmos5l_nor2_1 abstract view
.subckt sg13cmos5l_nor2_1 Y A B VDD VSS
.ends

* Black-box entry subcircuit for sg13cmos5l_a22oi_1 abstract view
.subckt sg13cmos5l_a22oi_1 Y A1 A2 B1 B2 VDD VSS
.ends

* Black-box entry subcircuit for sg13cmos5l_o21ai_1 abstract view
.subckt sg13cmos5l_o21ai_1 Y A1 A2 B1 VDD VSS
.ends

* Black-box entry subcircuit for sg13cmos5l_a21o_1 abstract view
.subckt sg13cmos5l_a21o_1 X A1 A2 B1 VDD VSS
.ends

* Black-box entry subcircuit for sg13cmos5l_mux2_1 abstract view
.subckt sg13cmos5l_mux2_1 X A0 A1 S VDD VSS
.ends

* Black-box entry subcircuit for sg13cmos5l_fill_1 abstract view
.subckt sg13cmos5l_fill_1 VDD VSS
.ends

* Black-box entry subcircuit for sg13cmos5l_and2_1 abstract view
.subckt sg13cmos5l_and2_1 X A B VDD VSS
.ends

* Black-box entry subcircuit for sg13cmos5l_a21oi_1 abstract view
.subckt sg13cmos5l_a21oi_1 Y A1 A2 B1 VDD VSS
.ends

* Black-box entry subcircuit for sg13cmos5l_fill_2 abstract view
.subckt sg13cmos5l_fill_2 VDD VSS
.ends

* Black-box entry subcircuit for sg13cmos5l_nor2b_1 abstract view
.subckt sg13cmos5l_nor2b_1 Y A B_N VDD VSS
.ends

* Black-box entry subcircuit for sg13cmos5l_xnor2_1 abstract view
.subckt sg13cmos5l_xnor2_1 Y A B VDD VSS
.ends

* Black-box entry subcircuit for sg13cmos5l_dfrbpq_1 abstract view
.subckt sg13cmos5l_dfrbpq_1 Q CLK D RESET_B VDD VSS
.ends

* Black-box entry subcircuit for sg13cmos5l_a221oi_1 abstract view
.subckt sg13cmos5l_a221oi_1 Y A1 A2 B1 B2 C1 VDD VSS
.ends

* Black-box entry subcircuit for sg13cmos5l_nand2b_1 abstract view
.subckt sg13cmos5l_nand2b_1 Y A_N B VDD VSS
.ends

* Black-box entry subcircuit for sg13cmos5l_dlygate4sd3_1 abstract view
.subckt sg13cmos5l_dlygate4sd3_1 X A VDD VSS
.ends

* Black-box entry subcircuit for sg13cmos5l_xor2_1 abstract view
.subckt sg13cmos5l_xor2_1 X A B VDD VSS
.ends

* Black-box entry subcircuit for sg13cmos5l_or2_1 abstract view
.subckt sg13cmos5l_or2_1 X A B VDD VSS
.ends

* Black-box entry subcircuit for sg13cmos5l_buf_1 abstract view
.subckt sg13cmos5l_buf_1 X A VDD VSS
.ends

* Black-box entry subcircuit for sg13cmos5l_inv_1 abstract view
.subckt sg13cmos5l_inv_1 Y A VDD VSS
.ends

* Black-box entry subcircuit for sg13cmos5l_tiehi abstract view
.subckt sg13cmos5l_tiehi L_HI VDD VSS
.ends

* Black-box entry subcircuit for sg13cmos5l_nor4_1 abstract view
.subckt sg13cmos5l_nor4_1 Y A B C D VDD VSS
.ends

* Black-box entry subcircuit for sg13cmos5l_nor3_1 abstract view
.subckt sg13cmos5l_nor3_1 Y A B C VDD VSS
.ends

* Black-box entry subcircuit for sg13cmos5l_nand3_1 abstract view
.subckt sg13cmos5l_nand3_1 Y A B C VDD VSS
.ends

* Black-box entry subcircuit for sg13cmos5l_or3_1 abstract view
.subckt sg13cmos5l_or3_1 X A B C VDD VSS
.ends

* Black-box entry subcircuit for sg13cmos5l_tielo abstract view
.subckt sg13cmos5l_tielo L_LO VDD VSS
.ends

* Black-box entry subcircuit for sg13cmos5l_decap_8 abstract view
.subckt sg13cmos5l_decap_8 VDD VSS
.ends

* Black-box entry subcircuit for sg13cmos5l_decap_4 abstract view
.subckt sg13cmos5l_decap_4 VDD VSS
.ends

* Black-box entry subcircuit for sg13cmos5l_buf_8 abstract view
.subckt sg13cmos5l_buf_8 X A VDD VSS
.ends

* Black-box entry subcircuit for sg13cmos5l_nand4_1 abstract view
.subckt sg13cmos5l_nand4_1 Y A B C D VDD VSS
.ends

* Black-box entry subcircuit for sg13cmos5l_or4_1 abstract view
.subckt sg13cmos5l_or4_1 X A B C D VDD VSS
.ends

* Black-box entry subcircuit for sg13cmos5l_inv_4 abstract view
.subckt sg13cmos5l_inv_4 Y A VDD VSS
.ends

* Black-box entry subcircuit for sg13cmos5l_inv_2 abstract view
.subckt sg13cmos5l_inv_2 Y A VDD VSS
.ends

* Black-box entry subcircuit for sg13cmos5l_inv_16 abstract view
.subckt sg13cmos5l_inv_16 Y A VDD VSS
.ends

* Black-box entry subcircuit for sg13cmos5l_and4_1 abstract view
.subckt sg13cmos5l_and4_1 X A B C D VDD VSS
.ends

.subckt heichips26_dna_sequencer VGND VPWR clk ena rst_n ui_in[0] ui_in[1] ui_in[2]
+ ui_in[3] ui_in[4] ui_in[5] ui_in[6] ui_in[7] uio_in[0] uio_in[1] uio_in[2] uio_in[3]
+ uio_in[4] uio_in[5] uio_in[6] uio_in[7] uio_oe[0] uio_oe[1] uio_oe[2] uio_oe[3]
+ uio_oe[4] uio_oe[5] uio_oe[6] uio_oe[7] uio_out[0] uio_out[1] uio_out[2] uio_out[3]
+ uio_out[4] uio_out[5] uio_out[6] uio_out[7] uo_out[0] uo_out[1] uo_out[2] uo_out[3]
+ uo_out[4] uo_out[5] uo_out[6] uo_out[7]
X_05903_ _05903_/X _05903_/A _05903_/B _05903_/C VPWR VGND sg13cmos5l_and3_1
X_06883_ _06883_/Y _06883_/A _06883_/B VPWR VGND sg13cmos5l_nand2_1
X_05834_ _05993_/B hold1371/X _05847_/A _05847_/C VPWR VGND sg13cmos5l_nand3b_1
X_08622_ _08623_/C _08622_/A _08622_/B VPWR VGND sg13cmos5l_nor2_1
X_08553_ _08553_/Y _08506_/A _09202_/Q _09201_/Q _04882_/Y VPWR VGND sg13cmos5l_a22oi_1
X_05765_ _05768_/B _05718_/A _05721_/Y _05718_/B VPWR VGND sg13cmos5l_o21ai_1
X_07504_ _07521_/B _07499_/Y _07502_/Y _07481_/Y VPWR VGND sg13cmos5l_a21o_1
X_08484_ _08530_/A _08494_/B _08494_/C VPWR VGND sg13cmos5l_nand2_1
X_07435_ _07436_/B _07264_/B _07315_/B _07447_/B VPWR VGND sg13cmos5l_mux2_1
XFILLER_23_634 VPWR VGND sg13cmos5l_fill_1
X_05696_ _09391_/D _05696_/A _05696_/B VPWR VGND sg13cmos5l_and2_1
X_07366_ _07366_/Y _04956_/Y fanout33/X _07365_/Y VPWR VGND sg13cmos5l_a21oi_1
XFILLER_22_188 VPWR VGND sg13cmos5l_fill_2
XFILLER_22_199 VPWR VGND sg13cmos5l_fill_2
X_06317_ _06320_/B _06365_/A _06680_/A VPWR VGND sg13cmos5l_nor2b_1
X_07297_ _07324_/B _09565_/Q _07320_/A VPWR VGND sg13cmos5l_xnor2_1
X_09105_ _09105_/Q clkload15/A _09105_/D _09105_/RESET_B VPWR VGND sg13cmos5l_dfrbpq_1
X_06248_ _06248_/Y _06085_/X _06099_/X _06155_/A _06155_/B _06100_/Y VPWR VGND sg13cmos5l_a221oi_1
X_09036_ _09036_/Q _09565_/CLK _09036_/D _09036_/RESET_B VPWR VGND sg13cmos5l_dfrbpq_1
X_06179_ _06179_/Y _06175_/X hold985/A VPWR VGND sg13cmos5l_nand2b_1
Xhold1040 _04906_/A _09067_/Q VPWR VGND sg13cmos5l_dlygate4sd3_1
Xhold1051 _08969_/B _09306_/Q VPWR VGND sg13cmos5l_dlygate4sd3_1
Xhold1073 hold1073/X _05385_/B VPWR VGND sg13cmos5l_dlygate4sd3_1
Xhold1062 _08353_/B _09164_/Q VPWR VGND sg13cmos5l_dlygate4sd3_1
Xhold1084 _08827_/B _08826_/Y VPWR VGND sg13cmos5l_dlygate4sd3_1
Xhold1095 _06988_/A _09549_/Q VPWR VGND sg13cmos5l_dlygate4sd3_1
XFILLER_27_940 VPWR VGND sg13cmos5l_fill_2
XFILLER_41_464 VPWR VGND sg13cmos5l_fill_2
XFILLER_41_497 VPWR VGND sg13cmos5l_fill_2
XFILLER_6_822 VPWR VGND sg13cmos5l_fill_1
XFILLER_49_531 VPWR VGND sg13cmos5l_fill_1
XFILLER_3_1007 VPWR VGND sg13cmos5l_fill_1
X_05550_ _05575_/B _09366_/Q _09365_/Q VPWR VGND sg13cmos5l_xor2_1
XFILLER_33_910 VPWR VGND sg13cmos5l_fill_2
XFILLER_33_921 VPWR VGND sg13cmos5l_fill_2
X_05481_ _05481_/Y _05477_/Y _05479_/Y _05480_/Y VPWR VGND sg13cmos5l_o21ai_1
X_07220_ _09027_/D _07220_/A _07220_/B VPWR VGND sg13cmos5l_nor2_1
X_07151_ _08893_/A _08784_/A _07151_/B VPWR VGND sg13cmos5l_nand2b_1
X_06102_ _09443_/D _06164_/A _06102_/B VPWR VGND sg13cmos5l_nor2_1
X_07082_ _07082_/Y _07082_/A _07082_/B VPWR VGND sg13cmos5l_nor2_1
X_06033_ _06034_/C _06033_/A _06045_/B VPWR VGND sg13cmos5l_or2_1
Xfanout138 _07386_/B _07221_/Y VPWR VGND sg13cmos5l_buf_1
Xfanout116 _08380_/A _08401_/B VPWR VGND sg13cmos5l_buf_1
Xfanout127 _07892_/B _07879_/B1 VPWR VGND sg13cmos5l_buf_1
Xfanout105 _05466_/B _05452_/Y VPWR VGND sg13cmos5l_buf_1
X_07984_ _07985_/B _07991_/C _09180_/Q _09181_/Q VPWR VGND sg13cmos5l_o21ai_1
Xfanout149 _06627_/A _06608_/Y VPWR VGND sg13cmos5l_buf_1
X_06935_ _06936_/B _06935_/A _06935_/B VPWR VGND sg13cmos5l_nor2_1
X_06866_ _07018_/B hold1410/X _06876_/B _06876_/C VPWR VGND sg13cmos5l_nand3b_1
XFILLER_27_214 VPWR VGND sg13cmos5l_fill_2
XFILLER_43_718 VPWR VGND sg13cmos5l_fill_1
X_05817_ _05826_/A _09408_/Q _05818_/B VPWR VGND sg13cmos5l_xnor2_1
X_08605_ _08682_/A _09238_/Q _09209_/Q VPWR VGND sg13cmos5l_nand2_1
X_09585_ _09585_/Q _09591_/CLK _09585_/D _09585_/RESET_B VPWR VGND sg13cmos5l_dfrbpq_1
X_06797_ _06798_/C _06797_/A _06797_/B _06797_/C VPWR VGND sg13cmos5l_and3_1
X_05748_ _05748_/Y _05748_/A VPWR VGND sg13cmos5l_inv_1
X_08536_ _08537_/B _08490_/Y _08535_/Y _08536_/S VPWR VGND sg13cmos5l_mux2_1
X_08467_ _09216_/D _08444_/B fanout21/X _08466_/Y VPWR VGND sg13cmos5l_a21oi_1
X_05679_ _05679_/Y _05658_/Y _05675_/B _05678_/Y VPWR VGND sg13cmos5l_a21oi_1
X_07418_ _07418_/Y _07274_/Y _07323_/B _07415_/Y _07416_/Y _07417_/Y VPWR VGND sg13cmos5l_a221oi_1
X_08398_ _09212_/D _08398_/A _08400_/B VPWR VGND sg13cmos5l_nor2_1
X_07349_ _07349_/Y _07349_/A VPWR VGND sg13cmos5l_inv_1
XFILLER_12_98 VPWR VGND sg13cmos5l_fill_1
X_09019_ hold932/A clkload3/A _09019_/D _09019_/RESET_B VPWR VGND sg13cmos5l_dfrbpq_1
XFILLER_18_247 VPWR VGND sg13cmos5l_fill_2
XFILLER_37_84 VPWR VGND sg13cmos5l_fill_1
XFILLER_37_95 VPWR VGND sg13cmos5l_fill_1
XFILLER_18_1004 VPWR VGND sg13cmos5l_fill_1
XFILLER_41_261 VPWR VGND sg13cmos5l_fill_2
X_09431__676 _09431_/RESET_B VPWR VGND sg13cmos5l_tiehi
XFILLER_5_184 VPWR VGND sg13cmos5l_fill_2
XFILLER_2_891 VPWR VGND sg13cmos5l_fill_1
X_04981_ _04981_/Y _09419_/Q VPWR VGND sg13cmos5l_inv_1
X_06720_ _06720_/Y _06698_/Y _06716_/B _06719_/Y VPWR VGND sg13cmos5l_a21oi_1
X_06651_ _06651_/Y _06651_/A _06651_/B VPWR VGND sg13cmos5l_nor2_1
X_05602_ _05602_/Y _05610_/B _05601_/B _05322_/A VPWR VGND sg13cmos5l_a21oi_1
X_09370_ _09370_/Q clkload11/A _09370_/D _09370_/RESET_B VPWR VGND sg13cmos5l_dfrbpq_1
X_06582_ _06582_/Y _06622_/A _06624_/A _06629_/A _06581_/Y VPWR VGND sg13cmos5l_a22oi_1
X_05533_ _05564_/B _09366_/Q _09365_/Q _09367_/Q _09368_/Q VPWR VGND sg13cmos5l_nor4_1
X_08321_ _08321_/Y _08007_/A _08318_/X _08320_/Y VPWR VGND sg13cmos5l_o21ai_1
X_08252_ _08254_/B _09216_/Q _09184_/Q VPWR VGND sg13cmos5l_nand2_1
XFILLER_32_283 VPWR VGND sg13cmos5l_fill_2
X_05464_ _05510_/B _05464_/A _05470_/B VPWR VGND sg13cmos5l_nor2b_1
X_07203_ _09021_/D _04937_/Y fanout54/X _07202_/Y VPWR VGND sg13cmos5l_a21oi_1
X_09289__484 _09289_/RESET_B VPWR VGND sg13cmos5l_tiehi
X_08183_ _08184_/B _08211_/A _08183_/B VPWR VGND sg13cmos5l_nor2_1
XFILLER_20_478 VPWR VGND sg13cmos5l_fill_2
X_05395_ _05401_/B _05387_/B _05408_/B _05394_/Y VPWR VGND sg13cmos5l_a21oi_1
X_07134_ _07134_/Y _07159_/B _07128_/Y _07133_/Y VPWR VGND sg13cmos5l_o21ai_1
X_07065_ _07065_/Y _07037_/Y _07069_/S _07071_/B1 VPWR VGND sg13cmos5l_o21ai_1
X_06016_ _06020_/A _06016_/A _06024_/B _06016_/C VPWR VGND sg13cmos5l_nor3_1
X_07967_ _07969_/A _07967_/A _07967_/B VPWR VGND sg13cmos5l_nor2_1
X_06918_ _07018_/D _06918_/A _06920_/A _06923_/C VPWR VGND sg13cmos5l_nand3_1
X_07898_ _07898_/Y hold950/A hold880/A VPWR VGND sg13cmos5l_xnor2_1
X_06849_ _06862_/B _09560_/Q _06850_/B VPWR VGND sg13cmos5l_nor2b_1
X_09568_ hold988/A clkload13/A hold989/X _09568_/RESET_B VPWR VGND sg13cmos5l_dfrbpq_1
X_08519_ _08657_/A _08539_/B _08539_/C _08518_/X VPWR VGND sg13cmos5l_o21ai_1
X_09499_ hold937/A _09575_/CLK _09499_/D _09499_/RESET_B VPWR VGND sg13cmos5l_dfrbpq_1
X_09158__315 _09158_/RESET_B VPWR VGND sg13cmos5l_tiehi
X_09019__466 _09019_/RESET_B VPWR VGND sg13cmos5l_tiehi
XFILLER_9_66 VPWR VGND sg13cmos5l_fill_2
XFILLER_31_1001 VPWR VGND sg13cmos5l_fill_1
X_05180_ _05183_/C hold1395/X _05199_/C _05199_/B VPWR VGND sg13cmos5l_nand3b_1
X_09165__308 _09165_/RESET_B VPWR VGND sg13cmos5l_tiehi
Xhold917 hold917/X hold917/A VPWR VGND sg13cmos5l_dlygate4sd3_1
Xhold906 hold906/X hold906/A VPWR VGND sg13cmos5l_dlygate4sd3_1
Xhold928 hold928/X hold928/A VPWR VGND sg13cmos5l_dlygate4sd3_1
Xhold939 hold939/X hold939/A VPWR VGND sg13cmos5l_dlygate4sd3_1
XFILLER_9_1013 VPWR VGND sg13cmos5l_fill_2
X_08870_ _08870_/Y _08870_/A _08870_/B _08870_/C VPWR VGND sg13cmos5l_nand3_1
X_07821_ _09116_/D _07875_/A _07821_/B VPWR VGND sg13cmos5l_nor2_1
X_07752_ _07752_/Y _07742_/Y _07747_/Y _07751_/Y VPWR VGND sg13cmos5l_o21ai_1
X_04964_ _04964_/Y _06935_/B VPWR VGND sg13cmos5l_inv_1
XFILLER_37_342 VPWR VGND sg13cmos5l_fill_1
XFILLER_38_854 VPWR VGND sg13cmos5l_fill_2
X_07683_ _07683_/Y _07698_/B _07682_/Y VPWR VGND sg13cmos5l_nor2b_1
X_06703_ _06707_/B _06703_/A VPWR VGND sg13cmos5l_inv_1
X_04895_ _08147_/A _04895_/A VPWR VGND sg13cmos5l_inv_1
X_09422_ hold886/A _09503_/CLK _09422_/D _09422_/RESET_B VPWR VGND sg13cmos5l_dfrbpq_1
X_06634_ _06670_/A _09488_/Q _09486_/Q _09487_/Q VPWR VGND sg13cmos5l_or3_1
X_09353_ _09353_/Q _09387_/CLK _09353_/D _09353_/RESET_B VPWR VGND sg13cmos5l_dfrbpq_1
X_08304_ _08334_/B _09153_/Q _09154_/Q hold1396/X VPWR VGND sg13cmos5l_o21ai_1
X_06565_ _06566_/B _09549_/Q _09517_/Q VPWR VGND sg13cmos5l_nand2_1
X_09284_ _09284_/Q clkload8/A _09284_/D _09284_/RESET_B VPWR VGND sg13cmos5l_dfrbpq_1
X_05516_ _05516_/X _05516_/A _05516_/B _05516_/C VPWR VGND sg13cmos5l_or3_1
X_06496_ _06496_/Y _06526_/B _06518_/A _06496_/C VPWR VGND sg13cmos5l_nand3_1
X_08235_ _08235_/Y _08592_/B _08838_/A VPWR VGND sg13cmos5l_nand2b_1
X_05447_ _09357_/D _05447_/A _05448_/B VPWR VGND sg13cmos5l_nor2_1
X_05378_ _09336_/D _05378_/A _05378_/B VPWR VGND sg13cmos5l_nor2_1
X_08166_ _08207_/B _08166_/A _08166_/B VPWR VGND sg13cmos5l_nor2_1
X_07117_ _07118_/B _09011_/Q _07142_/B VPWR VGND sg13cmos5l_nor2b_1
X_08097_ _08119_/A _09178_/Q _09121_/Q _08111_/B VPWR VGND sg13cmos5l_mux2_1
X_07048_ _07048_/Y _07037_/Y _07039_/X _07049_/A _07049_/B VPWR VGND sg13cmos5l_a22oi_1
X_08999_ _09318_/D _08999_/A _09001_/B VPWR VGND sg13cmos5l_nor2_1
X_09257__225 _09257_/D VPWR VGND sg13cmos5l_tielo
X_09114__229 _09114_/D VPWR VGND sg13cmos5l_tielo
XFILLER_12_787 VPWR VGND sg13cmos5l_fill_1
XFILLER_7_235 VPWR VGND sg13cmos5l_fill_2
XFILLER_4_953 VPWR VGND sg13cmos5l_fill_1
XFILLER_3_452 VPWR VGND sg13cmos5l_fill_2
XFILLER_46_194 VPWR VGND sg13cmos5l_fill_1
XFILLER_15_581 VPWR VGND sg13cmos5l_fill_1
X_06350_ _06350_/Y _09512_/Q _06656_/A VPWR VGND sg13cmos5l_nor2_1
X_06281_ _06281_/Y _06281_/A _06281_/B VPWR VGND sg13cmos5l_nor2_1
X_05301_ _05301_/X _09332_/Q _05301_/B VPWR VGND sg13cmos5l_xor2_1
X_05232_ _05234_/B _08933_/A _08939_/A _05232_/S VPWR VGND sg13cmos5l_mux2_1
X_08020_ _08175_/A _08019_/Y _08026_/B VPWR VGND sg13cmos5l_nand2b_1
XFILLER_30_584 VPWR VGND sg13cmos5l_fill_2
X_05163_ _08746_/A _09001_/A _05163_/B VPWR VGND sg13cmos5l_xnor2_1
X_05094_ _05094_/Y _09321_/Q _09289_/Q VPWR VGND sg13cmos5l_nand2_1
X_08922_ _08923_/B _08900_/X _08899_/Y _08924_/S VPWR VGND sg13cmos5l_mux2_1
Xhold1425 _05341_/A _09300_/Q VPWR VGND sg13cmos5l_dlygate4sd3_1
Xhold1403 hold1403/X _05852_/Y VPWR VGND sg13cmos5l_dlygate4sd3_1
Xhold1414 hold1414/X _05499_/A VPWR VGND sg13cmos5l_dlygate4sd3_1
X_08853_ _08864_/A _09279_/Q _08850_/B _08898_/A VPWR VGND sg13cmos5l_a21o_1
X_05996_ _05996_/Y _05845_/Y _05898_/B _05993_/Y _05994_/Y _05995_/Y VPWR VGND sg13cmos5l_a221oi_1
X_07804_ _07804_/Y _07792_/Y _07800_/Y _07803_/Y VPWR VGND sg13cmos5l_o21ai_1
X_08784_ _09262_/D _08784_/A _08784_/B _08784_/C VPWR VGND sg13cmos5l_nor3_1
X_07735_ _08056_/A _09142_/Q _09141_/Q VPWR VGND sg13cmos5l_xnor2_1
X_04947_ _04947_/Y _07589_/A VPWR VGND sg13cmos5l_inv_1
X_09405_ _09405_/Q clkload21/A _09405_/D _09405_/RESET_B VPWR VGND sg13cmos5l_dfrbpq_1
X_07666_ _07666_/Y _07665_/A _07665_/B _07665_/C _07665_/D VPWR VGND sg13cmos5l_a22oi_1
X_04878_ _07207_/B input5/X VPWR VGND sg13cmos5l_inv_1
XFILLER_40_304 VPWR VGND sg13cmos5l_fill_1
X_07597_ _07597_/Y _09084_/Q _07592_/Y _07596_/Y _09085_/Q VPWR VGND sg13cmos5l_a22oi_1
X_06617_ _06771_/A _06903_/A _06622_/B _06617_/C VPWR VGND sg13cmos5l_nand3_1
X_09336_ _09336_/Q clkload11/A _09336_/D _09336_/RESET_B VPWR VGND sg13cmos5l_dfrbpq_1
X_06548_ _06557_/S _06539_/Y _06546_/Y _06547_/Y VPWR VGND sg13cmos5l_a21oi_1
X_09267_ _09267_/Q clkload7/A _09267_/D _09267_/RESET_B VPWR VGND sg13cmos5l_dfrbpq_1
X_08218_ _08229_/B _08232_/A _08232_/C _08218_/C VPWR VGND sg13cmos5l_nand3_1
X_06479_ _06479_/Y hold937/A hold860/A VPWR VGND sg13cmos5l_xnor2_1
X_09198_ _09198_/Q clkload5/A _09198_/D _09198_/RESET_B VPWR VGND sg13cmos5l_dfrbpq_1
X_09148__325 _09148_/RESET_B VPWR VGND sg13cmos5l_tiehi
X_08149_ _09177_/D _08149_/A _08149_/B VPWR VGND sg13cmos5l_nor2_1
X_09599__520 _09599_/RESET_B VPWR VGND sg13cmos5l_tiehi
XFILLER_49_938 VPWR VGND sg13cmos5l_decap_8
X_09009__476 _09009_/RESET_B VPWR VGND sg13cmos5l_tiehi
XFILLER_45_62 VPWR VGND sg13cmos5l_fill_2
X_09155__318 _09155_/RESET_B VPWR VGND sg13cmos5l_tiehi
XFILLER_16_334 VPWR VGND sg13cmos5l_fill_2
XFILLER_8_500 VPWR VGND sg13cmos5l_decap_4
X_09016__469 _09016_/RESET_B VPWR VGND sg13cmos5l_tiehi
XFILLER_3_271 VPWR VGND sg13cmos5l_fill_1
XFILLER_3_260 VPWR VGND sg13cmos5l_fill_2
X_05850_ _06004_/A _05997_/A _05997_/B VPWR VGND sg13cmos5l_nand2_1
X_07520_ _07668_/A _07521_/B _07521_/C _07519_/Y VPWR VGND sg13cmos5l_a21o_1
X_05781_ _09401_/D _05784_/A _05781_/B _05781_/C VPWR VGND sg13cmos5l_nor3_1
XFILLER_19_194 VPWR VGND sg13cmos5l_fill_2
X_07451_ _07466_/B _07407_/A _07410_/Y _07407_/B VPWR VGND sg13cmos5l_a21oi_1
X_06402_ _06404_/A _06396_/A _06409_/C _06091_/Y VPWR VGND sg13cmos5l_o21ai_1
X_07382_ _09055_/D _07382_/A hold865/X VPWR VGND sg13cmos5l_and2_1
X_06333_ _06333_/Y _06333_/A _06333_/B _06333_/C VPWR VGND sg13cmos5l_nor3_1
X_09121_ _09121_/Q _09214_/CLK _09121_/D _09121_/RESET_B VPWR VGND sg13cmos5l_dfrbpq_1
X_06264_ _06264_/X _06096_/X _06150_/Y _06281_/B VPWR VGND sg13cmos5l_mux2_1
X_09052_ hold990/A clkload13/A _09052_/D _09052_/RESET_B VPWR VGND sg13cmos5l_dfrbpq_1
X_05215_ _05238_/B _05206_/Y _05212_/Y _05213_/Y VPWR VGND sg13cmos5l_a21o_1
X_08003_ _08004_/B _08038_/A _08314_/A VPWR VGND sg13cmos5l_nor2_1
X_06195_ _06195_/Y _09459_/Q _06177_/B _06194_/Y VPWR VGND sg13cmos5l_o21ai_1
X_05146_ _05146_/X _05146_/A _05146_/B VPWR VGND sg13cmos5l_and2_1
X_05077_ _05222_/A _05237_/B VPWR VGND sg13cmos5l_inv_1
X_08905_ _08905_/Y _08902_/Y _08904_/Y _08885_/Y VPWR VGND sg13cmos5l_o21ai_1
Xhold1200 _04861_/A _09286_/Q VPWR VGND sg13cmos5l_dlygate4sd3_1
Xhold1233 _04961_/A _09570_/Q VPWR VGND sg13cmos5l_dlygate4sd3_1
Xhold1211 hold1211/X _09217_/Q VPWR VGND sg13cmos5l_dlygate4sd3_1
X_08836_ _09274_/D _08838_/A hold867/X VPWR VGND sg13cmos5l_and2_1
Xhold1222 _05000_/A _09267_/Q VPWR VGND sg13cmos5l_dlygate4sd3_1
Xhold1255 _04942_/A _09161_/Q VPWR VGND sg13cmos5l_dlygate4sd3_1
Xhold1244 _08167_/A _09172_/Q VPWR VGND sg13cmos5l_dlygate4sd3_1
Xhold1266 hold1266/X _07096_/C VPWR VGND sg13cmos5l_dlygate4sd3_1
X_08767_ _08769_/B _08870_/B _08870_/C VPWR VGND sg13cmos5l_and2_1
Xhold1277 _06285_/C _09472_/Q VPWR VGND sg13cmos5l_dlygate4sd3_1
Xhold1288 _08342_/B _08318_/B VPWR VGND sg13cmos5l_dlygate4sd3_1
Xhold1299 _07913_/A _09134_/Q VPWR VGND sg13cmos5l_dlygate4sd3_1
X_05979_ _06016_/A _06015_/B _06015_/C _06015_/A VPWR VGND sg13cmos5l_a21oi_1
X_07718_ _09106_/D _07701_/B _07715_/S _07717_/Y VPWR VGND sg13cmos5l_a21oi_1
X_08698_ _08701_/A _08698_/A _08698_/B _08698_/C VPWR VGND sg13cmos5l_nor3_1
XFILLER_41_613 VPWR VGND sg13cmos5l_fill_2
X_07649_ _07692_/A _07691_/B _07691_/C _07691_/A VPWR VGND sg13cmos5l_a21oi_1
XFILLER_9_308 VPWR VGND sg13cmos5l_fill_1
X_09319_ _09319_/Q clkload8/A _09319_/D _09319_/RESET_B VPWR VGND sg13cmos5l_dfrbpq_1
XFILLER_40_189 VPWR VGND sg13cmos5l_fill_1
XFILLER_49_768 VPWR VGND sg13cmos5l_fill_2
XFILLER_44_440 VPWR VGND sg13cmos5l_fill_1
XFILLER_32_602 VPWR VGND sg13cmos5l_fill_2
XFILLER_31_134 VPWR VGND sg13cmos5l_fill_2
X_05000_ _05000_/Y _05000_/A VPWR VGND sg13cmos5l_inv_1
XFILLER_28_1028 VPWR VGND sg13cmos5l_fill_1
X_06951_ _06951_/Y _06950_/Y _09570_/Q VPWR VGND sg13cmos5l_nand2b_1
X_05902_ _09413_/D _05951_/A _05902_/B VPWR VGND sg13cmos5l_nor2_1
X_06882_ _09558_/D _06988_/B _07031_/A VPWR VGND sg13cmos5l_and2_1
XFILLER_11_0 VPWR VGND sg13cmos5l_fill_1
X_08621_ _08698_/B _08621_/A _08621_/B VPWR VGND sg13cmos5l_nor2_1
X_05833_ _05993_/A _05852_/C _05832_/Y _05831_/X VPWR VGND sg13cmos5l_o21ai_1
X_05764_ _05783_/A _05764_/A _05764_/B _05764_/C VPWR VGND sg13cmos5l_nand3_1
X_08552_ _08552_/Y _08552_/A _08552_/B VPWR VGND sg13cmos5l_nand2_1
X_07503_ _07503_/Y _07499_/Y _07502_/Y _07481_/Y VPWR VGND sg13cmos5l_a21oi_1
X_09138__335 _09138_/RESET_B VPWR VGND sg13cmos5l_tiehi
X_08483_ _08494_/C _09222_/Q _09223_/Q _09224_/Q VPWR VGND sg13cmos5l_o21ai_1
X_07434_ _07434_/Y _07434_/A _07434_/B VPWR VGND sg13cmos5l_nor2_1
X_05695_ _09390_/D _05961_/A hold890/X VPWR VGND sg13cmos5l_and2_1
X_07365_ _07365_/Y _07345_/A fanout33/X _07386_/B VPWR VGND sg13cmos5l_o21ai_1
X_07296_ _07296_/Y _06826_/X _07291_/Y _07293_/Y _07295_/X _07294_/X VPWR VGND sg13cmos5l_a221oi_1
X_09104_ _09104_/Q clkload15/A _09104_/D _09104_/RESET_B VPWR VGND sg13cmos5l_dfrbpq_1
X_06316_ _06680_/A _06319_/B _06316_/B VPWR VGND sg13cmos5l_nand2b_1
X_06247_ _06247_/Y _06090_/B _06266_/A _06150_/Y _06097_/B VPWR VGND sg13cmos5l_a22oi_1
X_09035_ _09035_/Q _09565_/CLK _09035_/D _09035_/RESET_B VPWR VGND sg13cmos5l_dfrbpq_1
X_06178_ _06178_/X _06473_/A _09417_/Q _06189_/B VPWR VGND sg13cmos5l_mux2_1
X_05129_ _08934_/A _05196_/A _05196_/B VPWR VGND sg13cmos5l_and2_1
X_09145__328 _09145_/RESET_B VPWR VGND sg13cmos5l_tiehi
XFILLER_46_716 VPWR VGND sg13cmos5l_fill_1
XFILLER_18_407 VPWR VGND sg13cmos5l_fill_1
Xhold1041 _04830_/A _09596_/Q VPWR VGND sg13cmos5l_dlygate4sd3_1
Xhold1030 hold1030/X _09264_/Q VPWR VGND sg13cmos5l_dlygate4sd3_1
XFILLER_46_749 VPWR VGND sg13cmos5l_fill_1
X_09006__479 _09006_/RESET_B VPWR VGND sg13cmos5l_tiehi
XFILLER_45_204 VPWR VGND sg13cmos5l_decap_8
Xhold1074 _08572_/A _09201_/Q VPWR VGND sg13cmos5l_dlygate4sd3_1
Xhold1063 _09164_/D _08133_/Y VPWR VGND sg13cmos5l_dlygate4sd3_1
X_08819_ _08819_/Y hold1212/X _08823_/S _08842_/B VPWR VGND sg13cmos5l_o21ai_1
Xhold1085 _09268_/D _08827_/Y VPWR VGND sg13cmos5l_dlygate4sd3_1
Xhold1052 _09306_/D _08984_/Y VPWR VGND sg13cmos5l_dlygate4sd3_1
Xhold1096 _05923_/A _09437_/Q VPWR VGND sg13cmos5l_dlygate4sd3_1
X_09371__238 _09371_/D VPWR VGND sg13cmos5l_tielo
Xclkbuf_3_6__f_clk clkbuf_3_6__f_clk/X clkbuf_0_clk/X VPWR VGND sg13cmos5l_buf_8
XFILLER_42_52 VPWR VGND sg13cmos5l_fill_2
XFILLER_42_96 VPWR VGND sg13cmos5l_fill_2
XFILLER_5_311 VPWR VGND sg13cmos5l_decap_8
XFILLER_6_867 VPWR VGND sg13cmos5l_fill_2
XFILLER_5_377 VPWR VGND sg13cmos5l_fill_2
XFILLER_3_79 VPWR VGND sg13cmos5l_fill_2
XFILLER_3_1019 VPWR VGND sg13cmos5l_decap_8
X_05480_ _05480_/Y _05329_/B _05484_/A _05384_/B _05332_/Y VPWR VGND sg13cmos5l_a22oi_1
X_07150_ _07150_/Y _08779_/A _08784_/A VPWR VGND sg13cmos5l_nor2_1
X_06101_ _06102_/B _06085_/X _06099_/X _06100_/Y VPWR VGND sg13cmos5l_a21o_1
X_07081_ _07082_/B _04831_/A _07079_/B _08479_/B VPWR VGND sg13cmos5l_o21ai_1
X_06032_ _06045_/C _06022_/Y _06027_/Y _06031_/Y VPWR VGND sg13cmos5l_o21ai_1
Xfanout117 _08400_/B _08401_/B VPWR VGND sg13cmos5l_buf_1
Xfanout128 _07895_/B _07879_/B1 VPWR VGND sg13cmos5l_buf_1
Xfanout106 _05470_/B _05452_/Y VPWR VGND sg13cmos5l_buf_1
Xfanout139 _07464_/B1 _07221_/Y VPWR VGND sg13cmos5l_buf_1
X_07983_ _07992_/B _09181_/Q _07991_/C _09180_/Q VPWR VGND sg13cmos5l_nor3_1
X_06934_ _09567_/D _07070_/A _07028_/B VPWR VGND sg13cmos5l_nor2_1
X_06865_ _07018_/A _06876_/B _06876_/C _06864_/Y VPWR VGND sg13cmos5l_a21o_1
X_05816_ _05816_/Y _05852_/B _05816_/B VPWR VGND sg13cmos5l_nand2_1
X_08604_ _08604_/Y _08604_/A _08604_/B VPWR VGND sg13cmos5l_nor2_1
X_09584_ _09584_/Q _09591_/CLK _09584_/D _09584_/RESET_B VPWR VGND sg13cmos5l_dfrbpq_1
X_08535_ _08535_/Y _08535_/A _08538_/B VPWR VGND sg13cmos5l_nor2_1
X_06796_ _06796_/Y _06793_/Y _06795_/Y _06780_/Y VPWR VGND sg13cmos5l_o21ai_1
X_05747_ _05748_/A _05574_/B _05760_/B _05746_/Y VPWR VGND sg13cmos5l_a21o_1
X_08466_ _08466_/Y _08444_/A fanout21/X _08397_/B VPWR VGND sg13cmos5l_o21ai_1
X_05678_ _05678_/Y _04986_/A _05675_/B _05530_/Y VPWR VGND sg13cmos5l_o21ai_1
X_07417_ _07417_/Y _07416_/A _07416_/B _07416_/C _07416_/D VPWR VGND sg13cmos5l_a22oi_1
X_08397_ _09211_/D _08397_/A _08397_/B VPWR VGND sg13cmos5l_and2_1
XFILLER_23_476 VPWR VGND sg13cmos5l_fill_2
X_07348_ _07349_/A _06969_/A _07347_/B _07347_/Y VPWR VGND sg13cmos5l_a21oi_1
X_07279_ _07279_/Y _07556_/A _07279_/B VPWR VGND sg13cmos5l_nand2b_1
XFILLER_12_55 VPWR VGND sg13cmos5l_fill_2
X_09018_ _09018_/Q _09288_/CLK _09018_/D _09018_/RESET_B VPWR VGND sg13cmos5l_dfrbpq_1
XFILLER_3_859 VPWR VGND sg13cmos5l_fill_2
XFILLER_2_347 VPWR VGND sg13cmos5l_decap_4
XFILLER_19_727 VPWR VGND sg13cmos5l_fill_2
XFILLER_15_999 VPWR VGND sg13cmos5l_fill_2
X_04980_ _04980_/Y hold973/X VPWR VGND sg13cmos5l_inv_1
X_09204__266 _09204_/RESET_B VPWR VGND sg13cmos5l_tiehi
XFILLER_37_502 VPWR VGND sg13cmos5l_decap_8
X_06650_ _06650_/Y _06645_/Y _06647_/Y _06649_/Y VPWR VGND sg13cmos5l_o21ai_1
X_05601_ _05630_/B _05610_/B _05601_/B VPWR VGND sg13cmos5l_and2_1
X_06581_ _06581_/Y _06992_/A _06581_/B VPWR VGND sg13cmos5l_xnor2_1
X_05532_ _05560_/B _09366_/Q _09365_/Q _09367_/Q VPWR VGND sg13cmos5l_or3_1
X_08320_ _08320_/Y _08320_/A _08329_/C VPWR VGND sg13cmos5l_nand2_1
X_09135__338 _09135_/RESET_B VPWR VGND sg13cmos5l_tiehi
X_09586__500 _09586_/RESET_B VPWR VGND sg13cmos5l_tiehi
X_08251_ _08251_/Y _08259_/B _08256_/C _08640_/A VPWR VGND sg13cmos5l_a21oi_1
X_05463_ _05510_/A _09357_/Q _05470_/B _05503_/A VPWR VGND sg13cmos5l_a21oi_1
X_07202_ _07202_/Y hold993/X fanout54/X _08834_/B1 VPWR VGND sg13cmos5l_o21ai_1
X_08182_ _08184_/A _08208_/A _08182_/B VPWR VGND sg13cmos5l_nor2_1
X_05394_ _05394_/Y _09359_/Q _05408_/B VPWR VGND sg13cmos5l_nor2_1
X_07133_ _07133_/Y _07154_/A _07129_/Y _07132_/Y VPWR VGND sg13cmos5l_o21ai_1
X_07064_ _09587_/D _07042_/X _07069_/S _07063_/Y VPWR VGND sg13cmos5l_a21oi_1
X_06015_ _06016_/C _06015_/A _06015_/B _06015_/C VPWR VGND sg13cmos5l_and3_1
X_07966_ _09142_/D _07945_/B _07959_/Y _07965_/Y VPWR VGND sg13cmos5l_a21oi_1
X_06917_ _07018_/C _06892_/Y _06914_/Y _06600_/Y VPWR VGND sg13cmos5l_o21ai_1
X_07897_ _07897_/Y hold906/A hold883/A VPWR VGND sg13cmos5l_xnor2_1
X_06848_ _06848_/Y _06834_/Y _06841_/Y _06847_/Y VPWR VGND sg13cmos5l_o21ai_1
X_09567_ _09567_/Q clkload17/A _09567_/D _09567_/RESET_B VPWR VGND sg13cmos5l_dfrbpq_1
X_06779_ _06780_/B _06627_/B _06676_/B _06799_/B VPWR VGND sg13cmos5l_mux2_1
X_08518_ _08518_/X _09245_/Q _08518_/B VPWR VGND sg13cmos5l_and2_1
X_09498_ hold912/A _09503_/CLK _09498_/D _09498_/RESET_B VPWR VGND sg13cmos5l_dfrbpq_1
X_08449_ _08449_/Y _08442_/Y _08444_/Y _08448_/Y VPWR VGND sg13cmos5l_o21ai_1
XFILLER_3_667 VPWR VGND sg13cmos5l_fill_1
XFILLER_19_524 VPWR VGND sg13cmos5l_fill_1
XFILLER_46_321 VPWR VGND sg13cmos5l_fill_1
XFILLER_19_535 VPWR VGND sg13cmos5l_fill_1
XFILLER_7_940 VPWR VGND sg13cmos5l_fill_2
XFILLER_6_461 VPWR VGND sg13cmos5l_fill_2
Xhold907 hold907/X hold907/A VPWR VGND sg13cmos5l_dlygate4sd3_1
Xhold918 hold918/X hold918/A VPWR VGND sg13cmos5l_dlygate4sd3_1
Xhold929 hold929/X hold929/A VPWR VGND sg13cmos5l_dlygate4sd3_1
X_07820_ _07821_/B _07921_/C _07921_/D VPWR VGND sg13cmos5l_nand2_1
X_07751_ _07751_/Y _07776_/B _07746_/Y _07781_/A _07753_/B VPWR VGND sg13cmos5l_a22oi_1
XFILLER_38_811 VPWR VGND sg13cmos5l_fill_2
X_04963_ _07332_/B hold988/X VPWR VGND sg13cmos5l_inv_1
X_06702_ _06703_/A _06991_/A _06705_/B _06701_/Y VPWR VGND sg13cmos5l_o21ai_1
X_04894_ _07999_/B _09150_/Q VPWR VGND sg13cmos5l_inv_1
X_07682_ _07682_/Y _07682_/A _07682_/B VPWR VGND sg13cmos5l_xnor2_1
X_06633_ _09522_/D _06737_/B _06802_/A VPWR VGND sg13cmos5l_and2_1
X_09421_ _09421_/Q _09503_/CLK _09421_/D _09421_/RESET_B VPWR VGND sg13cmos5l_dfrbpq_1
X_06564_ _06569_/A _06903_/A _06574_/B _06564_/C VPWR VGND sg13cmos5l_and3_1
X_09352_ hold890/A _09387_/CLK _09352_/D _09352_/RESET_B VPWR VGND sg13cmos5l_dfrbpq_1
X_08303_ _08329_/C _09158_/Q _09157_/Q _08313_/B VPWR VGND sg13cmos5l_or3_1
X_05515_ _05515_/Y _05516_/A _05516_/B _05516_/C VPWR VGND sg13cmos5l_nor3_1
X_06495_ _06496_/C _06495_/A _06495_/B VPWR VGND sg13cmos5l_or2_1
X_09283_ _09283_/Q clkload8/A _09283_/D _09283_/RESET_B VPWR VGND sg13cmos5l_dfrbpq_1
X_08234_ _08234_/Y _08234_/A _08592_/B VPWR VGND sg13cmos5l_nor2_1
X_05446_ _09356_/D _05446_/A _05448_/B VPWR VGND sg13cmos5l_nor2_1
X_05377_ _05378_/B _05478_/C _05478_/D VPWR VGND sg13cmos5l_nand2_1
X_08165_ _08166_/B hold1349/X _08169_/A VPWR VGND sg13cmos5l_nand2b_1
X_07116_ _07142_/B _09010_/Q _07137_/B VPWR VGND sg13cmos5l_nor2b_1
X_08096_ _08111_/B _09183_/Q _04943_/Y _08095_/Y VPWR VGND sg13cmos5l_a21oi_1
X_07047_ _07049_/B _06879_/B _06926_/B _07047_/S VPWR VGND sg13cmos5l_mux2_1
X_09601__522 _09601_/RESET_B VPWR VGND sg13cmos5l_tiehi
X_08998_ _09317_/D _08998_/A _09001_/B VPWR VGND sg13cmos5l_nor2_1
X_07949_ _07952_/A _07949_/A _07949_/B _07949_/C VPWR VGND sg13cmos5l_nor3_1
XFILLER_18_21 VPWR VGND sg13cmos5l_fill_2
XFILLER_28_332 VPWR VGND sg13cmos5l_fill_2
XFILLER_16_549 VPWR VGND sg13cmos5l_fill_1
XFILLER_18_98 VPWR VGND sg13cmos5l_fill_1
XFILLER_34_97 VPWR VGND sg13cmos5l_fill_1
XFILLER_3_497 VPWR VGND sg13cmos5l_fill_1
X_09201__269 _09201_/RESET_B VPWR VGND sg13cmos5l_tiehi
X_09583__503 _09583_/RESET_B VPWR VGND sg13cmos5l_tiehi
X_06280_ _06280_/Y _06283_/A VPWR VGND sg13cmos5l_inv_1
X_05300_ _05304_/B _09332_/Q _05301_/B VPWR VGND sg13cmos5l_xnor2_1
X_05231_ _05234_/A _05231_/A _05237_/B _05231_/C VPWR VGND sg13cmos5l_nor3_1
X_05162_ _05207_/A _09001_/A _05163_/B VPWR VGND sg13cmos5l_nor2_1
X_05093_ _05093_/X _05100_/B _05093_/B VPWR VGND sg13cmos5l_and2_1
X_08921_ _09284_/D _08930_/A _08921_/B VPWR VGND sg13cmos5l_nor2_1
X_09264__797 _09264_/RESET_B VPWR VGND sg13cmos5l_tiehi
X_08852_ _08898_/A _08897_/B _08897_/C _08897_/A VPWR VGND sg13cmos5l_a21oi_1
Xhold1404 _06086_/A _09441_/Q VPWR VGND sg13cmos5l_dlygate4sd3_1
Xhold1415 _07541_/B _09040_/Q VPWR VGND sg13cmos5l_dlygate4sd3_1
X_07803_ _07803_/Y _07792_/A _07826_/A _07802_/Y _07528_/B VPWR VGND sg13cmos5l_a22oi_1
X_08783_ _09261_/D _08882_/A _08783_/B VPWR VGND sg13cmos5l_nor2_1
X_05995_ _05995_/Y _05994_/A _05994_/B _05994_/C _05994_/D VPWR VGND sg13cmos5l_a22oi_1
Xhold1426 hold1426/X _09041_/Q VPWR VGND sg13cmos5l_dlygate4sd3_1
X_07734_ _07734_/Y _07732_/Y _07733_/Y _07780_/A VPWR VGND sg13cmos5l_o21ai_1
X_04946_ _04946_/Y _04946_/A VPWR VGND sg13cmos5l_inv_1
X_07665_ _07665_/Y _07665_/A _07665_/B _07665_/C _07665_/D VPWR VGND sg13cmos5l_nand4_1
X_09404_ _09404_/Q clkload21/A _09404_/D _09404_/RESET_B VPWR VGND sg13cmos5l_dfrbpq_1
X_04877_ _04877_/Y _09602_/Q VPWR VGND sg13cmos5l_inv_1
X_06616_ _06616_/Y _06903_/A _06622_/B VPWR VGND sg13cmos5l_nand2_1
X_07596_ _07596_/Y _07596_/A VPWR VGND sg13cmos5l_inv_1
X_09335_ _09335_/Q clkload11/A _09335_/D _09335_/RESET_B VPWR VGND sg13cmos5l_dfrbpq_1
X_06547_ _06547_/Y _06540_/Y _06545_/Y _06542_/Y VPWR VGND sg13cmos5l_o21ai_1
X_06478_ _06478_/Y hold936/A hold863/A VPWR VGND sg13cmos5l_nand2_1
X_09266_ _09266_/Q clkload7/A _09266_/D _09266_/RESET_B VPWR VGND sg13cmos5l_dfrbpq_1
X_08217_ _08218_/C _08217_/A _08232_/B VPWR VGND sg13cmos5l_or2_1
X_05429_ _05429_/Y _05416_/A _05418_/Y _05428_/Y VPWR VGND sg13cmos5l_a21oi_1
XFILLER_5_718 VPWR VGND sg13cmos5l_fill_1
X_09197_ _09197_/Q clkload5/A _09197_/D _09197_/RESET_B VPWR VGND sg13cmos5l_dfrbpq_1
X_08148_ _09176_/D _08148_/A _08149_/B VPWR VGND sg13cmos5l_nor2_1
X_08079_ _08178_/D _08079_/A _08079_/B _08082_/C VPWR VGND sg13cmos5l_nand3_1
XFILLER_1_913 VPWR VGND sg13cmos5l_decap_8
XFILLER_49_906 VPWR VGND sg13cmos5l_decap_8
XFILLER_8_523 VPWR VGND sg13cmos5l_fill_1
XFILLER_6_1028 VPWR VGND sg13cmos5l_fill_1
X_05780_ _05781_/C _05780_/A _05779_/A VPWR VGND sg13cmos5l_nor2b_1
XFILLER_48_983 VPWR VGND sg13cmos5l_decap_8
X_07450_ _07454_/A _07450_/A _07423_/B VPWR VGND sg13cmos5l_nor2b_1
X_06401_ _09486_/D _06552_/A _06401_/B VPWR VGND sg13cmos5l_nor2_1
X_07381_ _09054_/D _04827_/Y fanout51/X _07380_/Y VPWR VGND sg13cmos5l_a21oi_1
X_06332_ _06333_/C _09511_/Q _06329_/Y _06738_/A VPWR VGND sg13cmos5l_a21oi_1
X_09120_ _09120_/Q _09214_/CLK _09120_/D _09120_/RESET_B VPWR VGND sg13cmos5l_dfrbpq_1
X_09051_ _09051_/Q _09575_/CLK _09051_/D _09051_/RESET_B VPWR VGND sg13cmos5l_dfrbpq_1
XFILLER_31_894 VPWR VGND sg13cmos5l_fill_1
X_06263_ _06263_/Y _06263_/A VPWR VGND sg13cmos5l_inv_1
X_08002_ _08004_/A _08007_/B _08007_/C _08007_/A VPWR VGND sg13cmos5l_a21oi_1
X_05214_ _05232_/S _05206_/Y _05212_/Y _05213_/Y VPWR VGND sg13cmos5l_a21oi_1
X_06194_ _06194_/Y _06194_/A _06194_/B VPWR VGND sg13cmos5l_nand2_1
X_05145_ _05146_/B _09258_/Q _09259_/Q hold1359/X VPWR VGND sg13cmos5l_o21ai_1
XFILLER_44_1001 VPWR VGND sg13cmos5l_fill_1
X_05076_ _05237_/B _05076_/A _05076_/B VPWR VGND sg13cmos5l_nor2_1
X_08904_ _08904_/Y _08899_/A _08900_/X _08903_/Y VPWR VGND sg13cmos5l_o21ai_1
Xhold1234 _06971_/B _06970_/Y VPWR VGND sg13cmos5l_dlygate4sd3_1
Xhold1201 _04916_/A _09553_/Q VPWR VGND sg13cmos5l_dlygate4sd3_1
X_08835_ _09273_/D _04814_/Y fanout47/X _08834_/Y VPWR VGND sg13cmos5l_a21oi_1
Xhold1212 hold1212/X _09265_/Q VPWR VGND sg13cmos5l_dlygate4sd3_1
Xhold1223 _08824_/B _08823_/X VPWR VGND sg13cmos5l_dlygate4sd3_1
Xhold1245 _05089_/A _09295_/Q VPWR VGND sg13cmos5l_dlygate4sd3_1
X_08766_ _08870_/C _08761_/B _08761_/C _08765_/Y VPWR VGND sg13cmos5l_o21ai_1
Xhold1256 hold1256/X _09284_/Q VPWR VGND sg13cmos5l_dlygate4sd3_1
Xhold1267 _04946_/A _09123_/Q VPWR VGND sg13cmos5l_dlygate4sd3_1
Xhold1289 _04933_/A _09415_/Q VPWR VGND sg13cmos5l_dlygate4sd3_1
Xhold1278 hold1278/X _06291_/A VPWR VGND sg13cmos5l_dlygate4sd3_1
X_07717_ _07717_/Y _07701_/A _07715_/S _07717_/B1 VPWR VGND sg13cmos5l_o21ai_1
X_05978_ _06015_/C hold960/A hold878/A _09430_/Q VPWR VGND sg13cmos5l_nand3_1
XFILLER_38_471 VPWR VGND sg13cmos5l_fill_2
X_04929_ _08378_/A _04929_/A VPWR VGND sg13cmos5l_inv_1
X_08697_ _08698_/C _08697_/A _08697_/B _08697_/C VPWR VGND sg13cmos5l_and3_1
X_07648_ _07691_/C hold951/A hold885/A _09097_/Q VPWR VGND sg13cmos5l_nand3_1
XFILLER_15_22 VPWR VGND sg13cmos5l_fill_1
X_07579_ _07579_/Y _09102_/Q _07579_/B VPWR VGND sg13cmos5l_nand2_1
X_09318_ _09318_/Q clkload7/A _09318_/D _09318_/RESET_B VPWR VGND sg13cmos5l_dfrbpq_1
X_09249_ _09249_/Q clkload3/A _09249_/D _09249_/RESET_B VPWR VGND sg13cmos5l_dfrbpq_1
X_09015__470 _09015_/RESET_B VPWR VGND sg13cmos5l_tiehi
Xoutput10 uio_out[0] _10243_/X VPWR VGND sg13cmos5l_buf_1
X_09161__312 _09161_/RESET_B VPWR VGND sg13cmos5l_tiehi
XFILLER_16_132 VPWR VGND sg13cmos5l_fill_1
XFILLER_44_452 VPWR VGND sg13cmos5l_decap_8
XFILLER_32_614 VPWR VGND sg13cmos5l_fill_2
XFILLER_31_179 VPWR VGND sg13cmos5l_fill_2
X_09580__506 _09580_/RESET_B VPWR VGND sg13cmos5l_tiehi
X_06950_ _06950_/Y _04967_/Y _06957_/B _06949_/Y VPWR VGND sg13cmos5l_a21oi_1
X_05901_ _05902_/B _05997_/C _05997_/D VPWR VGND sg13cmos5l_nand2_1
X_06881_ _07031_/A _06839_/Y _06880_/Y _06881_/S VPWR VGND sg13cmos5l_mux2_1
X_05832_ _05832_/Y _05832_/A _06139_/A VPWR VGND sg13cmos5l_nor2_1
X_08620_ _08621_/B hold1334/X _08626_/B VPWR VGND sg13cmos5l_nand2b_1
X_08551_ _08552_/B _09249_/Q _08371_/A _04928_/Y _09248_/Q VPWR VGND sg13cmos5l_a22oi_1
X_05763_ _05763_/Y _05739_/Y _05757_/Y _05762_/X VPWR VGND sg13cmos5l_o21ai_1
X_07502_ _07502_/Y _07478_/Y _07500_/Y _07501_/Y VPWR VGND sg13cmos5l_a21oi_1
X_08482_ _08494_/B _09222_/Q _09223_/Q _09224_/Q VPWR VGND sg13cmos5l_or3_1
X_05694_ _09389_/D _05961_/A hold856/X VPWR VGND sg13cmos5l_and2_1
X_07433_ _07434_/B _07269_/B _07319_/B _07447_/B VPWR VGND sg13cmos5l_mux2_1
X_09103_ _09103_/Q clkload15/A _09103_/D _09103_/RESET_B VPWR VGND sg13cmos5l_dfrbpq_1
X_07364_ hold972/A _07579_/B fanout33/X _07363_/Y VPWR VGND sg13cmos5l_a21oi_1
X_07295_ _07295_/X _07295_/A _07295_/B VPWR VGND sg13cmos5l_or2_1
X_06315_ _06319_/B _09514_/Q _09515_/Q _09513_/Q _09512_/Q VPWR VGND sg13cmos5l_nor4_1
X_06246_ _06266_/B _06246_/A _06253_/A VPWR VGND sg13cmos5l_nor2b_1
X_09034_ _09034_/Q _09565_/CLK _09034_/D _09034_/RESET_B VPWR VGND sg13cmos5l_dfrbpq_1
XFILLER_2_507 VPWR VGND sg13cmos5l_fill_2
X_06177_ _06177_/Y _09459_/Q _06177_/B VPWR VGND sg13cmos5l_nand2_1
X_05128_ _05128_/Y _05196_/A _05196_/B VPWR VGND sg13cmos5l_nand2_1
X_05059_ _05060_/C _05059_/A _05059_/B _05059_/C VPWR VGND sg13cmos5l_nand3_1
Xhold1042 hold1042/X _07092_/Y VPWR VGND sg13cmos5l_dlygate4sd3_1
Xhold1031 _09264_/D _08818_/Y VPWR VGND sg13cmos5l_dlygate4sd3_1
Xhold1020 _05396_/A _09364_/Q VPWR VGND sg13cmos5l_dlygate4sd3_1
Xhold1053 _06181_/A _09475_/Q VPWR VGND sg13cmos5l_dlygate4sd3_1
Xhold1075 _09201_/D _08384_/Y VPWR VGND sg13cmos5l_dlygate4sd3_1
X_08818_ _08818_/Y _08818_/A _08818_/B VPWR VGND sg13cmos5l_nor2_1
Xhold1064 _08953_/B _09269_/Q VPWR VGND sg13cmos5l_dlygate4sd3_1
X_08749_ _08764_/B _08738_/Y _08743_/Y _08747_/Y VPWR VGND sg13cmos5l_a21o_1
XFILLER_27_942 VPWR VGND sg13cmos5l_fill_1
Xhold1086 _08959_/A _09323_/Q VPWR VGND sg13cmos5l_dlygate4sd3_1
Xhold1097 _05443_/A _09321_/Q VPWR VGND sg13cmos5l_dlygate4sd3_1
XFILLER_38_290 VPWR VGND sg13cmos5l_fill_1
XFILLER_26_65 VPWR VGND sg13cmos5l_fill_1
XFILLER_13_146 VPWR VGND sg13cmos5l_fill_1
X_09089__390 _09089_/RESET_B VPWR VGND sg13cmos5l_tiehi
XFILLER_37_728 VPWR VGND sg13cmos5l_fill_2
XFILLER_45_783 VPWR VGND sg13cmos5l_decap_4
XFILLER_17_485 VPWR VGND sg13cmos5l_fill_1
XFILLER_32_422 VPWR VGND sg13cmos5l_fill_2
X_06100_ _06100_/Y _06098_/A _06387_/A _06083_/Y _06084_/Y _06058_/Y VPWR VGND sg13cmos5l_a221oi_1
XFILLER_9_695 VPWR VGND sg13cmos5l_fill_1
X_07080_ _07082_/A _04831_/Y _09602_/Q _07079_/Y VPWR VGND sg13cmos5l_a21oi_1
X_06031_ _06031_/Y _06027_/A _06027_/B _06033_/A _06045_/B VPWR VGND sg13cmos5l_a22oi_1
Xfanout107 _05176_/B _05194_/A VPWR VGND sg13cmos5l_buf_1
X_07982_ _07982_/Y _07982_/A _07982_/B _07982_/C VPWR VGND sg13cmos5l_nor3_1
Xfanout118 _08401_/B _08235_/Y VPWR VGND sg13cmos5l_buf_1
Xfanout129 _07879_/B1 _07722_/Y VPWR VGND sg13cmos5l_buf_1
X_06933_ _07028_/B _06933_/A _06933_/B VPWR VGND sg13cmos5l_and2_1
XFILLER_41_1026 VPWR VGND sg13cmos5l_fill_2
X_06864_ _06864_/Y _07385_/A _06883_/B VPWR VGND sg13cmos5l_nand2_1
X_05815_ _05815_/Y _05814_/A _05815_/B VPWR VGND sg13cmos5l_nand2b_1
X_08603_ _09243_/D _08603_/A _08603_/B VPWR VGND sg13cmos5l_nor2_1
X_09583_ _09583_/Q _09586_/CLK _09583_/D _09583_/RESET_B VPWR VGND sg13cmos5l_dfrbpq_1
X_06795_ _06795_/Y _06789_/Y _06791_/Y _06794_/Y VPWR VGND sg13cmos5l_o21ai_1
X_05746_ _05746_/Y _05746_/A _05746_/B _05746_/C VPWR VGND sg13cmos5l_nor3_1
X_08534_ _09224_/D _08603_/B _08534_/B VPWR VGND sg13cmos5l_nor2_1
X_08465_ _08465_/Y _08461_/A _08476_/C _08465_/C VPWR VGND sg13cmos5l_nand3b_1
X_05677_ _09379_/D _05677_/A _05676_/Y VPWR VGND sg13cmos5l_nor2b_1
X_07416_ _07416_/Y _07416_/A _07416_/B _07416_/C _07416_/D VPWR VGND sg13cmos5l_nand4_1
X_09151__322 _09151_/RESET_B VPWR VGND sg13cmos5l_tiehi
X_08396_ _09210_/D _08396_/A _08397_/B VPWR VGND sg13cmos5l_and2_1
X_07347_ _07347_/Y _07347_/A _07347_/B VPWR VGND sg13cmos5l_nor2_1
XFILLER_12_45 VPWR VGND sg13cmos5l_fill_2
X_07278_ _09035_/D _07386_/B _07426_/A VPWR VGND sg13cmos5l_and2_1
X_09017_ hold922/A clkload8/A hold924/X _09017_/RESET_B VPWR VGND sg13cmos5l_dfrbpq_1
X_09012__473 _09012_/RESET_B VPWR VGND sg13cmos5l_tiehi
XFILLER_3_816 VPWR VGND sg13cmos5l_fill_1
XFILLER_2_304 VPWR VGND sg13cmos5l_fill_2
X_06229_ _06278_/A _09471_/Q _06243_/B VPWR VGND sg13cmos5l_xnor2_1
X_09424__685 _09424_/RESET_B VPWR VGND sg13cmos5l_tiehi
XFILLER_46_514 VPWR VGND sg13cmos5l_fill_2
XFILLER_46_503 VPWR VGND sg13cmos5l_decap_8
XFILLER_46_558 VPWR VGND sg13cmos5l_fill_2
XFILLER_42_720 VPWR VGND sg13cmos5l_fill_1
X_05600_ _05601_/B _09335_/Q _09334_/Q _09336_/Q VPWR VGND sg13cmos5l_o21ai_1
X_06580_ _06628_/A _09553_/Q _06581_/B VPWR VGND sg13cmos5l_xnor2_1
X_05531_ _05531_/Y hold869/X _06469_/A VPWR VGND sg13cmos5l_nand2b_1
X_08250_ _08285_/A _08259_/B _08256_/C VPWR VGND sg13cmos5l_nand2_1
X_05462_ _05503_/A _05502_/B _05502_/C _05502_/A VPWR VGND sg13cmos5l_a21oi_1
X_08181_ _08181_/Y _08177_/Y _08179_/Y _08180_/Y VPWR VGND sg13cmos5l_o21ai_1
X_09230__839 _09230_/RESET_B VPWR VGND sg13cmos5l_tiehi
XFILLER_20_425 VPWR VGND sg13cmos5l_fill_2
X_07201_ _09020_/D _04936_/Y fanout54/X _07200_/Y VPWR VGND sg13cmos5l_a21oi_1
X_07132_ _07132_/Y _07159_/B _07128_/Y _07131_/Y VPWR VGND sg13cmos5l_a21oi_1
XFILLER_9_470 VPWR VGND sg13cmos5l_fill_1
X_05393_ _05411_/B _09364_/Q _04992_/Y _05392_/Y VPWR VGND sg13cmos5l_a21oi_1
X_07063_ _07063_/Y _07012_/Y _07069_/S _07071_/B1 VPWR VGND sg13cmos5l_o21ai_1
X_06014_ _06014_/Y _06014_/A _06014_/B VPWR VGND sg13cmos5l_nor2_1
X_07965_ _07965_/Y _07945_/A _07959_/Y _07890_/B VPWR VGND sg13cmos5l_o21ai_1
X_09378__735 _09378_/RESET_B VPWR VGND sg13cmos5l_tiehi
X_06916_ _06927_/S _06920_/A _06923_/C VPWR VGND sg13cmos5l_nand2_1
X_07896_ _07932_/A hold916/X hold874/X VPWR VGND sg13cmos5l_nand2_1
X_06847_ _06847_/Y _06880_/A _06839_/Y _06884_/A _06856_/B VPWR VGND sg13cmos5l_a22oi_1
X_09566_ _09566_/Q clkload17/A _09566_/D _09566_/RESET_B VPWR VGND sg13cmos5l_dfrbpq_1
X_06778_ _06799_/B _06802_/A _06776_/B _06774_/Y _06777_/Y VPWR VGND sg13cmos5l_a22oi_1
X_05729_ _05729_/Y _05725_/Y _05727_/X _05728_/Y VPWR VGND sg13cmos5l_o21ai_1
X_08517_ _08536_/S _08530_/B _08530_/C VPWR VGND sg13cmos5l_nand2_1
XFILLER_23_241 VPWR VGND sg13cmos5l_fill_2
X_09497_ _09497_/Q _09586_/CLK _09497_/D _09497_/RESET_B VPWR VGND sg13cmos5l_dfrbpq_1
XFILLER_11_414 VPWR VGND sg13cmos5l_fill_2
X_08448_ _08448_/Y _08442_/A _08442_/B _08451_/A _08451_/B VPWR VGND sg13cmos5l_a22oi_1
XFILLER_8_908 VPWR VGND sg13cmos5l_fill_2
XFILLER_8_919 VPWR VGND sg13cmos5l_fill_2
X_08379_ _08379_/Y _08359_/Y _08378_/B _08378_/Y VPWR VGND sg13cmos5l_o21ai_1
X_09385__728 _09385_/RESET_B VPWR VGND sg13cmos5l_tiehi
X_09086__393 _09086_/RESET_B VPWR VGND sg13cmos5l_tiehi
XFILLER_46_388 VPWR VGND sg13cmos5l_fill_1
XFILLER_15_775 VPWR VGND sg13cmos5l_fill_1
XFILLER_42_594 VPWR VGND sg13cmos5l_decap_4
XFILLER_6_440 VPWR VGND sg13cmos5l_fill_2
XFILLER_10_491 VPWR VGND sg13cmos5l_decap_4
Xhold908 hold908/X hold908/A VPWR VGND sg13cmos5l_dlygate4sd3_1
Xhold919 hold919/X hold919/A VPWR VGND sg13cmos5l_dlygate4sd3_1
XFILLER_6_495 VPWR VGND sg13cmos5l_fill_2
XFILLER_9_1015 VPWR VGND sg13cmos5l_fill_1
X_09141__332 _09141_/RESET_B VPWR VGND sg13cmos5l_tiehi
X_07750_ _07780_/B _08148_/A _07750_/B VPWR VGND sg13cmos5l_xnor2_1
X_04962_ _04962_/Y _04962_/A VPWR VGND sg13cmos5l_inv_1
X_06701_ _06701_/Y _09495_/Q _06705_/B VPWR VGND sg13cmos5l_nand2_1
X_04893_ _07999_/A _09151_/Q VPWR VGND sg13cmos5l_inv_1
X_07681_ _07682_/B _07640_/Y _07691_/B VPWR VGND sg13cmos5l_nand2b_1
X_06632_ _06802_/A _06591_/X _06629_/B _06933_/A VPWR VGND sg13cmos5l_o21ai_1
X_09420_ hold973/A clkload22/A hold975/X _09420_/RESET_B VPWR VGND sg13cmos5l_dfrbpq_1
X_06563_ _06564_/C _09517_/Q _09518_/Q hold1343/X VPWR VGND sg13cmos5l_o21ai_1
X_09351_ hold856/A _09387_/CLK _09351_/D _09351_/RESET_B VPWR VGND sg13cmos5l_dfrbpq_1
X_08302_ _08302_/Y _09158_/Q _09157_/Q _08313_/B VPWR VGND sg13cmos5l_nor3_1
X_09282_ _09282_/Q _09288_/CLK _09282_/D _09282_/RESET_B VPWR VGND sg13cmos5l_dfrbpq_1
X_05514_ _05516_/C _05514_/A _05528_/A VPWR VGND sg13cmos5l_nor2_1
X_06494_ _06518_/A _06534_/B VPWR VGND sg13cmos5l_inv_1
X_08233_ _09183_/D _08217_/A _08232_/Y _08231_/A VPWR VGND sg13cmos5l_a21oi_1
X_05445_ _09355_/D _05445_/A _05448_/B VPWR VGND sg13cmos5l_nor2_1
X_05376_ _05478_/D _05376_/A _05376_/B _05376_/C VPWR VGND sg13cmos5l_nand3_1
X_08164_ _08166_/A _09176_/Q _08169_/A _08207_/A VPWR VGND sg13cmos5l_a21o_1
X_07115_ _07137_/B _09009_/Q _07128_/A VPWR VGND sg13cmos5l_nor2b_1
X_08095_ _08095_/Y _08401_/A _09126_/Q _09125_/Q _08400_/A _08094_/Y VPWR VGND sg13cmos5l_a221oi_1
X_07046_ _07049_/A _07046_/A _07052_/B _07046_/C VPWR VGND sg13cmos5l_nor3_1
XFILLER_47_1021 VPWR VGND sg13cmos5l_decap_8
X_08997_ _09316_/D _08997_/A _08997_/B VPWR VGND sg13cmos5l_and2_1
XFILLER_29_801 VPWR VGND sg13cmos5l_fill_1
X_07948_ _07949_/C _07948_/A _07948_/B _07948_/C VPWR VGND sg13cmos5l_and3_1
X_07879_ _07879_/Y _04943_/Y _07864_/B _07879_/B1 VPWR VGND sg13cmos5l_a21oi_1
XFILLER_18_55 VPWR VGND sg13cmos5l_fill_2
XFILLER_28_399 VPWR VGND sg13cmos5l_fill_2
X_09549_ _09549_/Q clkload24/A _09549_/D _09549_/RESET_B VPWR VGND sg13cmos5l_dfrbpq_1
XFILLER_11_266 VPWR VGND sg13cmos5l_fill_2
XFILLER_3_410 VPWR VGND sg13cmos5l_fill_1
XFILLER_3_454 VPWR VGND sg13cmos5l_fill_1
XFILLER_3_487 VPWR VGND sg13cmos5l_fill_2
XFILLER_1_0 VPWR VGND sg13cmos5l_fill_1
X_09368__745 _09368_/RESET_B VPWR VGND sg13cmos5l_tiehi
XFILLER_30_586 VPWR VGND sg13cmos5l_fill_1
X_05230_ _05231_/C _05230_/A _05230_/B _05230_/C VPWR VGND sg13cmos5l_and3_1
X_05161_ _08750_/A _09001_/A _05163_/B VPWR VGND sg13cmos5l_nand2_1
X_09229__841 _09229_/RESET_B VPWR VGND sg13cmos5l_tiehi
X_05092_ _05093_/B _09289_/Q _09290_/Q hold1424/X VPWR VGND sg13cmos5l_o21ai_1
X_08920_ _08921_/B _08891_/Y _08892_/A _08924_/S VPWR VGND sg13cmos5l_mux2_1
X_08851_ _08897_/C hold994/A hold892/A _09278_/Q VPWR VGND sg13cmos5l_nand3_1
X_07802_ _07802_/Y _09081_/Q _07802_/B VPWR VGND sg13cmos5l_xnor2_1
Xhold1416 _07740_/A _09109_/Q VPWR VGND sg13cmos5l_dlygate4sd3_1
Xhold1405 _05707_/A _09394_/Q VPWR VGND sg13cmos5l_dlygate4sd3_1
X_08782_ _09260_/D _08782_/A _08783_/B VPWR VGND sg13cmos5l_nor2_1
X_05994_ _05994_/Y _05994_/A _05994_/B _05994_/C _05994_/D VPWR VGND sg13cmos5l_nand4_1
Xhold1427 _06935_/A _09592_/Q VPWR VGND sg13cmos5l_dlygate4sd3_1
X_09375__738 _09375_/RESET_B VPWR VGND sg13cmos5l_tiehi
X_07733_ _07733_/Y _08087_/A _07780_/A VPWR VGND sg13cmos5l_nand2_1
X_04945_ _04945_/Y _04945_/A VPWR VGND sg13cmos5l_inv_1
X_07664_ _07664_/Y _07664_/A _07664_/B _07664_/C _07664_/D VPWR VGND sg13cmos5l_nand4_1
X_04876_ _05028_/B input9/X VPWR VGND sg13cmos5l_inv_1
X_09403_ _09403_/Q clkload21/A _09403_/D _09403_/RESET_B VPWR VGND sg13cmos5l_dfrbpq_1
X_09271__725 _09271_/RESET_B VPWR VGND sg13cmos5l_tiehi
X_06615_ _09518_/D _06627_/A _06615_/B VPWR VGND sg13cmos5l_nor2_1
XFILLER_13_509 VPWR VGND sg13cmos5l_decap_8
X_07595_ _07596_/A _07367_/A _07594_/B _07594_/Y VPWR VGND sg13cmos5l_a21oi_1
X_09334_ _09334_/Q clkload11/A _09334_/D _09334_/RESET_B VPWR VGND sg13cmos5l_dfrbpq_1
X_06546_ _06546_/Y _06534_/Y _06537_/Y _06540_/Y _06545_/Y VPWR VGND sg13cmos5l_a22oi_1
X_06477_ _09510_/D _06477_/A _06477_/B VPWR VGND sg13cmos5l_nor2_1
X_09265_ _09265_/Q clkload7/A _09265_/D _09265_/RESET_B VPWR VGND sg13cmos5l_dfrbpq_1
X_09196_ _09196_/Q clkload2/A _09196_/D _09196_/RESET_B VPWR VGND sg13cmos5l_dfrbpq_1
X_08216_ _08232_/C _08205_/Y _08210_/Y _08215_/X VPWR VGND sg13cmos5l_a21o_1
X_05428_ _05428_/Y _05416_/B _05418_/Y _05262_/Y VPWR VGND sg13cmos5l_o21ai_1
X_05359_ _05359_/Y _05116_/Y _05344_/X _05358_/Y VPWR VGND sg13cmos5l_o21ai_1
X_08147_ _09175_/D _08147_/A _08149_/B VPWR VGND sg13cmos5l_nor2_1
X_08078_ _08178_/C _08046_/Y _08067_/Y _07770_/Y VPWR VGND sg13cmos5l_o21ai_1
X_07029_ _07047_/S _07025_/Y _07027_/Y _07028_/X VPWR VGND sg13cmos5l_a21oi_1
XFILLER_0_468 VPWR VGND sg13cmos5l_fill_2
XFILLER_0_479 VPWR VGND sg13cmos5l_decap_4
X_09083__396 _09083_/RESET_B VPWR VGND sg13cmos5l_tiehi
XFILLER_21_1024 VPWR VGND sg13cmos5l_decap_4
X_09200__270 _09200_/RESET_B VPWR VGND sg13cmos5l_tiehi
XFILLER_43_166 VPWR VGND sg13cmos5l_fill_1
XFILLER_40_862 VPWR VGND sg13cmos5l_fill_1
XFILLER_8_513 VPWR VGND sg13cmos5l_fill_2
XFILLER_8_546 VPWR VGND sg13cmos5l_decap_8
X_09090__389 _09090_/RESET_B VPWR VGND sg13cmos5l_tiehi
X_09131__342 _09131_/RESET_B VPWR VGND sg13cmos5l_tiehi
XFILLER_48_940 VPWR VGND sg13cmos5l_fill_1
XFILLER_19_196 VPWR VGND sg13cmos5l_fill_1
X_06400_ _06400_/Y _06397_/A _06413_/S _06398_/X VPWR VGND sg13cmos5l_o21ai_1
X_07380_ _07380_/Y hold1007/X fanout51/X _07384_/A VPWR VGND sg13cmos5l_o21ai_1
X_06331_ _06333_/B _09511_/Q _09480_/Q _06348_/B VPWR VGND sg13cmos5l_a21oi_1
X_06262_ _06263_/A _06279_/B _06262_/B VPWR VGND sg13cmos5l_nand2b_1
X_09050_ _09050_/Q clkload15/A _09050_/D _09050_/RESET_B VPWR VGND sg13cmos5l_dfrbpq_1
X_05213_ _05213_/Y _05385_/A _05210_/B _05242_/A VPWR VGND sg13cmos5l_a21oi_1
X_08001_ _08001_/X _08007_/B _08007_/C VPWR VGND sg13cmos5l_and2_1
X_06193_ _06193_/Y _06185_/X _06188_/Y _06192_/Y VPWR VGND sg13cmos5l_a21oi_1
X_05144_ _05188_/A _09285_/Q _08997_/A VPWR VGND sg13cmos5l_xnor2_1
X_05075_ _05076_/B hold1321/X _05082_/B VPWR VGND sg13cmos5l_nand2b_1
X_08903_ _08903_/Y _08884_/A _08884_/B _08865_/Y VPWR VGND sg13cmos5l_o21ai_1
Xhold1224 _04970_/A _09495_/Q VPWR VGND sg13cmos5l_dlygate4sd3_1
X_08834_ _08834_/Y _07213_/A fanout47/X _08834_/B1 VPWR VGND sg13cmos5l_o21ai_1
Xhold1213 hold1213/X _09417_/Q VPWR VGND sg13cmos5l_dlygate4sd3_1
Xhold1202 _04853_/A _09400_/Q VPWR VGND sg13cmos5l_dlygate4sd3_1
Xhold1246 _05209_/A _05089_/Y VPWR VGND sg13cmos5l_dlygate4sd3_1
X_08765_ _08765_/Y _08765_/A _08770_/B VPWR VGND sg13cmos5l_nor2_1
XFILLER_39_962 VPWR VGND sg13cmos5l_fill_2
Xhold1235 _04945_/A _09124_/Q VPWR VGND sg13cmos5l_dlygate4sd3_1
Xhold1257 _04948_/A _09087_/Q VPWR VGND sg13cmos5l_dlygate4sd3_1
Xhold1268 _04856_/A _09398_/Q VPWR VGND sg13cmos5l_dlygate4sd3_1
X_07716_ _09105_/D _07716_/A _07716_/B VPWR VGND sg13cmos5l_nor2_1
Xhold1279 hold1279/X _09608_/Q VPWR VGND sg13cmos5l_dlygate4sd3_1
X_05977_ _06015_/B _09429_/Q _05986_/B VPWR VGND sg13cmos5l_nand2_1
X_04928_ _04928_/Y _04928_/A VPWR VGND sg13cmos5l_inv_1
X_08696_ _08696_/Y _08693_/Y _08695_/Y _08681_/Y VPWR VGND sg13cmos5l_o21ai_1
XFILLER_41_615 VPWR VGND sg13cmos5l_fill_1
X_04859_ _06221_/A _04859_/A VPWR VGND sg13cmos5l_inv_1
X_07647_ _07691_/B _09096_/Q _07657_/B VPWR VGND sg13cmos5l_nand2_1
XFILLER_25_155 VPWR VGND sg13cmos5l_fill_2
XFILLER_40_114 VPWR VGND sg13cmos5l_fill_2
X_07578_ _09082_/D _07636_/B _07674_/B VPWR VGND sg13cmos5l_nor2_1
XFILLER_40_147 VPWR VGND sg13cmos5l_fill_1
X_09317_ _09317_/Q clkload7/A _09317_/D _09317_/RESET_B VPWR VGND sg13cmos5l_dfrbpq_1
X_06529_ _06531_/B _06360_/B _06503_/B _06529_/S VPWR VGND sg13cmos5l_mux2_1
X_09566__532 _09566_/RESET_B VPWR VGND sg13cmos5l_tiehi
XFILLER_22_884 VPWR VGND sg13cmos5l_fill_1
X_09248_ _09248_/Q clkload2/A _09248_/D _09248_/RESET_B VPWR VGND sg13cmos5l_dfrbpq_1
X_09179_ _09179_/Q _09312_/CLK _09179_/D _09179_/RESET_B VPWR VGND sg13cmos5l_dfrbpq_1
XFILLER_5_549 VPWR VGND sg13cmos5l_decap_4
Xoutput11 uio_out[1] _10244_/X VPWR VGND sg13cmos5l_buf_1
XFILLER_0_287 VPWR VGND sg13cmos5l_fill_1
X_09358__755 _09358_/RESET_B VPWR VGND sg13cmos5l_tiehi
XFILLER_45_965 VPWR VGND sg13cmos5l_fill_1
XFILLER_16_199 VPWR VGND sg13cmos5l_fill_1
XFILLER_31_125 VPWR VGND sg13cmos5l_fill_1
XFILLER_8_310 VPWR VGND sg13cmos5l_fill_2
XFILLER_12_372 VPWR VGND sg13cmos5l_fill_1
XFILLER_12_394 VPWR VGND sg13cmos5l_fill_2
X_09365__748 _09365_/RESET_B VPWR VGND sg13cmos5l_tiehi
X_05900_ _05997_/D _05864_/B _05903_/C _05903_/A VPWR VGND sg13cmos5l_nand3b_1
XFILLER_39_225 VPWR VGND sg13cmos5l_fill_1
X_06880_ _06880_/Y _06880_/A _07307_/A VPWR VGND sg13cmos5l_nor2_1
X_05831_ _05831_/X _09435_/Q _05842_/B VPWR VGND sg13cmos5l_and2_1
X_08550_ _08552_/A _09248_/Q _04928_/Y _08549_/Y VPWR VGND sg13cmos5l_o21ai_1
X_05762_ _05762_/X _05780_/A _05762_/B VPWR VGND sg13cmos5l_or2_1
X_07501_ _07501_/Y _07501_/A _07528_/B VPWR VGND sg13cmos5l_nor2_1
X_08481_ _08529_/A _08494_/A VPWR VGND sg13cmos5l_inv_1
X_05693_ _09388_/D _05693_/A hold872/X VPWR VGND sg13cmos5l_and2_1
XFILLER_36_998 VPWR VGND sg13cmos5l_fill_1
X_07432_ _07434_/A _07446_/B _07432_/B VPWR VGND sg13cmos5l_nor2_1
XFILLER_35_486 VPWR VGND sg13cmos5l_fill_1
X_09102_ _09102_/Q clkload15/A _09102_/D _09102_/RESET_B VPWR VGND sg13cmos5l_dfrbpq_1
X_07363_ _07363_/Y _07340_/Y fanout33/X _07386_/B VPWR VGND sg13cmos5l_o21ai_1
X_07294_ _07294_/X _07295_/A _07295_/B VPWR VGND sg13cmos5l_and2_1
X_06314_ _06335_/A _09514_/Q _09513_/Q _09512_/Q VPWR VGND sg13cmos5l_nor3_1
X_09033_ _09033_/Q _09565_/CLK _09033_/D _09033_/RESET_B VPWR VGND sg13cmos5l_dfrbpq_1
X_06245_ _06259_/A _06279_/B _06245_/B VPWR VGND sg13cmos5l_nand2b_1
X_06176_ _06177_/B _06176_/A _09421_/Q VPWR VGND sg13cmos5l_nor2_1
X_05127_ _05196_/B _05199_/B _05125_/B _05122_/Y VPWR VGND sg13cmos5l_a21o_1
X_05058_ _05059_/C hold912/A hold915/A hold957/A _05058_/D VPWR VGND sg13cmos5l_nor4_1
Xhold1021 _07624_/B _09051_/Q VPWR VGND sg13cmos5l_dlygate4sd3_1
X_08817_ _08818_/B hold1030/X _08823_/S _08842_/B VPWR VGND sg13cmos5l_o21ai_1
Xhold1032 _04869_/A _09514_/Q VPWR VGND sg13cmos5l_dlygate4sd3_1
Xhold1010 _08841_/A _09029_/Q VPWR VGND sg13cmos5l_dlygate4sd3_1
Xhold1076 _07155_/A _09027_/Q VPWR VGND sg13cmos5l_dlygate4sd3_1
X_09080__399 _09080_/RESET_B VPWR VGND sg13cmos5l_tiehi
Xhold1054 _07588_/B _09050_/Q VPWR VGND sg13cmos5l_dlygate4sd3_1
Xhold1043 _07094_/B _07093_/Y VPWR VGND sg13cmos5l_dlygate4sd3_1
Xhold1065 _09269_/D _08828_/Y VPWR VGND sg13cmos5l_dlygate4sd3_1
X_08748_ _08761_/B _08738_/Y _08743_/Y _08747_/Y VPWR VGND sg13cmos5l_a21oi_1
Xhold1098 _06936_/A _09573_/Q VPWR VGND sg13cmos5l_dlygate4sd3_1
XFILLER_27_954 VPWR VGND sg13cmos5l_fill_1
Xhold1087 _04975_/A _09456_/Q VPWR VGND sg13cmos5l_dlygate4sd3_1
X_08679_ _08679_/Y _08679_/A _08699_/B VPWR VGND sg13cmos5l_nand2_1
XFILLER_41_412 VPWR VGND sg13cmos5l_fill_2
XFILLER_10_898 VPWR VGND sg13cmos5l_fill_2
XFILLER_5_379 VPWR VGND sg13cmos5l_fill_1
XFILLER_49_501 VPWR VGND sg13cmos5l_decap_8
XFILLER_49_567 VPWR VGND sg13cmos5l_decap_8
XFILLER_49_556 VPWR VGND sg13cmos5l_fill_2
XFILLER_49_545 VPWR VGND sg13cmos5l_decap_8
XFILLER_45_773 VPWR VGND sg13cmos5l_fill_2
XFILLER_33_979 VPWR VGND sg13cmos5l_fill_2
X_06030_ _06045_/B _06030_/A _06030_/B VPWR VGND sg13cmos5l_nor2_1
X_07981_ _07982_/C _07991_/C _07979_/B _08021_/A VPWR VGND sg13cmos5l_a21oi_1
Xfanout119 _08397_/B _08234_/Y VPWR VGND sg13cmos5l_buf_1
Xfanout108 _05078_/B _05082_/B VPWR VGND sg13cmos5l_buf_1
X_06932_ _09566_/D _06932_/A _06932_/B VPWR VGND sg13cmos5l_nor2_1
X_09556__542 _09556_/RESET_B VPWR VGND sg13cmos5l_tiehi
X_06863_ _06881_/S _06876_/B _06876_/C VPWR VGND sg13cmos5l_nand2_1
X_05814_ _05814_/Y _05814_/A _05815_/B VPWR VGND sg13cmos5l_nor2b_1
X_08602_ _09242_/D _08602_/A _08603_/B VPWR VGND sg13cmos5l_nor2_1
X_09582_ _09582_/Q _09586_/CLK _09582_/D _09582_/RESET_B VPWR VGND sg13cmos5l_dfrbpq_1
X_06794_ _06794_/Y _06780_/B _06794_/B VPWR VGND sg13cmos5l_nand2b_1
X_05745_ _05745_/X _05580_/B _05628_/B _05754_/S VPWR VGND sg13cmos5l_mux2_1
X_08533_ _08534_/B _08667_/A _08667_/B VPWR VGND sg13cmos5l_and2_1
XFILLER_36_762 VPWR VGND sg13cmos5l_fill_1
X_09417__693 _09417_/RESET_B VPWR VGND sg13cmos5l_tiehi
X_08464_ _08465_/C _08464_/A _08476_/B VPWR VGND sg13cmos5l_or2_1
X_05676_ _05676_/Y _05654_/Y _05675_/B _05776_/A VPWR VGND sg13cmos5l_a21oi_1
X_07415_ _07415_/Y _07415_/A _07415_/B _07415_/C _07415_/D VPWR VGND sg13cmos5l_nand4_1
X_08395_ _09209_/D _08994_/A hold871/X VPWR VGND sg13cmos5l_and2_1
X_07346_ _07346_/Y _09046_/Q _07345_/Y hold971/A VPWR VGND sg13cmos5l_o21ai_1
X_09563__535 _09563_/RESET_B VPWR VGND sg13cmos5l_tiehi
X_07277_ _07426_/A _07246_/Y _07276_/Y _07277_/S VPWR VGND sg13cmos5l_mux2_1
X_09016_ _09016_/Q _09288_/CLK _09016_/D _09016_/RESET_B VPWR VGND sg13cmos5l_dfrbpq_1
X_06228_ _06288_/A _06228_/A _06243_/B VPWR VGND sg13cmos5l_nand2_1
X_06159_ _06159_/X _05848_/Y _06122_/Y _06162_/S VPWR VGND sg13cmos5l_mux2_1
XFILLER_2_1021 VPWR VGND sg13cmos5l_decap_8
X_09570__528 _09570_/RESET_B VPWR VGND sg13cmos5l_tiehi
XFILLER_18_228 VPWR VGND sg13cmos5l_fill_1
XFILLER_37_54 VPWR VGND sg13cmos5l_fill_1
X_09355__758 _09355_/RESET_B VPWR VGND sg13cmos5l_tiehi
XFILLER_26_261 VPWR VGND sg13cmos5l_fill_2
XFILLER_6_655 VPWR VGND sg13cmos5l_fill_2
XFILLER_37_515 VPWR VGND sg13cmos5l_fill_1
XFILLER_33_721 VPWR VGND sg13cmos5l_fill_2
X_05530_ _05530_/Y _07721_/A hold869/X VPWR VGND sg13cmos5l_nor2_1
X_05461_ _05502_/C _09356_/Q _05466_/B _05471_/A VPWR VGND sg13cmos5l_o21ai_1
X_08180_ _08180_/Y _08035_/Y _08186_/A _08182_/B _08208_/A VPWR VGND sg13cmos5l_a22oi_1
X_07200_ _07200_/Y hold952/X fanout54/X _08479_/B VPWR VGND sg13cmos5l_o21ai_1
X_05392_ _05392_/Y _05701_/A _09307_/Q _09306_/Q _05700_/A _05391_/Y VPWR VGND sg13cmos5l_a221oi_1
X_07131_ _07131_/Y _07154_/A _07129_/Y _07130_/Y VPWR VGND sg13cmos5l_a21oi_1
X_07062_ _07062_/Y _07057_/Y _07073_/A _07073_/B VPWR VGND sg13cmos5l_o21ai_1
X_06013_ _06014_/B _05836_/B _05890_/B _06025_/B VPWR VGND sg13cmos5l_mux2_1
X_07964_ _09141_/D _07964_/A _07963_/Y VPWR VGND sg13cmos5l_nor2b_1
X_07895_ _09139_/D _07895_/A _07895_/B VPWR VGND sg13cmos5l_nor2_1
X_06915_ _06923_/C _06908_/Y _06911_/Y _06913_/Y VPWR VGND sg13cmos5l_a21o_1
X_06846_ _06883_/A _07389_/A _06846_/B VPWR VGND sg13cmos5l_xnor2_1
XFILLER_43_529 VPWR VGND sg13cmos5l_fill_2
X_09565_ _09565_/Q _09565_/CLK _09565_/D _09565_/RESET_B VPWR VGND sg13cmos5l_dfrbpq_1
X_06777_ _06777_/Y _06777_/A _06777_/B VPWR VGND sg13cmos5l_nor2_1
X_05728_ _05728_/Y _05585_/B _05632_/X _05737_/A _05730_/A VPWR VGND sg13cmos5l_a22oi_1
X_08516_ _08539_/C _09228_/Q _08516_/B VPWR VGND sg13cmos5l_xor2_1
X_09496_ _09496_/Q clkload24/A _09496_/D _09496_/RESET_B VPWR VGND sg13cmos5l_dfrbpq_1
X_08447_ _08451_/B _08288_/B _08336_/B _08456_/B VPWR VGND sg13cmos5l_mux2_1
X_05659_ _05659_/Y _09379_/Q _05654_/Y _05658_/Y _09380_/Q VPWR VGND sg13cmos5l_a22oi_1
X_08378_ _08378_/Y _08378_/A _08378_/B VPWR VGND sg13cmos5l_nand2_1
X_07329_ _09043_/D _07463_/A _07329_/B VPWR VGND sg13cmos5l_nor2_1
XFILLER_3_647 VPWR VGND sg13cmos5l_fill_2
XFILLER_0_16 VPWR VGND sg13cmos5l_fill_2
Xfanout90 _07412_/B _07394_/Y VPWR VGND sg13cmos5l_buf_1
XFILLER_7_953 VPWR VGND sg13cmos5l_decap_4
XFILLER_7_942 VPWR VGND sg13cmos5l_fill_1
XFILLER_7_931 VPWR VGND sg13cmos5l_fill_1
XFILLER_11_993 VPWR VGND sg13cmos5l_fill_2
X_09546__552 _09546_/RESET_B VPWR VGND sg13cmos5l_tiehi
XFILLER_6_463 VPWR VGND sg13cmos5l_fill_1
Xhold909 hold909/X hold909/A VPWR VGND sg13cmos5l_dlygate4sd3_1
X_04961_ _06969_/A _04961_/A VPWR VGND sg13cmos5l_inv_1
X_06700_ _06700_/Y _06713_/A _06695_/Y _06699_/Y VPWR VGND sg13cmos5l_o21ai_1
X_04892_ _08401_/A _07997_/B VPWR VGND sg13cmos5l_inv_1
X_07680_ _07680_/Y _07680_/A _07680_/B VPWR VGND sg13cmos5l_nor2_1
X_09553__545 _09553_/RESET_B VPWR VGND sg13cmos5l_tiehi
X_06631_ _09521_/D _06737_/B _06799_/A VPWR VGND sg13cmos5l_and2_1
X_09350_ hold872/A _09387_/CLK _09350_/D _09350_/RESET_B VPWR VGND sg13cmos5l_dfrbpq_1
X_06562_ _06574_/B _09517_/Q _09518_/Q _09519_/Q VPWR VGND sg13cmos5l_or3_1
X_08301_ _08313_/B _09155_/Q _09156_/Q _09153_/Q _09154_/Q VPWR VGND sg13cmos5l_or4_1
X_09281_ _09281_/Q _09288_/CLK _09281_/D _09281_/RESET_B VPWR VGND sg13cmos5l_dfrbpq_1
X_05513_ _05528_/B _05516_/A _05516_/B VPWR VGND sg13cmos5l_nor2_1
X_09414__696 _09414_/RESET_B VPWR VGND sg13cmos5l_tiehi
X_06493_ _06534_/B _06544_/B _06493_/B VPWR VGND sg13cmos5l_nor2_1
X_08232_ _08232_/Y _08232_/A _08232_/B _08232_/C VPWR VGND sg13cmos5l_nand3_1
XFILLER_20_245 VPWR VGND sg13cmos5l_fill_1
X_05444_ _09354_/D _08945_/A _05448_/B VPWR VGND sg13cmos5l_nor2_1
X_05375_ _05478_/C _05379_/A _05379_/C _05184_/Y VPWR VGND sg13cmos5l_o21ai_1
X_08163_ _08207_/A _08206_/B _08206_/C _08206_/A VPWR VGND sg13cmos5l_a21oi_1
X_07114_ _07128_/A _09008_/Q _09006_/Q _09007_/Q VPWR VGND sg13cmos5l_nor3_1
X_08094_ _08094_/Y _09182_/Q _04944_/Y _04945_/Y _09181_/Q _08093_/Y VPWR VGND sg13cmos5l_a221oi_1
X_09560__538 _09560_/RESET_B VPWR VGND sg13cmos5l_tiehi
X_07045_ _07046_/C _07045_/A _07045_/B _07045_/C VPWR VGND sg13cmos5l_and3_1
X_08996_ _09315_/D _08996_/A _09001_/B VPWR VGND sg13cmos5l_nor2_1
X_07947_ _07947_/Y _07967_/A _07944_/B _07943_/Y _07946_/Y VPWR VGND sg13cmos5l_a22oi_1
X_09421__689 _09421_/RESET_B VPWR VGND sg13cmos5l_tiehi
X_07878_ _07878_/Y _07878_/A _07878_/B VPWR VGND sg13cmos5l_nor2_1
XFILLER_18_45 VPWR VGND sg13cmos5l_fill_1
X_06829_ _06840_/C _09555_/Q _09556_/Q _09557_/Q VPWR VGND sg13cmos5l_o21ai_1
X_09548_ _09548_/Q clkload23/A _09548_/D _09548_/RESET_B VPWR VGND sg13cmos5l_dfrbpq_1
X_09479_ _09479_/Q _09491_/CLK _09479_/D _09479_/RESET_B VPWR VGND sg13cmos5l_dfrbpq_1
XFILLER_11_212 VPWR VGND sg13cmos5l_fill_2
XFILLER_11_234 VPWR VGND sg13cmos5l_fill_2
XFILLER_12_768 VPWR VGND sg13cmos5l_fill_1
XFILLER_7_249 VPWR VGND sg13cmos5l_fill_2
XFILLER_4_901 VPWR VGND sg13cmos5l_fill_2
XFILLER_4_923 VPWR VGND sg13cmos5l_fill_2
X_09576__512 _09576_/RESET_B VPWR VGND sg13cmos5l_tiehi
XFILLER_46_131 VPWR VGND sg13cmos5l_fill_1
XFILLER_34_315 VPWR VGND sg13cmos5l_fill_2
X_05160_ _08751_/A _09001_/A _05163_/B VPWR VGND sg13cmos5l_and2_1
X_05091_ _05355_/A _09323_/Q _09322_/Q VPWR VGND sg13cmos5l_xnor2_1
X_08850_ _08897_/B _09277_/Q _08850_/B VPWR VGND sg13cmos5l_nand2_1
X_07801_ _07829_/B _09081_/Q _07802_/B VPWR VGND sg13cmos5l_xor2_1
Xhold1406 _05759_/C _05758_/X VPWR VGND sg13cmos5l_dlygate4sd3_1
X_08781_ _09259_/D _08889_/A _08784_/C VPWR VGND sg13cmos5l_nor2_1
X_05993_ _05993_/Y _05993_/A _05993_/B _05993_/C _05993_/D VPWR VGND sg13cmos5l_nand4_1
Xhold1417 _08325_/A _09153_/Q VPWR VGND sg13cmos5l_dlygate4sd3_1
Xhold1428 hold1428/X _09603_/Q VPWR VGND sg13cmos5l_dlygate4sd3_1
X_07732_ _07732_/Y _09113_/Q _07732_/B VPWR VGND sg13cmos5l_xnor2_1
X_04944_ _04944_/Y _09125_/Q VPWR VGND sg13cmos5l_inv_1
X_07663_ _07680_/A _07663_/A _07663_/B VPWR VGND sg13cmos5l_nand2_1
X_04875_ _04875_/Y _06736_/A VPWR VGND sg13cmos5l_inv_1
XFILLER_19_890 VPWR VGND sg13cmos5l_fill_2
X_06614_ _06615_/B _06768_/A _06768_/B VPWR VGND sg13cmos5l_and2_1
X_09402_ _09402_/Q clkload19/A _09402_/D _09402_/RESET_B VPWR VGND sg13cmos5l_dfrbpq_1
X_09333_ _09333_/Q clkload11/A _09333_/D _09333_/RESET_B VPWR VGND sg13cmos5l_dfrbpq_1
X_07594_ _07594_/Y _09104_/Q _07594_/B VPWR VGND sg13cmos5l_nor2_1
X_06545_ _06545_/Y _06545_/A VPWR VGND sg13cmos5l_inv_1
X_06476_ _09509_/D _06476_/A _06477_/B VPWR VGND sg13cmos5l_nor2_1
X_09264_ _09264_/Q clkload7/A _09264_/D _09264_/RESET_B VPWR VGND sg13cmos5l_dfrbpq_1
X_09195_ _09195_/Q clkload4/A _09195_/D _09195_/RESET_B VPWR VGND sg13cmos5l_dfrbpq_1
X_08215_ _08215_/X _08217_/A _08232_/B _08214_/Y VPWR VGND sg13cmos5l_a21o_1
X_05427_ _09343_/D _04989_/Y _05421_/B _05426_/Y VPWR VGND sg13cmos5l_a21oi_1
X_08146_ _09174_/D _08146_/A _08149_/B VPWR VGND sg13cmos5l_nor2_1
X_05358_ _05358_/Y _05366_/A _05366_/B VPWR VGND sg13cmos5l_nand2_1
XFILLER_20_24 VPWR VGND sg13cmos5l_fill_2
X_08077_ _09154_/D _08081_/A _08077_/B VPWR VGND sg13cmos5l_nor2_1
XFILLER_20_68 VPWR VGND sg13cmos5l_fill_2
X_05289_ _05617_/A _05700_/A _05289_/B VPWR VGND sg13cmos5l_xnor2_1
X_07028_ _07028_/X _07057_/A _07028_/B VPWR VGND sg13cmos5l_and2_1
XFILLER_29_621 VPWR VGND sg13cmos5l_fill_1
X_08979_ _08979_/Y _08960_/Y fanout35/X _05248_/Y VPWR VGND sg13cmos5l_o21ai_1
X_09276__604 _09276_/RESET_B VPWR VGND sg13cmos5l_tiehi
XFILLER_44_624 VPWR VGND sg13cmos5l_fill_1
XFILLER_44_657 VPWR VGND sg13cmos5l_fill_2
XFILLER_6_48 VPWR VGND sg13cmos5l_fill_1
X_09543__555 _09543_/RESET_B VPWR VGND sg13cmos5l_tiehi
X_09259__802 _09259_/RESET_B VPWR VGND sg13cmos5l_tiehi
XFILLER_19_120 VPWR VGND sg13cmos5l_fill_1
X_09550__548 _09550_/RESET_B VPWR VGND sg13cmos5l_tiehi
XFILLER_34_178 VPWR VGND sg13cmos5l_fill_1
X_06330_ _06348_/B _09480_/Q _09479_/Q VPWR VGND sg13cmos5l_xor2_1
XFILLER_31_852 VPWR VGND sg13cmos5l_fill_2
X_09411__699 _09411_/RESET_B VPWR VGND sg13cmos5l_tiehi
XFILLER_30_362 VPWR VGND sg13cmos5l_fill_1
X_06261_ _06261_/X _06261_/A _06261_/B VPWR VGND sg13cmos5l_xor2_1
X_05212_ _05212_/Y _08935_/A _05204_/Y _05211_/Y VPWR VGND sg13cmos5l_a21oi_1
X_08000_ _08007_/C _07999_/B _07999_/C _07999_/A VPWR VGND sg13cmos5l_a21o_1
XFILLER_30_395 VPWR VGND sg13cmos5l_fill_2
X_06192_ _06192_/Y _04974_/Y _06187_/Y _06191_/Y VPWR VGND sg13cmos5l_o21ai_1
X_05143_ _05143_/Y _08999_/A _05143_/B VPWR VGND sg13cmos5l_xnor2_1
X_09381__732 _09381_/RESET_B VPWR VGND sg13cmos5l_tiehi
X_05074_ _05076_/A _09319_/Q _05078_/B _05237_/A VPWR VGND sg13cmos5l_a21o_1
X_08902_ _08902_/Y _08892_/Y _08896_/Y _08899_/A _08900_/X _08901_/Y VPWR VGND sg13cmos5l_a221oi_1
Xhold1203 hold1203/X _09339_/Q VPWR VGND sg13cmos5l_dlygate4sd3_1
Xhold1225 _07855_/A _09086_/Q VPWR VGND sg13cmos5l_dlygate4sd3_1
Xhold1214 _06586_/B _09554_/Q VPWR VGND sg13cmos5l_dlygate4sd3_1
X_08833_ _09272_/D _04816_/Y fanout47/X _08832_/Y VPWR VGND sg13cmos5l_a21oi_1
Xhold1247 hold1247/X _05210_/B VPWR VGND sg13cmos5l_dlygate4sd3_1
X_08764_ _08870_/B _05188_/Y _08764_/B VPWR VGND sg13cmos5l_nand2b_1
Xhold1258 _04863_/A _09436_/Q VPWR VGND sg13cmos5l_dlygate4sd3_1
Xhold1236 _04955_/A _09047_/Q VPWR VGND sg13cmos5l_dlygate4sd3_1
X_05976_ _06008_/B _05986_/A _05986_/B VPWR VGND sg13cmos5l_and2_1
XFILLER_39_996 VPWR VGND sg13cmos5l_fill_2
XFILLER_39_985 VPWR VGND sg13cmos5l_fill_1
X_04927_ _08371_/A _08572_/A VPWR VGND sg13cmos5l_inv_1
X_07715_ _07716_/B _07680_/A _07679_/Y _07715_/S VPWR VGND sg13cmos5l_mux2_1
Xhold1269 _05026_/B _09602_/Q VPWR VGND sg13cmos5l_dlygate4sd3_1
XFILLER_38_451 VPWR VGND sg13cmos5l_fill_2
X_08695_ _08695_/Y _08681_/A _08681_/B _08694_/X VPWR VGND sg13cmos5l_o21ai_1
X_07646_ _07691_/A _09098_/Q _07661_/B VPWR VGND sg13cmos5l_xnor2_1
X_04858_ _05968_/A _05651_/A VPWR VGND sg13cmos5l_inv_1
X_07577_ _07674_/B _07577_/A _07577_/B VPWR VGND sg13cmos5l_and2_1
X_06528_ _06528_/Y _06531_/A VPWR VGND sg13cmos5l_inv_1
X_09316_ _09316_/Q clkload7/A _09316_/D _09316_/RESET_B VPWR VGND sg13cmos5l_dfrbpq_1
X_09247_ _09247_/Q _09595_/CLK _09247_/D _09247_/RESET_B VPWR VGND sg13cmos5l_dfrbpq_1
XFILLER_21_373 VPWR VGND sg13cmos5l_fill_2
XFILLER_21_384 VPWR VGND sg13cmos5l_fill_1
X_06459_ _06459_/Y hold1078/X _06447_/Y _06473_/B VPWR VGND sg13cmos5l_o21ai_1
X_09178_ _09178_/Q _09312_/CLK _09178_/D _09178_/RESET_B VPWR VGND sg13cmos5l_dfrbpq_1
XFILLER_5_539 VPWR VGND sg13cmos5l_decap_4
X_08129_ hold981/A _08132_/A _08129_/B _08129_/C VPWR VGND sg13cmos5l_nor3_1
Xoutput12 uio_out[2] _10245_/X VPWR VGND sg13cmos5l_buf_1
X_09306__302 _09306_/RESET_B VPWR VGND sg13cmos5l_tiehi
XFILLER_1_745 VPWR VGND sg13cmos5l_fill_1
XFILLER_45_955 VPWR VGND sg13cmos5l_fill_2
XFILLER_12_340 VPWR VGND sg13cmos5l_fill_2
XFILLER_13_885 VPWR VGND sg13cmos5l_fill_2
XFILLER_8_388 VPWR VGND sg13cmos5l_fill_2
XFILLER_4_561 VPWR VGND sg13cmos5l_fill_1
X_05830_ _05830_/Y _05847_/A _05847_/C VPWR VGND sg13cmos5l_nand2_1
XFILLER_39_237 VPWR VGND sg13cmos5l_fill_2
X_05761_ _05762_/B _05732_/A _05760_/B _05760_/Y VPWR VGND sg13cmos5l_a21oi_1
X_07500_ _07500_/Y _07833_/A _07519_/A VPWR VGND sg13cmos5l_nand2_1
X_08480_ _08494_/A _09247_/Q _08555_/A VPWR VGND sg13cmos5l_xnor2_1
X_05692_ _09387_/D _04838_/Y fanout48/X _05691_/Y VPWR VGND sg13cmos5l_a21oi_1
X_07431_ _07431_/Y _07431_/A _07431_/B VPWR VGND sg13cmos5l_xnor2_1
X_07362_ _07367_/B _07359_/Y _07361_/Y _07342_/Y VPWR VGND sg13cmos5l_o21ai_1
X_06313_ _06369_/A _06341_/A _06365_/A VPWR VGND sg13cmos5l_nor2_1
X_09101_ _09101_/Q clkload15/A _09101_/D _09101_/RESET_B VPWR VGND sg13cmos5l_dfrbpq_1
X_07293_ _07293_/Y _09562_/Q _09563_/Q VPWR VGND sg13cmos5l_xnor2_1
X_09032_ _09032_/Q _09565_/CLK _09032_/D _09032_/RESET_B VPWR VGND sg13cmos5l_dfrbpq_1
X_06244_ _06245_/B _06244_/A _06244_/B VPWR VGND sg13cmos5l_xnor2_1
XFILLER_7_91 VPWR VGND sg13cmos5l_fill_1
X_06175_ _06175_/X _09473_/Q _09416_/Q _06189_/B VPWR VGND sg13cmos5l_mux2_1
X_05126_ _05196_/A _05199_/C _05126_/B _05199_/B VPWR VGND sg13cmos5l_nand3_1
X_05057_ _05058_/D hold991/A hold869/A hold886/A hold898/A VPWR VGND sg13cmos5l_or4_1
Xhold1000 _04931_/A _09197_/Q VPWR VGND sg13cmos5l_dlygate4sd3_1
Xhold1022 _06176_/A _09478_/Q VPWR VGND sg13cmos5l_dlygate4sd3_1
Xhold1011 hold1011/X _09229_/Q VPWR VGND sg13cmos5l_dlygate4sd3_1
X_08816_ _08818_/A _08816_/A _08823_/S VPWR VGND sg13cmos5l_nor2b_1
Xhold1033 _08842_/A _09030_/Q VPWR VGND sg13cmos5l_dlygate4sd3_1
Xhold1044 _06472_/A _09473_/Q VPWR VGND sg13cmos5l_dlygate4sd3_1
Xhold1055 _09050_/D _07374_/Y VPWR VGND sg13cmos5l_dlygate4sd3_1
Xhold1066 _04911_/A _09590_/Q VPWR VGND sg13cmos5l_dlygate4sd3_1
X_08747_ _08747_/Y _08751_/A _08774_/B _08746_/Y VPWR VGND sg13cmos5l_o21ai_1
Xhold1099 _09573_/D _06977_/Y VPWR VGND sg13cmos5l_dlygate4sd3_1
Xhold1077 _04890_/A _09182_/Q VPWR VGND sg13cmos5l_dlygate4sd3_1
X_05959_ hold931/A _04838_/Y fanout58/X _05958_/Y VPWR VGND sg13cmos5l_a21oi_1
Xhold1088 _09456_/D _06202_/Y VPWR VGND sg13cmos5l_dlygate4sd3_1
X_08678_ _08699_/B _08702_/A _08676_/B _08677_/Y _08674_/Y VPWR VGND sg13cmos5l_a22oi_1
XFILLER_26_45 VPWR VGND sg13cmos5l_fill_1
X_07629_ _07629_/Y hold951/X fanout59/X _07633_/A VPWR VGND sg13cmos5l_o21ai_1
XFILLER_10_800 VPWR VGND sg13cmos5l_fill_2
X_09249__812 _09249_/RESET_B VPWR VGND sg13cmos5l_tiehi
X_09540__558 _09540_/RESET_B VPWR VGND sg13cmos5l_tiehi
X_09256__805 _09256_/RESET_B VPWR VGND sg13cmos5l_tiehi
X_09371__742 _09371_/RESET_B VPWR VGND sg13cmos5l_tiehi
XFILLER_13_660 VPWR VGND sg13cmos5l_fill_1
XFILLER_40_490 VPWR VGND sg13cmos5l_decap_8
XFILLER_9_664 VPWR VGND sg13cmos5l_fill_2
Xfanout109 _08783_/B _08784_/C VPWR VGND sg13cmos5l_buf_1
X_07980_ _08021_/A _09146_/Q _09147_/Q VPWR VGND sg13cmos5l_xnor2_1
X_06931_ _06931_/Y _06932_/B VPWR VGND sg13cmos5l_inv_1
XFILLER_41_1028 VPWR VGND sg13cmos5l_fill_1
X_06862_ _06884_/C _09561_/Q _06862_/B VPWR VGND sg13cmos5l_xor2_1
X_08601_ _09241_/D _08601_/A _08603_/B VPWR VGND sg13cmos5l_nor2_1
X_05813_ _05815_/B _05848_/A _05847_/B _05809_/X _05853_/A VPWR VGND sg13cmos5l_a22oi_1
X_09581_ _09581_/Q _09591_/CLK _09581_/D _09581_/RESET_B VPWR VGND sg13cmos5l_dfrbpq_1
X_06793_ _06793_/Y _06785_/X _06787_/X _06789_/Y _06791_/Y _06792_/X VPWR VGND sg13cmos5l_a221oi_1
X_05744_ _05744_/X _05579_/X _05627_/X _05754_/S VPWR VGND sg13cmos5l_mux2_1
X_08532_ _08532_/Y _08667_/A _08667_/B VPWR VGND sg13cmos5l_nand2_1
X_08463_ _08476_/C _08453_/Y _08458_/Y _08462_/Y VPWR VGND sg13cmos5l_o21ai_1
X_07414_ _07429_/A _07446_/B _07414_/B VPWR VGND sg13cmos5l_nand2b_1
XFILLER_23_424 VPWR VGND sg13cmos5l_fill_1
X_05675_ _05677_/A _05918_/A _05675_/B VPWR VGND sg13cmos5l_nor2_1
X_08394_ _09208_/D _08394_/A hold875/X VPWR VGND sg13cmos5l_and2_1
X_07345_ _07345_/Y _07345_/A VPWR VGND sg13cmos5l_inv_1
X_07276_ _07276_/Y _07556_/A _07276_/B VPWR VGND sg13cmos5l_nor2_1
Xclkbuf_leaf_30_clk clkload14/A clkbuf_3_4__f_clk/X VPWR VGND sg13cmos5l_buf_8
XFILLER_12_36 VPWR VGND sg13cmos5l_fill_2
X_06227_ _06227_/Y _06225_/Y _06226_/Y _06224_/Y VPWR VGND sg13cmos5l_a21oi_1
X_09015_ hold920/A _09288_/CLK hold921/X _09015_/RESET_B VPWR VGND sg13cmos5l_dfrbpq_1
X_06158_ _06160_/B _06122_/Y _06162_/S _06157_/Y VPWR VGND sg13cmos5l_a21oi_1
XFILLER_2_306 VPWR VGND sg13cmos5l_fill_1
X_06089_ _06090_/B _06085_/X _06086_/Y _06088_/Y VPWR VGND sg13cmos5l_a21oi_1
X_05109_ _05109_/Y _05117_/A _05198_/A VPWR VGND sg13cmos5l_nor2_1
XFILLER_15_947 VPWR VGND sg13cmos5l_fill_2
Xclkbuf_leaf_21_clk clkload24/A clkload1/A VPWR VGND sg13cmos5l_buf_8
XFILLER_6_634 VPWR VGND sg13cmos5l_fill_1
XFILLER_5_122 VPWR VGND sg13cmos5l_fill_2
XFILLER_6_667 VPWR VGND sg13cmos5l_fill_2
X_09128__348 _09128_/RESET_B VPWR VGND sg13cmos5l_tiehi
XFILLER_49_321 VPWR VGND sg13cmos5l_fill_2
XFILLER_17_251 VPWR VGND sg13cmos5l_fill_1
XFILLER_33_755 VPWR VGND sg13cmos5l_fill_2
X_05460_ _05471_/A _09355_/Q _05466_/B _05495_/A VPWR VGND sg13cmos5l_a21o_1
X_05391_ _05391_/Y _09363_/Q _08972_/A _04994_/Y _09362_/Q _05390_/Y VPWR VGND sg13cmos5l_a221oi_1
Xclkbuf_leaf_12_clk clkload11/A clkload0/A VPWR VGND sg13cmos5l_buf_8
X_07130_ _07130_/Y _07130_/A _07130_/B VPWR VGND sg13cmos5l_xnor2_1
X_07061_ _07073_/B _07056_/Y _07060_/Y _07059_/A VPWR VGND sg13cmos5l_a21oi_1
X_06012_ _06012_/Y _06012_/A _06012_/B VPWR VGND sg13cmos5l_nor2_1
X_07963_ _07963_/Y _07936_/B _07967_/B _07892_/B VPWR VGND sg13cmos5l_a21oi_1
X_07894_ _09138_/D _07894_/A _07895_/B VPWR VGND sg13cmos5l_nor2_1
X_06914_ _06914_/Y _06908_/Y _06911_/Y _06913_/Y VPWR VGND sg13cmos5l_a21oi_1
X_06845_ _06856_/B _09591_/Q _06846_/B VPWR VGND sg13cmos5l_xnor2_1
X_09564_ _09564_/Q _09565_/CLK _09564_/D _09564_/RESET_B VPWR VGND sg13cmos5l_dfrbpq_1
X_09239__822 _09239_/RESET_B VPWR VGND sg13cmos5l_tiehi
X_08515_ _08530_/C _09228_/Q _08516_/B VPWR VGND sg13cmos5l_xnor2_1
X_06776_ _06777_/B _06802_/A _06776_/B VPWR VGND sg13cmos5l_nor2_1
X_05727_ _05727_/X _05579_/X _05628_/B _05726_/Y VPWR VGND sg13cmos5l_a21o_1
X_09495_ _09495_/Q _09586_/CLK _09495_/D _09495_/RESET_B VPWR VGND sg13cmos5l_dfrbpq_1
XFILLER_23_221 VPWR VGND sg13cmos5l_fill_1
X_08446_ _08451_/A _08446_/A _08455_/B _08446_/C VPWR VGND sg13cmos5l_nor3_1
X_05658_ _05658_/Y _05658_/A VPWR VGND sg13cmos5l_inv_1
X_08377_ _09198_/D _04930_/Y _08378_/B _08376_/Y VPWR VGND sg13cmos5l_a21oi_1
X_05589_ _05730_/A _05593_/S _05588_/Y _05587_/Y VPWR VGND sg13cmos5l_a21oi_1
X_07328_ _07328_/Y _07329_/B VPWR VGND sg13cmos5l_inv_1
XFILLER_20_994 VPWR VGND sg13cmos5l_decap_4
X_07259_ _07277_/S _07272_/B _07272_/C VPWR VGND sg13cmos5l_nand2_1
X_09246__815 _09246_/RESET_B VPWR VGND sg13cmos5l_tiehi
X_09361__752 _09361_/RESET_B VPWR VGND sg13cmos5l_tiehi
X_09539__560 _09539_/RESET_B VPWR VGND sg13cmos5l_tiehi
X_09253__808 _09253_/RESET_B VPWR VGND sg13cmos5l_tiehi
XFILLER_42_574 VPWR VGND sg13cmos5l_fill_1
Xfanout91 _07011_/B _07015_/B VPWR VGND sg13cmos5l_buf_1
Xfanout80 _08622_/B _08608_/Y VPWR VGND sg13cmos5l_buf_1
XFILLER_11_972 VPWR VGND sg13cmos5l_fill_2
XFILLER_7_987 VPWR VGND sg13cmos5l_fill_1
XFILLER_9_1028 VPWR VGND sg13cmos5l_fill_1
X_04960_ _04960_/Y _07352_/A VPWR VGND sg13cmos5l_inv_1
Xclkbuf_leaf_1_clk _09595_/CLK clkbuf_leaf_2_clk/A VPWR VGND sg13cmos5l_buf_8
XFILLER_49_173 VPWR VGND sg13cmos5l_fill_2
X_04891_ _08398_/A _04891_/A VPWR VGND sg13cmos5l_inv_1
X_06630_ _06799_/A _06628_/Y _06629_/Y _06630_/S VPWR VGND sg13cmos5l_mux2_1
X_06561_ _06903_/A _09551_/Q _09550_/Q VPWR VGND sg13cmos5l_xnor2_1
X_06492_ _06493_/B _09509_/Q _06541_/A _06542_/A VPWR VGND sg13cmos5l_a21o_1
X_08300_ _08334_/A _09155_/Q _09153_/Q _09154_/Q VPWR VGND sg13cmos5l_or3_1
X_09280_ _09280_/Q _09288_/CLK _09280_/D _09280_/RESET_B VPWR VGND sg13cmos5l_dfrbpq_1
X_05512_ _05516_/B _05501_/Y _05506_/X _05514_/A _05528_/A _05507_/X VPWR VGND sg13cmos5l_a221oi_1
X_08231_ _09182_/D _08231_/A _08231_/B _08231_/C VPWR VGND sg13cmos5l_nor3_1
XFILLER_21_725 VPWR VGND sg13cmos5l_fill_2
X_05443_ _09353_/D _05443_/A _05443_/B VPWR VGND sg13cmos5l_and2_1
X_05374_ _09335_/D _05378_/A _05374_/B VPWR VGND sg13cmos5l_nor2_1
X_08162_ _08206_/C _09175_/Q _08169_/A _08172_/A VPWR VGND sg13cmos5l_o21ai_1
X_08093_ _08093_/Y _08399_/A _09124_/Q _09123_/Q _08398_/A _08092_/Y VPWR VGND sg13cmos5l_a221oi_1
X_07113_ _07220_/A hold932/X _08838_/A VPWR VGND sg13cmos5l_nand2b_1
X_07044_ _07044_/X _07044_/A _07044_/B VPWR VGND sg13cmos5l_or2_1
X_08995_ _09314_/D _08995_/A hold870/X VPWR VGND sg13cmos5l_and2_1
X_07946_ _07946_/Y _07946_/A _07946_/B VPWR VGND sg13cmos5l_nor2_1
XFILLER_29_825 VPWR VGND sg13cmos5l_fill_2
X_07877_ _07878_/B hold1156/X _07874_/S _07890_/B VPWR VGND sg13cmos5l_o21ai_1
X_06828_ _06840_/B _09555_/Q _09556_/Q _09557_/Q VPWR VGND sg13cmos5l_or3_1
X_06759_ _06798_/B _06759_/A _06759_/B VPWR VGND sg13cmos5l_nor2_1
X_09547_ _09547_/Q clkload22/A _09547_/D _09547_/RESET_B VPWR VGND sg13cmos5l_dfrbpq_1
X_09478_ _09478_/Q clkload21/A _09478_/D _09478_/RESET_B VPWR VGND sg13cmos5l_dfrbpq_1
X_09118__358 _09118_/RESET_B VPWR VGND sg13cmos5l_tiehi
XFILLER_11_202 VPWR VGND sg13cmos5l_fill_1
X_08429_ _08429_/Y _08286_/Y _08336_/B _08426_/X _08427_/Y _08428_/Y VPWR VGND sg13cmos5l_a221oi_1
XFILLER_11_268 VPWR VGND sg13cmos5l_fill_1
Xclkload0 clkload0/X clkload0/A VPWR VGND sg13cmos5l_buf_8
XFILLER_3_445 VPWR VGND sg13cmos5l_decap_8
XFILLER_47_622 VPWR VGND sg13cmos5l_fill_2
XFILLER_47_611 VPWR VGND sg13cmos5l_fill_2
XFILLER_15_574 VPWR VGND sg13cmos5l_fill_2
XFILLER_11_791 VPWR VGND sg13cmos5l_fill_1
X_05090_ _05103_/B _09323_/Q _09322_/Q VPWR VGND sg13cmos5l_nor2_1
X_08780_ _09258_/D _08893_/A _08783_/B VPWR VGND sg13cmos5l_nor2_1
X_07800_ _07800_/Y _07798_/Y _07799_/Y _07794_/Y VPWR VGND sg13cmos5l_a21oi_1
Xhold1407 hold1407/X _09117_/Q VPWR VGND sg13cmos5l_dlygate4sd3_1
X_07731_ _07758_/B _09113_/Q _07732_/B VPWR VGND sg13cmos5l_nor2b_1
Xhold1418 _07495_/A _09074_/Q VPWR VGND sg13cmos5l_dlygate4sd3_1
Xhold1429 _06751_/A _09543_/Q VPWR VGND sg13cmos5l_dlygate4sd3_1
X_05992_ _06007_/A _05985_/A _05985_/B _05991_/Y VPWR VGND sg13cmos5l_o21ai_1
X_09420__690 _09420_/RESET_B VPWR VGND sg13cmos5l_tiehi
X_04943_ _04943_/Y _08098_/B VPWR VGND sg13cmos5l_inv_1
X_04874_ _06742_/A _06316_/B VPWR VGND sg13cmos5l_inv_1
X_07662_ _07663_/B _07662_/A _07662_/B VPWR VGND sg13cmos5l_xnor2_1
X_07593_ _07593_/Y _09084_/Q _07592_/Y hold978/A VPWR VGND sg13cmos5l_o21ai_1
X_06613_ _06768_/B _06623_/A _06603_/B _06612_/X VPWR VGND sg13cmos5l_o21ai_1
X_09401_ hold997/A clkload19/A _09401_/D _09401_/RESET_B VPWR VGND sg13cmos5l_dfrbpq_1
X_06544_ _06545_/A _06543_/Y _06544_/B VPWR VGND sg13cmos5l_nand2b_1
X_09332_ _09332_/Q clkload12/A _09332_/D _09332_/RESET_B VPWR VGND sg13cmos5l_dfrbpq_1
XFILLER_40_319 VPWR VGND sg13cmos5l_fill_2
X_09351__762 _09351_/RESET_B VPWR VGND sg13cmos5l_tiehi
XFILLER_33_360 VPWR VGND sg13cmos5l_fill_1
X_06475_ _09508_/D _06475_/A _06477_/B VPWR VGND sg13cmos5l_nor2_1
X_09263_ _09263_/Q clkload8/A _09263_/D _09263_/RESET_B VPWR VGND sg13cmos5l_dfrbpq_1
X_09194_ _09194_/Q _09595_/CLK _09194_/D _09194_/RESET_B VPWR VGND sg13cmos5l_dfrbpq_1
XFILLER_14_1022 VPWR VGND sg13cmos5l_fill_1
X_08214_ _08214_/Y _08230_/A _08229_/A VPWR VGND sg13cmos5l_nor2b_1
X_05426_ _05426_/Y _05409_/Y _05421_/B _05262_/Y VPWR VGND sg13cmos5l_o21ai_1
X_05357_ _05357_/Y _05348_/Y _05356_/Y _05347_/Y VPWR VGND sg13cmos5l_o21ai_1
X_08145_ _09173_/D _08145_/A _08231_/A VPWR VGND sg13cmos5l_nor2_1
X_08076_ _08076_/Y _08175_/C _08175_/D VPWR VGND sg13cmos5l_nand2_1
X_05288_ _05295_/B _09362_/Q _09363_/Q _05317_/A _09361_/Q VPWR VGND sg13cmos5l_nor4_1
XFILLER_1_927 VPWR VGND sg13cmos5l_decap_4
X_07027_ _07027_/Y _07053_/A _06931_/Y _07026_/Y VPWR VGND sg13cmos5l_a21oi_1
X_09243__818 _09243_/RESET_B VPWR VGND sg13cmos5l_tiehi
XFILLER_1_938 VPWR VGND sg13cmos5l_fill_2
XFILLER_29_45 VPWR VGND sg13cmos5l_fill_2
X_08978_ _08978_/Y _04996_/Y fanout35/X _08977_/Y VPWR VGND sg13cmos5l_a21oi_1
X_07929_ _07929_/Y _07784_/B _07831_/Y _07928_/Y VPWR VGND sg13cmos5l_a21oi_1
XFILLER_45_44 VPWR VGND sg13cmos5l_fill_2
XFILLER_8_504 VPWR VGND sg13cmos5l_fill_1
XFILLER_3_242 VPWR VGND sg13cmos5l_fill_1
XFILLER_0_982 VPWR VGND sg13cmos5l_decap_8
XFILLER_48_997 VPWR VGND sg13cmos5l_decap_8
XFILLER_19_154 VPWR VGND sg13cmos5l_fill_2
XFILLER_35_647 VPWR VGND sg13cmos5l_fill_1
X_06260_ _06261_/B _09467_/Q _06232_/B _06224_/Y VPWR VGND sg13cmos5l_a21oi_1
X_05211_ _05211_/Y _08942_/A _05242_/B VPWR VGND sg13cmos5l_nor2_1
X_06191_ _06191_/Y _06194_/B _06191_/B VPWR VGND sg13cmos5l_nand2b_1
X_05142_ _05192_/A _09286_/Q _05143_/B VPWR VGND sg13cmos5l_xnor2_1
XFILLER_7_592 VPWR VGND sg13cmos5l_fill_1
X_05073_ _05237_/A _05236_/B _05236_/C _05236_/A VPWR VGND sg13cmos5l_a21oi_1
X_08901_ _08901_/Y _08892_/B _08892_/C _08892_/A VPWR VGND sg13cmos5l_a21oi_1
X_09108__368 _09108_/RESET_B VPWR VGND sg13cmos5l_tiehi
Xhold1204 hold1204/X _05764_/C VPWR VGND sg13cmos5l_dlygate4sd3_1
Xhold1215 _04886_/A _09220_/Q VPWR VGND sg13cmos5l_dlygate4sd3_1
X_08832_ _08832_/Y hold993/X fanout47/X _08834_/B1 VPWR VGND sg13cmos5l_o21ai_1
X_08763_ _09252_/D _08783_/B _08763_/B VPWR VGND sg13cmos5l_nor2_1
XFILLER_39_964 VPWR VGND sg13cmos5l_fill_1
Xhold1248 _04845_/A _09322_/Q VPWR VGND sg13cmos5l_dlygate4sd3_1
Xhold1226 hold1226/X _09588_/Q VPWR VGND sg13cmos5l_dlygate4sd3_1
Xhold1237 _07369_/B _07368_/Y VPWR VGND sg13cmos5l_dlygate4sd3_1
X_05975_ _06015_/A _09431_/Q _05986_/B VPWR VGND sg13cmos5l_xnor2_1
Xhold1259 _07790_/A _09082_/Q VPWR VGND sg13cmos5l_dlygate4sd3_1
X_04926_ _04926_/Y _04926_/A VPWR VGND sg13cmos5l_inv_1
X_09078__401 _09078_/RESET_B VPWR VGND sg13cmos5l_tiehi
X_07714_ _09104_/D _07695_/B _07708_/Y _07713_/Y VPWR VGND sg13cmos5l_a21oi_1
X_08694_ _08694_/X _08694_/A _08694_/B VPWR VGND sg13cmos5l_or2_1
X_07645_ _07697_/B _09099_/Q _07661_/B VPWR VGND sg13cmos5l_nand2_1
X_04857_ _05965_/A _05656_/A VPWR VGND sg13cmos5l_inv_1
X_07576_ _09081_/D _07716_/A _07576_/B VPWR VGND sg13cmos5l_nor2_1
X_09315_ _09315_/Q _09608_/CLK _09315_/D _09315_/RESET_B VPWR VGND sg13cmos5l_dfrbpq_1
X_06527_ _06531_/A _06527_/A _06534_/B _06527_/C VPWR VGND sg13cmos5l_nor3_1
X_09246_ _09246_/Q _09595_/CLK _09246_/D _09246_/RESET_B VPWR VGND sg13cmos5l_dfrbpq_1
XFILLER_21_363 VPWR VGND sg13cmos5l_fill_1
XFILLER_22_864 VPWR VGND sg13cmos5l_fill_1
X_06458_ _06460_/A _06458_/A _06456_/S VPWR VGND sg13cmos5l_nor2b_1
X_05409_ _05409_/Y _05699_/A _05408_/B _05408_/Y VPWR VGND sg13cmos5l_o21ai_1
X_06389_ _06412_/B _09452_/Q _06389_/B VPWR VGND sg13cmos5l_xor2_1
X_09177_ _09177_/Q _09388_/CLK _09177_/D _09177_/RESET_B VPWR VGND sg13cmos5l_dfrbpq_1
X_08128_ _08129_/C hold980/X _08130_/B VPWR VGND sg13cmos5l_nor2_1
Xoutput13 uo_out[0] _09229_/Q VPWR VGND sg13cmos5l_buf_1
X_08059_ _08059_/Y _09119_/Q _08059_/B VPWR VGND sg13cmos5l_xnor2_1
XFILLER_0_212 VPWR VGND sg13cmos5l_fill_1
XFILLER_49_739 VPWR VGND sg13cmos5l_fill_1
X_09573__516 _09573_/RESET_B VPWR VGND sg13cmos5l_tiehi
XFILLER_45_978 VPWR VGND sg13cmos5l_fill_1
XFILLER_44_466 VPWR VGND sg13cmos5l_fill_2
Xclkbuf_3_1__f_clk clkbuf_leaf_4_clk/A clkbuf_0_clk/X VPWR VGND sg13cmos5l_buf_8
X_05760_ _05760_/Y _05760_/A _05760_/B VPWR VGND sg13cmos5l_nor2_1
XFILLER_47_260 VPWR VGND sg13cmos5l_fill_2
X_05691_ _05691_/Y hold982/X fanout47/X _08986_/A VPWR VGND sg13cmos5l_o21ai_1
X_07430_ _07431_/B _07430_/A _07430_/B VPWR VGND sg13cmos5l_nor2_1
X_07361_ _07361_/Y _09050_/Q _07342_/B _07360_/Y VPWR VGND sg13cmos5l_o21ai_1
X_06312_ _06365_/A _09485_/Q _06312_/B VPWR VGND sg13cmos5l_xor2_1
X_09100_ _09100_/Q clkload15/A _09100_/D _09100_/RESET_B VPWR VGND sg13cmos5l_dfrbpq_1
XFILLER_15_190 VPWR VGND sg13cmos5l_fill_2
X_07292_ _07295_/B _09587_/Q _09562_/Q VPWR VGND sg13cmos5l_nor2_1
XFILLER_31_683 VPWR VGND sg13cmos5l_fill_1
X_09031_ _09031_/Q _09288_/CLK _09031_/D _09031_/RESET_B VPWR VGND sg13cmos5l_dfrbpq_1
XFILLER_11_1014 VPWR VGND sg13cmos5l_fill_1
X_06243_ _06244_/B _06243_/A _06243_/B VPWR VGND sg13cmos5l_xnor2_1
X_06174_ _06189_/B _09478_/Q _04979_/Y _06173_/Y VPWR VGND sg13cmos5l_a21oi_1
X_05125_ _05125_/X _05199_/B _05125_/B VPWR VGND sg13cmos5l_and2_1
X_05056_ _05059_/B hold932/A _09051_/Q hold945/A hold948/A VPWR VGND sg13cmos5l_nor4_1
Xhold1001 _09197_/D _08375_/Y VPWR VGND sg13cmos5l_dlygate4sd3_1
Xhold1012 _08582_/B _08581_/Y VPWR VGND sg13cmos5l_dlygate4sd3_1
Xhold1023 _07106_/A _09598_/Q VPWR VGND sg13cmos5l_dlygate4sd3_1
X_08815_ _08815_/Y _08953_/B _08813_/B _08812_/Y _08814_/Y VPWR VGND sg13cmos5l_a22oi_1
Xhold1034 _07151_/B _09026_/Q VPWR VGND sg13cmos5l_dlygate4sd3_1
Xhold1056 _04895_/A _09143_/Q VPWR VGND sg13cmos5l_dlygate4sd3_1
Xhold1067 _07589_/A _09088_/Q VPWR VGND sg13cmos5l_dlygate4sd3_1
Xhold1045 _08478_/B _10245_/A VPWR VGND sg13cmos5l_dlygate4sd3_1
X_08746_ _08746_/Y _08746_/A _08746_/B _08746_/C VPWR VGND sg13cmos5l_nand3_1
Xhold1078 hold1078/X _09496_/Q VPWR VGND sg13cmos5l_dlygate4sd3_1
X_05958_ _05958_/Y hold960/A fanout58/X _05961_/A VPWR VGND sg13cmos5l_o21ai_1
Xhold1089 _05661_/A _09343_/Q VPWR VGND sg13cmos5l_dlygate4sd3_1
X_05889_ _05890_/B _05993_/C _05993_/D VPWR VGND sg13cmos5l_nand2_1
X_04909_ _07635_/A _04909_/A VPWR VGND sg13cmos5l_inv_1
X_08677_ _08677_/Y _08699_/A _08672_/Y _08676_/Y VPWR VGND sg13cmos5l_a21oi_1
X_07628_ _09091_/D _04828_/Y fanout61/X _07627_/Y VPWR VGND sg13cmos5l_a21oi_1
X_07559_ _07571_/C _07552_/Y _07555_/Y _07557_/Y VPWR VGND sg13cmos5l_a21o_1
X_09229_ _09229_/Q clkload5/A _09229_/D _09229_/RESET_B VPWR VGND sg13cmos5l_dfrbpq_1
XFILLER_5_359 VPWR VGND sg13cmos5l_fill_2
Xhold890 hold890/X hold890/A VPWR VGND sg13cmos5l_dlygate4sd3_1
XFILLER_18_901 VPWR VGND sg13cmos5l_fill_2
XFILLER_29_260 VPWR VGND sg13cmos5l_fill_1
XFILLER_45_764 VPWR VGND sg13cmos5l_fill_2
XFILLER_45_775 VPWR VGND sg13cmos5l_fill_1
XFILLER_41_992 VPWR VGND sg13cmos5l_fill_2
X_09068__411 _09068_/RESET_B VPWR VGND sg13cmos5l_tiehi
X_06930_ _06932_/B _06906_/A _06927_/S _06929_/X VPWR VGND sg13cmos5l_o21ai_1
X_06861_ _06876_/C _09561_/Q _06862_/B VPWR VGND sg13cmos5l_xnor2_1
X_08600_ _09240_/D _08600_/A _08723_/A VPWR VGND sg13cmos5l_and2_1
X_09580_ hold876/A _09586_/CLK _09580_/D _09580_/RESET_B VPWR VGND sg13cmos5l_dfrbpq_1
X_06792_ _06792_/X _06792_/A _06792_/B VPWR VGND sg13cmos5l_and2_1
X_05812_ _05816_/B _06222_/A _05812_/B VPWR VGND sg13cmos5l_xnor2_1
X_05743_ _05743_/Y _05743_/A VPWR VGND sg13cmos5l_inv_1
X_09075__404 _09075_/RESET_B VPWR VGND sg13cmos5l_tiehi
X_08531_ _08667_/B _08539_/B _08539_/C _08529_/Y VPWR VGND sg13cmos5l_o21ai_1
X_08462_ _08462_/Y _08458_/A _08458_/B _08464_/A _08476_/B VPWR VGND sg13cmos5l_a22oi_1
X_05674_ _09378_/D _05650_/Y _05675_/B _05673_/Y VPWR VGND sg13cmos5l_a21oi_1
X_07413_ _07414_/B _07413_/A _07413_/B VPWR VGND sg13cmos5l_xnor2_1
XFILLER_24_948 VPWR VGND sg13cmos5l_fill_1
X_08393_ _09207_/D _08393_/A hold879/X VPWR VGND sg13cmos5l_and2_1
XFILLER_32_970 VPWR VGND sg13cmos5l_fill_1
X_07344_ _07345_/A _07635_/A _07355_/B _07343_/Y VPWR VGND sg13cmos5l_o21ai_1
XFILLER_32_992 VPWR VGND sg13cmos5l_decap_8
X_07275_ _09034_/D _07389_/B _07275_/B VPWR VGND sg13cmos5l_nor2_1
X_06226_ _06226_/Y hold943/A hold852/A VPWR VGND sg13cmos5l_xnor2_1
X_09014_ _09014_/Q _09608_/CLK _09014_/D _09014_/RESET_B VPWR VGND sg13cmos5l_dfrbpq_1
X_09348__767 _09348_/RESET_B VPWR VGND sg13cmos5l_tiehi
X_06157_ _06157_/Y _06162_/S _05848_/Y VPWR VGND sg13cmos5l_nor2b_1
X_06088_ _06088_/Y _06083_/Y _06084_/Y _06397_/A VPWR VGND sg13cmos5l_a21oi_1
X_05108_ _05198_/A _05447_/A _05108_/B VPWR VGND sg13cmos5l_xnor2_1
X_05039_ _05040_/D hold955/X hold938/X VPWR VGND sg13cmos5l_nor2_1
X_08729_ _08729_/Y _09251_/Q _09252_/Q VPWR VGND sg13cmos5l_xnor2_1
XFILLER_41_200 VPWR VGND sg13cmos5l_fill_1
XFILLER_2_863 VPWR VGND sg13cmos5l_fill_1
XFILLER_32_233 VPWR VGND sg13cmos5l_fill_1
XFILLER_14_981 VPWR VGND sg13cmos5l_decap_8
X_05390_ _05390_/Y _05699_/A _09305_/Q _09304_/Q _05698_/A _05389_/Y VPWR VGND sg13cmos5l_a221oi_1
XFILLER_13_480 VPWR VGND sg13cmos5l_fill_2
X_07060_ _07060_/Y _07055_/A _07055_/B _07057_/Y _07073_/A VPWR VGND sg13cmos5l_a22oi_1
X_06011_ _06012_/B _05841_/B _05895_/B _06025_/B VPWR VGND sg13cmos5l_mux2_1
X_07962_ _07964_/A _07962_/A _07967_/B VPWR VGND sg13cmos5l_nor2_1
X_09296__427 _09296_/RESET_B VPWR VGND sg13cmos5l_tiehi
X_07893_ _09137_/D _07893_/A _07895_/B VPWR VGND sg13cmos5l_nor2_1
X_06913_ _06913_/Y _06596_/A _06910_/X _06912_/Y VPWR VGND sg13cmos5l_o21ai_1
X_06844_ _06853_/B _09590_/Q _09591_/Q _09589_/Q _07295_/A VPWR VGND sg13cmos5l_nor4_1
X_09563_ _09563_/Q _09565_/CLK _09563_/D _09563_/RESET_B VPWR VGND sg13cmos5l_dfrbpq_1
X_08514_ _08530_/B _08503_/Y _08511_/Y _08512_/Y VPWR VGND sg13cmos5l_a21o_1
X_06775_ _06777_/A _06799_/A _06775_/B VPWR VGND sg13cmos5l_nor2_1
X_05726_ _05726_/Y _05593_/S _05582_/X _05632_/A _05632_/B _05583_/Y VPWR VGND sg13cmos5l_a221oi_1
XFILLER_24_734 VPWR VGND sg13cmos5l_fill_2
X_09494_ _09494_/Q clkload24/A _09494_/D _09494_/RESET_B VPWR VGND sg13cmos5l_dfrbpq_1
XFILLER_12_918 VPWR VGND sg13cmos5l_fill_1
X_08445_ _08446_/C _08445_/A _08445_/B _08445_/C VPWR VGND sg13cmos5l_and3_1
X_05657_ _05658_/A _04990_/Y _05661_/B _05656_/Y VPWR VGND sg13cmos5l_a21oi_1
X_05588_ _05588_/Y _05588_/A _05588_/B VPWR VGND sg13cmos5l_nor2_1
X_08376_ _08376_/Y _08355_/X _08378_/B _08397_/B VPWR VGND sg13cmos5l_o21ai_1
X_07327_ _07329_/B _07300_/X _06883_/Y _07327_/S VPWR VGND sg13cmos5l_mux2_1
X_07258_ _07280_/C _09038_/Q _07258_/B VPWR VGND sg13cmos5l_xor2_1
X_06209_ _06209_/Y _09423_/Q fanout48/X _05961_/A VPWR VGND sg13cmos5l_o21ai_1
X_07189_ _07191_/B _09028_/Q _07193_/B VPWR VGND sg13cmos5l_nor2b_1
XFILLER_3_649 VPWR VGND sg13cmos5l_fill_1
X_09058__421 _09058_/RESET_B VPWR VGND sg13cmos5l_tiehi
XFILLER_42_564 VPWR VGND sg13cmos5l_fill_2
Xfanout70 _08568_/B _08572_/B VPWR VGND sg13cmos5l_buf_1
Xfanout81 _08423_/B _08405_/Y VPWR VGND sg13cmos5l_buf_1
Xfanout92 _06764_/B _06746_/Y VPWR VGND sg13cmos5l_buf_1
XFILLER_11_995 VPWR VGND sg13cmos5l_fill_1
X_09065__414 _09065_/RESET_B VPWR VGND sg13cmos5l_tiehi
XFILLER_2_660 VPWR VGND sg13cmos5l_fill_2
XFILLER_2_671 VPWR VGND sg13cmos5l_fill_2
XFILLER_49_141 VPWR VGND sg13cmos5l_fill_1
X_04890_ _08400_/A _04890_/A VPWR VGND sg13cmos5l_inv_1
XFILLER_38_826 VPWR VGND sg13cmos5l_fill_1
XFILLER_18_583 VPWR VGND sg13cmos5l_fill_2
X_06560_ _06572_/B _09551_/Q _09550_/Q VPWR VGND sg13cmos5l_nor2_1
X_06491_ _06542_/A _06533_/B _06533_/C _06533_/A VPWR VGND sg13cmos5l_a21oi_1
X_09072__407 _09072_/RESET_B VPWR VGND sg13cmos5l_tiehi
X_05511_ _05528_/A _05511_/A _05511_/B VPWR VGND sg13cmos5l_or2_1
X_08230_ _08231_/C _08230_/A _08229_/B VPWR VGND sg13cmos5l_nor2b_1
X_05442_ _09352_/D _08134_/A hold905/X VPWR VGND sg13cmos5l_and2_1
XFILLER_33_586 VPWR VGND sg13cmos5l_fill_1
X_05373_ _05374_/B _05474_/C _05474_/D VPWR VGND sg13cmos5l_nand2_1
X_08161_ _08172_/A _09174_/Q _08171_/B _08198_/A VPWR VGND sg13cmos5l_a21o_1
X_08092_ _08092_/Y _09180_/Q _04946_/Y _08089_/Y _08090_/Y _08091_/Y VPWR VGND sg13cmos5l_a221oi_1
X_07112_ hold935/A _07100_/X hold934/X _08234_/A VPWR VGND sg13cmos5l_a21oi_1
X_07043_ _07044_/B _07017_/A _07011_/X _07053_/B _06868_/B _07041_/Y VPWR VGND sg13cmos5l_a221oi_1
X_09597__485 _09597_/RESET_B VPWR VGND sg13cmos5l_tiehi
X_08994_ _09313_/D _08994_/A hold862/X VPWR VGND sg13cmos5l_and2_1
X_07945_ _07946_/B _07945_/A _07945_/B VPWR VGND sg13cmos5l_nor2_1
X_07876_ _07878_/A _07876_/A _07874_/S VPWR VGND sg13cmos5l_nor2b_1
X_06827_ _07298_/A _09589_/Q _07295_/A VPWR VGND sg13cmos5l_xnor2_1
X_09546_ _09546_/Q clkload24/A _09546_/D _09546_/RESET_B VPWR VGND sg13cmos5l_dfrbpq_1
X_06758_ _06759_/B hold1227/X _06762_/A VPWR VGND sg13cmos5l_nand2b_1
XFILLER_24_564 VPWR VGND sg13cmos5l_fill_2
X_05709_ _05751_/B _09391_/Q _05719_/B VPWR VGND sg13cmos5l_nand2_1
X_09477_ _09477_/Q clkload22/A _09477_/D _09477_/RESET_B VPWR VGND sg13cmos5l_dfrbpq_1
X_08428_ _08428_/Y _08427_/A _08427_/B _08427_/C _08427_/D VPWR VGND sg13cmos5l_a22oi_1
XFILLER_11_214 VPWR VGND sg13cmos5l_fill_1
XFILLER_12_715 VPWR VGND sg13cmos5l_fill_2
XFILLER_12_737 VPWR VGND sg13cmos5l_fill_2
X_06689_ _06689_/Y _09554_/Q _04968_/Y _06688_/Y VPWR VGND sg13cmos5l_a21oi_1
X_08359_ _08359_/Y _04942_/Y _08366_/B _08358_/Y VPWR VGND sg13cmos5l_a21oi_1
Xclkload1 clkload1/X clkload1/A VPWR VGND sg13cmos5l_buf_8
X_09281__559 _09281_/RESET_B VPWR VGND sg13cmos5l_tiehi
XFILLER_35_829 VPWR VGND sg13cmos5l_fill_1
XFILLER_46_199 VPWR VGND sg13cmos5l_fill_2
X_09409__701 _09409_/RESET_B VPWR VGND sg13cmos5l_tiehi
Xhold1408 hold1408/X _09070_/Q VPWR VGND sg13cmos5l_dlygate4sd3_1
X_07730_ _07732_/B _09112_/Q _07748_/B VPWR VGND sg13cmos5l_nor2b_1
X_05991_ _05991_/Y _05991_/A _05991_/B VPWR VGND sg13cmos5l_xnor2_1
Xhold1419 _06643_/B _09487_/Q VPWR VGND sg13cmos5l_dlygate4sd3_1
X_04942_ _04942_/Y _04942_/A VPWR VGND sg13cmos5l_inv_1
X_07661_ _07662_/B _09099_/Q _07661_/B VPWR VGND sg13cmos5l_xnor2_1
X_04873_ _06738_/A _04873_/A VPWR VGND sg13cmos5l_inv_1
X_07592_ _07592_/Y _07612_/A VPWR VGND sg13cmos5l_inv_1
X_06612_ _06612_/X _06612_/A _06612_/B VPWR VGND sg13cmos5l_and2_1
X_09400_ _09400_/Q clkload20/A _09400_/D _09400_/RESET_B VPWR VGND sg13cmos5l_dfrbpq_1
X_06543_ _06543_/Y _06493_/B _06542_/B _06542_/Y VPWR VGND sg13cmos5l_o21ai_1
X_09331_ _09331_/Q clkload12/A _09331_/D _09331_/RESET_B VPWR VGND sg13cmos5l_dfrbpq_1
X_06474_ _09507_/D _06474_/A _06477_/B VPWR VGND sg13cmos5l_nor2_1
X_09262_ _09262_/Q clkload8/A _09262_/D _09262_/RESET_B VPWR VGND sg13cmos5l_dfrbpq_1
X_09193_ _09193_/Q _09595_/CLK _09193_/D _09193_/RESET_B VPWR VGND sg13cmos5l_dfrbpq_1
X_08213_ _08232_/B _08213_/A _08166_/B VPWR VGND sg13cmos5l_nor2b_1
X_05425_ _09342_/D _04990_/Y _05421_/B _05424_/Y VPWR VGND sg13cmos5l_a21oi_1
X_05356_ _05356_/Y _05354_/Y _05355_/Y _05350_/Y VPWR VGND sg13cmos5l_a21oi_1
X_08144_ _09172_/D _08144_/A _08231_/A VPWR VGND sg13cmos5l_nor2_1
X_05287_ _05330_/B _09331_/Q _05287_/B VPWR VGND sg13cmos5l_xnor2_1
X_08075_ _08175_/D _08082_/A _08075_/B _08082_/C VPWR VGND sg13cmos5l_nand3_1
X_07026_ _07026_/Y _07057_/A _07028_/B VPWR VGND sg13cmos5l_nor2_1
X_09124__352 _09124_/RESET_B VPWR VGND sg13cmos5l_tiehi
X_08977_ _08977_/Y _08956_/Y fanout35/X _08997_/B VPWR VGND sg13cmos5l_o21ai_1
X_07928_ _07928_/Y _07953_/A _07928_/B VPWR VGND sg13cmos5l_nor2_1
X_07859_ _07859_/Y _09124_/Q _07859_/B VPWR VGND sg13cmos5l_nand2_1
XFILLER_45_56 VPWR VGND sg13cmos5l_fill_2
XFILLER_45_89 VPWR VGND sg13cmos5l_fill_1
X_09529_ _09529_/Q _09591_/CLK _09529_/D _09529_/RESET_B VPWR VGND sg13cmos5l_dfrbpq_1
X_09055__424 _09055_/RESET_B VPWR VGND sg13cmos5l_tiehi
X_09285__492 _09285_/RESET_B VPWR VGND sg13cmos5l_tiehi
X_09062__417 _09062_/RESET_B VPWR VGND sg13cmos5l_tiehi
XFILLER_48_910 VPWR VGND sg13cmos5l_fill_1
XFILLER_0_961 VPWR VGND sg13cmos5l_decap_8
XFILLER_48_954 VPWR VGND sg13cmos5l_decap_8
XFILLER_13_8 VPWR VGND sg13cmos5l_fill_2
XFILLER_48_976 VPWR VGND sg13cmos5l_decap_8
XFILLER_47_486 VPWR VGND sg13cmos5l_fill_1
X_05210_ _05242_/B _05385_/A _05210_/B VPWR VGND sg13cmos5l_nand2_1
XFILLER_30_397 VPWR VGND sg13cmos5l_fill_1
X_06190_ _06194_/B _04980_/Y _06189_/B _06189_/Y VPWR VGND sg13cmos5l_a21oi_1
X_05141_ _05155_/B _09285_/Q _08997_/A _09286_/Q VPWR VGND sg13cmos5l_nor3_1
X_05072_ _05236_/C _09318_/Q _05078_/B _05083_/A VPWR VGND sg13cmos5l_o21ai_1
X_08900_ _08900_/X _08769_/B _08782_/A _08909_/B VPWR VGND sg13cmos5l_mux2_1
X_08831_ _09271_/D _04818_/Y fanout47/X _08830_/Y VPWR VGND sg13cmos5l_a21oi_1
XFILLER_32_0 VPWR VGND sg13cmos5l_fill_1
Xhold1205 hold1205/X _09121_/Q VPWR VGND sg13cmos5l_dlygate4sd3_1
Xhold1216 _08358_/A _09218_/Q VPWR VGND sg13cmos5l_dlygate4sd3_1
X_08762_ _08763_/B _08868_/B _08868_/C VPWR VGND sg13cmos5l_or2_1
Xhold1249 hold1249/X _09510_/Q VPWR VGND sg13cmos5l_dlygate4sd3_1
Xhold1238 _05741_/A _09392_/Q VPWR VGND sg13cmos5l_dlygate4sd3_1
X_05974_ _06023_/B _09432_/Q _05986_/B VPWR VGND sg13cmos5l_nand2_1
Xhold1227 hold1227/X _09548_/Q VPWR VGND sg13cmos5l_dlygate4sd3_1
X_04925_ _04925_/Y _07130_/A VPWR VGND sg13cmos5l_inv_1
X_07713_ _07713_/Y _07695_/A _07715_/S _07634_/B VPWR VGND sg13cmos5l_o21ai_1
X_08693_ _08693_/Y _08686_/X _08688_/Y _08694_/A _08694_/B _08692_/X VPWR VGND sg13cmos5l_a221oi_1
XFILLER_39_998 VPWR VGND sg13cmos5l_fill_1
X_07644_ _07697_/A _09100_/Q _07661_/B VPWR VGND sg13cmos5l_xnor2_1
X_04856_ _05964_/A _04856_/A VPWR VGND sg13cmos5l_inv_1
X_07575_ _07575_/Y _07576_/B VPWR VGND sg13cmos5l_inv_1
X_09314_ hold905/A _09387_/CLK _09314_/D _09314_/RESET_B VPWR VGND sg13cmos5l_dfrbpq_1
X_06526_ _06527_/C _06526_/A _06526_/B _06526_/C VPWR VGND sg13cmos5l_and3_1
X_09245_ _09245_/Q _09595_/CLK _09245_/D _09245_/RESET_B VPWR VGND sg13cmos5l_dfrbpq_1
X_06457_ _09495_/D _06477_/B _06457_/B VPWR VGND sg13cmos5l_nor2_1
X_05408_ _05408_/Y _05408_/A _05408_/B VPWR VGND sg13cmos5l_nand2_1
X_06388_ _06392_/A _06380_/X _06385_/Y _06409_/B _06391_/A _06387_/X VPWR VGND sg13cmos5l_a221oi_1
X_09176_ _09176_/Q _09388_/CLK _09176_/D _09176_/RESET_B VPWR VGND sg13cmos5l_dfrbpq_1
X_05339_ _05379_/A _09300_/Q _09301_/Q _05341_/B VPWR VGND sg13cmos5l_nor3_1
X_08127_ _08129_/B _08127_/A _08130_/B VPWR VGND sg13cmos5l_nor2b_1
X_08058_ _08058_/X _09119_/Q _08059_/B VPWR VGND sg13cmos5l_xor2_1
Xoutput14 uo_out[1] _09230_/Q VPWR VGND sg13cmos5l_buf_1
X_07009_ _07052_/B _07009_/A _07009_/B VPWR VGND sg13cmos5l_nor2_1
X_09497__607 _09497_/RESET_B VPWR VGND sg13cmos5l_tiehi
XFILLER_0_246 VPWR VGND sg13cmos5l_fill_2
XFILLER_0_235 VPWR VGND sg13cmos5l_fill_2
XFILLER_49_729 VPWR VGND sg13cmos5l_fill_1
X_09198__272 _09198_/RESET_B VPWR VGND sg13cmos5l_tiehi
XFILLER_16_125 VPWR VGND sg13cmos5l_fill_2
XFILLER_13_843 VPWR VGND sg13cmos5l_fill_2
XFILLER_9_858 VPWR VGND sg13cmos5l_fill_1
X_09406__704 _09406_/RESET_B VPWR VGND sg13cmos5l_tiehi
XFILLER_39_206 VPWR VGND sg13cmos5l_fill_2
XFILLER_39_239 VPWR VGND sg13cmos5l_fill_1
X_05690_ _09386_/D _04839_/Y fanout48/X _05689_/Y VPWR VGND sg13cmos5l_a21oi_1
X_07360_ _07360_/Y _07360_/A _07360_/B VPWR VGND sg13cmos5l_nand2_1
X_06311_ _06341_/A _06311_/A _06311_/B VPWR VGND sg13cmos5l_xnor2_1
X_07291_ _07291_/Y _07320_/A _07320_/B VPWR VGND sg13cmos5l_nand2_1
X_09030_ _09030_/Q _09288_/CLK _09030_/D _09030_/RESET_B VPWR VGND sg13cmos5l_dfrbpq_1
X_06242_ _06242_/Y _06242_/A _06242_/B VPWR VGND sg13cmos5l_nand2_1
X_09114__362 _09114_/RESET_B VPWR VGND sg13cmos5l_tiehi
XFILLER_8_891 VPWR VGND sg13cmos5l_fill_1
X_06173_ _06173_/Y _06477_/A _09421_/Q hold973/A _06476_/A _06172_/Y VPWR VGND sg13cmos5l_a221oi_1
X_05124_ _05125_/B _05124_/A VPWR VGND sg13cmos5l_inv_1
X_05055_ _05059_/A hold877/A _09203_/Q hold908/A hold903/A VPWR VGND sg13cmos5l_nor4_1
Xhold1013 _09229_/D _08582_/Y VPWR VGND sg13cmos5l_dlygate4sd3_1
X_08814_ _08814_/Y _04999_/Y _08825_/A _08813_/Y VPWR VGND sg13cmos5l_a21oi_1
Xhold1002 _06441_/A _09515_/Q VPWR VGND sg13cmos5l_dlygate4sd3_1
Xhold1024 _08953_/A _09326_/Q VPWR VGND sg13cmos5l_dlygate4sd3_1
X_08745_ _08770_/B _09257_/Q _08746_/B VPWR VGND sg13cmos5l_xnor2_1
X_09121__355 _09121_/RESET_B VPWR VGND sg13cmos5l_tiehi
Xhold1035 _07847_/A _09140_/Q VPWR VGND sg13cmos5l_dlygate4sd3_1
Xhold1057 _07590_/A _09046_/Q VPWR VGND sg13cmos5l_dlygate4sd3_1
Xhold1046 _09244_/D _08604_/Y VPWR VGND sg13cmos5l_dlygate4sd3_1
Xhold1068 _09088_/D _07623_/Y VPWR VGND sg13cmos5l_dlygate4sd3_1
Xhold1079 _06460_/B _06459_/Y VPWR VGND sg13cmos5l_dlygate4sd3_1
X_05957_ hold919/A _04839_/Y fanout57/X _05956_/Y VPWR VGND sg13cmos5l_a21oi_1
X_05888_ _05888_/X _05893_/A _05893_/B VPWR VGND sg13cmos5l_or2_1
X_08676_ _08676_/Y _08702_/A _08676_/B VPWR VGND sg13cmos5l_nor2_1
X_04908_ _07636_/A _07347_/A VPWR VGND sg13cmos5l_inv_1
X_07627_ _07627_/Y hold996/X fanout61/X _07383_/A VPWR VGND sg13cmos5l_o21ai_1
X_04839_ _04839_/Y hold918/X VPWR VGND sg13cmos5l_inv_1
XFILLER_42_949 VPWR VGND sg13cmos5l_fill_1
X_07558_ _07558_/Y _07552_/Y _07555_/Y _07557_/Y VPWR VGND sg13cmos5l_a21oi_1
XFILLER_13_117 VPWR VGND sg13cmos5l_fill_2
X_06509_ _06512_/A _06504_/Y _06506_/Y _06508_/Y VPWR VGND sg13cmos5l_o21ai_1
X_07489_ _07489_/Y _07516_/A _07487_/Y _07488_/Y _09103_/Q _07485_/Y VPWR VGND sg13cmos5l_a221oi_1
X_09228_ _09228_/Q clkload2/A _09228_/D _09228_/RESET_B VPWR VGND sg13cmos5l_dfrbpq_1
X_09159_ _09159_/Q clkload4/A _09159_/D _09159_/RESET_B VPWR VGND sg13cmos5l_dfrbpq_1
Xhold880 hold880/X hold880/A VPWR VGND sg13cmos5l_dlygate4sd3_1
Xhold891 hold891/X hold891/A VPWR VGND sg13cmos5l_dlygate4sd3_1
XFILLER_17_412 VPWR VGND sg13cmos5l_fill_2
XFILLER_29_250 VPWR VGND sg13cmos5l_fill_1
XFILLER_44_231 VPWR VGND sg13cmos5l_fill_2
XFILLER_45_787 VPWR VGND sg13cmos5l_fill_2
XFILLER_26_990 VPWR VGND sg13cmos5l_fill_2
XFILLER_16_91 VPWR VGND sg13cmos5l_fill_2
XFILLER_9_666 VPWR VGND sg13cmos5l_fill_1
XFILLER_5_850 VPWR VGND sg13cmos5l_fill_1
X_06860_ _06876_/B _06848_/Y _06857_/Y _06858_/Y VPWR VGND sg13cmos5l_a21o_1
X_05811_ _05853_/A _09439_/Q _05812_/B VPWR VGND sg13cmos5l_xnor2_1
XFILLER_48_581 VPWR VGND sg13cmos5l_decap_4
X_06791_ _06791_/Y _06620_/Y _06799_/B _06790_/Y VPWR VGND sg13cmos5l_o21ai_1
X_05742_ _05743_/A _05742_/A _05742_/B VPWR VGND sg13cmos5l_nand2_1
X_08530_ _08667_/A _08530_/A _08530_/B _08530_/C VPWR VGND sg13cmos5l_nand3_1
X_08461_ _08476_/B _08461_/A _08461_/B VPWR VGND sg13cmos5l_nor2_1
X_05673_ _05673_/Y hold1160/X _05675_/B _05696_/B VPWR VGND sg13cmos5l_o21ai_1
X_07412_ _07413_/B _09061_/Q _07412_/B VPWR VGND sg13cmos5l_xnor2_1
X_08392_ _09206_/D _04819_/Y fanout53/X _08391_/Y VPWR VGND sg13cmos5l_a21oi_1
X_09272__686 _09272_/RESET_B VPWR VGND sg13cmos5l_tiehi
X_09487__617 _09487_/RESET_B VPWR VGND sg13cmos5l_tiehi
X_07343_ _07343_/Y _09569_/Q _07355_/B VPWR VGND sg13cmos5l_nand2_1
X_07274_ _07274_/Y _07419_/A _07419_/B VPWR VGND sg13cmos5l_nand2_1
X_06225_ _06225_/Y hold939/A hold868/A VPWR VGND sg13cmos5l_xnor2_1
X_09013_ hold983/A _09608_/CLK hold984/X _09013_/RESET_B VPWR VGND sg13cmos5l_dfrbpq_1
X_09188__282 _09188_/RESET_B VPWR VGND sg13cmos5l_tiehi
X_06156_ _09450_/D _06299_/A _06156_/B VPWR VGND sg13cmos5l_nor2_1
X_06087_ _06397_/A _06472_/A _06098_/A VPWR VGND sg13cmos5l_nand2_1
X_05107_ _05107_/Y _09325_/Q _05108_/B VPWR VGND sg13cmos5l_xnor2_1
X_05038_ _05040_/C input9/X hold1265/X _05017_/Y VPWR VGND sg13cmos5l_o21ai_1
XFILLER_37_13 VPWR VGND sg13cmos5l_fill_2
X_06989_ _09582_/D _06989_/A _06990_/B VPWR VGND sg13cmos5l_nor2_1
X_08728_ _08728_/Y _08728_/A _08728_/B VPWR VGND sg13cmos5l_nand2_1
XFILLER_27_732 VPWR VGND sg13cmos5l_fill_1
X_09195__275 _09195_/RESET_B VPWR VGND sg13cmos5l_tiehi
X_08659_ _08661_/D _08635_/Y _08663_/C _08659_/C VPWR VGND sg13cmos5l_nand3b_1
XFILLER_27_787 VPWR VGND sg13cmos5l_fill_2
XFILLER_41_234 VPWR VGND sg13cmos5l_fill_2
XFILLER_23_982 VPWR VGND sg13cmos5l_fill_2
XFILLER_6_669 VPWR VGND sg13cmos5l_fill_1
X_09403__707 _09403_/RESET_B VPWR VGND sg13cmos5l_tiehi
XFILLER_1_330 VPWR VGND sg13cmos5l_fill_1
XFILLER_49_301 VPWR VGND sg13cmos5l_decap_8
X_09104__372 _09104_/RESET_B VPWR VGND sg13cmos5l_tiehi
XFILLER_18_765 VPWR VGND sg13cmos5l_fill_1
XFILLER_45_584 VPWR VGND sg13cmos5l_decap_4
X_09111__365 _09111_/RESET_B VPWR VGND sg13cmos5l_tiehi
X_06010_ _06012_/A _06024_/B _06010_/B VPWR VGND sg13cmos5l_nor2_1
X_07961_ _09140_/D _07938_/B _07967_/B _07960_/Y VPWR VGND sg13cmos5l_a21oi_1
X_06912_ _06912_/Y _06912_/A _06920_/A VPWR VGND sg13cmos5l_nand2_1
X_07892_ _09136_/D _07892_/A _07892_/B VPWR VGND sg13cmos5l_nor2_1
X_06843_ _06884_/A _09559_/Q _06843_/B VPWR VGND sg13cmos5l_xor2_1
X_09562_ _09562_/Q _09565_/CLK _09562_/D _09562_/RESET_B VPWR VGND sg13cmos5l_dfrbpq_1
X_06774_ _06774_/Y _06770_/Y _06772_/Y _06773_/Y VPWR VGND sg13cmos5l_o21ai_1
X_05725_ _05725_/Y _05574_/B _05746_/A _05627_/X _05580_/B VPWR VGND sg13cmos5l_a22oi_1
X_08513_ _08539_/B _08503_/Y _08511_/Y _08512_/Y VPWR VGND sg13cmos5l_a21oi_1
X_09493_ _09493_/Q _09586_/CLK _09493_/D _09493_/RESET_B VPWR VGND sg13cmos5l_dfrbpq_1
X_08444_ _08444_/Y _08444_/A _08444_/B VPWR VGND sg13cmos5l_nor2_1
X_05656_ _05656_/Y _05656_/A _05661_/B VPWR VGND sg13cmos5l_nor2_1
X_05587_ _05587_/Y _05567_/Y _05569_/Y _05586_/Y VPWR VGND sg13cmos5l_a21oi_1
X_08375_ _08375_/Y _08547_/B _08378_/B _08374_/Y VPWR VGND sg13cmos5l_a21oi_1
XFILLER_11_429 VPWR VGND sg13cmos5l_fill_2
X_07326_ _09042_/D _07389_/B _07326_/B VPWR VGND sg13cmos5l_nor2_1
X_07257_ _07272_/C _09038_/Q _07258_/B VPWR VGND sg13cmos5l_xnor2_1
X_06208_ _09460_/D _06727_/A hold886/X VPWR VGND sg13cmos5l_and2_1
X_07188_ _09014_/D _09005_/A _07188_/B VPWR VGND sg13cmos5l_nor2_1
X_06139_ _06139_/Y _06139_/A _06144_/A VPWR VGND sg13cmos5l_nand2_1
XFILLER_2_138 VPWR VGND sg13cmos5l_fill_2
XFILLER_42_598 VPWR VGND sg13cmos5l_fill_1
Xfanout60 fanout60/X fanout61/X VPWR VGND sg13cmos5l_buf_1
Xfanout82 _08419_/B _08405_/Y VPWR VGND sg13cmos5l_buf_1
Xfanout71 _07193_/B _07196_/B VPWR VGND sg13cmos5l_buf_1
XFILLER_11_963 VPWR VGND sg13cmos5l_decap_4
Xfanout93 _06762_/A _06746_/Y VPWR VGND sg13cmos5l_buf_1
XFILLER_6_455 VPWR VGND sg13cmos5l_fill_2
XFILLER_6_488 VPWR VGND sg13cmos5l_fill_1
X_09477__627 _09477_/RESET_B VPWR VGND sg13cmos5l_tiehi
XFILLER_37_304 VPWR VGND sg13cmos5l_fill_2
X_09338__778 _09338_/RESET_B VPWR VGND sg13cmos5l_tiehi
X_09178__292 _09178_/RESET_B VPWR VGND sg13cmos5l_tiehi
X_05510_ _05511_/B _05510_/A _05510_/B VPWR VGND sg13cmos5l_nor2_1
X_06490_ _06533_/C _09508_/Q _06541_/A _06498_/A VPWR VGND sg13cmos5l_o21ai_1
X_05441_ _09351_/D _05693_/A hold899/X VPWR VGND sg13cmos5l_and2_1
X_08160_ _08198_/A _08197_/B _08197_/C _08197_/A VPWR VGND sg13cmos5l_a21oi_1
X_05372_ _05474_/D _05379_/C _05371_/B _05130_/Y VPWR VGND sg13cmos5l_o21ai_1
X_07111_ hold934/A _07098_/X _07110_/Y hold933/X VPWR VGND sg13cmos5l_o21ai_1
X_08091_ _08091_/Y _09122_/Q _08397_/A VPWR VGND sg13cmos5l_nor2b_1
X_07042_ _07042_/X _06868_/B _07053_/B _07041_/Y VPWR VGND sg13cmos5l_a21o_1
XFILLER_47_1014 VPWR VGND sg13cmos5l_decap_8
X_09185__285 _09185_/RESET_B VPWR VGND sg13cmos5l_tiehi
X_08993_ _09312_/D _08995_/A hold859/X VPWR VGND sg13cmos5l_and2_1
X_07944_ _07946_/A _07967_/A _07944_/B VPWR VGND sg13cmos5l_nor2_1
X_07875_ _09124_/D _07875_/A _07875_/B VPWR VGND sg13cmos5l_nor2_1
X_06826_ _06826_/X _09589_/Q _07295_/A VPWR VGND sg13cmos5l_xor2_1
X_09545_ _09545_/Q clkload24/A _09545_/D _09545_/RESET_B VPWR VGND sg13cmos5l_dfrbpq_1
X_06757_ _06759_/A _09547_/Q _06762_/A _06798_/A VPWR VGND sg13cmos5l_a21o_1
X_09476_ _09476_/Q clkload21/A _09476_/D _09476_/RESET_B VPWR VGND sg13cmos5l_dfrbpq_1
X_06688_ _06688_/Y _06993_/A _09497_/Q _09496_/Q _06992_/A _06687_/Y VPWR VGND sg13cmos5l_a221oi_1
X_05708_ _05751_/A _09393_/Q _05719_/B VPWR VGND sg13cmos5l_xnor2_1
XFILLER_34_36 VPWR VGND sg13cmos5l_fill_1
X_05639_ _09377_/D _05764_/A hold1204/X _05637_/A VPWR VGND sg13cmos5l_a21oi_1
X_08427_ _08427_/Y _08427_/A _08427_/B _08427_/C _08427_/D VPWR VGND sg13cmos5l_nand4_1
X_09192__278 _09192_/RESET_B VPWR VGND sg13cmos5l_tiehi
Xclkload2 clkload2/Y clkload2/A VPWR VGND sg13cmos5l_inv_4
X_08358_ _08358_/Y _08358_/A _08366_/B VPWR VGND sg13cmos5l_nor2_1
X_07309_ _07309_/Y _07303_/Y _07306_/Y _07308_/Y VPWR VGND sg13cmos5l_a21oi_1
X_08289_ _08289_/Y _08649_/A _08289_/B VPWR VGND sg13cmos5l_nor2_1
XFILLER_4_915 VPWR VGND sg13cmos5l_fill_2
XFILLER_47_613 VPWR VGND sg13cmos5l_fill_1
X_09101__375 _09101_/RESET_B VPWR VGND sg13cmos5l_tiehi
X_05990_ _05991_/B _09432_/Q _05990_/B VPWR VGND sg13cmos5l_xnor2_1
Xhold1409 hold1409/X _09564_/Q VPWR VGND sg13cmos5l_dlygate4sd3_1
X_04941_ _04941_/Y hold980/A VPWR VGND sg13cmos5l_inv_1
XFILLER_38_624 VPWR VGND sg13cmos5l_fill_2
X_07660_ _07705_/A _07698_/A _07660_/B VPWR VGND sg13cmos5l_and2_1
XFILLER_25_307 VPWR VGND sg13cmos5l_fill_1
X_04872_ _06739_/A _04872_/A VPWR VGND sg13cmos5l_inv_1
X_07591_ _07612_/A _07891_/A _07602_/B _07590_/Y VPWR VGND sg13cmos5l_o21ai_1
X_06611_ _06768_/A _06617_/C _06611_/B VPWR VGND sg13cmos5l_nand2_1
X_06542_ _06542_/Y _06542_/A _06542_/B VPWR VGND sg13cmos5l_nand2_1
X_09330_ _09330_/Q clkload12/A _09330_/D _09330_/RESET_B VPWR VGND sg13cmos5l_dfrbpq_1
X_09261_ _09261_/Q clkload9/A _09261_/D _09261_/RESET_B VPWR VGND sg13cmos5l_dfrbpq_1
X_08212_ _08213_/A _08166_/A _08170_/B _08232_/A VPWR VGND sg13cmos5l_o21ai_1
X_06473_ _09506_/D _06473_/A _06473_/B VPWR VGND sg13cmos5l_and2_1
X_09192_ _09192_/Q _09595_/CLK _09192_/D _09192_/RESET_B VPWR VGND sg13cmos5l_dfrbpq_1
X_05424_ _05424_/Y _05405_/A _05421_/B _05262_/Y VPWR VGND sg13cmos5l_o21ai_1
X_05355_ _05355_/Y _05355_/A _05376_/A _05376_/B VPWR VGND sg13cmos5l_nand3_1
X_09529__572 _09529_/RESET_B VPWR VGND sg13cmos5l_tiehi
X_08143_ _09171_/D _08994_/A hold992/X VPWR VGND sg13cmos5l_and2_1
X_08074_ _08175_/C _08082_/A _08082_/C _07765_/Y VPWR VGND sg13cmos5l_a21o_1
X_05286_ _05292_/B _05286_/A _05286_/B VPWR VGND sg13cmos5l_nor2_1
X_07025_ _07025_/Y _07021_/Y _07023_/Y _07024_/Y VPWR VGND sg13cmos5l_o21ai_1
XFILLER_0_417 VPWR VGND sg13cmos5l_fill_2
X_08976_ hold999/A _05387_/B fanout35/X _08975_/Y VPWR VGND sg13cmos5l_a21oi_1
X_07927_ _07927_/Y _07923_/Y _07925_/Y _07926_/Y VPWR VGND sg13cmos5l_o21ai_1
X_07858_ _07858_/Y _04946_/Y _07852_/A _07857_/A _04945_/Y VPWR VGND sg13cmos5l_a22oi_1
XFILLER_21_1028 VPWR VGND sg13cmos5l_fill_1
X_09536__565 _09536_/RESET_B VPWR VGND sg13cmos5l_tiehi
X_07789_ _07812_/A _09082_/Q _09081_/Q _07802_/B VPWR VGND sg13cmos5l_nor3_1
X_06809_ _06810_/C _06809_/A _06809_/B VPWR VGND sg13cmos5l_or2_1
X_09528_ _09528_/Q _09591_/CLK _09528_/D _09528_/RESET_B VPWR VGND sg13cmos5l_dfrbpq_1
X_09459_ _09459_/Q clkload22/A _09459_/D _09459_/RESET_B VPWR VGND sg13cmos5l_dfrbpq_1
X_09467__637 _09467_/RESET_B VPWR VGND sg13cmos5l_tiehi
XFILLER_8_539 VPWR VGND sg13cmos5l_fill_2
X_09328__788 _09328_/RESET_B VPWR VGND sg13cmos5l_tiehi
XFILLER_3_222 VPWR VGND sg13cmos5l_fill_2
X_09292__464 _09292_/RESET_B VPWR VGND sg13cmos5l_tiehi
X_09175__295 _09175_/RESET_B VPWR VGND sg13cmos5l_tiehi
XFILLER_15_373 VPWR VGND sg13cmos5l_fill_1
X_05140_ _05143_/B _09285_/Q _08997_/A VPWR VGND sg13cmos5l_nor2_1
X_05071_ _05083_/A _09317_/Q _05078_/B _05231_/A VPWR VGND sg13cmos5l_a21o_1
X_09182__288 _09182_/RESET_B VPWR VGND sg13cmos5l_tiehi
X_08830_ _08830_/Y hold952/X fanout47/X _08838_/A VPWR VGND sg13cmos5l_o21ai_1
Xhold1206 _07890_/A _09102_/Q VPWR VGND sg13cmos5l_dlygate4sd3_1
XFILLER_25_0 VPWR VGND sg13cmos5l_fill_2
X_08761_ _08868_/C _08761_/A _08761_/B _08761_/C VPWR VGND sg13cmos5l_nor3_1
XFILLER_39_955 VPWR VGND sg13cmos5l_decap_8
XFILLER_39_944 VPWR VGND sg13cmos5l_fill_2
Xhold1217 _07385_/A _09587_/Q VPWR VGND sg13cmos5l_dlygate4sd3_1
Xhold1228 _05466_/A _09353_/Q VPWR VGND sg13cmos5l_dlygate4sd3_1
Xhold1239 _05742_/B _05741_/X VPWR VGND sg13cmos5l_dlygate4sd3_1
X_05973_ _06023_/A _09433_/Q _05986_/B VPWR VGND sg13cmos5l_xnor2_1
X_04924_ _08779_/A _07151_/B VPWR VGND sg13cmos5l_inv_1
X_07712_ _09103_/D _07685_/X _07715_/S _07711_/Y VPWR VGND sg13cmos5l_a21oi_1
X_08692_ _08692_/X _08692_/A _08692_/B VPWR VGND sg13cmos5l_and2_1
X_04855_ _08996_/A _04855_/A VPWR VGND sg13cmos5l_inv_1
X_07643_ _07657_/B _07641_/Y _07642_/Y _07640_/Y VPWR VGND sg13cmos5l_a21oi_1
XFILLER_25_104 VPWR VGND sg13cmos5l_fill_2
XFILLER_26_627 VPWR VGND sg13cmos5l_fill_2
X_07574_ _07576_/B _07549_/Y _07279_/Y _07574_/S VPWR VGND sg13cmos5l_mux2_1
X_09313_ hold899/A _09387_/CLK _09313_/D _09313_/RESET_B VPWR VGND sg13cmos5l_dfrbpq_1
X_06525_ _06525_/X _06496_/Y _06524_/Y _06522_/Y VPWR VGND sg13cmos5l_a21o_1
X_09244_ _09244_/Q clkload3/A _09244_/D _09244_/RESET_B VPWR VGND sg13cmos5l_dfrbpq_1
X_06456_ _06457_/B _04970_/Y _06439_/Y _06456_/S VPWR VGND sg13cmos5l_mux2_1
X_09175_ _09175_/Q _09388_/CLK _09175_/D _09175_/RESET_B VPWR VGND sg13cmos5l_dfrbpq_1
X_05407_ _05407_/Y _05407_/A _05407_/B VPWR VGND sg13cmos5l_nand2_1
X_06387_ _06387_/X _06387_/A _06387_/B _06387_/C VPWR VGND sg13cmos5l_and3_1
X_08126_ _09161_/D _08132_/A _08126_/B VPWR VGND sg13cmos5l_nor2_1
X_05338_ _05341_/B _09298_/Q _09299_/Q _09297_/Q _09296_/Q VPWR VGND sg13cmos5l_or4_1
X_05269_ _05310_/A _09333_/Q _05269_/B VPWR VGND sg13cmos5l_xor2_1
Xoutput15 uo_out[2] _09231_/Q VPWR VGND sg13cmos5l_buf_1
X_08057_ _08057_/Y _07776_/B _08082_/B _08056_/Y VPWR VGND sg13cmos5l_o21ai_1
XFILLER_0_203 VPWR VGND sg13cmos5l_fill_1
X_07008_ _07009_/B hold1318/X _07015_/B VPWR VGND sg13cmos5l_nand2b_1
X_08959_ _08959_/Y _08959_/A _08964_/B VPWR VGND sg13cmos5l_nor2_1
XFILLER_44_468 VPWR VGND sg13cmos5l_fill_1
XFILLER_9_826 VPWR VGND sg13cmos5l_fill_2
XFILLER_40_685 VPWR VGND sg13cmos5l_fill_1
XFILLER_4_586 VPWR VGND sg13cmos5l_fill_1
X_09519__582 _09519_/RESET_B VPWR VGND sg13cmos5l_tiehi
XFILLER_36_958 VPWR VGND sg13cmos5l_fill_1
X_06310_ _06312_/B _09482_/Q _09484_/Q _09483_/Q _06337_/A VPWR VGND sg13cmos5l_nor4_1
X_07290_ _07320_/B _09562_/Q _09563_/Q hold1409/X VPWR VGND sg13cmos5l_o21ai_1
X_06241_ _06242_/B _06240_/A _06243_/B _06279_/B VPWR VGND sg13cmos5l_a21oi_1
X_06172_ _06172_/Y _09477_/Q _04980_/Y _04981_/Y _09476_/Q _06171_/Y VPWR VGND sg13cmos5l_a221oi_1
X_05123_ _05124_/A _05199_/C _05366_/A VPWR VGND sg13cmos5l_nor2_1
X_09526__575 _09526_/RESET_B VPWR VGND sg13cmos5l_tiehi
X_05054_ _07199_/B _05054_/A _05433_/A _05054_/C _05054_/D VPWR VGND sg13cmos5l_nor4_1
Xhold1014 _07341_/A _09069_/Q VPWR VGND sg13cmos5l_dlygate4sd3_1
Xhold1003 _08120_/A _09159_/Q VPWR VGND sg13cmos5l_dlygate4sd3_1
X_09320__836 _09320_/RESET_B VPWR VGND sg13cmos5l_tiehi
X_08813_ _08813_/Y _08953_/B _08813_/B VPWR VGND sg13cmos5l_nor2_1
X_08744_ _08774_/B _09257_/Q _08746_/B VPWR VGND sg13cmos5l_xor2_1
Xhold1036 _04902_/A _09105_/Q VPWR VGND sg13cmos5l_dlygate4sd3_1
Xhold1058 _09046_/D _07366_/Y VPWR VGND sg13cmos5l_dlygate4sd3_1
Xhold1025 _08599_/A _09216_/Q VPWR VGND sg13cmos5l_dlygate4sd3_1
X_05956_ _05956_/Y hold947/A fanout57/X _05961_/A VPWR VGND sg13cmos5l_o21ai_1
Xhold1047 _05403_/A _09361_/Q VPWR VGND sg13cmos5l_dlygate4sd3_1
X_04907_ _07638_/A _07355_/A VPWR VGND sg13cmos5l_inv_1
Xhold1069 _06692_/A _09493_/Q VPWR VGND sg13cmos5l_dlygate4sd3_1
X_05887_ _05893_/B _05887_/A _05903_/A VPWR VGND sg13cmos5l_nor2_1
X_08675_ _08676_/B _08675_/A _08675_/B VPWR VGND sg13cmos5l_and2_1
XFILLER_27_947 VPWR VGND sg13cmos5l_decap_8
X_09533__568 _09533_/RESET_B VPWR VGND sg13cmos5l_tiehi
X_07626_ _09090_/D _04829_/Y fanout61/X _07625_/Y VPWR VGND sg13cmos5l_a21oi_1
XFILLER_26_59 VPWR VGND sg13cmos5l_fill_1
X_04838_ _04838_/Y hold930/X VPWR VGND sg13cmos5l_inv_1
X_07557_ _07557_/Y _07233_/Y _07554_/X _07556_/Y VPWR VGND sg13cmos5l_o21ai_1
X_06508_ _06508_/Y _06371_/B _06540_/B _06507_/Y VPWR VGND sg13cmos5l_a21oi_1
Xclkbuf_leaf_33_clk _09388_/CLK clkbuf_leaf_4_clk/A VPWR VGND sg13cmos5l_buf_8
X_07488_ _07488_/Y _09071_/Q _09070_/Q _09102_/Q VPWR VGND sg13cmos5l_nand3b_1
X_09227_ _09227_/Q clkload2/A _09227_/D _09227_/RESET_B VPWR VGND sg13cmos5l_dfrbpq_1
X_06439_ _06439_/Y _06439_/A VPWR VGND sg13cmos5l_inv_1
X_09158_ _09158_/Q clkload4/A _09158_/D _09158_/RESET_B VPWR VGND sg13cmos5l_dfrbpq_1
X_08109_ _08127_/A _08399_/A _08111_/B _08108_/Y VPWR VGND sg13cmos5l_o21ai_1
X_09089_ hold945/A _09312_/CLK _09089_/D _09089_/RESET_B VPWR VGND sg13cmos5l_dfrbpq_1
Xhold881 hold881/X hold881/A VPWR VGND sg13cmos5l_dlygate4sd3_1
Xhold870 hold870/X hold870/A VPWR VGND sg13cmos5l_dlygate4sd3_1
Xhold892 hold892/X hold892/A VPWR VGND sg13cmos5l_dlygate4sd3_1
XFILLER_45_766 VPWR VGND sg13cmos5l_fill_1
Xclkbuf_leaf_24_clk clkload13/A clkbuf_3_4__f_clk/X VPWR VGND sg13cmos5l_buf_8
X_09172__298 _09172_/RESET_B VPWR VGND sg13cmos5l_tiehi
XFILLER_9_645 VPWR VGND sg13cmos5l_fill_1
XFILLER_12_195 VPWR VGND sg13cmos5l_fill_2
XFILLER_5_895 VPWR VGND sg13cmos5l_fill_2
X_05810_ _05820_/B _09438_/Q _09439_/Q _09437_/Q _09436_/Q VPWR VGND sg13cmos5l_nor4_1
X_06790_ _06790_/Y _06790_/A _06799_/B VPWR VGND sg13cmos5l_nand2_1
X_05741_ _05741_/X _05741_/A _05741_/B VPWR VGND sg13cmos5l_xor2_1
X_08460_ _08461_/B _08418_/A _08422_/B _08418_/B VPWR VGND sg13cmos5l_o21ai_1
X_05672_ _05672_/Y _05909_/B _05670_/B _05669_/X _05671_/Y VPWR VGND sg13cmos5l_a22oi_1
X_07411_ _07466_/A _07412_/B _07446_/A _07411_/C VPWR VGND sg13cmos5l_nand3b_1
X_08391_ _08391_/Y hold987/X fanout53/X _08134_/A VPWR VGND sg13cmos5l_o21ai_1
X_07342_ _07342_/Y _07588_/B _07342_/B VPWR VGND sg13cmos5l_nand2_1
Xclkbuf_leaf_15_clk clkload19/A clkbuf_3_6__f_clk/X VPWR VGND sg13cmos5l_buf_8
X_07273_ _07275_/B _07419_/A _07419_/B VPWR VGND sg13cmos5l_and2_1
X_06224_ _06224_/Y hold946/X hold873/X VPWR VGND sg13cmos5l_nand2_1
X_09012_ _09012_/Q _09288_/CLK _09012_/D _09012_/RESET_B VPWR VGND sg13cmos5l_dfrbpq_1
X_06155_ _06155_/X _06155_/A _06155_/B VPWR VGND sg13cmos5l_and2_1
X_09604__525 _09604_/RESET_B VPWR VGND sg13cmos5l_tiehi
X_05106_ _05113_/B _09324_/Q _09325_/Q _09323_/Q _09322_/Q VPWR VGND sg13cmos5l_nor4_1
X_06086_ _06086_/Y _06086_/A _06112_/A VPWR VGND sg13cmos5l_nor2_1
X_05037_ _05040_/B _05015_/Y _05036_/Y hold1296/X VPWR VGND sg13cmos5l_o21ai_1
XFILLER_2_1014 VPWR VGND sg13cmos5l_decap_8
X_06988_ _09581_/D _06988_/A _06988_/B VPWR VGND sg13cmos5l_and2_1
X_08727_ _08728_/B _09251_/Q _09283_/Q VPWR VGND sg13cmos5l_nand2_1
X_05939_ _05949_/B _09421_/Q _05937_/B _05936_/X _05938_/Y VPWR VGND sg13cmos5l_a22oi_1
X_08658_ _08661_/C _08659_/C _08663_/C _08278_/Y VPWR VGND sg13cmos5l_a21o_1
XFILLER_41_224 VPWR VGND sg13cmos5l_fill_1
X_07609_ _07609_/Y _07606_/Y _07608_/Y _07589_/Y VPWR VGND sg13cmos5l_o21ai_1
X_08589_ _08589_/Y _04823_/A _08579_/Y _08599_/B VPWR VGND sg13cmos5l_o21ai_1
XFILLER_23_994 VPWR VGND sg13cmos5l_fill_2
X_09509__592 _09509_/RESET_B VPWR VGND sg13cmos5l_tiehi
XFILLER_45_552 VPWR VGND sg13cmos5l_fill_2
X_09516__585 _09516_/RESET_B VPWR VGND sg13cmos5l_tiehi
X_07960_ _07960_/Y _07938_/A _07967_/B _07890_/B VPWR VGND sg13cmos5l_o21ai_1
X_09523__578 _09523_/RESET_B VPWR VGND sg13cmos5l_tiehi
X_06911_ _06911_/Y _06581_/Y _06906_/Y _06910_/X _06596_/A VPWR VGND sg13cmos5l_a22oi_1
Xclkbuf_leaf_4_clk _09312_/CLK clkbuf_leaf_4_clk/A VPWR VGND sg13cmos5l_buf_8
X_07891_ _09135_/D _07891_/A _07892_/B VPWR VGND sg13cmos5l_nor2_1
X_09493__611 _09493_/RESET_B VPWR VGND sg13cmos5l_tiehi
X_06842_ _06850_/B _09559_/Q _06843_/B VPWR VGND sg13cmos5l_nor2b_1
X_09561_ _09561_/Q _09565_/CLK _09561_/D _09561_/RESET_B VPWR VGND sg13cmos5l_dfrbpq_1
X_06773_ _06773_/Y _06626_/X _06676_/B _06775_/B _06799_/A VPWR VGND sg13cmos5l_a22oi_1
X_08512_ _08512_/Y _08518_/B _08510_/Y _08506_/Y VPWR VGND sg13cmos5l_a21oi_1
X_05724_ _05739_/A _05742_/A _05724_/B VPWR VGND sg13cmos5l_nand2_1
X_09492_ _09492_/Q _09586_/CLK _09492_/D _09492_/RESET_B VPWR VGND sg13cmos5l_dfrbpq_1
X_08443_ _08444_/B _08277_/B _08328_/B _08456_/B VPWR VGND sg13cmos5l_mux2_1
XFILLER_17_1000 VPWR VGND sg13cmos5l_fill_2
X_05655_ _05655_/Y _09379_/Q _05654_/Y _09378_/Q VPWR VGND sg13cmos5l_o21ai_1
X_05586_ _05586_/Y _05586_/A _05586_/B VPWR VGND sg13cmos5l_nand2_1
X_08374_ _08374_/Y _08352_/X _08378_/B _08397_/B VPWR VGND sg13cmos5l_o21ai_1
X_07325_ _07326_/B _06880_/Y _07327_/S _07324_/X VPWR VGND sg13cmos5l_a21oi_1
XFILLER_23_49 VPWR VGND sg13cmos5l_fill_2
X_07256_ _07272_/B _07253_/Y _07254_/Y _07234_/Y VPWR VGND sg13cmos5l_a21o_1
X_06207_ _06207_/Y _04972_/Y _06177_/B _06303_/A VPWR VGND sg13cmos5l_a21oi_1
X_07187_ _07188_/B hold1170/X _07193_/B _07186_/Y VPWR VGND sg13cmos5l_o21ai_1
X_06138_ _06138_/Y _05816_/B _06161_/A _06137_/X _05826_/B VPWR VGND sg13cmos5l_a22oi_1
X_06069_ _06106_/B _06069_/A _06073_/A VPWR VGND sg13cmos5l_xor2_1
XFILLER_24_1026 VPWR VGND sg13cmos5l_fill_2
XFILLER_27_530 VPWR VGND sg13cmos5l_fill_2
XFILLER_27_596 VPWR VGND sg13cmos5l_fill_1
XFILLER_42_566 VPWR VGND sg13cmos5l_fill_1
Xfanout72 _05199_/B _05132_/C VPWR VGND sg13cmos5l_buf_1
Xfanout83 _08169_/A _08153_/Y VPWR VGND sg13cmos5l_buf_1
Xfanout50 fanout50/X fanout51/X VPWR VGND sg13cmos5l_buf_1
Xfanout61 fanout61/X fanout62/X VPWR VGND sg13cmos5l_buf_1
XFILLER_7_902 VPWR VGND sg13cmos5l_fill_2
Xfanout94 _06674_/A _06656_/B VPWR VGND sg13cmos5l_buf_1
XFILLER_7_957 VPWR VGND sg13cmos5l_fill_2
XFILLER_6_423 VPWR VGND sg13cmos5l_fill_1
XFILLER_2_662 VPWR VGND sg13cmos5l_fill_1
XFILLER_46_861 VPWR VGND sg13cmos5l_fill_2
Xclkbuf_3_7__f_clk clkload1/A clkbuf_0_clk/X VPWR VGND sg13cmos5l_buf_8
X_05440_ _09350_/D _08134_/A hold857/X VPWR VGND sg13cmos5l_and2_1
X_05371_ _05474_/C _05379_/C _05371_/B _05371_/C VPWR VGND sg13cmos5l_or3_1
XFILLER_9_261 VPWR VGND sg13cmos5l_fill_2
X_07110_ _07110_/Y _07110_/A VPWR VGND sg13cmos5l_inv_1
Xclkload20 clkload20/Y clkload20/A VPWR VGND sg13cmos5l_inv_4
X_08090_ _08090_/Y _09121_/Q _09178_/Q VPWR VGND sg13cmos5l_nor2b_1
X_07041_ _07041_/Y _07018_/C _07018_/D _07025_/Y _07027_/Y _07028_/X VPWR VGND sg13cmos5l_a221oi_1
X_08992_ _09311_/D _04814_/Y fanout62/X _08991_/Y VPWR VGND sg13cmos5l_a21oi_1
X_07943_ _07943_/Y _07936_/Y _07938_/Y _07942_/Y VPWR VGND sg13cmos5l_o21ai_1
X_07874_ _07875_/B _04945_/Y _07859_/B _07874_/S VPWR VGND sg13cmos5l_mux2_1
X_06825_ _06825_/Y hold957/X _07382_/A VPWR VGND sg13cmos5l_nand2b_1
X_09544_ _09544_/Q clkload24/A _09544_/D _09544_/RESET_B VPWR VGND sg13cmos5l_dfrbpq_1
X_06756_ _06798_/A _06797_/B _06797_/C _06797_/A VPWR VGND sg13cmos5l_a21oi_1
X_09475_ _09475_/Q clkload21/A _09475_/D _09475_/RESET_B VPWR VGND sg13cmos5l_dfrbpq_1
X_06687_ _06687_/Y _09553_/Q _04969_/Y _04970_/Y _09552_/Q _06686_/Y VPWR VGND sg13cmos5l_a221oi_1
X_05707_ _05758_/B _05707_/A _05719_/B VPWR VGND sg13cmos5l_nand2_1
X_05638_ _05734_/B _05764_/A _05764_/C VPWR VGND sg13cmos5l_nand2_1
X_08426_ _08426_/X _08426_/A _08426_/B _08426_/C _08426_/D VPWR VGND sg13cmos5l_or4_1
X_05569_ _05569_/Y _05588_/A _05586_/A _05568_/Y VPWR VGND sg13cmos5l_a21oi_1
X_08357_ _08362_/A _04930_/Y _08355_/X _08356_/Y VPWR VGND sg13cmos5l_a21oi_1
Xclkload3 clkload3/Y clkload3/A VPWR VGND sg13cmos5l_inv_2
X_07308_ _07308_/Y _06855_/Y _07305_/X _07307_/Y VPWR VGND sg13cmos5l_o21ai_1
X_08288_ _09186_/D _08400_/B _08288_/B VPWR VGND sg13cmos5l_nor2_1
X_07239_ _07241_/B _09064_/Q _09032_/Q VPWR VGND sg13cmos5l_nand2_1
XFILLER_4_938 VPWR VGND sg13cmos5l_fill_1
X_09506__595 _09506_/RESET_B VPWR VGND sg13cmos5l_tiehi
XFILLER_46_168 VPWR VGND sg13cmos5l_fill_2
XFILLER_43_886 VPWR VGND sg13cmos5l_fill_1
X_09513__588 _09513_/RESET_B VPWR VGND sg13cmos5l_tiehi
X_09483__621 _09483_/RESET_B VPWR VGND sg13cmos5l_tiehi
X_09344__772 _09344_/RESET_B VPWR VGND sg13cmos5l_tiehi
X_04940_ _08113_/A hold969/X VPWR VGND sg13cmos5l_inv_1
X_04871_ _09000_/A _08809_/A VPWR VGND sg13cmos5l_inv_1
X_09490__614 _09490_/RESET_B VPWR VGND sg13cmos5l_tiehi
X_07590_ _07590_/Y _07590_/A _07602_/B VPWR VGND sg13cmos5l_nand2_1
X_06610_ _06611_/B _09550_/Q _06912_/A VPWR VGND sg13cmos5l_nor2_1
X_06541_ _06542_/B _06541_/A hold1249/X VPWR VGND sg13cmos5l_nor2b_1
X_09236__828 _09236_/RESET_B VPWR VGND sg13cmos5l_tiehi
X_09260_ _09260_/Q clkload9/A _09260_/D _09260_/RESET_B VPWR VGND sg13cmos5l_dfrbpq_1
X_06472_ _09505_/D _06472_/A _06473_/B VPWR VGND sg13cmos5l_and2_1
X_08211_ _08217_/A _08211_/A _08183_/B VPWR VGND sg13cmos5l_nor2b_1
X_05423_ _05423_/Y _05423_/A _05423_/B _05423_/C VPWR VGND sg13cmos5l_nor3_1
X_09191_ _09191_/Q _09595_/CLK _09191_/D _09191_/RESET_B VPWR VGND sg13cmos5l_dfrbpq_1
X_05354_ _05354_/Y _05370_/B _05352_/X _05353_/X _08945_/A VPWR VGND sg13cmos5l_a22oi_1
X_08142_ _09170_/D _08394_/A hold881/X VPWR VGND sg13cmos5l_and2_1
X_05285_ _05292_/A _05274_/X _05278_/Y _05286_/A _05286_/B _05279_/X VPWR VGND sg13cmos5l_a221oi_1
X_08073_ _09153_/D _08081_/A _08073_/B VPWR VGND sg13cmos5l_nor2_1
X_07024_ _07024_/Y _07031_/A _06928_/B _06932_/B _06885_/Y VPWR VGND sg13cmos5l_a22oi_1
XFILLER_0_429 VPWR VGND sg13cmos5l_fill_2
X_08975_ _08975_/Y _08952_/Y fanout35/X _08997_/B VPWR VGND sg13cmos5l_o21ai_1
X_09280__561 _09280_/RESET_B VPWR VGND sg13cmos5l_tiehi
X_07926_ _07926_/Y _07778_/A _07828_/B _07950_/A _07782_/Y VPWR VGND sg13cmos5l_a22oi_1
X_07857_ _07859_/B _07857_/A VPWR VGND sg13cmos5l_inv_1
X_07788_ _07802_/B _09079_/Q _09080_/Q _09077_/Q _09078_/Q VPWR VGND sg13cmos5l_or4_1
X_06808_ _06808_/Y _06810_/A _06810_/B VPWR VGND sg13cmos5l_nand2_1
X_09527_ _09527_/Q _09591_/CLK _09527_/D _09527_/RESET_B VPWR VGND sg13cmos5l_dfrbpq_1
X_06739_ _09545_/D _06739_/A _06742_/B VPWR VGND sg13cmos5l_nor2_1
XFILLER_36_190 VPWR VGND sg13cmos5l_fill_1
X_09458_ _09458_/Q clkload22/A _09458_/D _09458_/RESET_B VPWR VGND sg13cmos5l_dfrbpq_1
XFILLER_40_856 VPWR VGND sg13cmos5l_fill_2
X_08409_ _08438_/B _08419_/A _08419_/B VPWR VGND sg13cmos5l_and2_1
X_09389_ hold861/A clkload18/A _09389_/D _09389_/RESET_B VPWR VGND sg13cmos5l_dfrbpq_1
XFILLER_8_529 VPWR VGND sg13cmos5l_fill_1
XFILLER_4_702 VPWR VGND sg13cmos5l_fill_1
XFILLER_0_941 VPWR VGND sg13cmos5l_decap_8
XFILLER_47_422 VPWR VGND sg13cmos5l_fill_1
XFILLER_47_411 VPWR VGND sg13cmos5l_fill_2
XFILLER_0_996 VPWR VGND sg13cmos5l_decap_8
XFILLER_47_477 VPWR VGND sg13cmos5l_fill_1
XFILLER_19_168 VPWR VGND sg13cmos5l_fill_2
XFILLER_42_193 VPWR VGND sg13cmos5l_decap_8
X_05070_ _05231_/A _05230_/B _05230_/C _05230_/A VPWR VGND sg13cmos5l_a21oi_1
Xhold1207 hold1207/X _09605_/Q VPWR VGND sg13cmos5l_dlygate4sd3_1
X_08760_ _08868_/B _08729_/Y _08774_/B _08764_/B _08751_/Y VPWR VGND sg13cmos5l_a22oi_1
Xhold1218 hold1218/X _09122_/Q VPWR VGND sg13cmos5l_dlygate4sd3_1
X_05972_ _05972_/Y _05970_/Y _05971_/Y _06008_/A VPWR VGND sg13cmos5l_a21oi_1
Xhold1229 _07126_/A _09028_/Q VPWR VGND sg13cmos5l_dlygate4sd3_1
X_07711_ _07711_/Y _07683_/Y _07715_/S _07634_/B VPWR VGND sg13cmos5l_o21ai_1
X_08691_ _08694_/B _08534_/B _08664_/Y _08699_/B VPWR VGND sg13cmos5l_mux2_1
XFILLER_18_0 VPWR VGND sg13cmos5l_fill_2
X_04923_ _08785_/A _04923_/A VPWR VGND sg13cmos5l_inv_1
X_07642_ _07642_/Y hold996/A hold884/A VPWR VGND sg13cmos5l_xnor2_1
X_09275__641 _09275_/RESET_B VPWR VGND sg13cmos5l_tiehi
X_04854_ _05967_/A hold997/X VPWR VGND sg13cmos5l_inv_1
X_07573_ _09080_/D _07716_/A _07573_/B VPWR VGND sg13cmos5l_nor2_1
X_09312_ hold857/A _09312_/CLK _09312_/D _09312_/RESET_B VPWR VGND sg13cmos5l_dfrbpq_1
X_06524_ _06524_/Y _06401_/B _06535_/B _06523_/X VPWR VGND sg13cmos5l_o21ai_1
XFILLER_22_812 VPWR VGND sg13cmos5l_fill_1
X_09243_ _09243_/Q _09595_/CLK _09243_/D _09243_/RESET_B VPWR VGND sg13cmos5l_dfrbpq_1
X_06455_ _06455_/Y _06434_/Y _06456_/S _06454_/Y VPWR VGND sg13cmos5l_a21oi_1
XFILLER_33_182 VPWR VGND sg13cmos5l_fill_1
X_06386_ _06409_/B _09451_/Q _06387_/B VPWR VGND sg13cmos5l_xor2_1
X_09174_ _09174_/Q _09388_/CLK _09174_/D _09174_/RESET_B VPWR VGND sg13cmos5l_dfrbpq_1
X_05406_ _05407_/B _09341_/Q _05400_/Y _05405_/Y _09342_/Q VPWR VGND sg13cmos5l_a22oi_1
X_05337_ _05376_/A _09298_/Q _09297_/Q _09296_/Q VPWR VGND sg13cmos5l_or3_1
X_08125_ _08126_/B _04942_/Y _08105_/Y _08130_/B VPWR VGND sg13cmos5l_mux2_1
X_05268_ _05330_/A _09333_/Q _05269_/B VPWR VGND sg13cmos5l_xnor2_1
X_08056_ _08056_/Y _08056_/A _08079_/A _08079_/B VPWR VGND sg13cmos5l_nand3_1
X_05199_ _05199_/Y _05117_/A _05199_/B _05199_/C VPWR VGND sg13cmos5l_nand3b_1
Xoutput16 uo_out[3] _09232_/Q VPWR VGND sg13cmos5l_buf_1
X_07007_ _07009_/A _09585_/Q _07011_/B _07052_/A VPWR VGND sg13cmos5l_a21o_1
X_09503__598 _09503_/RESET_B VPWR VGND sg13cmos5l_tiehi
X_08958_ _08963_/A _04996_/Y _08956_/Y _08957_/Y VPWR VGND sg13cmos5l_a21oi_1
XFILLER_29_422 VPWR VGND sg13cmos5l_fill_2
X_09473__631 _09473_/RESET_B VPWR VGND sg13cmos5l_tiehi
X_08889_ _08892_/B _08889_/A _08889_/B _08889_/C VPWR VGND sg13cmos5l_nand3_1
X_07909_ _07949_/A _07948_/B _07948_/C _07948_/A VPWR VGND sg13cmos5l_a21oi_1
XFILLER_16_127 VPWR VGND sg13cmos5l_fill_1
XFILLER_31_119 VPWR VGND sg13cmos5l_fill_1
X_09334__782 _09334_/RESET_B VPWR VGND sg13cmos5l_tiehi
XFILLER_40_642 VPWR VGND sg13cmos5l_fill_1
XFILLER_40_664 VPWR VGND sg13cmos5l_fill_1
XFILLER_9_838 VPWR VGND sg13cmos5l_fill_1
X_09480__624 _09480_/RESET_B VPWR VGND sg13cmos5l_tiehi
XFILLER_4_532 VPWR VGND sg13cmos5l_fill_2
XFILLER_4_554 VPWR VGND sg13cmos5l_decap_8
X_09341__775 _09341_/RESET_B VPWR VGND sg13cmos5l_tiehi
Xclkbuf_0_clk clkbuf_0_clk/X clk VPWR VGND sg13cmos5l_buf_8
X_06240_ _06242_/A _06240_/A _06243_/B VPWR VGND sg13cmos5l_or2_1
XFILLER_11_1028 VPWR VGND sg13cmos5l_fill_1
X_06171_ _06171_/Y _06475_/A _09419_/Q _09418_/Q _06474_/A _06170_/Y VPWR VGND sg13cmos5l_a221oi_1
X_05122_ _05122_/Y _05122_/A _05198_/B VPWR VGND sg13cmos5l_nand2_1
X_05053_ _05060_/A _07211_/C VPWR VGND sg13cmos5l_inv_1
Xhold1004 _09159_/D _08121_/Y VPWR VGND sg13cmos5l_dlygate4sd3_1
X_08812_ _08812_/Y _04999_/Y _08825_/A _08811_/Y VPWR VGND sg13cmos5l_o21ai_1
Xhold1015 _05651_/A _09402_/Q VPWR VGND sg13cmos5l_dlygate4sd3_1
X_08743_ _08743_/Y _05164_/Y _08741_/Y _08742_/Y VPWR VGND sg13cmos5l_a21oi_1
Xhold1048 _08098_/B _09126_/Q VPWR VGND sg13cmos5l_dlygate4sd3_1
Xhold1026 _09239_/D _08599_/X VPWR VGND sg13cmos5l_dlygate4sd3_1
X_05955_ hold929/A _04840_/Y fanout57/X _05954_/Y VPWR VGND sg13cmos5l_a21oi_1
Xhold1037 _05963_/A _09397_/Q VPWR VGND sg13cmos5l_dlygate4sd3_1
XFILLER_38_230 VPWR VGND sg13cmos5l_fill_1
X_04906_ _07637_/A _04906_/A VPWR VGND sg13cmos5l_inv_1
Xhold1059 _05408_/A _09305_/Q VPWR VGND sg13cmos5l_dlygate4sd3_1
X_05886_ _05993_/D _05886_/A _05903_/A _05903_/C VPWR VGND sg13cmos5l_nand3_1
X_08674_ _08674_/Y _08666_/Y _08670_/Y _08673_/Y VPWR VGND sg13cmos5l_o21ai_1
XFILLER_42_918 VPWR VGND sg13cmos5l_fill_2
X_07625_ _07625_/Y hold944/X fanout61/X _07633_/A VPWR VGND sg13cmos5l_o21ai_1
X_04837_ _04837_/Y hold939/X VPWR VGND sg13cmos5l_inv_1
X_07556_ _07556_/Y _07556_/A _07571_/A VPWR VGND sg13cmos5l_nand2_1
X_06507_ _06507_/Y _06535_/A _06507_/B VPWR VGND sg13cmos5l_nor2_1
XFILLER_42_26 VPWR VGND sg13cmos5l_fill_1
X_09226_ _09226_/Q clkload2/A _09226_/D _09226_/RESET_B VPWR VGND sg13cmos5l_dfrbpq_1
X_07487_ _07487_/Y _09102_/Q _09070_/Q VPWR VGND sg13cmos5l_nand2_1
XFILLER_21_152 VPWR VGND sg13cmos5l_fill_1
X_06438_ _06439_/A _06740_/A _06437_/B _06437_/Y VPWR VGND sg13cmos5l_o21ai_1
X_06369_ _06371_/B _06369_/A _06680_/A VPWR VGND sg13cmos5l_nor2b_1
X_09157_ _09157_/Q clkload4/A _09157_/D _09157_/RESET_B VPWR VGND sg13cmos5l_dfrbpq_1
XFILLER_5_318 VPWR VGND sg13cmos5l_fill_2
X_08108_ _08108_/Y _09124_/Q _08111_/B VPWR VGND sg13cmos5l_nand2_1
X_09088_ _09088_/Q _09214_/CLK _09088_/D _09088_/RESET_B VPWR VGND sg13cmos5l_dfrbpq_1
X_08039_ _08039_/Y _08009_/Y _08013_/Y _08038_/Y VPWR VGND sg13cmos5l_o21ai_1
Xhold882 hold882/X hold882/A VPWR VGND sg13cmos5l_dlygate4sd3_1
Xhold871 hold871/X hold871/A VPWR VGND sg13cmos5l_dlygate4sd3_1
Xhold860 hold860/X hold860/A VPWR VGND sg13cmos5l_dlygate4sd3_1
Xhold893 hold893/X hold893/A VPWR VGND sg13cmos5l_dlygate4sd3_1
XFILLER_18_937 VPWR VGND sg13cmos5l_fill_1
XFILLER_44_233 VPWR VGND sg13cmos5l_fill_1
XFILLER_17_447 VPWR VGND sg13cmos5l_fill_1
XFILLER_26_992 VPWR VGND sg13cmos5l_fill_1
XFILLER_41_951 VPWR VGND sg13cmos5l_fill_2
XFILLER_40_461 VPWR VGND sg13cmos5l_decap_8
XFILLER_8_101 VPWR VGND sg13cmos5l_fill_1
XFILLER_9_613 VPWR VGND sg13cmos5l_fill_1
X_05740_ _05741_/B _09391_/Q _05719_/B _05702_/Y VPWR VGND sg13cmos5l_a21oi_1
X_05671_ _05671_/Y _04984_/Y _05682_/A _05670_/Y VPWR VGND sg13cmos5l_a21oi_1
X_07410_ _07410_/Y _07412_/B _07411_/C VPWR VGND sg13cmos5l_nand2b_1
X_08390_ _09205_/D _04820_/Y fanout48/X _08389_/Y VPWR VGND sg13cmos5l_a21oi_1
X_07341_ _07342_/B _07341_/A _09573_/Q VPWR VGND sg13cmos5l_nor2_1
X_07272_ _07419_/B _07272_/A _07272_/B _07272_/C VPWR VGND sg13cmos5l_nand3_1
X_06223_ _09472_/D _06223_/A _06303_/A VPWR VGND sg13cmos5l_nor2_1
X_09011_ _09011_/Q clkload8/A _09011_/D _09011_/RESET_B VPWR VGND sg13cmos5l_dfrbpq_1
X_06154_ _06156_/B _06155_/A _06155_/B VPWR VGND sg13cmos5l_nand2_1
X_05105_ _05117_/A _09293_/Q _05105_/B VPWR VGND sg13cmos5l_xnor2_1
X_06085_ _06085_/X _06083_/Y _06084_/Y _06058_/Y VPWR VGND sg13cmos5l_a21o_1
X_05036_ _05036_/Y input8/X _07076_/A _04877_/Y VPWR VGND sg13cmos5l_o21ai_1
X_09324__792 _09324_/RESET_B VPWR VGND sg13cmos5l_tiehi
XFILLER_39_550 VPWR VGND sg13cmos5l_fill_1
X_06987_ _09580_/D _07384_/A hold887/X VPWR VGND sg13cmos5l_and2_1
X_08726_ _08765_/A _08733_/B _08726_/B VPWR VGND sg13cmos5l_and2_1
X_05938_ _05938_/Y _04980_/Y _05950_/A _05937_/Y VPWR VGND sg13cmos5l_a21oi_1
X_05869_ _05869_/X _09397_/Q _09372_/Q VPWR VGND sg13cmos5l_or2_1
X_09470__634 _09470_/RESET_B VPWR VGND sg13cmos5l_tiehi
X_08657_ _08657_/Y _08657_/A _08657_/B _08657_/C _08657_/D VPWR VGND sg13cmos5l_nand4_1
X_07608_ _07608_/Y _07589_/A _07589_/B _07607_/Y VPWR VGND sg13cmos5l_o21ai_1
X_08588_ _08588_/Y _08570_/Y fanout36/X _08587_/Y VPWR VGND sg13cmos5l_a21oi_1
X_07539_ _07568_/B _09039_/Q _09040_/Q hold1426/X VPWR VGND sg13cmos5l_o21ai_1
X_09331__785 _09331_/RESET_B VPWR VGND sg13cmos5l_tiehi
X_09209_ _09209_/Q clkload3/A _09209_/D _09209_/RESET_B VPWR VGND sg13cmos5l_dfrbpq_1
XFILLER_2_811 VPWR VGND sg13cmos5l_fill_1
XFILLER_49_336 VPWR VGND sg13cmos5l_fill_1
XFILLER_49_358 VPWR VGND sg13cmos5l_fill_2
XFILLER_37_509 VPWR VGND sg13cmos5l_fill_2
Xhold1390 hold1390/X _09374_/Q VPWR VGND sg13cmos5l_dlygate4sd3_1
XFILLER_17_222 VPWR VGND sg13cmos5l_fill_2
XFILLER_45_597 VPWR VGND sg13cmos5l_fill_2
XFILLER_27_92 VPWR VGND sg13cmos5l_fill_2
X_09267__768 _09267_/RESET_B VPWR VGND sg13cmos5l_tiehi
X_06910_ _06910_/X _06920_/A _06910_/B VPWR VGND sg13cmos5l_and2_1
X_07890_ _09134_/D _07890_/A _07890_/B VPWR VGND sg13cmos5l_and2_1
X_06841_ _06841_/Y _06880_/A _06839_/Y _06840_/Y VPWR VGND sg13cmos5l_o21ai_1
X_09560_ _09560_/Q _09565_/CLK _09560_/D _09560_/RESET_B VPWR VGND sg13cmos5l_dfrbpq_1
X_06772_ _06772_/Y _06626_/X _06676_/B _06771_/Y VPWR VGND sg13cmos5l_o21ai_1
X_09491_ _09491_/Q _09491_/CLK _09491_/D _09491_/RESET_B VPWR VGND sg13cmos5l_dfrbpq_1
X_08511_ _08511_/Y _08539_/A _08501_/Y _08508_/Y _08510_/Y VPWR VGND sg13cmos5l_a22oi_1
X_05723_ _05724_/B _05723_/A _05723_/B VPWR VGND sg13cmos5l_xnor2_1
X_08442_ _08442_/Y _08442_/A _08442_/B VPWR VGND sg13cmos5l_nor2_1
X_05654_ _05654_/Y _05654_/A VPWR VGND sg13cmos5l_inv_1
X_05585_ _09367_/D _05637_/A _05585_/B VPWR VGND sg13cmos5l_nor2_1
X_08373_ _08373_/Y _08370_/Y _08372_/Y _08354_/Y VPWR VGND sg13cmos5l_o21ai_1
X_07324_ _07324_/X _07324_/A _07324_/B _07324_/C VPWR VGND sg13cmos5l_and3_1
X_07255_ _07280_/B _07253_/Y _07254_/Y _07234_/Y VPWR VGND sg13cmos5l_a21oi_1
X_09012__232 _09012_/D VPWR VGND sg13cmos5l_tielo
XFILLER_20_998 VPWR VGND sg13cmos5l_fill_2
X_06206_ _06206_/Y _06194_/A _06196_/Y _06205_/Y VPWR VGND sg13cmos5l_a21oi_1
X_09608__481 _09608_/RESET_B VPWR VGND sg13cmos5l_tiehi
X_07186_ _07186_/Y _08839_/A _07193_/B VPWR VGND sg13cmos5l_nand2_1
X_06137_ _06137_/X _06144_/A _06165_/B VPWR VGND sg13cmos5l_and2_1
X_06068_ _06391_/A _06475_/A _06068_/B VPWR VGND sg13cmos5l_xnor2_1
X_05019_ _05020_/B hold895/X _09594_/Q _09593_/Q VPWR VGND sg13cmos5l_nor3_1
XFILLER_48_36 VPWR VGND sg13cmos5l_fill_1
X_08709_ _08710_/C _08709_/A _08709_/B VPWR VGND sg13cmos5l_or2_1
Xfanout40 _05675_/B _05672_/Y VPWR VGND sg13cmos5l_buf_1
Xfanout73 _08784_/A _07121_/X VPWR VGND sg13cmos5l_buf_1
Xfanout62 fanout62/X _05432_/Y VPWR VGND sg13cmos5l_buf_1
Xfanout51 fanout51/X fanout52/X VPWR VGND sg13cmos5l_buf_1
Xfanout95 _06495_/B _06481_/Y VPWR VGND sg13cmos5l_buf_1
Xfanout84 _08171_/B _08153_/Y VPWR VGND sg13cmos5l_buf_1
XFILLER_22_291 VPWR VGND sg13cmos5l_fill_2
XFILLER_2_685 VPWR VGND sg13cmos5l_fill_2
X_05370_ _05371_/C _05379_/A _05370_/B VPWR VGND sg13cmos5l_nor2_1
Xclkload10 clkload10/Y clkload10/A VPWR VGND sg13cmos5l_inv_1
Xclkload21 clkload21/X clkload21/A VPWR VGND sg13cmos5l_buf_8
X_07040_ _07044_/A _06873_/B _07053_/B _07036_/Y _07017_/A _07038_/Y VPWR VGND sg13cmos5l_a221oi_1
X_08991_ _08991_/Y hold941/X fanout55/X _08995_/A VPWR VGND sg13cmos5l_o21ai_1
X_07942_ _07942_/Y _07962_/A _07936_/B _07945_/A _07945_/B VPWR VGND sg13cmos5l_a22oi_1
X_07873_ _09123_/D _07875_/A _07873_/B VPWR VGND sg13cmos5l_nor2_1
X_06824_ _06824_/Y _08757_/A hold957/X VPWR VGND sg13cmos5l_nor2_1
X_09543_ _09543_/Q clkload24/A _09543_/D _09543_/RESET_B VPWR VGND sg13cmos5l_dfrbpq_1
X_06755_ _06797_/C _09546_/Q _06762_/A _06765_/A VPWR VGND sg13cmos5l_o21ai_1
X_09474_ _09474_/Q clkload21/A _09474_/D _09474_/RESET_B VPWR VGND sg13cmos5l_dfrbpq_1
X_06686_ _06686_/Y _06991_/A _09495_/Q _09494_/Q _06990_/A _06685_/Y VPWR VGND sg13cmos5l_a221oi_1
XFILLER_24_523 VPWR VGND sg13cmos5l_fill_2
X_05706_ _05758_/A _09395_/Q _05719_/B VPWR VGND sg13cmos5l_xnor2_1
X_05637_ _09376_/D _05637_/A _05760_/A VPWR VGND sg13cmos5l_nor2_1
X_08425_ _08450_/A _08455_/B _08425_/B VPWR VGND sg13cmos5l_nor2_1
X_08356_ _08356_/Y _08352_/X _09197_/Q VPWR VGND sg13cmos5l_nand2b_1
X_05568_ _05568_/Y _05568_/A _05568_/B VPWR VGND sg13cmos5l_nor2_1
X_07307_ _07307_/Y _07307_/A _07324_/A VPWR VGND sg13cmos5l_nand2_1
Xclkload4 clkload4/Y clkload4/A VPWR VGND sg13cmos5l_inv_1
X_08287_ _08288_/B _08430_/A _08430_/B VPWR VGND sg13cmos5l_and2_1
X_05499_ _05499_/X _05499_/A _05499_/B VPWR VGND sg13cmos5l_or2_1
XFILLER_4_917 VPWR VGND sg13cmos5l_fill_1
X_07238_ _07238_/Y _07246_/B _07243_/C _07547_/A VPWR VGND sg13cmos5l_a21oi_1
X_07169_ _07216_/C _07164_/B _08909_/A _07167_/Y VPWR VGND sg13cmos5l_a21o_1
XFILLER_47_659 VPWR VGND sg13cmos5l_fill_2
XFILLER_46_158 VPWR VGND sg13cmos5l_fill_2
XFILLER_46_147 VPWR VGND sg13cmos5l_fill_2
XFILLER_28_851 VPWR VGND sg13cmos5l_fill_2
XFILLER_15_523 VPWR VGND sg13cmos5l_fill_2
XFILLER_7_733 VPWR VGND sg13cmos5l_fill_2
XFILLER_10_261 VPWR VGND sg13cmos5l_fill_1
XFILLER_2_460 VPWR VGND sg13cmos5l_fill_1
X_04870_ _06741_/A _06441_/A VPWR VGND sg13cmos5l_inv_1
X_06540_ _06540_/Y _06540_/A _06540_/B VPWR VGND sg13cmos5l_nor2_1
X_06471_ _09504_/D _06736_/A hold863/X VPWR VGND sg13cmos5l_and2_1
X_08210_ _08210_/Y _08229_/A _08230_/A VPWR VGND sg13cmos5l_nand2b_1
X_05422_ _05423_/C _05652_/A _05421_/B VPWR VGND sg13cmos5l_nor2b_1
X_09190_ _09190_/Q clkload4/A _09190_/D _09190_/RESET_B VPWR VGND sg13cmos5l_dfrbpq_1
XFILLER_14_1015 VPWR VGND sg13cmos5l_decap_8
XFILLER_21_559 VPWR VGND sg13cmos5l_fill_2
X_05353_ _05353_/X _09321_/Q _09297_/Q _09296_/Q VPWR VGND sg13cmos5l_or3_1
X_08141_ _09169_/D _08393_/A hold911/X VPWR VGND sg13cmos5l_and2_1
X_05284_ _05284_/Y _05286_/B VPWR VGND sg13cmos5l_inv_1
X_08072_ _08073_/B _08174_/C _08174_/D VPWR VGND sg13cmos5l_nand2_1
X_07023_ _07023_/Y _07031_/A _06928_/B _07022_/Y VPWR VGND sg13cmos5l_o21ai_1
XFILLER_0_419 VPWR VGND sg13cmos5l_fill_1
X_09048__434 _09048_/RESET_B VPWR VGND sg13cmos5l_tiehi
X_08974_ _08974_/Y _08971_/Y _08973_/Y _08954_/Y VPWR VGND sg13cmos5l_o21ai_1
X_07925_ _07925_/Y _07778_/A _07828_/B _07924_/Y VPWR VGND sg13cmos5l_o21ai_1
Xheichips26_dna_sequencer_850 uio_oe[7] VPWR VGND sg13cmos5l_tiehi
X_07856_ _07857_/A _08147_/A _07855_/B _07855_/Y VPWR VGND sg13cmos5l_o21ai_1
XFILLER_44_629 VPWR VGND sg13cmos5l_fill_1
X_07787_ _07822_/A _09079_/Q _09077_/Q _09078_/Q VPWR VGND sg13cmos5l_or3_1
X_06807_ _06810_/B _06796_/Y _06801_/Y _06806_/X VPWR VGND sg13cmos5l_a21o_1
X_04999_ _04999_/Y _04999_/A VPWR VGND sg13cmos5l_inv_1
X_09526_ _09526_/Q _09591_/CLK _09526_/D _09526_/RESET_B VPWR VGND sg13cmos5l_dfrbpq_1
X_06738_ _09544_/D _06738_/A _06742_/B VPWR VGND sg13cmos5l_nor2_1
X_09457_ _09457_/Q clkload24/A _09457_/D _09457_/RESET_B VPWR VGND sg13cmos5l_dfrbpq_1
XFILLER_12_504 VPWR VGND sg13cmos5l_fill_1
X_08408_ _08445_/A _09212_/Q _08423_/B VPWR VGND sg13cmos5l_xnor2_1
X_06669_ _09525_/D _06818_/A _06669_/B VPWR VGND sg13cmos5l_nor2_1
X_09388_ hold855/A _09388_/CLK _09388_/D _09388_/RESET_B VPWR VGND sg13cmos5l_dfrbpq_1
X_08339_ _08456_/A _08314_/B _08037_/Y _08339_/S VPWR VGND sg13cmos5l_mux2_1
XFILLER_0_920 VPWR VGND sg13cmos5l_decap_8
XFILLER_0_975 VPWR VGND sg13cmos5l_decap_8
XFILLER_37_1026 VPWR VGND sg13cmos5l_fill_2
XFILLER_7_530 VPWR VGND sg13cmos5l_decap_8
Xhold1208 _04865_/A _09476_/Q VPWR VGND sg13cmos5l_dlygate4sd3_1
XFILLER_39_946 VPWR VGND sg13cmos5l_fill_1
X_07710_ _09102_/D _07688_/X _07715_/S _07709_/Y VPWR VGND sg13cmos5l_a21oi_1
Xhold1219 _04915_/A _09552_/Q VPWR VGND sg13cmos5l_dlygate4sd3_1
XFILLER_25_2 VPWR VGND sg13cmos5l_fill_1
X_05971_ _05971_/Y hold947/A hold861/A VPWR VGND sg13cmos5l_xnor2_1
XFILLER_39_979 VPWR VGND sg13cmos5l_fill_1
X_08690_ _08694_/A _08690_/A _08698_/B _08690_/C VPWR VGND sg13cmos5l_nor3_1
X_04922_ _08839_/A _07154_/A VPWR VGND sg13cmos5l_inv_1
X_04853_ _05966_/A _04853_/A VPWR VGND sg13cmos5l_inv_1
X_07641_ _07641_/Y hold944/A hold882/A VPWR VGND sg13cmos5l_xnor2_1
X_07572_ _07573_/B _07276_/Y _07574_/S _07571_/X VPWR VGND sg13cmos5l_a21oi_1
X_06523_ _06523_/X _06512_/A _06512_/B _06347_/B VPWR VGND sg13cmos5l_a21o_1
X_09311_ hold941/A clkload7/A _09311_/D _09311_/RESET_B VPWR VGND sg13cmos5l_dfrbpq_1
XFILLER_40_109 VPWR VGND sg13cmos5l_fill_1
XFILLER_21_312 VPWR VGND sg13cmos5l_fill_1
X_09242_ _09242_/Q _09595_/CLK _09242_/D _09242_/RESET_B VPWR VGND sg13cmos5l_dfrbpq_1
X_06454_ _06454_/Y _04971_/A _06456_/S _06473_/B VPWR VGND sg13cmos5l_o21ai_1
X_06385_ _06385_/Y _06381_/Y _06382_/Y _06384_/A _06091_/A VPWR VGND sg13cmos5l_a22oi_1
X_09173_ _09173_/Q _09312_/CLK _09173_/D _09173_/RESET_B VPWR VGND sg13cmos5l_dfrbpq_1
X_05405_ _05405_/Y _05405_/A VPWR VGND sg13cmos5l_inv_1
X_05336_ _09332_/D _05423_/A _05509_/A VPWR VGND sg13cmos5l_nor2_1
X_08124_ _09160_/D _08124_/A _08123_/Y VPWR VGND sg13cmos5l_nor2b_1
X_05267_ _05269_/B _09330_/Q _09331_/Q _09332_/Q _05283_/B VPWR VGND sg13cmos5l_nor4_1
X_08055_ _08082_/B _09118_/Q _08079_/A VPWR VGND sg13cmos5l_xnor2_1
X_05198_ _05198_/Y _05198_/A _05198_/B VPWR VGND sg13cmos5l_nand2_1
Xoutput17 uo_out[4] _09233_/Q VPWR VGND sg13cmos5l_buf_1
X_07006_ _07052_/A _07051_/B _07051_/C _07051_/A VPWR VGND sg13cmos5l_a21oi_1
X_08957_ _08957_/Y _08952_/Y hold998/A VPWR VGND sg13cmos5l_nand2b_1
XFILLER_29_412 VPWR VGND sg13cmos5l_fill_1
XFILLER_5_1024 VPWR VGND sg13cmos5l_decap_4
X_07908_ _07948_/C _09137_/Q _07917_/B _07918_/A VPWR VGND sg13cmos5l_o21ai_1
X_08888_ _08892_/A _08858_/A _08858_/B _08887_/X VPWR VGND sg13cmos5l_o21ai_1
X_07839_ _07839_/Y _09142_/Q _04950_/Y _07836_/Y _07837_/Y _07838_/Y VPWR VGND sg13cmos5l_a221oi_1
XFILLER_44_459 VPWR VGND sg13cmos5l_decap_8
XFILLER_40_621 VPWR VGND sg13cmos5l_fill_2
XFILLER_40_610 VPWR VGND sg13cmos5l_fill_2
X_09509_ _09509_/Q clkload22/A _09509_/D _09509_/RESET_B VPWR VGND sg13cmos5l_dfrbpq_1
XFILLER_35_404 VPWR VGND sg13cmos5l_fill_1
XFILLER_44_982 VPWR VGND sg13cmos5l_fill_2
X_09038__444 _09038_/RESET_B VPWR VGND sg13cmos5l_tiehi
XFILLER_22_109 VPWR VGND sg13cmos5l_fill_2
XFILLER_30_131 VPWR VGND sg13cmos5l_fill_1
XFILLER_30_164 VPWR VGND sg13cmos5l_fill_1
X_06170_ _06170_/Y _09475_/Q _04982_/Y _06167_/Y _06168_/Y _06169_/Y VPWR VGND sg13cmos5l_a221oi_1
X_05121_ _05201_/S _05199_/C _05199_/B VPWR VGND sg13cmos5l_nand2_1
X_05052_ _07211_/C _05433_/A _05054_/C _05054_/D VPWR VGND sg13cmos5l_nand3_1
X_09045__437 _09045_/RESET_B VPWR VGND sg13cmos5l_tiehi
XFILLER_30_0 VPWR VGND sg13cmos5l_fill_2
Xhold1005 _04827_/A _09054_/Q VPWR VGND sg13cmos5l_dlygate4sd3_1
X_08811_ _08811_/Y _09267_/Q _08807_/Y _08808_/Y VPWR VGND sg13cmos5l_a21oi_1
X_08742_ _08742_/Y _08742_/A _08742_/B VPWR VGND sg13cmos5l_nor2_1
Xhold1049 _09126_/D _07879_/Y VPWR VGND sg13cmos5l_dlygate4sd3_1
Xhold1027 hold1027/X _09576_/Q VPWR VGND sg13cmos5l_dlygate4sd3_1
Xhold1016 _05009_/C _09597_/Q VPWR VGND sg13cmos5l_dlygate4sd3_1
X_05954_ _05954_/Y _09423_/Q fanout57/X _05961_/A VPWR VGND sg13cmos5l_o21ai_1
Xhold1038 _06691_/B _09497_/Q VPWR VGND sg13cmos5l_dlygate4sd3_1
X_04905_ _07895_/A _07473_/B VPWR VGND sg13cmos5l_inv_1
X_08673_ _08673_/Y _08537_/B _08679_/A _08672_/A _08541_/X VPWR VGND sg13cmos5l_a22oi_1
X_05885_ _05993_/C _05891_/A _05893_/A _05572_/Y VPWR VGND sg13cmos5l_o21ai_1
X_07624_ _09089_/D _08393_/A _07624_/B VPWR VGND sg13cmos5l_and2_1
X_04836_ _04836_/Y hold943/X VPWR VGND sg13cmos5l_inv_1
X_07555_ _07555_/Y _07279_/B _07549_/Y _07554_/X _07233_/Y VPWR VGND sg13cmos5l_a22oi_1
X_06506_ _06506_/Y _06364_/B _06513_/A _06505_/Y VPWR VGND sg13cmos5l_o21ai_1
X_07486_ _07516_/A _09070_/Q _09071_/Q VPWR VGND sg13cmos5l_xnor2_1
X_09225_ _09225_/Q clkload2/A _09225_/D _09225_/RESET_B VPWR VGND sg13cmos5l_dfrbpq_1
X_06437_ _06437_/Y _06437_/A _06437_/B VPWR VGND sg13cmos5l_nand2_1
X_06368_ _09483_/D _06473_/B _06535_/A VPWR VGND sg13cmos5l_and2_1
X_09156_ _09156_/Q clkload4/A _09156_/D _09156_/RESET_B VPWR VGND sg13cmos5l_dfrbpq_1
X_06299_ _09475_/D _06299_/A _06299_/B VPWR VGND sg13cmos5l_nor2_1
X_05319_ _05320_/B _05474_/A _05474_/B VPWR VGND sg13cmos5l_and2_1
X_08107_ _08107_/Y _08107_/A _08107_/B VPWR VGND sg13cmos5l_nand2_1
X_09087_ _09087_/Q _09388_/CLK _09087_/D _09087_/RESET_B VPWR VGND sg13cmos5l_dfrbpq_1
X_08038_ _08038_/Y _08038_/A _08038_/B VPWR VGND sg13cmos5l_nor2_1
Xhold872 hold872/X hold872/A VPWR VGND sg13cmos5l_dlygate4sd3_1
Xhold861 hold861/X hold861/A VPWR VGND sg13cmos5l_dlygate4sd3_1
Xhold883 hold883/X hold883/A VPWR VGND sg13cmos5l_dlygate4sd3_1
Xhold894 hold894/X hold894/A VPWR VGND sg13cmos5l_dlygate4sd3_1
XFILLER_26_971 VPWR VGND sg13cmos5l_fill_1
XFILLER_12_142 VPWR VGND sg13cmos5l_fill_2
XFILLER_8_124 VPWR VGND sg13cmos5l_fill_1
XFILLER_48_551 VPWR VGND sg13cmos5l_fill_2
X_05670_ _05670_/Y _05909_/B _05670_/B VPWR VGND sg13cmos5l_nor2_1
X_07340_ _07340_/Y _07332_/B _07355_/B _07339_/Y VPWR VGND sg13cmos5l_a21oi_1
X_09010_ _09010_/Q clkload8/A _09010_/D _09010_/RESET_B VPWR VGND sg13cmos5l_dfrbpq_1
X_07271_ _07419_/A _07272_/B _07272_/C _07270_/Y VPWR VGND sg13cmos5l_a21o_1
X_06222_ _09471_/D _06222_/A _06303_/A VPWR VGND sg13cmos5l_nor2_1
X_06153_ _06155_/B _06153_/A _06153_/B _06161_/B VPWR VGND sg13cmos5l_nand3_1
X_09463__642 _09463_/RESET_B VPWR VGND sg13cmos5l_tiehi
X_05104_ _05104_/Y _05355_/A _05093_/X _05099_/X _05122_/A VPWR VGND sg13cmos5l_a22oi_1
X_06084_ _06084_/Y _06112_/A _06098_/A _06061_/Y _06062_/Y VPWR VGND sg13cmos5l_a22oi_1
X_05035_ _10244_/A _07101_/B _07076_/A VPWR VGND sg13cmos5l_nand2b_1
X_06986_ _09579_/D _07384_/A hold853/X VPWR VGND sg13cmos5l_and2_1
X_08725_ _08726_/B _09251_/Q _09252_/Q _09253_/Q VPWR VGND sg13cmos5l_o21ai_1
XFILLER_39_595 VPWR VGND sg13cmos5l_fill_2
XFILLER_39_573 VPWR VGND sg13cmos5l_fill_1
X_05937_ _05937_/Y _09421_/Q _05937_/B VPWR VGND sg13cmos5l_nor2_1
X_05868_ _05891_/B _09373_/Q _09372_/Q VPWR VGND sg13cmos5l_xor2_1
X_08656_ _08656_/X _08657_/C _08657_/D VPWR VGND sg13cmos5l_and2_1
X_08587_ _08587_/Y hold1147/X fanout36/X _08599_/B VPWR VGND sg13cmos5l_o21ai_1
X_07607_ _07607_/Y _07607_/A _07620_/A VPWR VGND sg13cmos5l_nand2_1
X_04819_ _04819_/Y hold964/X VPWR VGND sg13cmos5l_inv_1
X_05799_ _05799_/Y _09404_/Q _09403_/Q _09435_/Q VPWR VGND sg13cmos5l_nand3b_1
X_07538_ _07571_/A _07538_/A _07550_/A _07550_/B VPWR VGND sg13cmos5l_nand3_1
X_07469_ _07469_/Y hold945/A _08394_/A VPWR VGND sg13cmos5l_nand2b_1
XFILLER_23_996 VPWR VGND sg13cmos5l_fill_1
X_09208_ _09208_/Q _09312_/CLK _09208_/D _09208_/RESET_B VPWR VGND sg13cmos5l_dfrbpq_1
X_09139_ _09139_/Q clkload15/A _09139_/D _09139_/RESET_B VPWR VGND sg13cmos5l_dfrbpq_1
XFILLER_2_834 VPWR VGND sg13cmos5l_decap_4
XFILLER_1_344 VPWR VGND sg13cmos5l_fill_1
X_09028__454 _09028_/RESET_B VPWR VGND sg13cmos5l_tiehi
XFILLER_2_889 VPWR VGND sg13cmos5l_fill_2
Xhold1380 _06344_/A _09479_/Q VPWR VGND sg13cmos5l_dlygate4sd3_1
Xhold1391 _07682_/A _09097_/Q VPWR VGND sg13cmos5l_dlygate4sd3_1
XFILLER_45_576 VPWR VGND sg13cmos5l_fill_2
XFILLER_41_782 VPWR VGND sg13cmos5l_fill_1
X_09035__447 _09035_/RESET_B VPWR VGND sg13cmos5l_tiehi
X_06840_ _06840_/Y _07298_/A _06840_/B _06840_/C VPWR VGND sg13cmos5l_nand3_1
X_06771_ _06771_/Y _06771_/A _06771_/B _06771_/C _06771_/D VPWR VGND sg13cmos5l_nand4_1
X_08510_ _08510_/Y _09227_/Q _08510_/B VPWR VGND sg13cmos5l_xnor2_1
X_05722_ _05723_/B _09394_/Q _05722_/B VPWR VGND sg13cmos5l_xnor2_1
X_09319__840 _09319_/RESET_B VPWR VGND sg13cmos5l_tiehi
X_09490_ _09490_/Q clkload22/A _09490_/D _09490_/RESET_B VPWR VGND sg13cmos5l_dfrbpq_1
X_08441_ _08442_/B _08282_/B _08332_/B _08456_/B VPWR VGND sg13cmos5l_mux2_1
X_05653_ _05654_/A _05964_/A _05661_/B _05652_/Y VPWR VGND sg13cmos5l_o21ai_1
X_05584_ _05585_/B _05593_/S _05582_/X _05583_/Y VPWR VGND sg13cmos5l_a21o_1
X_08372_ _08372_/Y _09202_/Q _08354_/B _08371_/Y VPWR VGND sg13cmos5l_o21ai_1
XFILLER_17_1002 VPWR VGND sg13cmos5l_fill_1
X_07323_ _09041_/D _07389_/B _07323_/B VPWR VGND sg13cmos5l_nor2_1
X_07254_ _07254_/Y _07232_/Y _07233_/Y _07248_/Y _07279_/B VPWR VGND sg13cmos5l_a22oi_1
XFILLER_20_955 VPWR VGND sg13cmos5l_fill_2
X_06205_ _06205_/Y _06194_/B _06196_/Y _06047_/Y VPWR VGND sg13cmos5l_o21ai_1
X_07185_ hold984/A _07185_/A _07184_/Y VPWR VGND sg13cmos5l_nor2b_1
X_06136_ _06165_/B _06133_/A _06133_/B _06121_/B VPWR VGND sg13cmos5l_a21o_1
X_06067_ _06103_/B _09476_/Q _06068_/B VPWR VGND sg13cmos5l_xnor2_1
X_05018_ _05018_/Y _09594_/Q _09593_/Q VPWR VGND sg13cmos5l_nor2_1
X_09307__265 _09307_/RESET_B VPWR VGND sg13cmos5l_tiehi
XFILLER_24_1028 VPWR VGND sg13cmos5l_fill_1
X_06969_ _06969_/Y _06969_/A _06974_/B VPWR VGND sg13cmos5l_nand2_1
X_08708_ _08708_/Y _08710_/A _08710_/B VPWR VGND sg13cmos5l_nand2_1
XFILLER_15_716 VPWR VGND sg13cmos5l_fill_1
X_08639_ _08639_/Y _09194_/Q _08663_/A VPWR VGND sg13cmos5l_xnor2_1
XFILLER_15_738 VPWR VGND sg13cmos5l_fill_1
Xfanout30 _05517_/B _05516_/X VPWR VGND sg13cmos5l_buf_1
Xfanout74 _07158_/A _07121_/X VPWR VGND sg13cmos5l_buf_1
Xfanout41 _08378_/B _08373_/Y VPWR VGND sg13cmos5l_buf_1
Xfanout52 fanout52/X fanout53/X VPWR VGND sg13cmos5l_buf_1
Xfanout63 _05408_/B _05411_/B VPWR VGND sg13cmos5l_buf_1
Xfanout96 _06541_/A _06481_/Y VPWR VGND sg13cmos5l_buf_1
Xfanout85 _07917_/B _07899_/Y VPWR VGND sg13cmos5l_buf_1
XFILLER_6_469 VPWR VGND sg13cmos5l_fill_2
XFILLER_46_885 VPWR VGND sg13cmos5l_decap_8
XFILLER_46_863 VPWR VGND sg13cmos5l_fill_1
XFILLER_20_229 VPWR VGND sg13cmos5l_fill_2
XFILLER_9_263 VPWR VGND sg13cmos5l_fill_1
XFILLER_9_285 VPWR VGND sg13cmos5l_fill_2
Xclkload11 clkload11/Y clkload11/A VPWR VGND sg13cmos5l_inv_4
Xclkload22 clkload22/Y clkload22/A VPWR VGND sg13cmos5l_inv_2
XFILLER_47_1028 VPWR VGND sg13cmos5l_fill_1
X_09226__241 _09226_/RESET_B VPWR VGND sg13cmos5l_tiehi
X_08990_ _09310_/D _04816_/Y fanout55/X _08989_/Y VPWR VGND sg13cmos5l_a21oi_1
X_07941_ _07945_/B _07775_/B _07825_/B _07950_/B VPWR VGND sg13cmos5l_mux2_1
X_07872_ _07873_/B _04946_/Y _07852_/Y _07874_/S VPWR VGND sg13cmos5l_mux2_1
X_06823_ _09554_/D _06823_/A _06823_/B VPWR VGND sg13cmos5l_and2_1
X_09542_ hold887/A _09586_/CLK _09542_/D _09542_/RESET_B VPWR VGND sg13cmos5l_dfrbpq_1
X_06754_ _06765_/A _09545_/Q _06764_/B _06789_/A VPWR VGND sg13cmos5l_a21o_1
X_05705_ _05705_/Y _05703_/Y _05704_/Y _05702_/Y VPWR VGND sg13cmos5l_a21oi_1
XFILLER_36_340 VPWR VGND sg13cmos5l_fill_1
X_09473_ _09473_/Q clkload21/A _09473_/D _09473_/RESET_B VPWR VGND sg13cmos5l_dfrbpq_1
X_06685_ _06685_/Y _09551_/Q _04971_/Y _06682_/Y _06683_/Y _06684_/Y VPWR VGND sg13cmos5l_a221oi_1
X_05636_ _05760_/A _05617_/B _05331_/Y _05636_/S VPWR VGND sg13cmos5l_mux2_1
X_08424_ _08425_/B _08424_/A _08424_/B VPWR VGND sg13cmos5l_xnor2_1
X_05567_ _05567_/Y _05565_/Y _05566_/Y _05549_/Y VPWR VGND sg13cmos5l_o21ai_1
X_08355_ _08355_/X _08278_/A _08122_/A _08366_/B VPWR VGND sg13cmos5l_mux2_1
X_07306_ _07306_/Y _06883_/A _07300_/X _07305_/X _06855_/Y VPWR VGND sg13cmos5l_a22oi_1
Xclkload5 clkload5/Y clkload5/A VPWR VGND sg13cmos5l_inv_16
X_08286_ _08286_/Y _08430_/A _08430_/B VPWR VGND sg13cmos5l_nand2_1
X_05498_ _05498_/Y _05491_/X _05493_/Y _05499_/A _05499_/B _05497_/X VPWR VGND sg13cmos5l_a221oi_1
X_07237_ _07272_/A _07246_/B _07243_/C VPWR VGND sg13cmos5l_nand2_1
X_07168_ _08909_/A _08784_/A _08784_/B VPWR VGND sg13cmos5l_nor2_1
X_06119_ _06133_/B _09412_/Q _09413_/Q _09411_/Q _09410_/Q VPWR VGND sg13cmos5l_nor4_1
XFILLER_3_428 VPWR VGND sg13cmos5l_fill_2
X_07099_ _07106_/B input9/X _07099_/B VPWR VGND sg13cmos5l_nand2_1
X_09025__457 _09025_/RESET_B VPWR VGND sg13cmos5l_tiehi
XFILLER_11_741 VPWR VGND sg13cmos5l_fill_2
XFILLER_11_752 VPWR VGND sg13cmos5l_fill_1
XFILLER_2_494 VPWR VGND sg13cmos5l_fill_1
X_06470_ _09503_/D _06470_/A hold866/X VPWR VGND sg13cmos5l_and2_1
X_05421_ _05423_/B _05421_/A _05421_/B VPWR VGND sg13cmos5l_nor2_1
XFILLER_34_888 VPWR VGND sg13cmos5l_fill_2
X_08140_ hold917/A _04824_/Y fanout57/X _08139_/Y VPWR VGND sg13cmos5l_a21oi_1
X_05352_ _05352_/X _09321_/Q _09296_/Q VPWR VGND sg13cmos5l_or2_1
XFILLER_14_1027 VPWR VGND sg13cmos5l_fill_2
X_05283_ _05286_/B _09330_/Q _05283_/B VPWR VGND sg13cmos5l_xor2_1
X_08071_ _08174_/D _08046_/Y _08067_/Y _07760_/Y VPWR VGND sg13cmos5l_o21ai_1
X_07022_ _07022_/Y _07022_/A _07022_/B _07022_/C _07022_/D VPWR VGND sg13cmos5l_nand4_1
X_08973_ _08973_/Y _09307_/Q _08954_/B _08972_/Y VPWR VGND sg13cmos5l_o21ai_1
X_07924_ _07924_/Y _07924_/A _07924_/B _07924_/C _07924_/D VPWR VGND sg13cmos5l_nand4_1
XFILLER_21_1009 VPWR VGND sg13cmos5l_fill_2
X_07855_ _07855_/Y _07855_/A _07855_/B VPWR VGND sg13cmos5l_nand2_1
X_07786_ _09113_/D _07890_/B _07953_/A VPWR VGND sg13cmos5l_and2_1
X_06806_ _06806_/X _06809_/A _06809_/B _06805_/Y VPWR VGND sg13cmos5l_a21o_1
X_04998_ _04998_/Y _08953_/B VPWR VGND sg13cmos5l_inv_1
X_09525_ _09525_/Q _09591_/CLK _09525_/D _09525_/RESET_B VPWR VGND sg13cmos5l_dfrbpq_1
X_06737_ _09543_/D _06737_/A _06737_/B VPWR VGND sg13cmos5l_and2_1
X_09456_ _09456_/Q clkload24/A _09456_/D _09456_/RESET_B VPWR VGND sg13cmos5l_dfrbpq_1
X_06668_ _06669_/B _06768_/C _06768_/D VPWR VGND sg13cmos5l_nand2_1
X_05619_ _05619_/Y _05327_/B _05630_/A _05616_/Y _05298_/X VPWR VGND sg13cmos5l_a22oi_1
X_08407_ _08454_/B _09213_/Q _08423_/B VPWR VGND sg13cmos5l_nand2_1
XFILLER_8_509 VPWR VGND sg13cmos5l_decap_4
X_06599_ _06617_/C _06583_/Y _06593_/Y _06597_/Y VPWR VGND sg13cmos5l_a21o_1
X_09387_ hold930/A _09387_/CLK _09387_/D _09387_/RESET_B VPWR VGND sg13cmos5l_dfrbpq_1
X_08338_ _09194_/D _08401_/B _08338_/B VPWR VGND sg13cmos5l_nor2_1
X_08269_ _08285_/B _08265_/Y _08267_/Y _08247_/Y VPWR VGND sg13cmos5l_a21o_1
XFILLER_48_903 VPWR VGND sg13cmos5l_decap_8
XFILLER_0_954 VPWR VGND sg13cmos5l_decap_8
XFILLER_48_969 VPWR VGND sg13cmos5l_decap_8
X_09099__377 _09099_/RESET_B VPWR VGND sg13cmos5l_tiehi
X_09216__251 _09216_/RESET_B VPWR VGND sg13cmos5l_tiehi
XFILLER_30_346 VPWR VGND sg13cmos5l_fill_2
X_09587__499 _09587_/RESET_B VPWR VGND sg13cmos5l_tiehi
XFILLER_7_520 VPWR VGND sg13cmos5l_decap_4
X_09223__244 _09223_/RESET_B VPWR VGND sg13cmos5l_tiehi
X_05970_ _05970_/Y _09423_/Q hold855/A VPWR VGND sg13cmos5l_xnor2_1
X_04921_ _06589_/B _09521_/Q VPWR VGND sg13cmos5l_inv_1
Xhold1209 _04859_/A _09438_/Q VPWR VGND sg13cmos5l_dlygate4sd3_1
XFILLER_39_969 VPWR VGND sg13cmos5l_fill_2
X_04852_ _09001_/A _04852_/A VPWR VGND sg13cmos5l_inv_1
X_07640_ _07640_/Y hold951/A hold885/A VPWR VGND sg13cmos5l_nand2_1
X_07571_ _07571_/X _07571_/A _07571_/B _07571_/C VPWR VGND sg13cmos5l_and3_1
X_09310_ hold909/A clkload7/A _09310_/D _09310_/RESET_B VPWR VGND sg13cmos5l_dfrbpq_1
X_06522_ _06522_/Y _06405_/B _06529_/S _06517_/X _06518_/A _06520_/Y VPWR VGND sg13cmos5l_a221oi_1
X_09241_ _09241_/Q _09347_/CLK _09241_/D _09241_/RESET_B VPWR VGND sg13cmos5l_dfrbpq_1
X_06453_ _06453_/Y _06453_/A _06452_/Y VPWR VGND sg13cmos5l_nor2b_1
X_06384_ _06403_/B _06384_/A VPWR VGND sg13cmos5l_inv_1
X_09172_ _09172_/Q _09388_/CLK _09172_/D _09172_/RESET_B VPWR VGND sg13cmos5l_dfrbpq_1
X_05404_ _05405_/A _04995_/Y _05408_/B _05403_/Y VPWR VGND sg13cmos5l_a21oi_1
X_05335_ _05509_/A _05330_/A _05301_/X _05297_/Y VPWR VGND sg13cmos5l_a21oi_1
X_08123_ _08123_/Y _08100_/Y _08118_/Y _08132_/A VPWR VGND sg13cmos5l_a21oi_1
X_08054_ _08054_/Y _08054_/A _08054_/B _08054_/C VPWR VGND sg13cmos5l_nor3_1
X_07005_ _07051_/C _09584_/Q _07011_/B _07016_/A VPWR VGND sg13cmos5l_o21ai_1
X_05266_ _05301_/B _09331_/Q _05287_/B VPWR VGND sg13cmos5l_nor2b_1
X_05197_ _05197_/Y _05186_/Y _08939_/A _05196_/Y VPWR VGND sg13cmos5l_o21ai_1
Xoutput18 uo_out[5] hold958/A VPWR VGND sg13cmos5l_buf_1
X_08956_ _08956_/Y _08945_/A _08964_/B _08955_/Y VPWR VGND sg13cmos5l_o21ai_1
X_07907_ _07918_/A _09136_/Q _07913_/B _07940_/A VPWR VGND sg13cmos5l_a21o_1
X_08887_ _08887_/X _08887_/A _08887_/B VPWR VGND sg13cmos5l_xor2_1
X_07838_ _07838_/Y _08145_/A _09084_/Q VPWR VGND sg13cmos5l_nor2_1
XFILLER_17_608 VPWR VGND sg13cmos5l_fill_1
Xclkbuf_leaf_36_clk clkload4/A clkbuf_leaf_2_clk/A VPWR VGND sg13cmos5l_buf_8
X_07769_ _09109_/D _07892_/B _07769_/B VPWR VGND sg13cmos5l_nor2_1
X_09508_ _09508_/Q clkload22/A _09508_/D _09508_/RESET_B VPWR VGND sg13cmos5l_dfrbpq_1
XFILLER_13_858 VPWR VGND sg13cmos5l_fill_1
X_09439_ _09439_/Q clkload19/A _09439_/D _09439_/RESET_B VPWR VGND sg13cmos5l_dfrbpq_1
XFILLER_40_699 VPWR VGND sg13cmos5l_fill_2
XFILLER_4_534 VPWR VGND sg13cmos5l_fill_1
XFILLER_36_906 VPWR VGND sg13cmos5l_fill_1
Xclkbuf_leaf_27_clk clkload17/A clkbuf_3_5__f_clk/X VPWR VGND sg13cmos5l_buf_8
XFILLER_31_633 VPWR VGND sg13cmos5l_fill_1
X_05120_ _05132_/C _05110_/Y _05118_/Y _05119_/Y VPWR VGND sg13cmos5l_o21ai_1
XFILLER_7_383 VPWR VGND sg13cmos5l_fill_2
X_05051_ _05433_/B _05054_/C _05054_/D VPWR VGND sg13cmos5l_nand2_1
X_08810_ _08825_/A _05004_/Y _08793_/Y _08809_/Y VPWR VGND sg13cmos5l_a21oi_1
Xhold1006 _07602_/A _09106_/Q VPWR VGND sg13cmos5l_dlygate4sd3_1
X_08741_ _08741_/Y _08746_/B _08746_/C VPWR VGND sg13cmos5l_nand2_1
Xhold1017 _07104_/B _07103_/Y VPWR VGND sg13cmos5l_dlygate4sd3_1
Xhold1039 _09497_/D _06461_/Y VPWR VGND sg13cmos5l_dlygate4sd3_1
X_05953_ _09422_/D _06727_/A hold869/X VPWR VGND sg13cmos5l_and2_1
Xhold1028 _05652_/A _09341_/Q VPWR VGND sg13cmos5l_dlygate4sd3_1
X_05884_ _05884_/Y _05891_/A _05893_/A VPWR VGND sg13cmos5l_nor2_1
XFILLER_39_777 VPWR VGND sg13cmos5l_fill_2
X_08672_ _08672_/Y _08672_/A VPWR VGND sg13cmos5l_inv_1
X_04904_ _07892_/A _04904_/A VPWR VGND sg13cmos5l_inv_1
XFILLER_27_917 VPWR VGND sg13cmos5l_fill_2
X_07623_ _07623_/Y _04947_/Y _07589_/B _07716_/A VPWR VGND sg13cmos5l_a21oi_1
Xclkbuf_leaf_18_clk _09491_/CLK clkload1/A VPWR VGND sg13cmos5l_buf_8
X_04835_ _04835_/Y hold946/X VPWR VGND sg13cmos5l_inv_1
X_07554_ _07554_/X _07571_/A _07577_/B VPWR VGND sg13cmos5l_and2_1
X_06505_ _06505_/Y _06535_/A _06507_/B VPWR VGND sg13cmos5l_nand2_1
X_07485_ _07485_/Y _07493_/B _07490_/C _07799_/A VPWR VGND sg13cmos5l_a21oi_1
X_09224_ _09224_/Q clkload2/A _09224_/D _09224_/RESET_B VPWR VGND sg13cmos5l_dfrbpq_1
XFILLER_21_132 VPWR VGND sg13cmos5l_fill_2
X_06436_ _06436_/Y _06436_/A _06436_/B VPWR VGND sg13cmos5l_nand2_1
X_06367_ _06535_/A _06365_/Y _06366_/Y _06367_/S VPWR VGND sg13cmos5l_mux2_1
X_09155_ _09155_/Q _09214_/CLK _09155_/D _09155_/RESET_B VPWR VGND sg13cmos5l_dfrbpq_1
X_06298_ _06299_/B _06276_/B _06273_/Y _06302_/S VPWR VGND sg13cmos5l_mux2_1
X_05318_ _05474_/B _05310_/A _05306_/Y _05317_/Y VPWR VGND sg13cmos5l_o21ai_1
X_08106_ _08107_/B _09160_/Q _08100_/Y _08105_/Y _09161_/Q VPWR VGND sg13cmos5l_a22oi_1
X_09086_ _09086_/Q _09388_/CLK _09086_/D _09086_/RESET_B VPWR VGND sg13cmos5l_dfrbpq_1
X_08037_ _08037_/Y _08314_/A _08037_/B VPWR VGND sg13cmos5l_nand2_1
X_05249_ _05249_/Y hold903/X _08134_/A VPWR VGND sg13cmos5l_nand2b_1
Xhold862 hold862/X hold862/A VPWR VGND sg13cmos5l_dlygate4sd3_1
Xhold851 hold851/X hold851/A VPWR VGND sg13cmos5l_dlygate4sd3_1
Xhold873 hold873/X hold873/A VPWR VGND sg13cmos5l_dlygate4sd3_1
Xhold895 hold895/X hold895/A VPWR VGND sg13cmos5l_dlygate4sd3_1
Xhold884 hold884/X hold884/A VPWR VGND sg13cmos5l_dlygate4sd3_1
XFILLER_49_508 VPWR VGND sg13cmos5l_decap_4
X_08939_ _09298_/D _08939_/A _08939_/B VPWR VGND sg13cmos5l_nor2_1
XFILLER_44_268 VPWR VGND sg13cmos5l_fill_2
XFILLER_16_62 VPWR VGND sg13cmos5l_fill_2
XFILLER_41_953 VPWR VGND sg13cmos5l_fill_1
X_09213__254 _09213_/RESET_B VPWR VGND sg13cmos5l_tiehi
X_09220__247 _09220_/RESET_B VPWR VGND sg13cmos5l_tiehi
XFILLER_48_585 VPWR VGND sg13cmos5l_fill_2
XFILLER_44_780 VPWR VGND sg13cmos5l_fill_2
X_09038__231 _09038_/D VPWR VGND sg13cmos5l_tielo
X_07270_ _07270_/Y _07556_/A _07547_/A VPWR VGND sg13cmos5l_nand2b_1
X_06221_ _09470_/D _06221_/A _06303_/A VPWR VGND sg13cmos5l_nor2_1
X_09051__431 _09051_/RESET_B VPWR VGND sg13cmos5l_tiehi
X_06152_ _06155_/A _06148_/A _06148_/C _05842_/Y VPWR VGND sg13cmos5l_o21ai_1
X_09561__233 _09561_/D VPWR VGND sg13cmos5l_tielo
X_06083_ _06083_/Y _06066_/X _06082_/Y _06063_/Y VPWR VGND sg13cmos5l_o21ai_1
X_05103_ _05122_/A _05446_/A _05103_/B VPWR VGND sg13cmos5l_xnor2_1
X_05034_ _09600_/D _05028_/B hold1266/X _08479_/B VPWR VGND sg13cmos5l_o21ai_1
Xclkbuf_leaf_7_clk _09608_/CLK clkbuf_leaf_9_clk/A VPWR VGND sg13cmos5l_buf_8
X_08724_ _08733_/B _09251_/Q _09252_/Q _09253_/Q VPWR VGND sg13cmos5l_or3_1
X_06985_ _09578_/D _07382_/A hold858/X VPWR VGND sg13cmos5l_and2_1
XFILLER_2_1028 VPWR VGND sg13cmos5l_fill_1
X_05936_ _05936_/X _05927_/Y _05931_/Y _05935_/Y VPWR VGND sg13cmos5l_a21o_1
X_05867_ _05867_/X _09397_/Q _09373_/Q _09372_/Q VPWR VGND sg13cmos5l_or3_1
X_08655_ _08657_/D _09191_/Q _08659_/C _08663_/C VPWR VGND sg13cmos5l_nand3_1
XFILLER_26_246 VPWR VGND sg13cmos5l_fill_1
X_08586_ _08586_/Y _08567_/B fanout36/X _08585_/Y VPWR VGND sg13cmos5l_a21oi_1
X_07606_ _07606_/Y _07598_/Y _07601_/Y _07605_/Y VPWR VGND sg13cmos5l_a21oi_1
X_04818_ _04818_/Y hold904/X VPWR VGND sg13cmos5l_inv_1
X_05798_ _05798_/Y _09435_/Q _09403_/Q VPWR VGND sg13cmos5l_nand2_1
X_07537_ _07537_/Y _09044_/Q _09043_/Q _09042_/Q _07568_/A VPWR VGND sg13cmos5l_nor4_1
X_07468_ _07468_/Y _07721_/A hold945/X VPWR VGND sg13cmos5l_nor2_1
X_07399_ _07437_/B _09058_/Q _07408_/B VPWR VGND sg13cmos5l_nand2_1
X_09207_ _09207_/Q _09312_/CLK _09207_/D _09207_/RESET_B VPWR VGND sg13cmos5l_dfrbpq_1
X_06419_ _06419_/Y _09513_/Q _04975_/Y _04976_/Y _09512_/Q _06418_/Y VPWR VGND sg13cmos5l_a221oi_1
X_09138_ _09138_/Q clkload16/A _09138_/D _09138_/RESET_B VPWR VGND sg13cmos5l_dfrbpq_1
X_09069_ _09069_/Q _09573_/CLK _09069_/D _09069_/RESET_B VPWR VGND sg13cmos5l_dfrbpq_1
XFILLER_49_327 VPWR VGND sg13cmos5l_decap_4
Xhold1370 _07036_/A _09582_/Q VPWR VGND sg13cmos5l_dlygate4sd3_1
Xhold1392 _05612_/A _09338_/Q VPWR VGND sg13cmos5l_dlygate4sd3_1
XFILLER_17_224 VPWR VGND sg13cmos5l_fill_1
Xhold1381 _05220_/A _09316_/Q VPWR VGND sg13cmos5l_dlygate4sd3_1
XFILLER_45_588 VPWR VGND sg13cmos5l_fill_1
X_09310__838 _09310_/RESET_B VPWR VGND sg13cmos5l_tiehi
XFILLER_5_673 VPWR VGND sg13cmos5l_decap_4
X_06770_ _06770_/Y _06620_/Y _06790_/A _06767_/Y _06768_/Y _06769_/Y VPWR VGND sg13cmos5l_a221oi_1
X_05721_ _05721_/Y _05722_/B hold1366/X VPWR VGND sg13cmos5l_nor2b_1
X_08440_ _08442_/A _08455_/B _08440_/B VPWR VGND sg13cmos5l_nor2_1
X_05652_ _05652_/Y _05652_/A _05661_/B VPWR VGND sg13cmos5l_nand2_1
X_05583_ _05583_/Y _05592_/A _05887_/A _05567_/Y _05569_/Y _05581_/X VPWR VGND sg13cmos5l_a221oi_1
X_08371_ _08371_/Y _08371_/A _08371_/B VPWR VGND sg13cmos5l_nand2_1
X_07322_ _07323_/B _07419_/C _07419_/D VPWR VGND sg13cmos5l_nand2_1
X_07253_ _07253_/Y _07242_/Y _07247_/Y _07252_/Y VPWR VGND sg13cmos5l_o21ai_1
X_07184_ _07184_/Y _08779_/A _07193_/B _09005_/A VPWR VGND sg13cmos5l_a21oi_1
X_06204_ _06204_/Y _04974_/Y fanout43/X _06203_/Y VPWR VGND sg13cmos5l_a21oi_1
X_06135_ _06135_/Y _06130_/X _06131_/Y _06134_/Y VPWR VGND sg13cmos5l_o21ai_1
X_06066_ _06066_/X _06112_/B _06390_/A VPWR VGND sg13cmos5l_and2_1
X_05017_ _05017_/Y input8/X _07076_/A VPWR VGND sg13cmos5l_nor2_1
X_06968_ _09569_/D _04962_/Y _06964_/Y _06967_/Y VPWR VGND sg13cmos5l_a21oi_1
X_08707_ _08710_/B _08696_/Y _08701_/X _08706_/Y VPWR VGND sg13cmos5l_a21o_1
X_05919_ _05920_/A _06219_/A _05933_/B _05918_/Y VPWR VGND sg13cmos5l_o21ai_1
X_08638_ _08638_/Y _08600_/A _08635_/Y _08636_/Y _08637_/Y _08634_/Y VPWR VGND sg13cmos5l_a221oi_1
X_06899_ _06899_/X _09549_/Q _09524_/Q _09525_/Q VPWR VGND sg13cmos5l_or3_1
X_08569_ _08570_/A _04881_/Y _08568_/B _08568_/Y VPWR VGND sg13cmos5l_o21ai_1
Xfanout20 fanout20/X _08710_/Y VPWR VGND sg13cmos5l_buf_1
Xfanout31 _05256_/S _05247_/Y VPWR VGND sg13cmos5l_buf_1
Xfanout42 _06974_/B _06964_/Y VPWR VGND sg13cmos5l_buf_1
Xfanout53 fanout53/X _05433_/X VPWR VGND sg13cmos5l_buf_1
Xfanout64 _08964_/B _08967_/B VPWR VGND sg13cmos5l_buf_1
Xfanout75 _05847_/A _05832_/A VPWR VGND sg13cmos5l_buf_1
Xfanout97 _06409_/A _06412_/A VPWR VGND sg13cmos5l_buf_1
Xfanout86 _07913_/B _07899_/Y VPWR VGND sg13cmos5l_buf_1
XFILLER_7_927 VPWR VGND sg13cmos5l_decap_4
X_09210__257 _09210_/RESET_B VPWR VGND sg13cmos5l_tiehi
X_09041__441 _09041_/RESET_B VPWR VGND sg13cmos5l_tiehi
XFILLER_45_385 VPWR VGND sg13cmos5l_decap_4
Xclkload23 clkload23/Y clkload23/A VPWR VGND sg13cmos5l_inv_2
Xclkload12 clkload12/Y clkload12/A VPWR VGND sg13cmos5l_inv_1
XFILLER_47_1007 VPWR VGND sg13cmos5l_decap_8
X_07940_ _07945_/A _07940_/A _07949_/B _07940_/C VPWR VGND sg13cmos5l_nor3_1
X_07871_ _09122_/D _07846_/Y _07874_/S _07870_/Y VPWR VGND sg13cmos5l_a21oi_1
X_06822_ _06823_/B _06804_/A _06808_/Y _06809_/A VPWR VGND sg13cmos5l_o21ai_1
XFILLER_49_680 VPWR VGND sg13cmos5l_fill_1
X_09541_ hold853/A clkload13/A _09541_/D _09541_/RESET_B VPWR VGND sg13cmos5l_dfrbpq_1
X_06753_ _06789_/A _06788_/B _06788_/C _06788_/A VPWR VGND sg13cmos5l_a21oi_1
XFILLER_37_831 VPWR VGND sg13cmos5l_fill_1
X_05704_ _05704_/Y hold918/A hold856/A VPWR VGND sg13cmos5l_xnor2_1
X_09472_ _09472_/Q clkload19/A _09472_/D _09472_/RESET_B VPWR VGND sg13cmos5l_dfrbpq_1
X_06684_ _06684_/Y _06989_/A _09493_/Q VPWR VGND sg13cmos5l_nor2_1
XFILLER_24_525 VPWR VGND sg13cmos5l_fill_1
X_05635_ _09375_/D _05696_/B _05737_/A VPWR VGND sg13cmos5l_and2_1
X_08423_ _08424_/B _08423_/A _08423_/B VPWR VGND sg13cmos5l_xor2_1
X_05566_ _05566_/Y _05876_/A _05592_/B VPWR VGND sg13cmos5l_nor2_1
X_08354_ _08354_/Y _09202_/Q _08354_/B VPWR VGND sg13cmos5l_nand2_1
X_07305_ _07305_/X _07324_/A _07330_/B VPWR VGND sg13cmos5l_and2_1
Xclkload6 clkload6/Y clkload6/A VPWR VGND sg13cmos5l_inv_2
X_08285_ _08430_/B _08285_/A _08285_/B _08285_/C VPWR VGND sg13cmos5l_nand3_1
XFILLER_20_786 VPWR VGND sg13cmos5l_fill_2
X_05497_ _05497_/X _05497_/A _05497_/B VPWR VGND sg13cmos5l_and2_1
X_07236_ _07243_/C _09032_/Q _09033_/Q hold1423/X VPWR VGND sg13cmos5l_o21ai_1
X_07167_ _07167_/Y _07167_/A _07137_/X VPWR VGND sg13cmos5l_nor2b_1
X_06118_ _06153_/A _09412_/Q _09411_/Q _09410_/Q VPWR VGND sg13cmos5l_or3_1
X_07098_ _07098_/X _07100_/A _07099_/B VPWR VGND sg13cmos5l_or2_1
X_06049_ _06073_/A _09442_/Q _09441_/Q _09443_/Q VPWR VGND sg13cmos5l_or3_1
XFILLER_8_1001 VPWR VGND sg13cmos5l_fill_1
Xfanout210 _06727_/A fanout211/X VPWR VGND sg13cmos5l_buf_1
XFILLER_46_149 VPWR VGND sg13cmos5l_fill_1
XFILLER_15_525 VPWR VGND sg13cmos5l_fill_1
XFILLER_3_952 VPWR VGND sg13cmos5l_fill_1
XFILLER_27_7 VPWR VGND sg13cmos5l_fill_1
X_05420_ hold967/A _05401_/A _05421_/B _05419_/Y VPWR VGND sg13cmos5l_a21oi_1
X_05351_ _05370_/B _09297_/Q _09296_/Q VPWR VGND sg13cmos5l_xor2_1
X_08070_ _08174_/C _08070_/A _08082_/A _08082_/C VPWR VGND sg13cmos5l_nand3_1
X_05282_ _05286_/A _05699_/A _05282_/B VPWR VGND sg13cmos5l_xnor2_1
X_07021_ _07021_/Y _06878_/Y _06926_/B _07018_/Y _07019_/Y _07020_/Y VPWR VGND sg13cmos5l_a221oi_1
X_08972_ _08972_/Y _08972_/A _08972_/B VPWR VGND sg13cmos5l_nand2_1
X_07923_ _07923_/Y _07773_/Y _07825_/B _07920_/X _07921_/Y _07922_/Y VPWR VGND sg13cmos5l_a221oi_1
X_07854_ _07854_/Y _07867_/A _07849_/Y _07853_/Y VPWR VGND sg13cmos5l_o21ai_1
X_06805_ _06805_/Y _06819_/A _06798_/Y VPWR VGND sg13cmos5l_nor2b_1
X_07785_ _07953_/A _07732_/Y _07781_/C _08087_/A VPWR VGND sg13cmos5l_o21ai_1
X_04997_ _05387_/B hold998/X VPWR VGND sg13cmos5l_inv_1
X_09524_ _09524_/Q _09591_/CLK _09524_/D _09524_/RESET_B VPWR VGND sg13cmos5l_dfrbpq_1
X_06736_ _09542_/D _06736_/A hold854/X VPWR VGND sg13cmos5l_and2_1
XFILLER_25_812 VPWR VGND sg13cmos5l_fill_1
X_09455_ _09455_/Q clkload24/A _09455_/D _09455_/RESET_B VPWR VGND sg13cmos5l_dfrbpq_1
X_06667_ _06768_/D _06674_/A _06667_/B _06670_/C VPWR VGND sg13cmos5l_nand3_1
X_05618_ _05618_/Y _05298_/X _05616_/Y _05617_/Y VPWR VGND sg13cmos5l_o21ai_1
XFILLER_12_517 VPWR VGND sg13cmos5l_fill_2
X_09170__300 _09170_/RESET_B VPWR VGND sg13cmos5l_tiehi
X_08406_ _08454_/A _09214_/Q _08423_/B VPWR VGND sg13cmos5l_xnor2_1
XFILLER_24_388 VPWR VGND sg13cmos5l_fill_1
X_06598_ _06623_/A _06583_/Y _06593_/Y _06597_/Y VPWR VGND sg13cmos5l_a21oi_1
X_09386_ hold918/A _09387_/CLK _09386_/D _09386_/RESET_B VPWR VGND sg13cmos5l_dfrbpq_1
X_05549_ _05549_/Y _05568_/A _05568_/B VPWR VGND sg13cmos5l_nand2_1
X_08337_ _08338_/B _08315_/B _08032_/Y _08339_/S VPWR VGND sg13cmos5l_mux2_1
X_08268_ _08293_/B _08265_/Y _08267_/Y _08247_/Y VPWR VGND sg13cmos5l_a21oi_1
X_07219_ _07220_/B _07219_/A _07217_/A VPWR VGND sg13cmos5l_nor2b_1
X_09031__451 _09031_/RESET_B VPWR VGND sg13cmos5l_tiehi
X_08199_ _08203_/B _08199_/A VPWR VGND sg13cmos5l_inv_1
XFILLER_19_95 VPWR VGND sg13cmos5l_fill_1
XFILLER_28_661 VPWR VGND sg13cmos5l_fill_2
XFILLER_43_620 VPWR VGND sg13cmos5l_fill_2
XFILLER_16_812 VPWR VGND sg13cmos5l_fill_1
XFILLER_42_152 VPWR VGND sg13cmos5l_fill_2
XFILLER_35_72 VPWR VGND sg13cmos5l_fill_1
XFILLER_37_1028 VPWR VGND sg13cmos5l_fill_1
X_04920_ _06589_/A _09522_/Q VPWR VGND sg13cmos5l_inv_1
X_04851_ _05701_/A _05396_/A VPWR VGND sg13cmos5l_inv_1
XFILLER_47_992 VPWR VGND sg13cmos5l_decap_8
X_07570_ _09079_/D _07636_/B _07570_/B VPWR VGND sg13cmos5l_nor2_1
XFILLER_19_694 VPWR VGND sg13cmos5l_fill_1
XFILLER_46_491 VPWR VGND sg13cmos5l_fill_1
XFILLER_34_631 VPWR VGND sg13cmos5l_fill_1
X_06521_ _06521_/X _06405_/B _06529_/S _06520_/Y VPWR VGND sg13cmos5l_a21o_1
X_09240_ _09240_/Q clkload3/A _09240_/D _09240_/RESET_B VPWR VGND sg13cmos5l_dfrbpq_1
X_06452_ _06452_/Y _06429_/Y _06456_/S _06477_/B VPWR VGND sg13cmos5l_a21oi_1
X_06383_ _06384_/A _09449_/Q _09448_/Q VPWR VGND sg13cmos5l_xnor2_1
X_09171_ hold871/A _09347_/CLK _09171_/D _09171_/RESET_B VPWR VGND sg13cmos5l_dfrbpq_1
X_05403_ _05403_/Y _05403_/A _05408_/B VPWR VGND sg13cmos5l_nor2_1
X_05334_ _09331_/D _05378_/A _05504_/A VPWR VGND sg13cmos5l_nor2_1
X_08122_ _08124_/A _08122_/A _08130_/B VPWR VGND sg13cmos5l_nor2_1
X_08053_ _08054_/C _08145_/A _08052_/B _08075_/B VPWR VGND sg13cmos5l_a21oi_1
X_05265_ _05287_/B _09328_/Q _09327_/Q _09329_/Q _09330_/Q VPWR VGND sg13cmos5l_nor4_1
X_07004_ _07016_/A _09583_/Q _07011_/B _07046_/A VPWR VGND sg13cmos5l_a21o_1
X_05196_ _05196_/Y _05196_/A _05196_/B _05196_/C _05196_/D VPWR VGND sg13cmos5l_nand4_1
X_08955_ _08955_/Y _09265_/Q _08964_/B VPWR VGND sg13cmos5l_nand2_1
X_09397__713 _09397_/RESET_B VPWR VGND sg13cmos5l_tiehi
X_07906_ _07940_/A _07939_/B _07939_/C _07939_/A VPWR VGND sg13cmos5l_a21oi_1
X_08886_ _08887_/B _09277_/Q _08850_/B _08843_/Y VPWR VGND sg13cmos5l_a21oi_1
X_07837_ _07837_/Y _08144_/A hold978/A VPWR VGND sg13cmos5l_nor2_1
X_07768_ _07769_/B _07921_/A _07921_/B VPWR VGND sg13cmos5l_and2_1
XFILLER_38_992 VPWR VGND sg13cmos5l_fill_1
X_06719_ _06719_/Y _04967_/A _06716_/B _06737_/B VPWR VGND sg13cmos5l_o21ai_1
X_09507_ _09507_/Q clkload22/A _09507_/D _09507_/RESET_B VPWR VGND sg13cmos5l_dfrbpq_1
X_07699_ _07699_/Y _07699_/A _07699_/B VPWR VGND sg13cmos5l_nand2_1
XFILLER_25_686 VPWR VGND sg13cmos5l_fill_2
XFILLER_40_623 VPWR VGND sg13cmos5l_fill_1
X_09438_ _09438_/Q clkload19/A _09438_/D _09438_/RESET_B VPWR VGND sg13cmos5l_dfrbpq_1
X_09369_ _09369_/Q clkload20/A _09369_/D _09369_/RESET_B VPWR VGND sg13cmos5l_dfrbpq_1
X_09593__493 _09593_/RESET_B VPWR VGND sg13cmos5l_tiehi
XFILLER_35_428 VPWR VGND sg13cmos5l_fill_1
XFILLER_44_940 VPWR VGND sg13cmos5l_decap_8
XFILLER_31_656 VPWR VGND sg13cmos5l_fill_1
XFILLER_8_841 VPWR VGND sg13cmos5l_fill_1
XFILLER_31_689 VPWR VGND sg13cmos5l_fill_1
XFILLER_8_874 VPWR VGND sg13cmos5l_fill_1
XFILLER_7_373 VPWR VGND sg13cmos5l_fill_2
X_05050_ _05054_/D _05028_/B _05040_/A hold1286/X VPWR VGND sg13cmos5l_o21ai_1
X_08740_ _08746_/C _09255_/Q _08739_/C _09256_/Q VPWR VGND sg13cmos5l_o21ai_1
Xhold1007 hold1007/X _09577_/Q VPWR VGND sg13cmos5l_dlygate4sd3_1
Xhold1029 _09341_/D _05423_/Y VPWR VGND sg13cmos5l_dlygate4sd3_1
Xhold1018 _05411_/A _09363_/Q VPWR VGND sg13cmos5l_dlygate4sd3_1
X_05952_ _09421_/D _04979_/Y _05937_/B _05951_/A VPWR VGND sg13cmos5l_a21oi_1
X_05883_ _05903_/C _05875_/Y _05879_/Y _05881_/Y VPWR VGND sg13cmos5l_a21o_1
X_08671_ _08672_/A _08642_/X _08294_/Y _08671_/S VPWR VGND sg13cmos5l_mux2_1
XFILLER_16_0 VPWR VGND sg13cmos5l_fill_2
X_04903_ _07891_/A _04903_/A VPWR VGND sg13cmos5l_inv_1
XFILLER_38_222 VPWR VGND sg13cmos5l_fill_2
X_07622_ _09087_/D _07622_/A _07621_/Y VPWR VGND sg13cmos5l_nor2b_1
X_04834_ _04834_/Y hold926/X VPWR VGND sg13cmos5l_inv_1
X_07553_ _07577_/B _07550_/A _07550_/B _07538_/A VPWR VGND sg13cmos5l_a21o_1
X_06504_ _06504_/Y _06364_/B _06513_/A _06501_/X _06502_/Y _06503_/Y VPWR VGND sg13cmos5l_a221oi_1
X_07484_ _07521_/A _07493_/B _07490_/C VPWR VGND sg13cmos5l_nand2_1
XFILLER_34_494 VPWR VGND sg13cmos5l_fill_2
X_09223_ _09223_/Q _09595_/CLK _09223_/D _09223_/RESET_B VPWR VGND sg13cmos5l_dfrbpq_1
X_06435_ _06436_/B _09493_/Q _06429_/Y _06434_/Y _09494_/Q VPWR VGND sg13cmos5l_a22oi_1
X_09154_ _09154_/Q clkload4/A _09154_/D _09154_/RESET_B VPWR VGND sg13cmos5l_dfrbpq_1
X_08105_ _08105_/Y _08105_/A VPWR VGND sg13cmos5l_inv_1
X_06366_ _06366_/Y _06656_/A _06651_/A VPWR VGND sg13cmos5l_nor2_1
X_05317_ _05317_/Y _05317_/A _05327_/B VPWR VGND sg13cmos5l_nor2_1
X_06297_ _09474_/D _06263_/A _06302_/S _06296_/Y VPWR VGND sg13cmos5l_a21oi_1
X_09085_ _09085_/Q _09388_/CLK _09085_/D _09085_/RESET_B VPWR VGND sg13cmos5l_dfrbpq_1
X_08036_ _09149_/D _08084_/A _08035_/Y VPWR VGND sg13cmos5l_nor2b_1
X_05248_ _05248_/Y _08757_/A hold903/X VPWR VGND sg13cmos5l_nor2_1
Xhold852 hold852/X hold852/A VPWR VGND sg13cmos5l_dlygate4sd3_1
Xhold863 hold863/X hold863/A VPWR VGND sg13cmos5l_dlygate4sd3_1
X_05179_ _05179_/Y _05443_/A _05198_/B VPWR VGND sg13cmos5l_nand2_1
Xhold896 hold896/X hold896/A VPWR VGND sg13cmos5l_dlygate4sd3_1
Xhold885 hold885/X hold885/A VPWR VGND sg13cmos5l_dlygate4sd3_1
Xhold874 hold874/X hold874/A VPWR VGND sg13cmos5l_dlygate4sd3_1
X_09206__262 _09206_/RESET_B VPWR VGND sg13cmos5l_tiehi
X_08938_ _09297_/D _08938_/A _08939_/B VPWR VGND sg13cmos5l_nor2_1
X_08869_ _08869_/Y _08782_/A _08768_/Y _08868_/Y VPWR VGND sg13cmos5l_a21oi_1
XFILLER_40_431 VPWR VGND sg13cmos5l_fill_1
XFILLER_12_144 VPWR VGND sg13cmos5l_fill_1
XFILLER_12_166 VPWR VGND sg13cmos5l_fill_2
XFILLER_13_689 VPWR VGND sg13cmos5l_fill_2
XFILLER_4_376 VPWR VGND sg13cmos5l_fill_1
XFILLER_4_365 VPWR VGND sg13cmos5l_fill_1
XFILLER_0_571 VPWR VGND sg13cmos5l_decap_4
XFILLER_48_553 VPWR VGND sg13cmos5l_fill_1
X_09456__651 _09456_/RESET_B VPWR VGND sg13cmos5l_tiehi
XFILLER_17_951 VPWR VGND sg13cmos5l_fill_1
XFILLER_17_973 VPWR VGND sg13cmos5l_fill_1
XFILLER_17_984 VPWR VGND sg13cmos5l_fill_1
XFILLER_32_943 VPWR VGND sg13cmos5l_fill_1
X_06220_ _09469_/D _06220_/A _06303_/A VPWR VGND sg13cmos5l_nor2_1
X_06151_ _09449_/D _06299_/A _06151_/B VPWR VGND sg13cmos5l_nor2_1
X_06082_ _06082_/Y _06103_/B _06070_/Y _06079_/Y _06080_/Y _06081_/Y VPWR VGND sg13cmos5l_a221oi_1
X_05102_ _05348_/A _09324_/Q _05103_/B VPWR VGND sg13cmos5l_xnor2_1
X_05033_ _09606_/D _09604_/D _09605_/D _09603_/D VPWR VGND sg13cmos5l_or3_1
X_06984_ hold894/A _04832_/Y fanout60/X _06983_/Y VPWR VGND sg13cmos5l_a21oi_1
X_08723_ _09250_/D _08723_/A _08723_/B VPWR VGND sg13cmos5l_and2_1
X_09394__716 _09394_/RESET_B VPWR VGND sg13cmos5l_tiehi
X_05935_ _05935_/Y _04980_/Y _05950_/A _05932_/Y VPWR VGND sg13cmos5l_o21ai_1
X_05866_ _05866_/Y _05896_/A _05896_/B _05871_/A VPWR VGND sg13cmos5l_a21oi_1
X_08654_ _08657_/C _08631_/Y _08651_/Y _08273_/Y VPWR VGND sg13cmos5l_o21ai_1
X_05797_ _05839_/B _09404_/Q _09403_/Q VPWR VGND sg13cmos5l_xnor2_1
X_08585_ _08585_/Y hold1117/X fanout36/X _08599_/B VPWR VGND sg13cmos5l_o21ai_1
X_07605_ _07605_/Y _07617_/A _07600_/Y _07604_/Y VPWR VGND sg13cmos5l_o21ai_1
X_04817_ _04817_/Y hold888/X VPWR VGND sg13cmos5l_inv_1
X_07536_ _07550_/B _09041_/Q _09042_/Q _09039_/Q _09040_/Q VPWR VGND sg13cmos5l_nor4_1
X_09095__381 _09095_/RESET_B VPWR VGND sg13cmos5l_tiehi
XFILLER_23_954 VPWR VGND sg13cmos5l_fill_1
XFILLER_23_976 VPWR VGND sg13cmos5l_fill_2
X_07467_ _09069_/D _07454_/A hold1310/X _07463_/A VPWR VGND sg13cmos5l_a21oi_1
X_09206_ hold964/A _09312_/CLK _09206_/D _09206_/RESET_B VPWR VGND sg13cmos5l_dfrbpq_1
X_07398_ _07430_/B _07408_/A _07408_/B VPWR VGND sg13cmos5l_and2_1
X_06418_ _06418_/Y _06738_/A _09455_/Q _06417_/Y VPWR VGND sg13cmos5l_a21oi_1
X_06349_ _06349_/Y _06349_/A _06349_/B _06349_/C _06349_/D VPWR VGND sg13cmos5l_nor4_1
X_09137_ _09137_/Q clkload16/A _09137_/D _09137_/RESET_B VPWR VGND sg13cmos5l_dfrbpq_1
X_09167__305 _09167_/RESET_B VPWR VGND sg13cmos5l_tiehi
X_09068_ _09068_/Q _09573_/CLK _09068_/D _09068_/RESET_B VPWR VGND sg13cmos5l_dfrbpq_1
X_08019_ _08019_/Y _08397_/A _08037_/B VPWR VGND sg13cmos5l_nand2b_1
XFILLER_49_317 VPWR VGND sg13cmos5l_decap_4
Xhold1360 _06311_/A _09484_/Q VPWR VGND sg13cmos5l_dlygate4sd3_1
XFILLER_40_1024 VPWR VGND sg13cmos5l_decap_4
Xhold1371 hold1371/X _09403_/Q VPWR VGND sg13cmos5l_dlygate4sd3_1
Xhold1393 hold1393/X _09526_/Q VPWR VGND sg13cmos5l_dlygate4sd3_1
Xhold1382 _05464_/A _09358_/Q VPWR VGND sg13cmos5l_dlygate4sd3_1
XFILLER_45_578 VPWR VGND sg13cmos5l_fill_1
X_09590__496 _09590_/RESET_B VPWR VGND sg13cmos5l_tiehi
XFILLER_9_457 VPWR VGND sg13cmos5l_fill_1
XFILLER_5_630 VPWR VGND sg13cmos5l_fill_1
XFILLER_4_151 VPWR VGND sg13cmos5l_fill_1
X_09302__345 _09302_/RESET_B VPWR VGND sg13cmos5l_tiehi
XFILLER_49_873 VPWR VGND sg13cmos5l_fill_2
XFILLER_49_862 VPWR VGND sg13cmos5l_fill_2
XFILLER_48_394 VPWR VGND sg13cmos5l_fill_1
X_05720_ _05720_/Y _05720_/A VPWR VGND sg13cmos5l_inv_1
X_05651_ _05670_/B _05651_/A _05651_/B VPWR VGND sg13cmos5l_nor2_1
X_08370_ _08370_/Y _08362_/X _08365_/Y _08369_/Y VPWR VGND sg13cmos5l_a21oi_1
X_05582_ _05582_/X _05560_/B _05554_/B _05588_/A VPWR VGND sg13cmos5l_a21o_1
X_07321_ _07419_/D _07288_/Y _07309_/Y _06874_/Y VPWR VGND sg13cmos5l_o21ai_1
X_07252_ _07252_/Y _07276_/B _07246_/Y _07280_/A _07250_/Y VPWR VGND sg13cmos5l_a22oi_1
Xclkbuf_3_2__f_clk clkbuf_leaf_9_clk/A clkbuf_0_clk/X VPWR VGND sg13cmos5l_buf_8
X_06203_ _06203_/Y _06187_/Y fanout43/X _06047_/Y VPWR VGND sg13cmos5l_o21ai_1
X_07183_ _07185_/A hold983/X _07193_/B VPWR VGND sg13cmos5l_nor2_1
X_06134_ _06134_/Y _05848_/A _06122_/Y _06133_/Y _05853_/A VPWR VGND sg13cmos5l_a22oi_1
X_06065_ _06390_/A _09477_/Q _06065_/B VPWR VGND sg13cmos5l_xnor2_1
X_05016_ _07076_/A _09604_/Q _09603_/Q VPWR VGND sg13cmos5l_nor2_1
X_06967_ _06967_/Y _06945_/X _06964_/Y _06988_/B VPWR VGND sg13cmos5l_o21ai_1
XFILLER_39_383 VPWR VGND sg13cmos5l_fill_2
X_08706_ _08706_/Y _08706_/A VPWR VGND sg13cmos5l_inv_1
X_06898_ _06898_/Y _06923_/A _06923_/B _06903_/A VPWR VGND sg13cmos5l_a21oi_1
X_05918_ _05918_/Y _05918_/A _05933_/B VPWR VGND sg13cmos5l_nand2_1
X_05849_ _05997_/B _05852_/A _05852_/C _05848_/Y VPWR VGND sg13cmos5l_o21ai_1
X_08637_ _08637_/Y _09216_/Q _09191_/Q VPWR VGND sg13cmos5l_nor2_1
X_08568_ _08568_/Y _09200_/Q _08568_/B VPWR VGND sg13cmos5l_nand2_1
Xfanout21 fanout21/X _08465_/Y VPWR VGND sg13cmos5l_buf_1
X_08499_ _08506_/B _09248_/Q _09249_/Q _09247_/Q _08555_/A VPWR VGND sg13cmos5l_nor4_1
X_07519_ _07519_/Y _07519_/A _07799_/A VPWR VGND sg13cmos5l_nand2_1
Xfanout32 _07620_/B _07609_/Y VPWR VGND sg13cmos5l_buf_1
Xfanout54 fanout54/X fanout62/X VPWR VGND sg13cmos5l_buf_1
Xfanout43 fanout43/X _06196_/Y VPWR VGND sg13cmos5l_buf_1
Xfanout65 _08809_/B _08793_/Y VPWR VGND sg13cmos5l_buf_1
Xfanout76 _05199_/C _05089_/Y VPWR VGND sg13cmos5l_buf_1
Xfanout98 _06243_/B _06232_/B VPWR VGND sg13cmos5l_buf_1
Xfanout87 _07818_/A _07829_/A VPWR VGND sg13cmos5l_buf_1
XFILLER_11_979 VPWR VGND sg13cmos5l_fill_1
X_09446__661 _09446_/RESET_B VPWR VGND sg13cmos5l_tiehi
X_09453__654 _09453_/RESET_B VPWR VGND sg13cmos5l_tiehi
XFILLER_45_331 VPWR VGND sg13cmos5l_fill_2
Xhold1190 _09419_/D _05948_/Y VPWR VGND sg13cmos5l_dlygate4sd3_1
XFILLER_14_795 VPWR VGND sg13cmos5l_fill_1
Xclkload13 clkload13/Y clkload13/A VPWR VGND sg13cmos5l_inv_2
Xclkload24 clkload24/Y clkload24/A VPWR VGND sg13cmos5l_inv_1
X_09460__647 _09460_/RESET_B VPWR VGND sg13cmos5l_tiehi
X_07870_ _07870_/Y hold1218/X _07874_/S _07890_/B VPWR VGND sg13cmos5l_o21ai_1
X_06821_ _09553_/D _06821_/A _06821_/B VPWR VGND sg13cmos5l_nor2_1
X_09540_ hold858/A _09575_/CLK _09540_/D _09540_/RESET_B VPWR VGND sg13cmos5l_dfrbpq_1
X_06752_ _06788_/C hold893/A hold854/A _09544_/Q VPWR VGND sg13cmos5l_nand3_1
X_09391__719 _09391_/RESET_B VPWR VGND sg13cmos5l_tiehi
X_05703_ _05703_/Y hold928/A hold872/A VPWR VGND sg13cmos5l_xnor2_1
X_09471_ _09471_/Q clkload19/A _09471_/D _09471_/RESET_B VPWR VGND sg13cmos5l_dfrbpq_1
X_08422_ _08461_/A _08455_/A _08422_/B VPWR VGND sg13cmos5l_and2_1
X_06683_ _06683_/Y _09492_/Q _09549_/Q VPWR VGND sg13cmos5l_nor2b_1
X_05634_ _05737_/A _05610_/Y _05327_/Y _05636_/S VPWR VGND sg13cmos5l_mux2_1
X_05565_ _05565_/Y _05557_/X _05561_/Y _05876_/A _05592_/B _05562_/Y VPWR VGND sg13cmos5l_a221oi_1
X_08353_ _08354_/B _09221_/Q _08353_/B VPWR VGND sg13cmos5l_nor2_1
X_07304_ _07330_/B _09566_/Q _07301_/B hold1291/X VPWR VGND sg13cmos5l_o21ai_1
X_08284_ _08430_/A _08285_/B _08285_/C _08283_/Y VPWR VGND sg13cmos5l_a21o_1
X_05496_ _05499_/B _05326_/B _05378_/B _05508_/B VPWR VGND sg13cmos5l_mux2_1
X_07235_ _07547_/A _09066_/Q _09065_/Q VPWR VGND sg13cmos5l_xnor2_1
XFILLER_30_1001 VPWR VGND sg13cmos5l_fill_1
Xclkload7 clkload7/Y clkload7/A VPWR VGND sg13cmos5l_inv_1
X_07166_ _09009_/D _07197_/A _07216_/B VPWR VGND sg13cmos5l_nor2b_1
XFILLER_3_408 VPWR VGND sg13cmos5l_fill_2
X_06117_ _09446_/D _06218_/B _06253_/A VPWR VGND sg13cmos5l_and2_1
X_07097_ _07099_/B _07101_/B hold938/X _04877_/Y VPWR VGND sg13cmos5l_o21ai_1
X_06048_ _06048_/Y hold898/X _06470_/A VPWR VGND sg13cmos5l_nand2b_1
Xfanout200 _08134_/A _08986_/A VPWR VGND sg13cmos5l_buf_1
Xfanout211 fanout211/X fanout216/X VPWR VGND sg13cmos5l_buf_1
X_07999_ _08007_/B _07999_/A _07999_/B _07999_/C VPWR VGND sg13cmos5l_nand3_1
XFILLER_27_364 VPWR VGND sg13cmos5l_fill_2
XFILLER_24_74 VPWR VGND sg13cmos5l_fill_2
XFILLER_6_202 VPWR VGND sg13cmos5l_fill_1
XFILLER_6_279 VPWR VGND sg13cmos5l_fill_2
X_09600__521 _09600_/RESET_B VPWR VGND sg13cmos5l_tiehi
XFILLER_37_117 VPWR VGND sg13cmos5l_fill_1
XFILLER_46_640 VPWR VGND sg13cmos5l_fill_1
XFILLER_34_802 VPWR VGND sg13cmos5l_fill_1
XFILLER_33_312 VPWR VGND sg13cmos5l_fill_1
X_05350_ _05350_/Y _05376_/A _05376_/B _05355_/A VPWR VGND sg13cmos5l_a21oi_1
X_05281_ _05327_/A _09362_/Q _05282_/B VPWR VGND sg13cmos5l_xnor2_1
X_07020_ _07020_/Y _07019_/A _07019_/B _07019_/C _07019_/D VPWR VGND sg13cmos5l_a22oi_1
XFILLER_46_0 VPWR VGND sg13cmos5l_fill_2
X_08971_ _08971_/Y _08963_/X _08966_/Y _08970_/Y VPWR VGND sg13cmos5l_a21oi_1
X_07922_ _07922_/Y _07921_/A _07921_/B _07921_/C _07921_/D VPWR VGND sg13cmos5l_a22oi_1
XFILLER_29_19 VPWR VGND sg13cmos5l_fill_1
X_07853_ _07853_/Y _09122_/Q _07846_/Y _07852_/Y _09123_/Q VPWR VGND sg13cmos5l_a22oi_1
X_06804_ _06809_/B _06804_/A _06810_/A VPWR VGND sg13cmos5l_nor2b_1
X_07784_ _09112_/D _07875_/A _07784_/B VPWR VGND sg13cmos5l_nor2_1
X_04996_ _04996_/Y _04996_/A VPWR VGND sg13cmos5l_inv_1
X_09436__671 _09436_/RESET_B VPWR VGND sg13cmos5l_tiehi
X_09523_ _09523_/Q clkload23/A _09523_/D _09523_/RESET_B VPWR VGND sg13cmos5l_dfrbpq_1
X_06735_ _09541_/D _06736_/A hold851/X VPWR VGND sg13cmos5l_and2_1
X_09454_ hold985/A clkload24/A hold986/X _09454_/RESET_B VPWR VGND sg13cmos5l_dfrbpq_1
X_06666_ _06768_/C _06674_/A _06670_/C _06350_/Y VPWR VGND sg13cmos5l_a21o_1
X_05617_ _05617_/Y _05617_/A _05617_/B VPWR VGND sg13cmos5l_nand2_1
X_08405_ _08405_/Y _08403_/Y _08404_/Y _08438_/A VPWR VGND sg13cmos5l_a21oi_1
X_09385_ hold928/A _09387_/CLK _09385_/D _09385_/RESET_B VPWR VGND sg13cmos5l_dfrbpq_1
X_08336_ _09193_/D _08380_/A _08336_/B VPWR VGND sg13cmos5l_nor2_1
X_06597_ _06597_/Y _06912_/A _06612_/B _06596_/Y VPWR VGND sg13cmos5l_o21ai_1
X_05548_ _05568_/B _09370_/Q _05548_/B VPWR VGND sg13cmos5l_xor2_1
X_05479_ _05479_/Y _05329_/B _05484_/A _05478_/Y VPWR VGND sg13cmos5l_o21ai_1
X_08267_ _08267_/Y _08245_/Y _08246_/Y _08266_/Y VPWR VGND sg13cmos5l_a21oi_1
X_07218_ _09026_/D _09006_/D _07218_/B VPWR VGND sg13cmos5l_and2_1
X_08198_ _08199_/A _08198_/A _08207_/B _08198_/C VPWR VGND sg13cmos5l_nor3_1
X_07149_ _07149_/Y _07167_/A VPWR VGND sg13cmos5l_inv_1
X_09443__664 _09443_/RESET_B VPWR VGND sg13cmos5l_tiehi
XFILLER_10_54 VPWR VGND sg13cmos5l_fill_1
XFILLER_0_934 VPWR VGND sg13cmos5l_decap_8
XFILLER_0_989 VPWR VGND sg13cmos5l_decap_8
XFILLER_48_938 VPWR VGND sg13cmos5l_fill_2
X_09450__657 _09450_/RESET_B VPWR VGND sg13cmos5l_tiehi
XFILLER_7_544 VPWR VGND sg13cmos5l_decap_8
XFILLER_2_260 VPWR VGND sg13cmos5l_fill_2
X_04850_ _05698_/A _05403_/A VPWR VGND sg13cmos5l_inv_1
X_06520_ _06520_/Y _06512_/A _06512_/B _06352_/B VPWR VGND sg13cmos5l_a21oi_1
X_06451_ _06453_/A _06692_/A _06456_/S VPWR VGND sg13cmos5l_nor2_1
X_05402_ _05407_/A _09341_/Q _05400_/Y _05401_/Y VPWR VGND sg13cmos5l_o21ai_1
X_06382_ _06382_/Y _09473_/Q _09448_/Q VPWR VGND sg13cmos5l_nor2_1
X_09170_ hold875/A _09388_/CLK _09170_/D _09170_/RESET_B VPWR VGND sg13cmos5l_dfrbpq_1
X_05333_ _05504_/A _05328_/S _05331_/Y _05330_/X VPWR VGND sg13cmos5l_a21o_1
X_08121_ _08121_/Y _08132_/A _08121_/B _08121_/C VPWR VGND sg13cmos5l_nor3_1
X_05264_ _05283_/B _09328_/Q _09327_/Q _09329_/Q VPWR VGND sg13cmos5l_or3_1
X_08052_ _08054_/B _08145_/A _08052_/B VPWR VGND sg13cmos5l_nor2_1
X_07003_ _07046_/A _07045_/B _07045_/C _07045_/A VPWR VGND sg13cmos5l_a21oi_1
X_05195_ _08940_/A _05196_/C _05196_/D VPWR VGND sg13cmos5l_nand2_1
X_08954_ _08954_/Y _09307_/Q _08954_/B VPWR VGND sg13cmos5l_nand2_1
X_07905_ _07939_/C hold916/A hold874/A _09135_/Q VPWR VGND sg13cmos5l_nand3_1
X_08885_ _08885_/Y _08865_/Y _08885_/B VPWR VGND sg13cmos5l_nand2b_1
X_07836_ _07836_/Y _08145_/A _09084_/Q VPWR VGND sg13cmos5l_nand2_1
X_04979_ _04979_/Y _04979_/A VPWR VGND sg13cmos5l_inv_1
X_07767_ _07921_/B _07767_/A _07772_/B _07772_/C VPWR VGND sg13cmos5l_nand3_1
X_06718_ _09531_/D _06718_/A _06717_/Y VPWR VGND sg13cmos5l_nor2b_1
XFILLER_25_643 VPWR VGND sg13cmos5l_fill_1
X_09506_ _09506_/Q clkload24/A _09506_/D _09506_/RESET_B VPWR VGND sg13cmos5l_dfrbpq_1
X_07698_ _07701_/A _07698_/A _07698_/B _07698_/C VPWR VGND sg13cmos5l_nor3_1
X_09291__480 _09291_/RESET_B VPWR VGND sg13cmos5l_tiehi
X_06649_ _06649_/Y _06361_/B _06674_/B _06651_/B _06651_/A VPWR VGND sg13cmos5l_a22oi_1
X_09437_ _09437_/Q clkload19/A _09437_/D _09437_/RESET_B VPWR VGND sg13cmos5l_dfrbpq_1
X_09368_ _09368_/Q clkload11/A _09368_/D _09368_/RESET_B VPWR VGND sg13cmos5l_dfrbpq_1
X_09299_ _09299_/Q clkload10/A _09299_/D _09299_/RESET_B VPWR VGND sg13cmos5l_dfrbpq_1
X_08319_ _08319_/Y _08314_/A _08314_/B _08318_/X _08007_/A VPWR VGND sg13cmos5l_a22oi_1
XFILLER_29_960 VPWR VGND sg13cmos5l_decap_8
XFILLER_30_112 VPWR VGND sg13cmos5l_fill_2
XFILLER_7_330 VPWR VGND sg13cmos5l_fill_2
XFILLER_7_385 VPWR VGND sg13cmos5l_fill_1
X_09426__681 _09426_/RESET_B VPWR VGND sg13cmos5l_tiehi
Xhold1008 _04828_/A _09053_/Q VPWR VGND sg13cmos5l_dlygate4sd3_1
Xhold1019 _07213_/A _09022_/Q VPWR VGND sg13cmos5l_dlygate4sd3_1
X_05951_ hold975/A _05951_/A hold974/X _05951_/C VPWR VGND sg13cmos5l_nor3_1
X_05882_ _05893_/A _05875_/Y _05879_/Y _05881_/Y VPWR VGND sg13cmos5l_a21oi_1
X_08670_ _08670_/Y _08537_/B _08679_/A _08667_/Y VPWR VGND sg13cmos5l_o21ai_1
X_04902_ _07893_/A _04902_/A VPWR VGND sg13cmos5l_inv_1
X_07621_ _07621_/Y _07607_/A _07620_/B _07716_/A VPWR VGND sg13cmos5l_a21oi_1
X_04833_ _04833_/Y hold913/X VPWR VGND sg13cmos5l_inv_1
X_07552_ _07552_/Y _07545_/Y _07548_/Y _07551_/Y VPWR VGND sg13cmos5l_o21ai_1
X_06503_ _06503_/Y _06503_/A _06503_/B VPWR VGND sg13cmos5l_nor2_1
X_07483_ _07490_/C _09070_/Q _09071_/Q _09072_/Q VPWR VGND sg13cmos5l_o21ai_1
X_09433__674 _09433_/RESET_B VPWR VGND sg13cmos5l_tiehi
X_09222_ _09222_/Q _09595_/CLK _09222_/D _09222_/RESET_B VPWR VGND sg13cmos5l_dfrbpq_1
X_06434_ _06434_/Y _06434_/A VPWR VGND sg13cmos5l_inv_1
X_06365_ _06365_/Y _06365_/A _06365_/B VPWR VGND sg13cmos5l_nor2_1
X_09153_ _09153_/Q _09214_/CLK _09153_/D _09153_/RESET_B VPWR VGND sg13cmos5l_dfrbpq_1
X_05316_ _05474_/A _05330_/A _05316_/B _05330_/C VPWR VGND sg13cmos5l_nand3_1
X_08104_ _08105_/A _04946_/Y _08111_/B _08103_/Y VPWR VGND sg13cmos5l_a21oi_1
X_06296_ _06296_/Y _06264_/X _06302_/S _06218_/B VPWR VGND sg13cmos5l_o21ai_1
X_09084_ _09084_/Q _09388_/CLK _09084_/D _09084_/RESET_B VPWR VGND sg13cmos5l_dfrbpq_1
X_08035_ _08035_/Y _08009_/Y _08032_/Y _08034_/Y VPWR VGND sg13cmos5l_o21ai_1
X_05247_ _05247_/Y _05242_/Y _05260_/A _05260_/B VPWR VGND sg13cmos5l_o21ai_1
X_05178_ _08937_/B _05176_/B _05194_/C _05177_/Y VPWR VGND sg13cmos5l_a21o_1
Xhold853 hold853/X hold853/A VPWR VGND sg13cmos5l_dlygate4sd3_1
Xhold864 hold864/X hold864/A VPWR VGND sg13cmos5l_dlygate4sd3_1
Xhold897 hold897/X hold897/A VPWR VGND sg13cmos5l_dlygate4sd3_1
Xhold875 hold875/X hold875/A VPWR VGND sg13cmos5l_dlygate4sd3_1
Xhold886 hold886/X hold886/A VPWR VGND sg13cmos5l_dlygate4sd3_1
X_09440__667 _09440_/RESET_B VPWR VGND sg13cmos5l_tiehi
X_08937_ _09296_/D _08937_/A _08937_/B _08997_/B VPWR VGND sg13cmos5l_and3_1
X_08868_ _08868_/Y _08868_/A _08868_/B _08868_/C VPWR VGND sg13cmos5l_nor3_1
X_07819_ _07921_/D _07818_/A _07829_/C _07514_/Y VPWR VGND sg13cmos5l_a21o_1
X_08799_ _08800_/C _09265_/Q _08799_/B VPWR VGND sg13cmos5l_nor2_1
XFILLER_25_484 VPWR VGND sg13cmos5l_fill_2
XFILLER_41_977 VPWR VGND sg13cmos5l_fill_2
XFILLER_40_454 VPWR VGND sg13cmos5l_decap_8
X_09232__835 _09232_/RESET_B VPWR VGND sg13cmos5l_tiehi
XFILLER_12_123 VPWR VGND sg13cmos5l_fill_1
XFILLER_5_856 VPWR VGND sg13cmos5l_fill_1
XFILLER_4_322 VPWR VGND sg13cmos5l_decap_8
XFILLER_44_760 VPWR VGND sg13cmos5l_fill_2
XFILLER_44_782 VPWR VGND sg13cmos5l_fill_1
X_09387__724 _09387_/RESET_B VPWR VGND sg13cmos5l_tiehi
XFILLER_32_999 VPWR VGND sg13cmos5l_fill_2
X_06150_ _06150_/Y _05837_/Y _06144_/Y _06148_/Y VPWR VGND sg13cmos5l_a21oi_1
X_06081_ _06081_/Y _06112_/B _06390_/A VPWR VGND sg13cmos5l_nor2_1
X_05101_ _05108_/B _09324_/Q _09323_/Q _09322_/Q VPWR VGND sg13cmos5l_nor3_1
X_05032_ _09603_/D _08478_/A _05032_/B VPWR VGND sg13cmos5l_nor2_1
X_06983_ _06983_/Y _09577_/Q fanout60/X _06736_/A VPWR VGND sg13cmos5l_o21ai_1
X_08722_ _08723_/B _08704_/A _08708_/Y _08709_/A VPWR VGND sg13cmos5l_o21ai_1
X_05934_ _05950_/A _04984_/Y _05917_/Y _05933_/Y VPWR VGND sg13cmos5l_a21oi_1
X_05865_ _05896_/B _09373_/Q _09372_/Q hold1390/X VPWR VGND sg13cmos5l_o21ai_1
X_08653_ _08671_/S _08659_/C _08663_/C VPWR VGND sg13cmos5l_nand2_1
X_05796_ _05796_/X _05843_/A _05843_/C _06129_/A VPWR VGND sg13cmos5l_a21o_1
X_08584_ _08584_/Y _08557_/Y fanout36/X _08583_/Y VPWR VGND sg13cmos5l_a21oi_1
X_07604_ _07604_/Y _07620_/A _09087_/Q VPWR VGND sg13cmos5l_nand2b_1
X_04816_ _04816_/Y hold976/X VPWR VGND sg13cmos5l_inv_1
X_07535_ _07568_/A _09041_/Q _09039_/Q _09040_/Q VPWR VGND sg13cmos5l_or3_1
X_07466_ _07466_/Y _07466_/A _07466_/B _07466_/C VPWR VGND sg13cmos5l_nand3_1
X_09205_ hold900/A _09387_/CLK _09205_/D _09205_/RESET_B VPWR VGND sg13cmos5l_dfrbpq_1
X_06417_ _06417_/Y _09511_/Q _06417_/B VPWR VGND sg13cmos5l_nand2_1
X_07397_ _07437_/A _09060_/Q _07408_/B VPWR VGND sg13cmos5l_xnor2_1
X_06348_ _06349_/D _06365_/A _06348_/B VPWR VGND sg13cmos5l_or2_1
X_09136_ _09136_/Q clkload16/A _09136_/D _09136_/RESET_B VPWR VGND sg13cmos5l_dfrbpq_1
X_09067_ _09067_/Q _09573_/CLK _09067_/D _09067_/RESET_B VPWR VGND sg13cmos5l_dfrbpq_1
X_06279_ _06283_/A _06285_/B _06279_/B _06279_/C VPWR VGND sg13cmos5l_nor3_1
X_08018_ _09146_/D _08018_/A _08081_/A VPWR VGND sg13cmos5l_nor2_1
X_09579__507 _09579_/RESET_B VPWR VGND sg13cmos5l_tiehi
Xhold1361 hold1361/X _09215_/Q VPWR VGND sg13cmos5l_dlygate4sd3_1
Xhold1350 _05078_/A _09315_/Q VPWR VGND sg13cmos5l_dlygate4sd3_1
XFILLER_45_546 VPWR VGND sg13cmos5l_fill_1
Xhold1394 _08497_/A _09226_/Q VPWR VGND sg13cmos5l_dlygate4sd3_1
Xhold1383 hold1383/X _09222_/Q VPWR VGND sg13cmos5l_dlygate4sd3_1
Xhold1372 _07657_/A _09096_/Q VPWR VGND sg13cmos5l_dlygate4sd3_1
XFILLER_18_749 VPWR VGND sg13cmos5l_fill_2
XFILLER_1_881 VPWR VGND sg13cmos5l_fill_1
XFILLER_36_502 VPWR VGND sg13cmos5l_decap_4
X_05650_ _05650_/Y _05650_/A VPWR VGND sg13cmos5l_inv_1
X_05581_ _05581_/X _05586_/A _05871_/A VPWR VGND sg13cmos5l_and2_1
X_07320_ _07419_/C _07320_/A _07320_/B _07324_/C VPWR VGND sg13cmos5l_nand3_1
X_09430__677 _09430_/RESET_B VPWR VGND sg13cmos5l_tiehi
XFILLER_31_262 VPWR VGND sg13cmos5l_fill_1
X_07251_ _07279_/B _07638_/A _07251_/B VPWR VGND sg13cmos5l_xnor2_1
X_06202_ _06202_/Y _04975_/Y fanout43/X _06201_/Y VPWR VGND sg13cmos5l_a21oi_1
X_07182_ _07196_/B _08785_/A _09018_/Q _07180_/Y _07181_/Y VPWR VGND sg13cmos5l_a22oi_1
X_06133_ _06133_/Y _06133_/A _06133_/B VPWR VGND sg13cmos5l_xnor2_1
X_06064_ _06112_/B _09445_/Q _06064_/B VPWR VGND sg13cmos5l_xnor2_1
X_05015_ _05015_/Y _05015_/A _07101_/B VPWR VGND sg13cmos5l_nor2b_1
X_06966_ hold989/A _07332_/B _06974_/B _06965_/Y VPWR VGND sg13cmos5l_a21oi_1
X_08705_ _08706_/A _08701_/A _08701_/B _08709_/A _08709_/B VPWR VGND sg13cmos5l_a22oi_1
X_06897_ _06923_/B _09524_/Q _09525_/Q hold1393/X VPWR VGND sg13cmos5l_o21ai_1
X_05917_ _05917_/Y _09440_/Q _04983_/Y _05916_/Y VPWR VGND sg13cmos5l_a21oi_1
X_05848_ _05848_/Y _05848_/A _06139_/A VPWR VGND sg13cmos5l_nor2_1
X_08636_ _08636_/Y _08600_/A _09192_/Q VPWR VGND sg13cmos5l_nand2b_1
X_08567_ _08567_/Y _09231_/Q _08567_/B VPWR VGND sg13cmos5l_nor2_1
Xfanout22 _07967_/B _07959_/Y VPWR VGND sg13cmos5l_buf_1
X_05779_ _05781_/B _05779_/A _05762_/B VPWR VGND sg13cmos5l_nor2b_1
X_08498_ _08498_/X _09226_/Q _08498_/B VPWR VGND sg13cmos5l_xor2_1
Xfanout33 fanout33/X _07367_/B VPWR VGND sg13cmos5l_buf_1
Xfanout44 _07602_/B _07594_/B VPWR VGND sg13cmos5l_buf_1
X_07518_ _09071_/D _07636_/B _07518_/B VPWR VGND sg13cmos5l_nor2_1
Xfanout55 fanout55/X fanout56/X VPWR VGND sg13cmos5l_buf_1
X_07449_ _07449_/Y _07449_/A _07449_/B VPWR VGND sg13cmos5l_nor2_1
Xfanout66 _07855_/B _07860_/B VPWR VGND sg13cmos5l_buf_1
Xfanout88 _07661_/B _07657_/B VPWR VGND sg13cmos5l_buf_1
Xfanout99 _06232_/B _06227_/Y VPWR VGND sg13cmos5l_buf_1
Xfanout77 _08850_/B _08846_/Y VPWR VGND sg13cmos5l_buf_1
XFILLER_10_457 VPWR VGND sg13cmos5l_fill_1
X_09119_ _09119_/Q _09214_/CLK _09119_/D _09119_/RESET_B VPWR VGND sg13cmos5l_dfrbpq_1
Xhold1180 hold1180/X _09530_/Q VPWR VGND sg13cmos5l_dlygate4sd3_1
Xhold1191 _04852_/A _09288_/Q VPWR VGND sg13cmos5l_dlygate4sd3_1
XFILLER_9_255 VPWR VGND sg13cmos5l_fill_2
Xclkload14 clkload14/Y clkload14/A VPWR VGND sg13cmos5l_inv_4
XFILLER_48_4 VPWR VGND sg13cmos5l_fill_1
X_09501__601 _09501_/RESET_B VPWR VGND sg13cmos5l_tiehi
X_06820_ _06821_/B _06798_/Y _06810_/Y _06823_/A VPWR VGND sg13cmos5l_o21ai_1
X_06751_ _06788_/B _06751_/A _06764_/B VPWR VGND sg13cmos5l_nand2_1
X_09157__316 _09157_/RESET_B VPWR VGND sg13cmos5l_tiehi
X_06682_ _06682_/Y _06989_/A _09493_/Q VPWR VGND sg13cmos5l_nand2_1
X_05702_ _05702_/Y hold930/X hold890/X VPWR VGND sg13cmos5l_nand2_1
X_09470_ _09470_/Q clkload19/A _09470_/D _09470_/RESET_B VPWR VGND sg13cmos5l_dfrbpq_1
X_08421_ _08422_/B _08423_/B hold1361/X VPWR VGND sg13cmos5l_nor2b_1
X_05633_ _09374_/D _05776_/A _05633_/B VPWR VGND sg13cmos5l_nor2_1
X_05564_ _05592_/B _09369_/Q _05564_/B VPWR VGND sg13cmos5l_xor2_1
X_08352_ _08352_/X _09216_/Q _09159_/Q _08366_/B VPWR VGND sg13cmos5l_mux2_1
X_09018__467 _09018_/RESET_B VPWR VGND sg13cmos5l_tiehi
X_07303_ _07303_/Y _07296_/Y _07299_/Y _07302_/Y VPWR VGND sg13cmos5l_o21ai_1
X_08283_ _08283_/Y _08294_/A _08640_/A VPWR VGND sg13cmos5l_nand2_1
X_09092__385 _09092_/RESET_B VPWR VGND sg13cmos5l_tiehi
X_05495_ _05499_/A _05495_/A _05503_/B _05495_/C VPWR VGND sg13cmos5l_nor3_1
X_07234_ _07234_/Y _07232_/Y _07233_/Y _07233_/B VPWR VGND sg13cmos5l_o21ai_1
Xclkload8 clkload8/X clkload8/A VPWR VGND sg13cmos5l_buf_8
X_07165_ _07216_/B _07136_/B _07167_/A _07164_/Y VPWR VGND sg13cmos5l_o21ai_1
X_06116_ _06253_/A _06112_/A _06062_/Y _06415_/A VPWR VGND sg13cmos5l_o21ai_1
X_09164__309 _09164_/RESET_B VPWR VGND sg13cmos5l_tiehi
X_07096_ _07100_/A _07096_/A _07096_/B _07096_/C _07096_/D VPWR VGND sg13cmos5l_nand4_1
X_06047_ _06047_/Y _07721_/A hold898/X VPWR VGND sg13cmos5l_nor2_1
Xfanout212 _07382_/A fanout216/X VPWR VGND sg13cmos5l_buf_1
Xfanout201 _08986_/A fanout217/X VPWR VGND sg13cmos5l_buf_1
X_07998_ _08007_/A _08401_/A _07998_/B VPWR VGND sg13cmos5l_xnor2_1
X_06949_ _06949_/Y _09589_/Q _06957_/B VPWR VGND sg13cmos5l_nor2_1
XFILLER_39_181 VPWR VGND sg13cmos5l_fill_1
X_08619_ _08621_/A _09243_/Q _08626_/B _08698_/A VPWR VGND sg13cmos5l_a21o_1
X_09599_ hold933/A clkload3/A hold935/X _09599_/RESET_B VPWR VGND sg13cmos5l_dfrbpq_1
XFILLER_24_42 VPWR VGND sg13cmos5l_fill_1
XFILLER_7_704 VPWR VGND sg13cmos5l_fill_2
XFILLER_6_0 VPWR VGND sg13cmos5l_fill_2
XFILLER_2_453 VPWR VGND sg13cmos5l_decap_8
XFILLER_19_811 VPWR VGND sg13cmos5l_fill_1
XFILLER_18_376 VPWR VGND sg13cmos5l_fill_2
X_09390__720 _09390_/RESET_B VPWR VGND sg13cmos5l_tiehi
X_05280_ _05289_/B _09362_/Q _05317_/A _09361_/Q VPWR VGND sg13cmos5l_nor3_1
X_08970_ _08970_/Y _04994_/Y _08965_/Y _08969_/Y VPWR VGND sg13cmos5l_o21ai_1
X_07921_ _07921_/Y _07921_/A _07921_/B _07921_/C _07921_/D VPWR VGND sg13cmos5l_nand4_1
XFILLER_39_0 VPWR VGND sg13cmos5l_fill_1
X_07852_ _07852_/Y _07852_/A VPWR VGND sg13cmos5l_inv_1
Xinput1 input1/X rst_n VPWR VGND sg13cmos5l_buf_1
Xheichips26_dna_sequencer_843 uio_oe[0] VPWR VGND sg13cmos5l_tiehi
X_06803_ _06804_/A _06759_/A _06763_/B _06759_/B VPWR VGND sg13cmos5l_o21ai_1
X_07783_ _07784_/B _07777_/S _07780_/Y _07781_/Y VPWR VGND sg13cmos5l_a21o_1
X_04995_ _04995_/Y _04995_/A VPWR VGND sg13cmos5l_inv_1
X_09522_ _09522_/Q clkload23/A _09522_/D _09522_/RESET_B VPWR VGND sg13cmos5l_dfrbpq_1
X_06734_ _09540_/D _07383_/A hold864/X VPWR VGND sg13cmos5l_and2_1
X_09453_ _09453_/Q _09491_/CLK _09453_/D _09453_/RESET_B VPWR VGND sg13cmos5l_dfrbpq_1
X_06665_ _09524_/D _06818_/A _06665_/B VPWR VGND sg13cmos5l_nor2_1
XFILLER_37_696 VPWR VGND sg13cmos5l_fill_1
X_05616_ _05616_/Y _05630_/A _05764_/C VPWR VGND sg13cmos5l_nand2_1
XFILLER_12_519 VPWR VGND sg13cmos5l_fill_1
X_08404_ _08404_/Y hold900/A hold875/A VPWR VGND sg13cmos5l_xnor2_1
X_09384_ hold869/A _09575_/CLK _09384_/D _09384_/RESET_B VPWR VGND sg13cmos5l_dfrbpq_1
X_08335_ _08336_/B _08430_/C _08430_/D VPWR VGND sg13cmos5l_nand2_1
X_06596_ _06596_/Y _06596_/A _06596_/B _06596_/C VPWR VGND sg13cmos5l_nand3_1
X_05547_ _05547_/Y _05586_/A _05907_/A VPWR VGND sg13cmos5l_nand2_1
X_05478_ _05478_/Y _05478_/A _05478_/B _05478_/C _05478_/D VPWR VGND sg13cmos5l_nand4_1
X_08266_ _08266_/Y _08293_/A _08266_/B VPWR VGND sg13cmos5l_nor2_1
X_07217_ _07218_/B _07217_/A _07219_/A VPWR VGND sg13cmos5l_nand2_1
X_08197_ _08198_/C _08197_/A _08197_/B _08197_/C VPWR VGND sg13cmos5l_and3_1
X_07148_ _07167_/A _08784_/A _07146_/Y _07118_/Y VPWR VGND sg13cmos5l_o21ai_1
XFILLER_0_913 VPWR VGND sg13cmos5l_decap_8
X_07079_ _07079_/Y _07095_/B _07079_/B VPWR VGND sg13cmos5l_nand2b_1
XFILLER_0_968 VPWR VGND sg13cmos5l_decap_8
XFILLER_28_641 VPWR VGND sg13cmos5l_fill_1
XFILLER_15_302 VPWR VGND sg13cmos5l_fill_2
XFILLER_43_622 VPWR VGND sg13cmos5l_fill_1
X_09147__326 _09147_/RESET_B VPWR VGND sg13cmos5l_tiehi
X_09008__477 _09008_/RESET_B VPWR VGND sg13cmos5l_tiehi
XFILLER_46_482 VPWR VGND sg13cmos5l_fill_1
XFILLER_34_611 VPWR VGND sg13cmos5l_fill_2
X_09154__319 _09154_/RESET_B VPWR VGND sg13cmos5l_tiehi
X_06450_ _06450_/Y _06450_/A _06450_/B VPWR VGND sg13cmos5l_nor2_1
XFILLER_33_132 VPWR VGND sg13cmos5l_fill_1
XFILLER_34_655 VPWR VGND sg13cmos5l_fill_2
XFILLER_34_666 VPWR VGND sg13cmos5l_fill_2
X_05401_ _05401_/Y _05401_/A _05401_/B VPWR VGND sg13cmos5l_nor2_1
X_06381_ _06381_/Y _06091_/A _09449_/Q VPWR VGND sg13cmos5l_nand2b_1
X_05332_ _05332_/Y _05328_/S _05331_/Y _05330_/X VPWR VGND sg13cmos5l_a21oi_1
X_08120_ _08121_/C _08120_/A _08130_/B VPWR VGND sg13cmos5l_nor2_1
XFILLER_30_861 VPWR VGND sg13cmos5l_fill_1
X_08051_ _08075_/B _09115_/Q _08051_/B VPWR VGND sg13cmos5l_xor2_1
X_05263_ _05263_/Y hold991/A _05693_/A VPWR VGND sg13cmos5l_nand2b_1
X_07002_ _07045_/C _09577_/Q hold887/A _09582_/Q VPWR VGND sg13cmos5l_nand3_1
X_05194_ _05196_/D _05194_/A _05194_/B _05194_/C VPWR VGND sg13cmos5l_nand3_1
X_08953_ _08954_/B _08953_/A _08953_/B VPWR VGND sg13cmos5l_nor2_1
X_07904_ _07939_/B _09134_/Q _07913_/B VPWR VGND sg13cmos5l_nand2_1
X_08884_ _08885_/B _08884_/A _08884_/B VPWR VGND sg13cmos5l_nor2_1
XFILLER_5_1028 VPWR VGND sg13cmos5l_fill_1
X_07835_ _07864_/B _09145_/Q _09088_/Q VPWR VGND sg13cmos5l_nor2_1
X_04978_ _06228_/A _06285_/C VPWR VGND sg13cmos5l_inv_1
X_07766_ _07921_/A _07781_/B _07781_/C _07765_/Y VPWR VGND sg13cmos5l_o21ai_1
X_06717_ _06717_/Y _06694_/Y _06716_/B _06742_/B VPWR VGND sg13cmos5l_a21oi_1
X_09505_ _09505_/Q clkload22/A _09505_/D _09505_/RESET_B VPWR VGND sg13cmos5l_dfrbpq_1
X_09436_ _09436_/Q clkload20/A _09436_/D _09436_/RESET_B VPWR VGND sg13cmos5l_dfrbpq_1
X_07697_ _07698_/C _07697_/A _07697_/B _07697_/C VPWR VGND sg13cmos5l_and3_1
X_06648_ _06651_/B _09490_/Q _06648_/B VPWR VGND sg13cmos5l_xnor2_1
X_09367_ _09367_/Q clkload11/A _09367_/D _09367_/RESET_B VPWR VGND sg13cmos5l_dfrbpq_1
XFILLER_40_647 VPWR VGND sg13cmos5l_fill_2
X_06579_ _06588_/B _09552_/Q _09553_/Q _09551_/Q _09550_/Q VPWR VGND sg13cmos5l_nor4_1
X_09298_ _09298_/Q clkload10/A _09298_/D _09298_/RESET_B VPWR VGND sg13cmos5l_dfrbpq_1
X_08318_ _08318_/X _08329_/C _08318_/B VPWR VGND sg13cmos5l_and2_1
X_08249_ _08256_/C _09184_/Q _09185_/Q _09186_/Q VPWR VGND sg13cmos5l_o21ai_1
XFILLER_43_463 VPWR VGND sg13cmos5l_fill_2
X_09313__827 _09313_/RESET_B VPWR VGND sg13cmos5l_tiehi
XFILLER_30_124 VPWR VGND sg13cmos5l_fill_1
XFILLER_11_360 VPWR VGND sg13cmos5l_fill_1
Xhold1009 _08809_/A _09287_/Q VPWR VGND sg13cmos5l_dlygate4sd3_1
X_05950_ _05951_/C _05950_/A _05949_/B VPWR VGND sg13cmos5l_nor2b_1
X_05881_ _05881_/Y _05547_/Y _05878_/X _05880_/Y VPWR VGND sg13cmos5l_o21ai_1
X_04901_ _07894_/A _07602_/A VPWR VGND sg13cmos5l_inv_1
XFILLER_16_2 VPWR VGND sg13cmos5l_fill_1
X_07620_ _07622_/A _07620_/A _07620_/B VPWR VGND sg13cmos5l_nor2_1
X_04832_ _04832_/Y hold893/X VPWR VGND sg13cmos5l_inv_1
X_07551_ _07551_/Y _07276_/B _07571_/B _07550_/Y _07250_/Y VPWR VGND sg13cmos5l_a22oi_1
X_09021__463 _09021_/RESET_B VPWR VGND sg13cmos5l_tiehi
X_06502_ _06502_/Y _06352_/B _06405_/B _06503_/B _06503_/A VPWR VGND sg13cmos5l_a22oi_1
XFILLER_35_953 VPWR VGND sg13cmos5l_fill_2
X_07482_ _07799_/A _09103_/Q _09104_/Q VPWR VGND sg13cmos5l_xnor2_1
X_09221_ _09221_/Q _09595_/CLK _09221_/D _09221_/RESET_B VPWR VGND sg13cmos5l_dfrbpq_1
X_06433_ _06434_/A _04975_/Y _06437_/B _06432_/Y VPWR VGND sg13cmos5l_a21oi_1
X_06364_ _09482_/D _06552_/A _06364_/B VPWR VGND sg13cmos5l_nor2_1
X_09152_ _09152_/Q clkload4/A _09152_/D _09152_/RESET_B VPWR VGND sg13cmos5l_dfrbpq_1
X_05315_ _09327_/D _05378_/A _05315_/B VPWR VGND sg13cmos5l_nor2_1
X_08103_ _08103_/Y _09180_/Q _08111_/B VPWR VGND sg13cmos5l_nor2_1
X_06295_ _09473_/D _06242_/Y _06302_/S _06294_/Y VPWR VGND sg13cmos5l_a21oi_1
X_09083_ hold978/A _09388_/CLK hold979/X _09083_/RESET_B VPWR VGND sg13cmos5l_dfrbpq_1
X_08034_ _08034_/Y _08009_/Y _08013_/Y _08033_/Y VPWR VGND sg13cmos5l_o21ai_1
X_05246_ _05260_/B _05241_/Y _05245_/Y _05244_/A VPWR VGND sg13cmos5l_a21oi_1
X_05177_ _05177_/Y _08996_/A _08751_/A VPWR VGND sg13cmos5l_nor2_1
Xhold854 hold854/X hold854/A VPWR VGND sg13cmos5l_dlygate4sd3_1
Xhold865 hold865/X hold865/A VPWR VGND sg13cmos5l_dlygate4sd3_1
Xhold876 hold876/X hold876/A VPWR VGND sg13cmos5l_dlygate4sd3_1
Xhold887 hold887/X hold887/A VPWR VGND sg13cmos5l_dlygate4sd3_1
Xhold898 hold898/X hold898/A VPWR VGND sg13cmos5l_dlygate4sd3_1
X_08936_ _09294_/D _05385_/A hold1247/X _08939_/B VPWR VGND sg13cmos5l_a21oi_1
X_08867_ _08867_/Y _08893_/A _08756_/X _08866_/Y VPWR VGND sg13cmos5l_o21ai_1
X_07818_ _07921_/C _07818_/A _07818_/B _07829_/C VPWR VGND sg13cmos5l_nand3_1
X_08798_ _08799_/B _08798_/A VPWR VGND sg13cmos5l_inv_1
X_07749_ _07753_/B _09144_/Q _07750_/B VPWR VGND sg13cmos5l_xnor2_1
XFILLER_41_923 VPWR VGND sg13cmos5l_decap_8
X_09137__336 _09137_/RESET_B VPWR VGND sg13cmos5l_tiehi
XFILLER_40_444 VPWR VGND sg13cmos5l_fill_2
X_09419_ _09419_/Q _09503_/CLK _09419_/D _09419_/RESET_B VPWR VGND sg13cmos5l_dfrbpq_1
XFILLER_12_168 VPWR VGND sg13cmos5l_fill_1
XFILLER_10_1000 VPWR VGND sg13cmos5l_fill_2
X_09144__329 _09144_/RESET_B VPWR VGND sg13cmos5l_tiehi
XFILLER_32_901 VPWR VGND sg13cmos5l_fill_1
XFILLER_31_499 VPWR VGND sg13cmos5l_fill_1
X_06080_ _06080_/Y _06391_/A _06106_/B _06387_/A _06073_/X VPWR VGND sg13cmos5l_a22oi_1
X_05100_ _05126_/B _09292_/Q _05100_/B VPWR VGND sg13cmos5l_xnor2_1
X_05031_ _05032_/B _05028_/B _07078_/A hold938/X VPWR VGND sg13cmos5l_a21oi_1
X_06982_ hold914/A _04833_/Y fanout60/X _06981_/Y VPWR VGND sg13cmos5l_a21oi_1
XFILLER_39_533 VPWR VGND sg13cmos5l_fill_1
X_08721_ _09249_/D _08701_/B _08710_/Y _08720_/Y VPWR VGND sg13cmos5l_a21oi_1
X_05933_ _05933_/Y _09439_/Q _05933_/B VPWR VGND sg13cmos5l_nor2_1
X_08652_ _08663_/C _08645_/Y _08648_/Y _08650_/Y VPWR VGND sg13cmos5l_a21o_1
X_05864_ _05864_/Y _05864_/A _05864_/B VPWR VGND sg13cmos5l_nor2_1
XFILLER_39_588 VPWR VGND sg13cmos5l_decap_8
X_07603_ _07620_/A _07360_/A _07602_/B _07602_/Y VPWR VGND sg13cmos5l_a21oi_1
X_05795_ _05843_/C _09404_/Q _09403_/Q _09405_/Q VPWR VGND sg13cmos5l_o21ai_1
X_08583_ _08583_/Y hold1104/X fanout36/X _08599_/B VPWR VGND sg13cmos5l_o21ai_1
X_04815_ _04815_/Y hold909/X VPWR VGND sg13cmos5l_inv_1
X_07534_ _09075_/D _07634_/B _07703_/A VPWR VGND sg13cmos5l_and2_1
X_07465_ _09068_/D _07449_/B _07455_/Y _07464_/Y VPWR VGND sg13cmos5l_a21oi_1
X_06416_ _09491_/D _06415_/A hold1132/X _06552_/A VPWR VGND sg13cmos5l_a21oi_1
X_09204_ hold953/A _09312_/CLK hold954/X _09204_/RESET_B VPWR VGND sg13cmos5l_dfrbpq_1
X_07396_ _07445_/B _09061_/Q _07408_/B VPWR VGND sg13cmos5l_nand2_1
X_06347_ _09479_/D _06552_/A _06347_/B VPWR VGND sg13cmos5l_nor2_1
X_09284__509 _09284_/RESET_B VPWR VGND sg13cmos5l_tiehi
X_09135_ _09135_/Q clkload16/A _09135_/D _09135_/RESET_B VPWR VGND sg13cmos5l_dfrbpq_1
X_06278_ _06279_/C _06278_/A _06278_/B _06278_/C VPWR VGND sg13cmos5l_and3_1
X_09066_ _09066_/Q _09573_/CLK _09066_/D _09066_/RESET_B VPWR VGND sg13cmos5l_dfrbpq_1
X_08017_ _08017_/Y hold877/X _08393_/A VPWR VGND sg13cmos5l_nand2b_1
X_05229_ _05229_/X _05222_/Y _05224_/X _05228_/Y VPWR VGND sg13cmos5l_a21o_1
XFILLER_49_308 VPWR VGND sg13cmos5l_fill_1
X_08919_ _09283_/D _08860_/Y _08924_/S _08918_/Y VPWR VGND sg13cmos5l_a21oi_1
Xhold1351 _05156_/A _09262_/Q VPWR VGND sg13cmos5l_dlygate4sd3_1
Xhold1340 _08848_/A _09280_/Q VPWR VGND sg13cmos5l_dlygate4sd3_1
Xhold1373 hold1373/X _09365_/Q VPWR VGND sg13cmos5l_dlygate4sd3_1
XFILLER_45_525 VPWR VGND sg13cmos5l_decap_4
Xhold1395 hold1395/X _09289_/Q VPWR VGND sg13cmos5l_dlygate4sd3_1
Xhold1362 _08238_/B _09221_/Q VPWR VGND sg13cmos5l_dlygate4sd3_1
Xhold1384 _08523_/B _08522_/A VPWR VGND sg13cmos5l_dlygate4sd3_1
XFILLER_9_415 VPWR VGND sg13cmos5l_fill_2
XFILLER_49_864 VPWR VGND sg13cmos5l_fill_1
X_05580_ _09366_/D _05637_/A _05580_/B VPWR VGND sg13cmos5l_nor2_1
XFILLER_17_772 VPWR VGND sg13cmos5l_fill_2
XFILLER_17_1028 VPWR VGND sg13cmos5l_fill_1
X_07250_ _07250_/Y _09068_/Q _07251_/B VPWR VGND sg13cmos5l_xnor2_1
XFILLER_9_960 VPWR VGND sg13cmos5l_decap_8
X_06201_ _06201_/Y _06182_/Y fanout43/X _06047_/Y VPWR VGND sg13cmos5l_o21ai_1
X_07181_ _07181_/Y _09031_/Q _05003_/Y _05004_/Y _09030_/Q VPWR VGND sg13cmos5l_a22oi_1
X_06132_ _06161_/A _06132_/A _06133_/B VPWR VGND sg13cmos5l_xnor2_1
XFILLER_9_993 VPWR VGND sg13cmos5l_fill_2
X_06063_ _06063_/Y _06062_/Y _06063_/B VPWR VGND sg13cmos5l_nand2b_1
X_05014_ _09608_/D _05014_/A VPWR VGND sg13cmos5l_inv_1
X_06965_ _06965_/Y _06946_/X _06974_/B _06988_/B VPWR VGND sg13cmos5l_o21ai_1
X_08704_ _08709_/B _08704_/A _08710_/A VPWR VGND sg13cmos5l_nor2b_1
X_09203__267 _09203_/RESET_B VPWR VGND sg13cmos5l_tiehi
X_06896_ _06896_/Y _06896_/A _06896_/B VPWR VGND sg13cmos5l_nor2_1
X_05916_ _05916_/Y _06223_/A _09383_/Q _09382_/Q _06222_/A _05915_/Y VPWR VGND sg13cmos5l_a221oi_1
X_05847_ _05997_/A _05847_/A _05847_/B _05847_/C VPWR VGND sg13cmos5l_nand3_1
X_08635_ _08635_/Y _09191_/Q _09192_/Q VPWR VGND sg13cmos5l_xnor2_1
XFILLER_15_709 VPWR VGND sg13cmos5l_fill_2
X_08566_ _08566_/Y _08566_/A _08566_/B VPWR VGND sg13cmos5l_nand2_1
X_07517_ _07518_/B _07665_/A _07665_/B VPWR VGND sg13cmos5l_and2_1
XFILLER_35_591 VPWR VGND sg13cmos5l_fill_2
X_05778_ _05778_/Y _05739_/A _05769_/Y _05777_/Y VPWR VGND sg13cmos5l_a21oi_1
Xfanout45 _07355_/B _07347_/B VPWR VGND sg13cmos5l_buf_1
Xfanout23 _07715_/S _07708_/Y VPWR VGND sg13cmos5l_buf_1
X_08497_ _08539_/A _08497_/A _08498_/B VPWR VGND sg13cmos5l_xnor2_1
X_09134__339 _09134_/RESET_B VPWR VGND sg13cmos5l_tiehi
X_09585__501 _09585_/RESET_B VPWR VGND sg13cmos5l_tiehi
Xfanout56 fanout56/X fanout62/X VPWR VGND sg13cmos5l_buf_1
Xfanout34 _05421_/B _05418_/Y VPWR VGND sg13cmos5l_buf_1
X_07448_ _07449_/B _07328_/Y _07447_/B _07447_/Y VPWR VGND sg13cmos5l_a21oi_1
Xfanout89 _07408_/B _07394_/Y VPWR VGND sg13cmos5l_buf_1
Xfanout67 _06705_/B _06689_/Y VPWR VGND sg13cmos5l_buf_1
Xfanout78 _08863_/B _08846_/Y VPWR VGND sg13cmos5l_buf_1
X_07379_ _09053_/D _04828_/Y fanout52/X _07378_/Y VPWR VGND sg13cmos5l_a21oi_1
X_09118_ _09118_/Q clkload6/A _09118_/D _09118_/RESET_B VPWR VGND sg13cmos5l_dfrbpq_1
X_09288__486 _09288_/RESET_B VPWR VGND sg13cmos5l_tiehi
X_09049_ _09049_/Q clkload15/A _09049_/D _09049_/RESET_B VPWR VGND sg13cmos5l_dfrbpq_1
X_09266__795 _09266_/RESET_B VPWR VGND sg13cmos5l_tiehi
Xhold1170 hold1170/X _09014_/Q VPWR VGND sg13cmos5l_dlygate4sd3_1
Xhold1192 _04896_/A _09144_/Q VPWR VGND sg13cmos5l_dlygate4sd3_1
Xhold1181 _04866_/A _09477_/Q VPWR VGND sg13cmos5l_dlygate4sd3_1
XFILLER_9_201 VPWR VGND sg13cmos5l_fill_2
Xclkload15 clkload15/X clkload15/A VPWR VGND sg13cmos5l_buf_8
XFILLER_5_473 VPWR VGND sg13cmos5l_fill_2
X_09278__600 _09278_/RESET_B VPWR VGND sg13cmos5l_tiehi
X_06750_ _06781_/B _06760_/A _06764_/B VPWR VGND sg13cmos5l_and2_1
X_05701_ _09396_/D _05701_/A _05784_/A VPWR VGND sg13cmos5l_nor2_1
X_06681_ _09529_/D _06818_/A _06776_/B VPWR VGND sg13cmos5l_nor2_1
X_05632_ _05632_/X _05632_/A _05632_/B VPWR VGND sg13cmos5l_and2_1
X_08420_ _08444_/A _08438_/B _08455_/B _08420_/C VPWR VGND sg13cmos5l_nor3_1
XFILLER_36_377 VPWR VGND sg13cmos5l_fill_2
X_09569__529 _09569_/RESET_B VPWR VGND sg13cmos5l_tiehi
X_05563_ _05876_/A hold997/A _05563_/B VPWR VGND sg13cmos5l_xnor2_1
X_08351_ _08366_/B _09221_/Q _04939_/Y _08350_/Y VPWR VGND sg13cmos5l_a21oi_1
X_07302_ _07302_/Y _06880_/A _07324_/B _07301_/Y _06856_/B VPWR VGND sg13cmos5l_a22oi_1
X_08282_ _09185_/D _08400_/B _08282_/B VPWR VGND sg13cmos5l_nor2_1
X_05494_ _05495_/C _05494_/A _05494_/B _05494_/C VPWR VGND sg13cmos5l_and3_1
Xclkload9 clkload9/Y clkload9/A VPWR VGND sg13cmos5l_inv_1
X_07233_ _07233_/Y _07577_/A _07233_/B VPWR VGND sg13cmos5l_nand2_1
X_07164_ _07164_/Y _08882_/A _07164_/B VPWR VGND sg13cmos5l_nand2b_1
X_06115_ _09445_/D _06164_/A _06281_/A VPWR VGND sg13cmos5l_nor2_1
X_07095_ _07096_/D _10244_/A _07095_/B VPWR VGND sg13cmos5l_nand2b_1
X_06046_ _09440_/D _06033_/A _06045_/Y _06042_/A VPWR VGND sg13cmos5l_a21oi_1
Xfanout202 _08394_/A fanout206/X VPWR VGND sg13cmos5l_buf_1
Xfanout213 _07384_/A fanout216/X VPWR VGND sg13cmos5l_buf_1
X_07997_ _08342_/A _07998_/B _07997_/B VPWR VGND sg13cmos5l_nand2b_1
X_06948_ _06953_/A _04962_/Y _06945_/X _06947_/Y VPWR VGND sg13cmos5l_a21oi_1
XFILLER_27_300 VPWR VGND sg13cmos5l_fill_2
XFILLER_28_867 VPWR VGND sg13cmos5l_fill_2
X_06879_ _09557_/D _06932_/A _06879_/B VPWR VGND sg13cmos5l_nor2_1
X_08618_ _08698_/A _08697_/B _08697_/C _08697_/A VPWR VGND sg13cmos5l_a21oi_1
XFILLER_27_366 VPWR VGND sg13cmos5l_fill_1
X_09598_ _09598_/Q clkload3/A _09598_/D _09598_/RESET_B VPWR VGND sg13cmos5l_dfrbpq_1
XFILLER_27_399 VPWR VGND sg13cmos5l_fill_1
XFILLER_42_369 VPWR VGND sg13cmos5l_fill_2
X_08549_ _08549_/Y _04883_/Y _09199_/Q _08547_/Y _08548_/Y VPWR VGND sg13cmos5l_a22oi_1
XFILLER_10_266 VPWR VGND sg13cmos5l_fill_2
XFILLER_46_675 VPWR VGND sg13cmos5l_fill_2
X_09163__310 _09163_/RESET_B VPWR VGND sg13cmos5l_tiehi
XFILLER_46_2 VPWR VGND sg13cmos5l_fill_1
X_07920_ _07920_/X _07920_/A _07920_/B _07920_/C _07920_/D VPWR VGND sg13cmos5l_or4_1
X_07851_ _07852_/A _04950_/Y _07855_/B _07850_/Y VPWR VGND sg13cmos5l_a21oi_1
X_07782_ _07782_/Y _07777_/S _07780_/Y _07781_/Y VPWR VGND sg13cmos5l_a21oi_1
Xheichips26_dna_sequencer_844 uio_oe[1] VPWR VGND sg13cmos5l_tiehi
X_06802_ _06809_/A _06802_/A _06776_/B VPWR VGND sg13cmos5l_nor2b_1
Xinput2 input2/X ui_in[0] VPWR VGND sg13cmos5l_buf_1
X_06733_ _09539_/D _04832_/Y fanout50/X _06732_/Y VPWR VGND sg13cmos5l_a21oi_1
X_09521_ _09521_/Q clkload23/A _09521_/D _09521_/RESET_B VPWR VGND sg13cmos5l_dfrbpq_1
X_04994_ _04994_/Y _05408_/A VPWR VGND sg13cmos5l_inv_1
XFILLER_37_620 VPWR VGND sg13cmos5l_fill_2
X_09452_ _09452_/Q _09491_/CLK _09452_/D _09452_/RESET_B VPWR VGND sg13cmos5l_dfrbpq_1
X_06664_ _06665_/B _06767_/C _06767_/D VPWR VGND sg13cmos5l_nand2_1
X_05615_ _05764_/C _09338_/Q _05612_/B hold1203/X VPWR VGND sg13cmos5l_o21ai_1
X_08403_ _08403_/Y hold953/A hold879/A VPWR VGND sg13cmos5l_xnor2_1
X_06595_ _06629_/B _09523_/Q _06596_/B VPWR VGND sg13cmos5l_xnor2_1
X_09383_ _09383_/Q clkload19/A _09383_/D _09383_/RESET_B VPWR VGND sg13cmos5l_dfrbpq_1
X_05546_ _05568_/A _05586_/A _05907_/A VPWR VGND sg13cmos5l_and2_1
X_08334_ _08430_/D _08334_/A _08334_/B _08334_/C VPWR VGND sg13cmos5l_nand3_1
X_09582__504 _09582_/RESET_B VPWR VGND sg13cmos5l_tiehi
X_05477_ _05477_/Y _05325_/Y _05378_/B _05474_/Y _05475_/Y _05476_/Y VPWR VGND sg13cmos5l_a221oi_1
X_08265_ _08265_/Y _08255_/Y _08260_/Y _08264_/Y VPWR VGND sg13cmos5l_o21ai_1
X_08196_ _08196_/X _08219_/A _08196_/B VPWR VGND sg13cmos5l_or2_1
X_07216_ _07219_/A _07216_/A _07216_/B _07216_/C _07216_/D VPWR VGND sg13cmos5l_nor4_1
X_07147_ _07164_/B _07118_/Y _08784_/A _07146_/Y VPWR VGND sg13cmos5l_o21ai_1
X_07078_ _07079_/B _07078_/A _07078_/B VPWR VGND sg13cmos5l_nor2_1
X_09263__798 _09263_/RESET_B VPWR VGND sg13cmos5l_tiehi
X_06029_ _06030_/B _05985_/A _05985_/B _05989_/B VPWR VGND sg13cmos5l_a21oi_1
XFILLER_19_43 VPWR VGND sg13cmos5l_fill_1
XFILLER_27_185 VPWR VGND sg13cmos5l_fill_2
XFILLER_11_531 VPWR VGND sg13cmos5l_fill_2
XFILLER_7_524 VPWR VGND sg13cmos5l_fill_2
XFILLER_7_513 VPWR VGND sg13cmos5l_decap_8
X_09559__539 _09559_/RESET_B VPWR VGND sg13cmos5l_tiehi
XFILLER_22_818 VPWR VGND sg13cmos5l_fill_2
X_05400_ _05400_/Y _05421_/A VPWR VGND sg13cmos5l_inv_1
X_06380_ _06380_/X _06387_/B _06387_/C _06387_/A VPWR VGND sg13cmos5l_a21o_1
X_05331_ _05331_/Y _05617_/A _05331_/B VPWR VGND sg13cmos5l_nand2_1
X_08050_ _08052_/B _09140_/Q _09115_/Q VPWR VGND sg13cmos5l_or2_1
X_05262_ _05262_/Y _07721_/A hold991/X VPWR VGND sg13cmos5l_nor2_1
X_07001_ _07045_/B _09581_/Q _07011_/B VPWR VGND sg13cmos5l_nand2_1
X_05193_ _05196_/C _05176_/B _05194_/C _05192_/Y VPWR VGND sg13cmos5l_a21o_1
X_08952_ _08952_/Y _08800_/A _08964_/B _08951_/Y VPWR VGND sg13cmos5l_a21oi_1
X_08883_ _08884_/B _08889_/B _08889_/C _08773_/B VPWR VGND sg13cmos5l_a21oi_1
X_07903_ _07932_/B _07913_/A _07913_/B VPWR VGND sg13cmos5l_and2_1
X_07834_ _09120_/D _07892_/B _07928_/B VPWR VGND sg13cmos5l_nor2_1
X_07765_ _07765_/Y _09141_/Q _08065_/A VPWR VGND sg13cmos5l_nor2_1
X_04977_ _06417_/B hold985/X VPWR VGND sg13cmos5l_inv_1
X_07696_ _07696_/Y _07680_/A _07680_/B _07690_/X _07694_/Y _07695_/Y VPWR VGND sg13cmos5l_a221oi_1
X_06716_ _06718_/A _06716_/A _06716_/B VPWR VGND sg13cmos5l_nor2_1
X_09504_ hold854/A clkload24/A _09504_/D _09504_/RESET_B VPWR VGND sg13cmos5l_dfrbpq_1
X_06647_ _06647_/Y _06361_/B _06674_/B _06646_/Y VPWR VGND sg13cmos5l_o21ai_1
X_09435_ _09435_/Q clkload20/A _09435_/D _09435_/RESET_B VPWR VGND sg13cmos5l_dfrbpq_1
X_09366_ _09366_/Q clkload11/A _09366_/D _09366_/RESET_B VPWR VGND sg13cmos5l_dfrbpq_1
X_06578_ _06578_/Y _06629_/A VPWR VGND sg13cmos5l_inv_1
X_09297_ _09297_/Q clkload10/A _09297_/D _09297_/RESET_B VPWR VGND sg13cmos5l_dfrbpq_1
X_08317_ _08318_/B _09157_/Q _08313_/B hold1287/X VPWR VGND sg13cmos5l_o21ai_1
X_05529_ _09364_/D _05514_/A _05528_/Y _05448_/B VPWR VGND sg13cmos5l_a21oi_1
X_08248_ _08640_/A _09218_/Q _08278_/A VPWR VGND sg13cmos5l_xnor2_1
X_08179_ _08179_/Y _08035_/Y _08186_/A _08178_/Y VPWR VGND sg13cmos5l_o21ai_1
XFILLER_46_30 VPWR VGND sg13cmos5l_fill_2
XFILLER_46_96 VPWR VGND sg13cmos5l_fill_2
XFILLER_44_954 VPWR VGND sg13cmos5l_fill_1
XFILLER_43_453 VPWR VGND sg13cmos5l_fill_2
X_09153__320 _09153_/RESET_B VPWR VGND sg13cmos5l_tiehi
XFILLER_31_604 VPWR VGND sg13cmos5l_fill_1
XFILLER_12_862 VPWR VGND sg13cmos5l_fill_1
XFILLER_30_169 VPWR VGND sg13cmos5l_fill_2
XFILLER_8_833 VPWR VGND sg13cmos5l_fill_2
X_09014__471 _09014_/RESET_B VPWR VGND sg13cmos5l_tiehi
XFILLER_3_560 VPWR VGND sg13cmos5l_fill_2
X_09160__313 _09160_/RESET_B VPWR VGND sg13cmos5l_tiehi
X_04900_ _08144_/A _07847_/A VPWR VGND sg13cmos5l_inv_1
XFILLER_39_748 VPWR VGND sg13cmos5l_fill_2
X_05880_ _05880_/Y _05887_/A _05903_/A VPWR VGND sg13cmos5l_nand2_1
X_04831_ _04831_/Y _04831_/A VPWR VGND sg13cmos5l_inv_1
X_07550_ _07550_/Y _07550_/A _07550_/B VPWR VGND sg13cmos5l_xnor2_1
X_06501_ _06501_/X _06347_/B _06400_/Y _06500_/Y VPWR VGND sg13cmos5l_a21o_1
XFILLER_35_965 VPWR VGND sg13cmos5l_fill_2
X_07481_ _07481_/Y _07478_/Y _07519_/A _07472_/Y VPWR VGND sg13cmos5l_a21oi_1
X_09220_ _09220_/Q _09595_/CLK _09220_/D _09220_/RESET_B VPWR VGND sg13cmos5l_dfrbpq_1
XFILLER_22_637 VPWR VGND sg13cmos5l_fill_2
X_06432_ _06432_/Y _09513_/Q _06437_/B VPWR VGND sg13cmos5l_nor2_1
X_06363_ _06364_/B _06362_/Y _06361_/X _06367_/S VPWR VGND sg13cmos5l_mux2_1
X_09151_ _09151_/Q clkload6/A _09151_/D _09151_/RESET_B VPWR VGND sg13cmos5l_dfrbpq_1
X_05314_ _05314_/Y _05315_/B VPWR VGND sg13cmos5l_inv_1
X_09082_ _09082_/Q clkload14/A _09082_/D _09082_/RESET_B VPWR VGND sg13cmos5l_dfrbpq_1
X_08102_ _08107_/A _09160_/Q _08100_/Y _08101_/Y VPWR VGND sg13cmos5l_o21ai_1
X_06294_ _06294_/Y _06268_/Y _06302_/S _06218_/B VPWR VGND sg13cmos5l_o21ai_1
X_08033_ _08033_/Y _08033_/A _08038_/B VPWR VGND sg13cmos5l_nor2_1
X_05245_ _05245_/Y _05240_/A _05240_/B _05242_/Y _05260_/A VPWR VGND sg13cmos5l_a22oi_1
X_05176_ _08937_/A _05176_/A _05176_/B _05194_/C VPWR VGND sg13cmos5l_nand3_1
Xhold855 hold855/X hold855/A VPWR VGND sg13cmos5l_dlygate4sd3_1
Xhold877 hold877/X hold877/A VPWR VGND sg13cmos5l_dlygate4sd3_1
Xhold888 hold888/X hold888/A VPWR VGND sg13cmos5l_dlygate4sd3_1
Xhold866 hold866/X hold866/A VPWR VGND sg13cmos5l_dlygate4sd3_1
Xhold899 hold899/X hold899/A VPWR VGND sg13cmos5l_dlygate4sd3_1
X_08935_ _09293_/D _08935_/A _08939_/B VPWR VGND sg13cmos5l_nor2_1
X_08866_ _08866_/Y _08868_/B _08868_/C _08868_/A VPWR VGND sg13cmos5l_o21ai_1
X_07817_ _09115_/D _07875_/A _07817_/B VPWR VGND sg13cmos5l_nor2_1
X_08797_ _08798_/A _08997_/A hold1170/X _08809_/B VPWR VGND sg13cmos5l_mux2_1
X_07748_ _07781_/A _09112_/Q _07748_/B VPWR VGND sg13cmos5l_xor2_1
XFILLER_26_921 VPWR VGND sg13cmos5l_fill_2
X_07679_ _07679_/Y _07680_/B VPWR VGND sg13cmos5l_inv_1
XFILLER_26_998 VPWR VGND sg13cmos5l_fill_2
X_09418_ _09418_/Q clkload24/A _09418_/D _09418_/RESET_B VPWR VGND sg13cmos5l_dfrbpq_1
X_09549__549 _09549_/RESET_B VPWR VGND sg13cmos5l_tiehi
X_09349_ hold982/A _09387_/CLK hold942/X _09349_/RESET_B VPWR VGND sg13cmos5l_dfrbpq_1
XFILLER_5_803 VPWR VGND sg13cmos5l_fill_1
XFILLER_0_541 VPWR VGND sg13cmos5l_decap_8
XFILLER_43_272 VPWR VGND sg13cmos5l_fill_1
XFILLER_7_184 VPWR VGND sg13cmos5l_fill_1
X_05030_ _09607_/D _09605_/D _09602_/D VPWR VGND sg13cmos5l_or2_1
X_09088__391 _09088_/RESET_B VPWR VGND sg13cmos5l_tiehi
XFILLER_4_891 VPWR VGND sg13cmos5l_fill_1
X_06981_ _06981_/Y _09576_/Q fanout60/X _07382_/A VPWR VGND sg13cmos5l_o21ai_1
X_08720_ _08720_/Y _08701_/A _08710_/Y _08723_/A VPWR VGND sg13cmos5l_o21ai_1
X_05932_ _05932_/Y _09419_/Q _05932_/B VPWR VGND sg13cmos5l_nand2_1
X_05863_ _05864_/B _09375_/Q _05896_/A VPWR VGND sg13cmos5l_xnor2_1
X_08651_ _08651_/Y _08645_/Y _08648_/Y _08650_/Y VPWR VGND sg13cmos5l_a21oi_1
X_07602_ _07602_/Y _07602_/A _07602_/B VPWR VGND sg13cmos5l_nor2_1
X_04814_ _04814_/Y hold994/X VPWR VGND sg13cmos5l_inv_1
X_05794_ _06129_/A _09437_/Q _09436_/Q VPWR VGND sg13cmos5l_xnor2_1
X_08582_ _08582_/Y _08582_/A _08582_/B VPWR VGND sg13cmos5l_nor2_1
X_07533_ _07703_/A _07478_/Y _07506_/X _07833_/A VPWR VGND sg13cmos5l_o21ai_1
XFILLER_23_913 VPWR VGND sg13cmos5l_fill_1
X_07464_ _07464_/Y _07449_/A _07462_/S _07464_/B1 VPWR VGND sg13cmos5l_o21ai_1
X_06415_ _06540_/B _06415_/A _06415_/B VPWR VGND sg13cmos5l_nand2_1
X_09203_ _09203_/Q _09312_/CLK _09203_/D _09203_/RESET_B VPWR VGND sg13cmos5l_dfrbpq_1
X_07395_ _07445_/A _09062_/Q _07408_/B VPWR VGND sg13cmos5l_xnor2_1
X_09134_ _09134_/Q clkload16/A _09134_/D _09134_/RESET_B VPWR VGND sg13cmos5l_dfrbpq_1
X_06346_ _06347_/B _06344_/X _06345_/Y _06367_/S VPWR VGND sg13cmos5l_mux2_1
X_06277_ _06277_/Y _06259_/A _06259_/B _06270_/X _06275_/Y _06276_/Y VPWR VGND sg13cmos5l_a221oi_1
X_09065_ _09065_/Q _09573_/CLK _09065_/D _09065_/RESET_B VPWR VGND sg13cmos5l_dfrbpq_1
X_08016_ _08016_/X _08174_/A _08174_/B VPWR VGND sg13cmos5l_and2_1
X_05228_ _05228_/Y _05222_/A _05078_/X _08931_/A _05238_/B _05226_/Y VPWR VGND sg13cmos5l_a221oi_1
X_05159_ _05159_/Y _08742_/A _05159_/B VPWR VGND sg13cmos5l_nand2_1
X_09143__330 _09143_/RESET_B VPWR VGND sg13cmos5l_tiehi
X_08918_ _08918_/Y _08895_/X _08924_/S _08842_/B VPWR VGND sg13cmos5l_o21ai_1
Xhold1330 _05806_/A _09406_/Q VPWR VGND sg13cmos5l_dlygate4sd3_1
Xhold1352 hold1352/X _09032_/Q VPWR VGND sg13cmos5l_dlygate4sd3_1
Xhold1341 _08908_/A _08906_/Y VPWR VGND sg13cmos5l_dlygate4sd3_1
Xhold1374 _08753_/A _09251_/Q VPWR VGND sg13cmos5l_dlygate4sd3_1
Xhold1363 _08507_/B _09250_/Q VPWR VGND sg13cmos5l_dlygate4sd3_1
X_08849_ _08897_/A _09279_/Q _08850_/B VPWR VGND sg13cmos5l_xnor2_1
Xhold1385 hold1385/X _09488_/Q VPWR VGND sg13cmos5l_dlygate4sd3_1
Xhold1396 hold1396/X _09155_/Q VPWR VGND sg13cmos5l_dlygate4sd3_1
XFILLER_17_239 VPWR VGND sg13cmos5l_fill_1
XFILLER_26_751 VPWR VGND sg13cmos5l_fill_1
X_09150__323 _09150_/RESET_B VPWR VGND sg13cmos5l_tiehi
X_09011__474 _09011_/RESET_B VPWR VGND sg13cmos5l_tiehi
XFILLER_49_832 VPWR VGND sg13cmos5l_fill_1
XFILLER_16_261 VPWR VGND sg13cmos5l_fill_2
X_06200_ _06200_/Y _04976_/Y fanout43/X _06199_/Y VPWR VGND sg13cmos5l_a21oi_1
X_07180_ _07180_/Y _07179_/Y _07180_/B VPWR VGND sg13cmos5l_nand2b_1
X_06131_ _06131_/Y _05848_/A _06122_/Y _06129_/Y VPWR VGND sg13cmos5l_o21ai_1
X_06062_ _06062_/Y _09446_/Q _06062_/B VPWR VGND sg13cmos5l_xnor2_1
X_05013_ _05014_/A _09604_/D _09601_/D VPWR VGND sg13cmos5l_nor2_1
X_06964_ _06964_/Y _06961_/Y _06963_/Y _06936_/Y VPWR VGND sg13cmos5l_o21ai_1
X_08703_ _08704_/A _08621_/A _08625_/B _08621_/B VPWR VGND sg13cmos5l_o21ai_1
X_06895_ _06896_/B _09527_/Q _06923_/A VPWR VGND sg13cmos5l_xnor2_1
X_05915_ _05915_/Y _09439_/Q _04984_/Y _04985_/Y _09438_/Q _05914_/Y VPWR VGND sg13cmos5l_a221oi_1
X_05846_ _09405_/D _05898_/A _05846_/B VPWR VGND sg13cmos5l_nor2_1
X_08634_ _08634_/Y _08663_/A _08663_/B _08640_/A VPWR VGND sg13cmos5l_a21oi_1
XFILLER_27_559 VPWR VGND sg13cmos5l_fill_1
X_08565_ _08566_/B _09230_/Q _08557_/Y _08567_/B _09231_/Q VPWR VGND sg13cmos5l_a22oi_1
X_05777_ _05777_/Y _05739_/B _05779_/A _05696_/B VPWR VGND sg13cmos5l_o21ai_1
X_07516_ _07665_/B _07516_/A _07521_/B _07521_/C VPWR VGND sg13cmos5l_nand3_1
Xfanout24 _07462_/S _07455_/Y VPWR VGND sg13cmos5l_buf_1
X_08496_ _08510_/B _09226_/Q _08498_/B VPWR VGND sg13cmos5l_nor2b_1
Xfanout35 fanout35/X _08974_/Y VPWR VGND sg13cmos5l_buf_1
Xfanout46 _06437_/B _06441_/B VPWR VGND sg13cmos5l_buf_1
Xfanout68 _05933_/B _05917_/Y VPWR VGND sg13cmos5l_buf_1
X_07447_ _07447_/Y _07447_/A _07447_/B VPWR VGND sg13cmos5l_nor2_1
Xfanout79 _08626_/B _08608_/Y VPWR VGND sg13cmos5l_buf_1
Xfanout57 fanout57/X fanout58/X VPWR VGND sg13cmos5l_buf_1
XFILLER_13_45 VPWR VGND sg13cmos5l_fill_1
X_07378_ _07378_/Y hold1027/X fanout50/X _07382_/A VPWR VGND sg13cmos5l_o21ai_1
X_06329_ _06329_/Y _09480_/Q _09479_/Q VPWR VGND sg13cmos5l_nor2b_1
X_09117_ _09117_/Q clkload6/A _09117_/D _09117_/RESET_B VPWR VGND sg13cmos5l_dfrbpq_1
X_09048_ _09048_/Q clkload16/A _09048_/D _09048_/RESET_B VPWR VGND sg13cmos5l_dfrbpq_1
X_09377__736 _09377_/RESET_B VPWR VGND sg13cmos5l_tiehi
XFILLER_38_53 VPWR VGND sg13cmos5l_fill_2
Xhold1160 hold1160/X _09378_/Q VPWR VGND sg13cmos5l_dlygate4sd3_1
Xhold1193 _06854_/B _09592_/Q VPWR VGND sg13cmos5l_dlygate4sd3_1
Xhold1182 _05928_/A _09381_/Q VPWR VGND sg13cmos5l_dlygate4sd3_1
Xhold1171 _04992_/A _09307_/Q VPWR VGND sg13cmos5l_dlygate4sd3_1
XFILLER_41_595 VPWR VGND sg13cmos5l_decap_4
XFILLER_9_268 VPWR VGND sg13cmos5l_decap_4
XFILLER_10_960 VPWR VGND sg13cmos5l_decap_4
XFILLER_10_971 VPWR VGND sg13cmos5l_fill_2
XFILLER_10_982 VPWR VGND sg13cmos5l_fill_2
Xclkload16 clkload16/Y clkload16/A VPWR VGND sg13cmos5l_inv_2
X_09384__729 _09384_/RESET_B VPWR VGND sg13cmos5l_tiehi
XFILLER_10_993 VPWR VGND sg13cmos5l_fill_1
X_09085__394 _09085_/RESET_B VPWR VGND sg13cmos5l_tiehi
XFILLER_49_640 VPWR VGND sg13cmos5l_decap_4
X_06680_ _06776_/B _06680_/A _06680_/B VPWR VGND sg13cmos5l_and2_1
XFILLER_36_345 VPWR VGND sg13cmos5l_fill_2
X_05700_ _09395_/D _05700_/A _05784_/A VPWR VGND sg13cmos5l_nor2_1
X_05631_ _05633_/B _05632_/A _05632_/B VPWR VGND sg13cmos5l_nand2_1
X_08350_ _08350_/Y _08604_/A _09164_/Q hold969/A _08603_/A _08349_/Y VPWR VGND sg13cmos5l_a221oi_1
XFILLER_17_592 VPWR VGND sg13cmos5l_fill_2
X_05562_ _05562_/Y _05586_/B _05588_/B VPWR VGND sg13cmos5l_nor2_1
X_07301_ _07301_/Y _09566_/Q _07301_/B VPWR VGND sg13cmos5l_xnor2_1
X_08281_ _08282_/B _08427_/A _08427_/B VPWR VGND sg13cmos5l_and2_1
X_05493_ _05493_/Y _05517_/A _05493_/B VPWR VGND sg13cmos5l_nand2b_1
X_07232_ _07232_/Y _09037_/Q _07232_/B VPWR VGND sg13cmos5l_xnor2_1
X_09133__340 _09133_/RESET_B VPWR VGND sg13cmos5l_tiehi
X_07163_ _08882_/A _08784_/A _07163_/B VPWR VGND sg13cmos5l_or2_1
X_06114_ _06114_/Y _06281_/A VPWR VGND sg13cmos5l_inv_1
X_07094_ _09596_/D _08478_/A _07094_/B VPWR VGND sg13cmos5l_nor2_1
X_06045_ _06045_/Y _06030_/A _06045_/B _06045_/C VPWR VGND sg13cmos5l_nand3b_1
Xfanout203 _05693_/A fanout206/X VPWR VGND sg13cmos5l_buf_1
Xfanout214 _06736_/A _06470_/A VPWR VGND sg13cmos5l_buf_1
X_07996_ _08037_/B _08401_/A _07998_/B VPWR VGND sg13cmos5l_nand2_1
X_09140__333 _09140_/RESET_B VPWR VGND sg13cmos5l_tiehi
X_06947_ _06947_/Y _06946_/X hold988/A VPWR VGND sg13cmos5l_nand2b_1
X_06878_ _06878_/Y _07022_/A _07022_/B VPWR VGND sg13cmos5l_nand2_1
X_08617_ _08697_/C _09242_/Q _08626_/B _08627_/A VPWR VGND sg13cmos5l_o21ai_1
X_05829_ _05847_/C _05814_/Y _05825_/Y _05827_/Y VPWR VGND sg13cmos5l_o21ai_1
X_09597_ _09597_/Q clkload3/A _09597_/D _09597_/RESET_B VPWR VGND sg13cmos5l_dfrbpq_1
X_08548_ _08548_/Y _09247_/Q _08378_/A _04930_/Y _08555_/A VPWR VGND sg13cmos5l_a22oi_1
X_08479_ _08604_/B _08478_/B _08479_/B VPWR VGND sg13cmos5l_nand2b_1
XFILLER_2_444 VPWR VGND sg13cmos5l_decap_4
XFILLER_2_477 VPWR VGND sg13cmos5l_fill_1
XFILLER_46_610 VPWR VGND sg13cmos5l_fill_2
XFILLER_19_857 VPWR VGND sg13cmos5l_fill_2
X_09568__530 _09568_/RESET_B VPWR VGND sg13cmos5l_tiehi
X_09447__236 _09447_/D VPWR VGND sg13cmos5l_tielo
X_07850_ _07850_/Y _09142_/Q _07855_/B VPWR VGND sg13cmos5l_nor2_1
X_07781_ _07781_/Y _07781_/A _07781_/B _07781_/C VPWR VGND sg13cmos5l_nor3_1
Xheichips26_dna_sequencer_845 uio_oe[2] VPWR VGND sg13cmos5l_tiehi
X_06801_ _06801_/Y _06798_/Y _06819_/A VPWR VGND sg13cmos5l_nand2b_1
X_04993_ _08972_/A _08969_/B VPWR VGND sg13cmos5l_inv_1
Xinput3 input3/X ui_in[1] VPWR VGND sg13cmos5l_buf_1
X_06732_ _06732_/Y hold936/X fanout50/X _06736_/A VPWR VGND sg13cmos5l_o21ai_1
X_09520_ _09520_/Q clkload23/A _09520_/D _09520_/RESET_B VPWR VGND sg13cmos5l_dfrbpq_1
X_09451_ _09451_/Q _09491_/CLK _09451_/D _09451_/RESET_B VPWR VGND sg13cmos5l_dfrbpq_1
X_06663_ _06675_/S _06656_/A _06674_/A _06670_/C VPWR VGND sg13cmos5l_o21ai_1
X_05614_ _05614_/Y _05327_/A _05610_/Y _05611_/Y _05608_/X _05613_/Y VPWR VGND sg13cmos5l_a221oi_1
X_08402_ _08438_/A hold964/A hold871/A VPWR VGND sg13cmos5l_nand2_1
X_06594_ _06612_/B _09523_/Q _06596_/B VPWR VGND sg13cmos5l_xor2_1
X_09382_ _09382_/Q clkload19/A _09382_/D _09382_/RESET_B VPWR VGND sg13cmos5l_dfrbpq_1
X_05545_ _05545_/Y _05907_/A VPWR VGND sg13cmos5l_inv_1
X_08333_ _08430_/C _08302_/Y _08322_/Y _08025_/Y VPWR VGND sg13cmos5l_o21ai_1
X_08264_ _08264_/Y _08289_/B _08259_/Y _08293_/A _08266_/B VPWR VGND sg13cmos5l_a22oi_1
X_05476_ _05476_/Y _05474_/A _05474_/B _05474_/C _05474_/D VPWR VGND sg13cmos5l_a22oi_1
X_09367__746 _09367_/RESET_B VPWR VGND sg13cmos5l_tiehi
X_08195_ _08196_/B _08016_/X _08073_/B _08208_/B VPWR VGND sg13cmos5l_mux2_1
X_07215_ _07216_/D _07215_/A _07215_/B _07215_/C _07215_/D VPWR VGND sg13cmos5l_nand4_1
X_07146_ _07146_/Y _07146_/A VPWR VGND sg13cmos5l_inv_1
X_09228__842 _09228_/RESET_B VPWR VGND sg13cmos5l_tiehi
X_07077_ _07078_/B _05028_/B _07096_/C _07076_/Y VPWR VGND sg13cmos5l_o21ai_1
X_06028_ _06033_/A _06028_/A _06001_/B VPWR VGND sg13cmos5l_nor2b_1
XFILLER_0_948 VPWR VGND sg13cmos5l_fill_2
X_07979_ _07982_/B _07991_/C _07979_/B VPWR VGND sg13cmos5l_nor2_1
X_09374__739 _09374_/RESET_B VPWR VGND sg13cmos5l_tiehi
XFILLER_16_849 VPWR VGND sg13cmos5l_fill_1
XFILLER_35_43 VPWR VGND sg13cmos5l_fill_2
XFILLER_23_381 VPWR VGND sg13cmos5l_fill_2
XFILLER_3_775 VPWR VGND sg13cmos5l_fill_1
X_09082__397 _09082_/RESET_B VPWR VGND sg13cmos5l_tiehi
XFILLER_20_1025 VPWR VGND sg13cmos5l_decap_4
XFILLER_34_613 VPWR VGND sg13cmos5l_fill_1
XFILLER_21_318 VPWR VGND sg13cmos5l_fill_1
X_05330_ _05330_/X _05330_/A _05330_/B _05330_/C VPWR VGND sg13cmos5l_and3_1
X_05261_ _09326_/D _05242_/Y _05260_/Y _09001_/B VPWR VGND sg13cmos5l_a21oi_1
X_05192_ _05192_/Y _05192_/A _08751_/A VPWR VGND sg13cmos5l_nor2_1
X_07000_ _07045_/A _09583_/Q _07011_/B VPWR VGND sg13cmos5l_xnor2_1
XFILLER_44_0 VPWR VGND sg13cmos5l_fill_1
X_08951_ _08951_/Y _09321_/Q _08964_/B VPWR VGND sg13cmos5l_nor2_1
X_08882_ _08884_/A _08882_/A _08893_/B _08893_/C VPWR VGND sg13cmos5l_nor3_1
X_07902_ _07939_/A _09136_/Q _07917_/B VPWR VGND sg13cmos5l_xnor2_1
X_07833_ _07928_/B _07833_/A _07833_/B VPWR VGND sg13cmos5l_and2_1
X_07764_ _09108_/D _07892_/B _07764_/B VPWR VGND sg13cmos5l_nor2_1
X_04976_ _04976_/Y _04976_/A VPWR VGND sg13cmos5l_inv_1
X_07695_ _07695_/Y _07695_/A _07695_/B VPWR VGND sg13cmos5l_nor2_1
X_06715_ _09530_/D _06715_/A _06715_/B VPWR VGND sg13cmos5l_nor2_1
XFILLER_25_613 VPWR VGND sg13cmos5l_fill_2
X_09503_ hold851/A _09503_/CLK _09503_/D _09503_/RESET_B VPWR VGND sg13cmos5l_dfrbpq_1
X_06646_ _06646_/Y _06646_/A _06670_/A _06670_/B VPWR VGND sg13cmos5l_nand3_1
X_09434_ _09434_/Q clkload19/A _09434_/D _09434_/RESET_B VPWR VGND sg13cmos5l_dfrbpq_1
XFILLER_40_605 VPWR VGND sg13cmos5l_fill_1
X_09365_ _09365_/Q clkload11/A _09365_/D _09365_/RESET_B VPWR VGND sg13cmos5l_dfrbpq_1
XFILLER_40_649 VPWR VGND sg13cmos5l_fill_1
X_06577_ _06629_/A _09521_/Q _06589_/C VPWR VGND sg13cmos5l_xnor2_1
X_09296_ _09296_/Q clkload10/A _09296_/D _09296_/RESET_B VPWR VGND sg13cmos5l_dfrbpq_1
X_08316_ _08316_/X _08316_/A _08316_/B _08316_/C VPWR VGND sg13cmos5l_or3_1
XFILLER_20_351 VPWR VGND sg13cmos5l_fill_1
X_05528_ _05528_/Y _05528_/A _05528_/B VPWR VGND sg13cmos5l_nand2_1
X_08247_ _08247_/Y _08245_/Y _08246_/Y _08294_/A VPWR VGND sg13cmos5l_o21ai_1
X_05459_ _05495_/A _05494_/B _05494_/C _05494_/A VPWR VGND sg13cmos5l_a21oi_1
X_08178_ _08178_/Y _08178_/A _08178_/B _08178_/C _08178_/D VPWR VGND sg13cmos5l_nand4_1
X_07129_ _07129_/Y _09026_/Q _09006_/Q VPWR VGND sg13cmos5l_nand2_1
XFILLER_0_712 VPWR VGND sg13cmos5l_decap_4
XFILLER_43_1025 VPWR VGND sg13cmos5l_decap_4
X_09558__540 _09558_/RESET_B VPWR VGND sg13cmos5l_tiehi
X_09419__691 _09419_/RESET_B VPWR VGND sg13cmos5l_tiehi
X_09565__533 _09565_/RESET_B VPWR VGND sg13cmos5l_tiehi
X_09357__756 _09357_/RESET_B VPWR VGND sg13cmos5l_tiehi
X_04830_ _05020_/A _04830_/A VPWR VGND sg13cmos5l_inv_1
XFILLER_46_292 VPWR VGND sg13cmos5l_fill_1
X_06500_ _06500_/Y _06367_/S _06350_/Y _06404_/A _06404_/B _06349_/Y VPWR VGND sg13cmos5l_a221oi_1
X_07480_ _07519_/A _07895_/A _07480_/B VPWR VGND sg13cmos5l_nand2_1
XFILLER_35_988 VPWR VGND sg13cmos5l_fill_1
XFILLER_21_126 VPWR VGND sg13cmos5l_fill_1
X_06431_ _06436_/A _09493_/Q _06429_/Y _06430_/Y VPWR VGND sg13cmos5l_o21ai_1
X_06362_ _06362_/Y _06365_/A _06362_/B VPWR VGND sg13cmos5l_nand2b_1
X_09150_ _09150_/Q clkload6/A _09150_/D _09150_/RESET_B VPWR VGND sg13cmos5l_dfrbpq_1
X_05313_ _05315_/B _05475_/A _05475_/B VPWR VGND sg13cmos5l_and2_1
X_06293_ _06302_/S _06291_/A _06291_/B _06292_/Y _06284_/Y _06286_/Y VPWR VGND sg13cmos5l_a221oi_1
X_09081_ _09081_/Q clkload14/A _09081_/D _09081_/RESET_B VPWR VGND sg13cmos5l_dfrbpq_1
X_08101_ _08101_/Y _08119_/A _09159_/Q VPWR VGND sg13cmos5l_nor2b_1
X_08032_ _08032_/Y _08315_/A _08037_/B VPWR VGND sg13cmos5l_nand2_1
X_05244_ _05260_/A _05244_/A _05244_/B VPWR VGND sg13cmos5l_nor2_1
X_09364__749 _09364_/RESET_B VPWR VGND sg13cmos5l_tiehi
X_05175_ _05175_/Y _05175_/A _05175_/B _05175_/C _05175_/D VPWR VGND sg13cmos5l_nand4_1
Xhold889 hold889/X hold889/A VPWR VGND sg13cmos5l_dlygate4sd3_1
Xhold856 hold856/X hold856/A VPWR VGND sg13cmos5l_dlygate4sd3_1
Xhold867 hold867/X hold867/A VPWR VGND sg13cmos5l_dlygate4sd3_1
Xhold878 hold878/X hold878/A VPWR VGND sg13cmos5l_dlygate4sd3_1
X_08934_ _09292_/D _08934_/A _08939_/B VPWR VGND sg13cmos5l_nor2_1
X_08865_ _08865_/Y _08858_/A _08858_/B _08864_/Y VPWR VGND sg13cmos5l_o21ai_1
X_07816_ _07817_/B _07920_/C _07920_/D VPWR VGND sg13cmos5l_or2_1
X_08796_ _08813_/B _09288_/Q _09018_/Q VPWR VGND sg13cmos5l_nor2_1
X_07747_ _07747_/Y _07776_/B _07746_/Y _07743_/Y VPWR VGND sg13cmos5l_o21ai_1
X_04959_ _06974_/A _04959_/A VPWR VGND sg13cmos5l_inv_1
XFILLER_25_443 VPWR VGND sg13cmos5l_fill_1
X_07678_ _07680_/B _07573_/B _07693_/S _07677_/Y VPWR VGND sg13cmos5l_a21oi_1
X_06629_ _06629_/Y _06629_/A _06629_/B VPWR VGND sg13cmos5l_nor2_1
X_09417_ _09417_/Q _09503_/CLK _09417_/D _09417_/RESET_B VPWR VGND sg13cmos5l_dfrbpq_1
XFILLER_40_468 VPWR VGND sg13cmos5l_fill_2
X_09348_ hold977/A clkload7/A hold910/X _09348_/RESET_B VPWR VGND sg13cmos5l_dfrbpq_1
XFILLER_8_119 VPWR VGND sg13cmos5l_fill_1
X_09279_ _09279_/Q _09288_/CLK _09279_/D _09279_/RESET_B VPWR VGND sg13cmos5l_dfrbpq_1
XFILLER_4_347 VPWR VGND sg13cmos5l_decap_4
XFILLER_0_575 VPWR VGND sg13cmos5l_fill_1
XFILLER_44_741 VPWR VGND sg13cmos5l_fill_2
X_06980_ hold927/A _04834_/Y fanout59/X _06979_/Y VPWR VGND sg13cmos5l_a21oi_1
X_05931_ _05931_/Y _04982_/Y _05925_/A _05930_/A _04981_/Y VPWR VGND sg13cmos5l_a22oi_1
X_05862_ _05903_/A _09376_/Q _09377_/Q _05873_/B VPWR VGND sg13cmos5l_or3_1
X_08650_ _08650_/Y _08246_/Y _08647_/X _08649_/Y VPWR VGND sg13cmos5l_o21ai_1
X_07601_ _07601_/Y _04950_/Y _07596_/A _07600_/Y _07617_/A VPWR VGND sg13cmos5l_a22oi_1
X_04813_ _04813_/Y hold941/X VPWR VGND sg13cmos5l_inv_1
X_05793_ _05804_/B _09437_/Q _09436_/Q VPWR VGND sg13cmos5l_nor2_1
X_08581_ _08581_/Y hold1011/X fanout36/X _08599_/B VPWR VGND sg13cmos5l_o21ai_1
X_07532_ _09074_/D _07636_/B _07699_/A VPWR VGND sg13cmos5l_nor2_1
X_07463_ _09067_/D _07463_/A _07463_/B VPWR VGND sg13cmos5l_nor2_1
X_06414_ _09490_/D _06552_/A _06507_/B VPWR VGND sg13cmos5l_nor2_1
X_09202_ _09202_/Q clkload4/A _09202_/D _09202_/RESET_B VPWR VGND sg13cmos5l_dfrbpq_1
X_09133_ hold992/A _09388_/CLK _09133_/D _09133_/RESET_B VPWR VGND sg13cmos5l_dfrbpq_1
X_07394_ _07394_/Y _07392_/Y _07393_/Y _07430_/A VPWR VGND sg13cmos5l_a21oi_1
X_09548__550 _09548_/RESET_B VPWR VGND sg13cmos5l_tiehi
X_06345_ _06345_/Y _06737_/A _06652_/B VPWR VGND sg13cmos5l_nand2_1
X_06276_ _06276_/Y _06276_/A _06276_/B VPWR VGND sg13cmos5l_nor2_1
X_09064_ _09064_/Q clkload17/A _09064_/D _09064_/RESET_B VPWR VGND sg13cmos5l_dfrbpq_1
X_08015_ _08174_/B _08009_/Y _08013_/Y _08014_/Y VPWR VGND sg13cmos5l_o21ai_1
X_05227_ _05227_/X _08931_/A _05238_/B _05226_/Y VPWR VGND sg13cmos5l_a21o_1
X_05158_ _05158_/Y _05139_/Y _05192_/A _05152_/Y _05153_/Y _05157_/Y VPWR VGND sg13cmos5l_a221oi_1
X_05089_ _05089_/Y _05089_/A _05089_/B VPWR VGND sg13cmos5l_xnor2_1
X_08917_ _08924_/S _08907_/A _08862_/B _08928_/B _08929_/A _08928_/C VPWR VGND sg13cmos5l_a221oi_1
XFILLER_40_1028 VPWR VGND sg13cmos5l_fill_1
Xhold1331 _05137_/A _09263_/Q VPWR VGND sg13cmos5l_dlygate4sd3_1
Xhold1320 _08070_/A _09115_/Q VPWR VGND sg13cmos5l_dlygate4sd3_1
X_09555__543 _09555_/RESET_B VPWR VGND sg13cmos5l_tiehi
Xhold1342 hold1342/X _09360_/Q VPWR VGND sg13cmos5l_dlygate4sd3_1
X_08848_ _08906_/B _08848_/A _08850_/B VPWR VGND sg13cmos5l_nand2_1
Xhold1386 _06398_/A _09448_/Q VPWR VGND sg13cmos5l_dlygate4sd3_1
Xhold1353 hold1353/X _09101_/Q VPWR VGND sg13cmos5l_dlygate4sd3_1
Xhold1375 _07011_/A _09581_/Q VPWR VGND sg13cmos5l_dlygate4sd3_1
Xhold1364 _06604_/A _09517_/Q VPWR VGND sg13cmos5l_dlygate4sd3_1
Xhold1397 _07240_/B _09033_/Q VPWR VGND sg13cmos5l_dlygate4sd3_1
X_08779_ _09277_/D _08779_/A _08930_/A VPWR VGND sg13cmos5l_nor2_1
X_09416__694 _09416_/RESET_B VPWR VGND sg13cmos5l_tiehi
Xclkbuf_leaf_20_clk clkload23/A clkload1/A VPWR VGND sg13cmos5l_buf_8
X_09562__536 _09562_/RESET_B VPWR VGND sg13cmos5l_tiehi
X_09423__687 _09423_/RESET_B VPWR VGND sg13cmos5l_tiehi
XFILLER_48_310 VPWR VGND sg13cmos5l_fill_2
XFILLER_49_855 VPWR VGND sg13cmos5l_decap_8
X_09354__759 _09354_/RESET_B VPWR VGND sg13cmos5l_tiehi
Xclkbuf_leaf_11_clk clkload10/A clkload0/A VPWR VGND sg13cmos5l_buf_8
XFILLER_12_490 VPWR VGND sg13cmos5l_fill_2
XFILLER_13_991 VPWR VGND sg13cmos5l_fill_2
X_06130_ _06130_/X _06130_/A _06130_/B _06130_/C VPWR VGND sg13cmos5l_and3_1
XFILLER_9_973 VPWR VGND sg13cmos5l_fill_1
XFILLER_9_995 VPWR VGND sg13cmos5l_fill_1
X_06061_ _06061_/Y _06098_/A _06415_/A VPWR VGND sg13cmos5l_nand2_1
X_09283__511 _09283_/RESET_B VPWR VGND sg13cmos5l_tiehi
X_05012_ _09601_/D _08478_/A _07096_/A VPWR VGND sg13cmos5l_nor2_1
X_06963_ _06963_/Y _06936_/A _06936_/B _06962_/Y VPWR VGND sg13cmos5l_o21ai_1
X_08702_ _08709_/A _08702_/A _08676_/B VPWR VGND sg13cmos5l_nor2b_1
X_05914_ _05914_/Y _06221_/A _09381_/Q _09380_/Q _06220_/A _05913_/Y VPWR VGND sg13cmos5l_a221oi_1
XFILLER_39_354 VPWR VGND sg13cmos5l_fill_2
X_06894_ _06894_/X _06894_/A _06923_/A VPWR VGND sg13cmos5l_xor2_1
X_05845_ _05845_/Y _05830_/Y _05842_/Y _05843_/X VPWR VGND sg13cmos5l_a21oi_1
XFILLER_39_398 VPWR VGND sg13cmos5l_fill_2
X_08633_ _08663_/B _09191_/Q _09192_/Q _09193_/Q VPWR VGND sg13cmos5l_o21ai_1
X_08564_ _08567_/B _08564_/A VPWR VGND sg13cmos5l_inv_1
X_05776_ _09399_/D _05776_/A _05776_/B VPWR VGND sg13cmos5l_nor2_1
X_07515_ _07665_/A _07503_/Y _07506_/X _07514_/Y VPWR VGND sg13cmos5l_o21ai_1
Xfanout36 fanout36/X _08579_/Y VPWR VGND sg13cmos5l_buf_1
X_08495_ _08495_/Y _08490_/Y _08535_/A _08494_/Y VPWR VGND sg13cmos5l_o21ai_1
Xfanout25 _07069_/S _07062_/Y VPWR VGND sg13cmos5l_buf_1
Xfanout47 fanout47/X fanout53/X VPWR VGND sg13cmos5l_buf_1
X_07446_ _07449_/A _07446_/A _07446_/B _07446_/C VPWR VGND sg13cmos5l_nor3_1
Xfanout58 fanout58/X fanout62/X VPWR VGND sg13cmos5l_buf_1
Xfanout69 _05661_/B _05665_/B VPWR VGND sg13cmos5l_buf_1
X_07377_ _09052_/D _04829_/Y fanout50/X _07376_/Y VPWR VGND sg13cmos5l_a21oi_1
X_06328_ _06333_/A _06337_/A _06337_/C _06646_/A VPWR VGND sg13cmos5l_a21oi_1
XFILLER_6_409 VPWR VGND sg13cmos5l_fill_1
X_09116_ _09116_/Q clkload6/A _09116_/D _09116_/RESET_B VPWR VGND sg13cmos5l_dfrbpq_1
X_09047_ _09047_/Q clkload15/A _09047_/D _09047_/RESET_B VPWR VGND sg13cmos5l_dfrbpq_1
X_06259_ _06259_/Y _06259_/A _06259_/B VPWR VGND sg13cmos5l_nor2_1
XFILLER_1_114 VPWR VGND sg13cmos5l_fill_2
Xhold1150 _09492_/D _06450_/Y VPWR VGND sg13cmos5l_dlygate4sd3_1
Xhold1183 _04885_/A _09219_/Q VPWR VGND sg13cmos5l_dlygate4sd3_1
Xhold1161 _07083_/A _09594_/Q VPWR VGND sg13cmos5l_dlygate4sd3_1
Xhold1194 _04831_/A _09593_/Q VPWR VGND sg13cmos5l_dlygate4sd3_1
Xhold1172 _06316_/B _09516_/Q VPWR VGND sg13cmos5l_dlygate4sd3_1
XFILLER_33_519 VPWR VGND sg13cmos5l_fill_2
XFILLER_41_530 VPWR VGND sg13cmos5l_decap_4
XFILLER_41_563 VPWR VGND sg13cmos5l_fill_2
XFILLER_9_203 VPWR VGND sg13cmos5l_fill_1
Xclkload17 clkload17/Y clkload17/A VPWR VGND sg13cmos5l_inv_2
XFILLER_49_630 VPWR VGND sg13cmos5l_fill_2
XFILLER_48_151 VPWR VGND sg13cmos5l_fill_2
Xclkbuf_leaf_0_clk clkload2/A clkbuf_leaf_2_clk/A VPWR VGND sg13cmos5l_buf_8
XFILLER_37_814 VPWR VGND sg13cmos5l_fill_2
XFILLER_48_195 VPWR VGND sg13cmos5l_fill_2
X_05630_ _05632_/B _05630_/A _05630_/B _05630_/C VPWR VGND sg13cmos5l_nand3_1
XFILLER_36_368 VPWR VGND sg13cmos5l_fill_1
X_05561_ _05561_/Y _05871_/A _05554_/X _05586_/B _05588_/B VPWR VGND sg13cmos5l_a22oi_1
X_07300_ _07300_/X _09566_/Q _07301_/B VPWR VGND sg13cmos5l_xor2_1
X_05492_ _05493_/B _05314_/Y _05368_/Y _05508_/B VPWR VGND sg13cmos5l_mux2_1
X_08280_ _08427_/B _08280_/A _08285_/B _08285_/C VPWR VGND sg13cmos5l_nand3_1
X_07231_ _07258_/B _09037_/Q _07232_/B VPWR VGND sg13cmos5l_nor2b_1
X_07162_ _09008_/D _07197_/A _07216_/A VPWR VGND sg13cmos5l_nor2b_1
X_06113_ _06281_/A _06085_/X _06112_/Y _06111_/Y VPWR VGND sg13cmos5l_a21oi_1
X_09545__553 _09545_/RESET_B VPWR VGND sg13cmos5l_tiehi
X_07093_ _07093_/Y _07095_/B _07079_/B hold1042/X VPWR VGND sg13cmos5l_a21oi_1
X_06044_ _09439_/D _06027_/B _06041_/S _06043_/Y VPWR VGND sg13cmos5l_a21oi_1
Xfanout204 _07889_/A fanout206/X VPWR VGND sg13cmos5l_buf_1
Xfanout215 _06470_/A fanout216/X VPWR VGND sg13cmos5l_buf_1
X_07995_ _08320_/A _08401_/A _07998_/B VPWR VGND sg13cmos5l_and2_1
X_06946_ _06946_/X _09587_/Q _09530_/Q _06957_/B VPWR VGND sg13cmos5l_mux2_1
X_06877_ _06879_/B _07022_/A _07022_/B VPWR VGND sg13cmos5l_and2_1
X_05828_ _05852_/C _05847_/A _06139_/A _05824_/Y _05815_/Y _05826_/Y VPWR VGND sg13cmos5l_a221oi_1
X_08616_ _08627_/A _09241_/Q _08622_/B _08690_/A VPWR VGND sg13cmos5l_a21o_1
X_09552__546 _09552_/RESET_B VPWR VGND sg13cmos5l_tiehi
XFILLER_27_357 VPWR VGND sg13cmos5l_fill_2
X_09596_ _09596_/Q clkload3/A _09596_/D _09596_/RESET_B VPWR VGND sg13cmos5l_dfrbpq_1
X_08547_ _08547_/Y _09245_/Q _08547_/B _08547_/C VPWR VGND sg13cmos5l_nand3_1
X_05759_ _05780_/A _05759_/A _05759_/B _05759_/C VPWR VGND sg13cmos5l_nor3_1
X_08478_ _08478_/Y _08478_/A _08478_/B VPWR VGND sg13cmos5l_nor2_1
X_09413__697 _09413_/RESET_B VPWR VGND sg13cmos5l_tiehi
X_07429_ _07429_/Y _07429_/A _07429_/B VPWR VGND sg13cmos5l_nor2_1
XFILLER_11_758 VPWR VGND sg13cmos5l_fill_1
X_09383__730 _09383_/RESET_B VPWR VGND sg13cmos5l_tiehi
XFILLER_46_677 VPWR VGND sg13cmos5l_fill_1
XFILLER_45_154 VPWR VGND sg13cmos5l_fill_2
XFILLER_45_132 VPWR VGND sg13cmos5l_fill_1
XFILLER_46_688 VPWR VGND sg13cmos5l_fill_1
XFILLER_42_861 VPWR VGND sg13cmos5l_fill_1
X_04992_ _04992_/Y _04992_/A VPWR VGND sg13cmos5l_inv_1
X_07780_ _07780_/Y _07780_/A _07780_/B VPWR VGND sg13cmos5l_nand2_1
Xheichips26_dna_sequencer_846 uio_oe[3] VPWR VGND sg13cmos5l_tiehi
X_06800_ _06819_/A _06775_/B _06799_/B _06799_/Y VPWR VGND sg13cmos5l_a21oi_1
Xinput4 input4/X ui_in[2] VPWR VGND sg13cmos5l_buf_1
X_06731_ _09538_/D _04833_/Y fanout50/X _06730_/Y VPWR VGND sg13cmos5l_a21oi_1
XFILLER_37_622 VPWR VGND sg13cmos5l_fill_1
X_09450_ _09450_/Q _09491_/CLK _09450_/D _09450_/RESET_B VPWR VGND sg13cmos5l_dfrbpq_1
XFILLER_25_806 VPWR VGND sg13cmos5l_fill_1
XFILLER_37_644 VPWR VGND sg13cmos5l_fill_2
X_08401_ _09215_/D _08401_/A _08401_/B VPWR VGND sg13cmos5l_nor2_1
X_06662_ _06767_/D _06636_/Y _06658_/Y _06345_/Y VPWR VGND sg13cmos5l_o21ai_1
X_05613_ _05613_/Y _05617_/A _05617_/B VPWR VGND sg13cmos5l_nor2_1
X_06593_ _06593_/Y _06578_/Y _06628_/A _06587_/X _06592_/Y VPWR VGND sg13cmos5l_a22oi_1
X_09381_ _09381_/Q clkload19/A _09381_/D _09381_/RESET_B VPWR VGND sg13cmos5l_dfrbpq_1
X_08332_ _09192_/D _08400_/B _08332_/B VPWR VGND sg13cmos5l_nor2_1
X_05544_ _05907_/A _05542_/B _05651_/A VPWR VGND sg13cmos5l_nand2b_1
X_08263_ _08294_/B _08603_/A _08263_/B VPWR VGND sg13cmos5l_xnor2_1
X_05475_ _05475_/Y _05475_/A _05475_/B _05475_/C _05475_/D VPWR VGND sg13cmos5l_nand4_1
X_07214_ _07215_/D hold993/X _07214_/B VPWR VGND sg13cmos5l_xnor2_1
X_08194_ _08194_/Y _08201_/B _08194_/B VPWR VGND sg13cmos5l_nand2b_1
X_07145_ _07146_/A _07141_/Y _07142_/X _07144_/Y VPWR VGND sg13cmos5l_o21ai_1
X_07076_ _07076_/Y _07076_/A _07095_/B VPWR VGND sg13cmos5l_nand2_1
X_06027_ _06027_/Y _06027_/A _06027_/B VPWR VGND sg13cmos5l_nor2_1
XFILLER_0_927 VPWR VGND sg13cmos5l_decap_8
X_07978_ _07979_/B _09178_/Q _09146_/Q VPWR VGND sg13cmos5l_nand2_1
X_06929_ _06929_/X _06920_/A _06923_/C _06628_/Y VPWR VGND sg13cmos5l_a21o_1
XFILLER_42_135 VPWR VGND sg13cmos5l_fill_2
X_09579_ hold902/A _09586_/CLK _09579_/D _09579_/RESET_B VPWR VGND sg13cmos5l_dfrbpq_1
X_09270__727 _09270_/RESET_B VPWR VGND sg13cmos5l_tiehi
XFILLER_35_99 VPWR VGND sg13cmos5l_fill_1
XFILLER_7_537 VPWR VGND sg13cmos5l_decap_8
XFILLER_13_1022 VPWR VGND sg13cmos5l_decap_8
XFILLER_46_430 VPWR VGND sg13cmos5l_fill_1
XFILLER_19_666 VPWR VGND sg13cmos5l_fill_1
XFILLER_18_165 VPWR VGND sg13cmos5l_fill_2
XFILLER_46_496 VPWR VGND sg13cmos5l_decap_8
XFILLER_14_360 VPWR VGND sg13cmos5l_fill_2
X_05260_ _05260_/Y _05260_/A _05260_/B VPWR VGND sg13cmos5l_nand2_1
X_09130__344 _09130_/RESET_B VPWR VGND sg13cmos5l_tiehi
X_05191_ _05191_/Y _05175_/Y _05183_/Y _05186_/Y _08939_/A _05190_/Y VPWR VGND sg13cmos5l_a221oi_1
X_09542__556 _09542_/RESET_B VPWR VGND sg13cmos5l_tiehi
X_08950_ _08967_/B _09326_/Q _04998_/Y _08949_/Y VPWR VGND sg13cmos5l_a21oi_1
X_08881_ _08909_/B _08893_/B _08893_/C VPWR VGND sg13cmos5l_nor2_1
X_07901_ _07948_/B _09137_/Q _07917_/B VPWR VGND sg13cmos5l_nand2_1
X_07832_ _09119_/D _07875_/A _07950_/A VPWR VGND sg13cmos5l_nor2_1
X_09258__803 _09258_/RESET_B VPWR VGND sg13cmos5l_tiehi
X_07763_ _07764_/B _07920_/A _07920_/B VPWR VGND sg13cmos5l_nor2_1
X_09502_ hold864/A _09575_/CLK _09502_/D _09502_/RESET_B VPWR VGND sg13cmos5l_dfrbpq_1
X_04975_ _04975_/Y _04975_/A VPWR VGND sg13cmos5l_inv_1
X_09373__740 _09373_/RESET_B VPWR VGND sg13cmos5l_tiehi
X_07694_ _07694_/Y _07683_/Y _07685_/X _07695_/A _07695_/B VPWR VGND sg13cmos5l_a22oi_1
X_06714_ _06715_/B hold1180/X _06716_/B _06737_/B VPWR VGND sg13cmos5l_o21ai_1
XFILLER_25_658 VPWR VGND sg13cmos5l_fill_1
X_09433_ _09433_/Q clkload19/A _09433_/D _09433_/RESET_B VPWR VGND sg13cmos5l_dfrbpq_1
X_06645_ _06645_/Y _06645_/A _06645_/B _06645_/C VPWR VGND sg13cmos5l_nor3_1
X_09364_ _09364_/Q clkload12/A _09364_/D _09364_/RESET_B VPWR VGND sg13cmos5l_dfrbpq_1
XFILLER_40_628 VPWR VGND sg13cmos5l_fill_2
X_08315_ _08316_/C _08315_/A _08315_/B VPWR VGND sg13cmos5l_nor2_1
X_06576_ _06576_/Y _06622_/A _06624_/A _06575_/X VPWR VGND sg13cmos5l_o21ai_1
X_09295_ _09295_/Q clkload10/A _09295_/D _09295_/RESET_B VPWR VGND sg13cmos5l_dfrbpq_1
X_05527_ _09363_/D _05507_/B _05516_/X _05526_/Y VPWR VGND sg13cmos5l_a21oi_1
X_08246_ _08246_/Y _08675_/A _08294_/A VPWR VGND sg13cmos5l_nand2_1
X_05458_ _05494_/C hold982/A hold905/A _09354_/Q VPWR VGND sg13cmos5l_nand3_1
X_08177_ _08177_/Y _08030_/Y _08081_/B _08174_/Y _08175_/Y _08176_/Y VPWR VGND sg13cmos5l_a221oi_1
X_07128_ _07128_/Y _07128_/A _07127_/Y VPWR VGND sg13cmos5l_nor2b_1
X_05389_ _05389_/Y _09361_/Q _04995_/Y _04996_/Y _05317_/A _05388_/Y VPWR VGND sg13cmos5l_a221oi_1
X_09380__733 _09380_/RESET_B VPWR VGND sg13cmos5l_tiehi
X_07059_ _07073_/A _07059_/A _07059_/B VPWR VGND sg13cmos5l_nor2_1
XFILLER_44_912 VPWR VGND sg13cmos5l_fill_2
XFILLER_43_411 VPWR VGND sg13cmos5l_fill_1
XFILLER_43_499 VPWR VGND sg13cmos5l_fill_2
XFILLER_43_488 VPWR VGND sg13cmos5l_decap_8
XFILLER_24_691 VPWR VGND sg13cmos5l_fill_2
XFILLER_12_853 VPWR VGND sg13cmos5l_fill_1
XFILLER_30_149 VPWR VGND sg13cmos5l_fill_1
XFILLER_7_356 VPWR VGND sg13cmos5l_fill_2
XFILLER_11_385 VPWR VGND sg13cmos5l_fill_1
XFILLER_3_562 VPWR VGND sg13cmos5l_fill_1
XFILLER_3_584 VPWR VGND sg13cmos5l_fill_1
XFILLER_47_750 VPWR VGND sg13cmos5l_fill_2
X_06430_ _06430_/Y _06448_/A _09492_/Q VPWR VGND sg13cmos5l_nor2b_1
XFILLER_22_639 VPWR VGND sg13cmos5l_fill_1
X_06361_ _06361_/X _06656_/A _06361_/B VPWR VGND sg13cmos5l_or2_1
X_05312_ _05475_/B hold1348/X _05330_/A _05330_/C VPWR VGND sg13cmos5l_nand3b_1
X_08100_ _08100_/Y _08100_/A VPWR VGND sg13cmos5l_inv_1
X_09080_ _09080_/Q clkload14/A _09080_/D _09080_/RESET_B VPWR VGND sg13cmos5l_dfrbpq_1
X_06292_ _06292_/Y _06283_/A _06283_/B _06291_/Y VPWR VGND sg13cmos5l_a21oi_1
X_08031_ _09148_/D _08081_/A _08031_/B VPWR VGND sg13cmos5l_nor2_1
X_05243_ _05243_/Y _05076_/A _05076_/B _05081_/B VPWR VGND sg13cmos5l_a21oi_1
X_05174_ _08938_/A _05175_/C _05175_/D VPWR VGND sg13cmos5l_nand2_1
Xhold879 hold879/X hold879/A VPWR VGND sg13cmos5l_dlygate4sd3_1
Xhold857 hold857/X hold857/A VPWR VGND sg13cmos5l_dlygate4sd3_1
Xhold868 hold868/X hold868/A VPWR VGND sg13cmos5l_dlygate4sd3_1
X_08933_ _09291_/D _08933_/A _08939_/B VPWR VGND sg13cmos5l_nor2_1
X_08864_ _08864_/Y _08864_/A _08864_/B VPWR VGND sg13cmos5l_xnor2_1
XFILLER_45_709 VPWR VGND sg13cmos5l_fill_2
X_07815_ _07815_/Y _07808_/A _07818_/A _07829_/C VPWR VGND sg13cmos5l_o21ai_1
X_08795_ _08816_/A _08996_/A _08809_/B _08794_/Y VPWR VGND sg13cmos5l_o21ai_1
X_07746_ _07746_/Y _09111_/Q _07746_/B VPWR VGND sg13cmos5l_xnor2_1
X_04958_ _04958_/Y _06936_/A VPWR VGND sg13cmos5l_inv_1
X_07677_ _07677_/Y _07677_/A _07693_/S VPWR VGND sg13cmos5l_nor2_1
X_04889_ _08399_/A _04889_/A VPWR VGND sg13cmos5l_inv_1
X_09416_ _09416_/Q clkload24/A _09416_/D _09416_/RESET_B VPWR VGND sg13cmos5l_dfrbpq_1
X_06628_ _06628_/Y _06628_/A _06912_/A VPWR VGND sg13cmos5l_nor2_1
X_06559_ _09516_/D _06540_/Y _06545_/A _06477_/B VPWR VGND sg13cmos5l_a21oi_1
X_09347_ hold968/A _09347_/CLK hold889/X _09347_/RESET_B VPWR VGND sg13cmos5l_dfrbpq_1
X_09312__830 _09312_/RESET_B VPWR VGND sg13cmos5l_tiehi
X_09278_ _09278_/Q _09288_/CLK _09278_/D _09278_/RESET_B VPWR VGND sg13cmos5l_dfrbpq_1
X_08229_ _08231_/B _08229_/A _08229_/B VPWR VGND sg13cmos5l_nor2_1
XFILLER_4_359 VPWR VGND sg13cmos5l_fill_1
XFILLER_8_665 VPWR VGND sg13cmos5l_fill_1
XFILLER_8_698 VPWR VGND sg13cmos5l_fill_2
X_09248__813 _09248_/RESET_B VPWR VGND sg13cmos5l_tiehi
X_09363__750 _09363_/RESET_B VPWR VGND sg13cmos5l_tiehi
X_05930_ _05932_/B _05930_/A VPWR VGND sg13cmos5l_inv_1
X_05861_ _05891_/A _09376_/Q _09377_/Q _05873_/B VPWR VGND sg13cmos5l_nor3_1
X_08580_ _08582_/A _08580_/A fanout36/X VPWR VGND sg13cmos5l_nor2b_1
X_07600_ _07600_/Y _07893_/A _07602_/B _07599_/Y VPWR VGND sg13cmos5l_o21ai_1
X_09255__806 _09255_/RESET_B VPWR VGND sg13cmos5l_tiehi
X_05792_ _05852_/A _05792_/A _05792_/B VPWR VGND sg13cmos5l_xor2_1
X_07531_ _07699_/A _07501_/A _07530_/S _07529_/Y VPWR VGND sg13cmos5l_o21ai_1
X_09370__743 _09370_/RESET_B VPWR VGND sg13cmos5l_tiehi
X_07462_ _07463_/B _07429_/A _07428_/Y _07462_/S VPWR VGND sg13cmos5l_mux2_1
XFILLER_35_797 VPWR VGND sg13cmos5l_fill_1
X_06413_ _06507_/B _06110_/Y _06412_/X _06413_/S VPWR VGND sg13cmos5l_mux2_1
X_09201_ _09201_/Q clkload2/A _09201_/D _09201_/RESET_B VPWR VGND sg13cmos5l_dfrbpq_1
X_07393_ _07393_/Y _09053_/Q hold902/A VPWR VGND sg13cmos5l_xnor2_1
X_06344_ _06344_/X _06344_/A _06365_/A VPWR VGND sg13cmos5l_or2_1
X_09132_ hold881/A clkload16/A _09132_/D _09132_/RESET_B VPWR VGND sg13cmos5l_dfrbpq_1
XFILLER_31_970 VPWR VGND sg13cmos5l_fill_2
X_06275_ _06275_/Y _06263_/Y _06265_/X _06276_/A _06276_/B VPWR VGND sg13cmos5l_a22oi_1
X_09063_ _09063_/Q clkload17/A _09063_/D _09063_/RESET_B VPWR VGND sg13cmos5l_dfrbpq_1
X_05226_ _05226_/Y _08937_/A _08937_/B _05206_/Y _05212_/Y _05213_/Y VPWR VGND sg13cmos5l_a221oi_1
X_08014_ _08014_/Y _08014_/A _08038_/B VPWR VGND sg13cmos5l_nor2_1
X_05157_ _05157_/Y _08742_/A _05159_/B VPWR VGND sg13cmos5l_nor2_1
X_05088_ _05089_/B _09292_/Q _09294_/Q _09293_/Q _05100_/B VPWR VGND sg13cmos5l_nor4_1
X_08916_ _08928_/C _08905_/Y _08911_/Y _08915_/Y VPWR VGND sg13cmos5l_a21oi_1
Xhold1332 hold1332/X _05166_/B VPWR VGND sg13cmos5l_dlygate4sd3_1
Xhold1310 hold1310/X _07466_/Y VPWR VGND sg13cmos5l_dlygate4sd3_1
Xhold1343 hold1343/X _09519_/Q VPWR VGND sg13cmos5l_dlygate4sd3_1
X_08847_ _08906_/A _09281_/Q _08850_/B VPWR VGND sg13cmos5l_xnor2_1
Xhold1321 hold1321/X _09320_/Q VPWR VGND sg13cmos5l_dlygate4sd3_1
Xhold1365 _07561_/A _09039_/Q VPWR VGND sg13cmos5l_dlygate4sd3_1
Xhold1354 _07705_/B _07704_/Y VPWR VGND sg13cmos5l_dlygate4sd3_1
Xhold1376 _08171_/A _09175_/Q VPWR VGND sg13cmos5l_dlygate4sd3_1
Xhold1387 _05622_/A _09334_/Q VPWR VGND sg13cmos5l_dlygate4sd3_1
X_08778_ _09256_/D _08783_/B _08913_/B VPWR VGND sg13cmos5l_nor2_1
Xhold1398 _08253_/B _09185_/Q VPWR VGND sg13cmos5l_dlygate4sd3_1
XFILLER_38_580 VPWR VGND sg13cmos5l_decap_8
X_07729_ _07748_/B _09109_/Q _09108_/Q _09110_/Q _09111_/Q VPWR VGND sg13cmos5l_nor4_1
XFILLER_25_230 VPWR VGND sg13cmos5l_fill_2
XFILLER_25_241 VPWR VGND sg13cmos5l_fill_1
XFILLER_49_823 VPWR VGND sg13cmos5l_decap_4
XFILLER_0_373 VPWR VGND sg13cmos5l_fill_1
XFILLER_36_506 VPWR VGND sg13cmos5l_fill_1
XFILLER_1_1012 VPWR VGND sg13cmos5l_decap_8
XFILLER_17_731 VPWR VGND sg13cmos5l_fill_1
XFILLER_16_263 VPWR VGND sg13cmos5l_fill_1
X_06060_ _06063_/B _06098_/A _06415_/A VPWR VGND sg13cmos5l_and2_1
X_05011_ _07096_/A _07101_/B _05015_/A VPWR VGND sg13cmos5l_nand2_1
X_09127__349 _09127_/RESET_B VPWR VGND sg13cmos5l_tiehi
X_06962_ _06962_/Y _06974_/A _06962_/B VPWR VGND sg13cmos5l_nand2_1
X_08701_ _08701_/X _08701_/A _08701_/B VPWR VGND sg13cmos5l_or2_1
X_05913_ _05913_/Y _09437_/Q _04986_/Y _05910_/Y _05911_/Y _05912_/Y VPWR VGND sg13cmos5l_a221oi_1
X_08632_ _08659_/C _09196_/Q _09195_/Q _08643_/B VPWR VGND sg13cmos5l_or3_1
X_06893_ _06920_/A _09529_/Q _09528_/Q _06905_/B VPWR VGND sg13cmos5l_or3_1
X_05844_ _05846_/B _05830_/Y _05842_/Y _05843_/X VPWR VGND sg13cmos5l_a21o_1
X_08563_ _08564_/A _04883_/Y _08568_/B _08562_/Y VPWR VGND sg13cmos5l_o21ai_1
X_05775_ _05776_/B _05756_/B _05753_/Y _05779_/A VPWR VGND sg13cmos5l_mux2_1
X_07514_ _07514_/Y _09103_/Q _07808_/A VPWR VGND sg13cmos5l_nor2_1
X_08494_ _08494_/Y _08494_/A _08494_/B _08494_/C VPWR VGND sg13cmos5l_nand3_1
Xfanout37 _08130_/B _08118_/Y VPWR VGND sg13cmos5l_buf_1
X_07445_ _07446_/C _07445_/A _07445_/B _07445_/C VPWR VGND sg13cmos5l_and3_1
Xfanout26 _06817_/S _06810_/Y VPWR VGND sg13cmos5l_buf_1
Xfanout48 fanout48/X fanout52/X VPWR VGND sg13cmos5l_buf_1
Xfanout59 fanout59/X fanout61/X VPWR VGND sg13cmos5l_buf_1
X_07376_ _07376_/Y hold995/X fanout50/X _07382_/A VPWR VGND sg13cmos5l_o21ai_1
X_06327_ _06337_/C _09480_/Q _09479_/Q _09481_/Q VPWR VGND sg13cmos5l_o21ai_1
X_09115_ _09115_/Q clkload6/A _09115_/D _09115_/RESET_B VPWR VGND sg13cmos5l_dfrbpq_1
X_06258_ _06259_/B _06160_/B _06281_/B _06257_/Y VPWR VGND sg13cmos5l_a21oi_1
X_09046_ _09046_/Q clkload16/A _09046_/D _09046_/RESET_B VPWR VGND sg13cmos5l_dfrbpq_1
X_05209_ _05210_/B _05209_/A _05209_/B VPWR VGND sg13cmos5l_nand2_1
X_06189_ _06189_/Y _09477_/Q _06189_/B VPWR VGND sg13cmos5l_nor2_1
XFILLER_46_826 VPWR VGND sg13cmos5l_fill_1
Xhold1151 _07599_/A _09048_/Q VPWR VGND sg13cmos5l_dlygate4sd3_1
Xhold1140 _05651_/B _09345_/Q VPWR VGND sg13cmos5l_dlygate4sd3_1
Xhold1173 _04930_/A _09198_/Q VPWR VGND sg13cmos5l_dlygate4sd3_1
Xhold1162 _09594_/D _07086_/Y VPWR VGND sg13cmos5l_dlygate4sd3_1
Xhold1184 _04917_/A _09551_/Q VPWR VGND sg13cmos5l_dlygate4sd3_1
Xhold1195 _09593_/D _07082_/Y VPWR VGND sg13cmos5l_dlygate4sd3_1
X_09353__760 _09353_/RESET_B VPWR VGND sg13cmos5l_tiehi
XFILLER_13_277 VPWR VGND sg13cmos5l_fill_1
XFILLER_10_984 VPWR VGND sg13cmos5l_fill_1
Xclkload18 clkload18/X clkload18/A VPWR VGND sg13cmos5l_buf_8
X_09245__816 _09245_/RESET_B VPWR VGND sg13cmos5l_tiehi
X_09360__753 _09360_/RESET_B VPWR VGND sg13cmos5l_tiehi
XFILLER_48_185 VPWR VGND sg13cmos5l_fill_1
XFILLER_37_837 VPWR VGND sg13cmos5l_fill_1
XFILLER_36_347 VPWR VGND sg13cmos5l_fill_1
XFILLER_36_358 VPWR VGND sg13cmos5l_fill_2
X_05560_ _05588_/B _09368_/Q _05560_/B VPWR VGND sg13cmos5l_xor2_1
X_09252__809 _09252_/RESET_B VPWR VGND sg13cmos5l_tiehi
X_05491_ _05491_/X _05497_/A _05497_/B VPWR VGND sg13cmos5l_or2_1
X_07230_ _07232_/B _09036_/Q _07249_/B VPWR VGND sg13cmos5l_nor2b_1
X_07161_ _07216_/A _07128_/Y _07167_/A _07160_/Y VPWR VGND sg13cmos5l_o21ai_1
X_06112_ _06112_/Y _06112_/A _06112_/B VPWR VGND sg13cmos5l_nor2_1
X_07092_ _07092_/Y _07079_/B _07088_/Y _05020_/A VPWR VGND sg13cmos5l_a21oi_1
X_06043_ _06043_/Y _06027_/A _06041_/S _05963_/B VPWR VGND sg13cmos5l_o21ai_1
Xfanout205 _05961_/A fanout206/X VPWR VGND sg13cmos5l_buf_1
Xfanout216 fanout216/X fanout217/X VPWR VGND sg13cmos5l_buf_1
X_07994_ _07994_/Y _07982_/Y _07989_/Y _07993_/Y VPWR VGND sg13cmos5l_o21ai_1
X_06945_ _06945_/X _07386_/A _06716_/A _06957_/B VPWR VGND sg13cmos5l_mux2_1
X_06876_ _07022_/B _06876_/A _06876_/B _06876_/C VPWR VGND sg13cmos5l_nand3_1
X_09294__460 _09294_/RESET_B VPWR VGND sg13cmos5l_tiehi
X_05827_ _05827_/Y _05847_/A _06139_/A _05822_/X _05818_/X VPWR VGND sg13cmos5l_a22oi_1
X_09595_ hold895/A _09595_/CLK hold897/X _09595_/RESET_B VPWR VGND sg13cmos5l_dfrbpq_1
X_08615_ _08690_/A _08689_/B _08689_/C _08689_/A VPWR VGND sg13cmos5l_a21oi_1
X_08546_ _08547_/C _08555_/A _09198_/Q VPWR VGND sg13cmos5l_nand2b_1
X_05758_ _05758_/X _05758_/A _05758_/B _05758_/C VPWR VGND sg13cmos5l_and3_1
XFILLER_36_892 VPWR VGND sg13cmos5l_fill_1
X_08477_ _09221_/D _08464_/A _08476_/Y _08400_/B VPWR VGND sg13cmos5l_a21oi_1
X_05689_ _05689_/Y hold977/X fanout48/X _05693_/A VPWR VGND sg13cmos5l_o21ai_1
X_07428_ _07428_/Y _07429_/B VPWR VGND sg13cmos5l_inv_1
X_07359_ _07359_/Y _07351_/Y _07354_/Y _07358_/Y VPWR VGND sg13cmos5l_a21oi_1
X_09029_ _09029_/Q _09288_/CLK _09029_/D _09029_/RESET_B VPWR VGND sg13cmos5l_dfrbpq_1
XFILLER_49_43 VPWR VGND sg13cmos5l_fill_2
XFILLER_46_601 VPWR VGND sg13cmos5l_fill_1
X_09295__224 _09295_/D VPWR VGND sg13cmos5l_tielo
XFILLER_46_612 VPWR VGND sg13cmos5l_fill_1
XFILLER_18_336 VPWR VGND sg13cmos5l_fill_2
X_09152__228 _09152_/D VPWR VGND sg13cmos5l_tielo
X_09117__359 _09117_/RESET_B VPWR VGND sg13cmos5l_tiehi
X_09575__514 _09575_/RESET_B VPWR VGND sg13cmos5l_tiehi
Xheichips26_dna_sequencer_847 uio_oe[4] VPWR VGND sg13cmos5l_tiehi
X_04991_ _05401_/A hold966/X VPWR VGND sg13cmos5l_inv_1
XFILLER_49_461 VPWR VGND sg13cmos5l_fill_1
Xinput5 input5/X ui_in[3] VPWR VGND sg13cmos5l_buf_1
X_06730_ _06730_/Y hold925/X fanout50/X _06470_/A VPWR VGND sg13cmos5l_o21ai_1
X_06661_ _06767_/C _06661_/A _06674_/A _06670_/C VPWR VGND sg13cmos5l_nand3_1
X_05612_ _05617_/B _05612_/A _05612_/B VPWR VGND sg13cmos5l_xor2_1
X_08400_ _09214_/D _08400_/A _08400_/B VPWR VGND sg13cmos5l_nor2_1
X_06592_ _06592_/Y _06596_/B _06596_/C VPWR VGND sg13cmos5l_nand2_1
X_09380_ _09380_/Q _09503_/CLK _09380_/D _09380_/RESET_B VPWR VGND sg13cmos5l_dfrbpq_1
X_05543_ _05543_/Y _05588_/A _05586_/A VPWR VGND sg13cmos5l_nor2_1
X_08331_ _08332_/B _08427_/C _08427_/D VPWR VGND sg13cmos5l_nand2_1
X_05474_ _05474_/Y _05474_/A _05474_/B _05474_/C _05474_/D VPWR VGND sg13cmos5l_nand4_1
X_08262_ _08266_/B _09220_/Q _08263_/B VPWR VGND sg13cmos5l_xnor2_1
X_07213_ _07215_/C _07213_/A _07213_/B VPWR VGND sg13cmos5l_and2_1
X_08193_ _08201_/B _08024_/B _08076_/Y _08208_/B VPWR VGND sg13cmos5l_mux2_1
X_07144_ _07144_/Y _07135_/Y _07139_/Y _07143_/Y VPWR VGND sg13cmos5l_o21ai_1
X_07075_ _07095_/B _09602_/Q hold938/X VPWR VGND sg13cmos5l_nor2_1
X_06026_ _06027_/B _05855_/X _06025_/B _06025_/Y VPWR VGND sg13cmos5l_o21ai_1
XFILLER_0_906 VPWR VGND sg13cmos5l_decap_8
X_07977_ _07982_/A _08311_/A _07987_/B _07977_/C VPWR VGND sg13cmos5l_and3_1
X_06928_ _09565_/D _07070_/A _06928_/B VPWR VGND sg13cmos5l_nor2_1
X_06859_ _06884_/B _06848_/Y _06857_/Y _06858_/Y VPWR VGND sg13cmos5l_a21oi_1
X_09578_ hold865/A clkload13/A _09578_/D _09578_/RESET_B VPWR VGND sg13cmos5l_dfrbpq_1
XFILLER_42_158 VPWR VGND sg13cmos5l_fill_2
X_08529_ _08529_/Y _08529_/A _08538_/B VPWR VGND sg13cmos5l_nor2_1
X_09350__763 _09350_/RESET_B VPWR VGND sg13cmos5l_tiehi
XFILLER_13_1001 VPWR VGND sg13cmos5l_decap_8
XFILLER_11_589 VPWR VGND sg13cmos5l_fill_1
X_09242__819 _09242_/RESET_B VPWR VGND sg13cmos5l_tiehi
XFILLER_47_987 VPWR VGND sg13cmos5l_fill_1
XFILLER_18_188 VPWR VGND sg13cmos5l_fill_1
XFILLER_33_147 VPWR VGND sg13cmos5l_fill_2
X_05190_ _05190_/Y _05175_/A _05175_/B _05175_/C _05175_/D VPWR VGND sg13cmos5l_a22oi_1
X_08880_ _08889_/C _08880_/A _08913_/B VPWR VGND sg13cmos5l_or2_1
X_07900_ _07948_/A _09138_/Q _07917_/B VPWR VGND sg13cmos5l_xnor2_1
X_07831_ _07831_/Y _07950_/A VPWR VGND sg13cmos5l_inv_1
X_07762_ _07920_/B _07762_/A _07781_/B _07781_/C VPWR VGND sg13cmos5l_nor3_1
XFILLER_2_93 VPWR VGND sg13cmos5l_fill_1
X_09501_ hold936/A _09503_/CLK _09501_/D _09501_/RESET_B VPWR VGND sg13cmos5l_dfrbpq_1
X_04974_ _04974_/Y _06437_/A VPWR VGND sg13cmos5l_inv_1
X_07693_ _07695_/B _07524_/B _07570_/B _07693_/S VPWR VGND sg13cmos5l_mux2_1
X_06713_ _06715_/A _06713_/A _06716_/B VPWR VGND sg13cmos5l_nor2b_1
XFILLER_25_615 VPWR VGND sg13cmos5l_fill_1
XFILLER_38_976 VPWR VGND sg13cmos5l_fill_2
X_09432_ _09432_/Q clkload18/A _09432_/D _09432_/RESET_B VPWR VGND sg13cmos5l_dfrbpq_1
X_06644_ _06645_/C _06738_/A _06642_/B _06667_/B VPWR VGND sg13cmos5l_a21oi_1
X_06575_ _06575_/X _06574_/B _06564_/C _06903_/A VPWR VGND sg13cmos5l_a21o_1
X_09363_ _09363_/Q clkload12/A _09363_/D _09363_/RESET_B VPWR VGND sg13cmos5l_dfrbpq_1
X_08314_ _08316_/B _08314_/A _08314_/B VPWR VGND sg13cmos5l_nor2_1
X_05526_ _05526_/Y _05507_/A _05517_/B _05443_/B VPWR VGND sg13cmos5l_o21ai_1
X_09294_ _09294_/Q clkload10/A _09294_/D _09294_/RESET_B VPWR VGND sg13cmos5l_dfrbpq_1
X_08245_ _08245_/Y _09189_/Q _08245_/B VPWR VGND sg13cmos5l_xnor2_1
X_05457_ _05494_/B _09353_/Q _05466_/B VPWR VGND sg13cmos5l_nand2_1
X_08176_ _08176_/Y _08175_/A _08175_/B _08175_/C _08175_/D VPWR VGND sg13cmos5l_a22oi_1
XFILLER_21_36 VPWR VGND sg13cmos5l_fill_2
X_05388_ _05388_/Y _05697_/A _09303_/Q _05387_/Y VPWR VGND sg13cmos5l_a21oi_1
X_07127_ _07127_/Y _09006_/Q _09007_/Q _09008_/Q VPWR VGND sg13cmos5l_o21ai_1
X_07058_ _07058_/Y _07009_/A _07009_/B _07014_/B VPWR VGND sg13cmos5l_a21oi_1
X_06009_ _06010_/B _06009_/A _06009_/B VPWR VGND sg13cmos5l_xnor2_1
X_09107__369 _09107_/RESET_B VPWR VGND sg13cmos5l_tiehi
X_09077__402 _09077_/RESET_B VPWR VGND sg13cmos5l_tiehi
XFILLER_29_998 VPWR VGND sg13cmos5l_decap_4
XFILLER_44_935 VPWR VGND sg13cmos5l_fill_1
XFILLER_8_825 VPWR VGND sg13cmos5l_fill_2
XFILLER_11_91 VPWR VGND sg13cmos5l_fill_2
X_09305__304 _09305_/RESET_B VPWR VGND sg13cmos5l_tiehi
X_09572__517 _09572_/RESET_B VPWR VGND sg13cmos5l_tiehi
XFILLER_46_272 VPWR VGND sg13cmos5l_fill_2
XFILLER_15_681 VPWR VGND sg13cmos5l_fill_1
X_06360_ _09481_/D _06552_/A _06360_/B VPWR VGND sg13cmos5l_nor2_1
X_05311_ _05475_/A _05330_/C _05310_/Y _05309_/Y VPWR VGND sg13cmos5l_a21o_1
X_06291_ _06291_/Y _06291_/A _06291_/B VPWR VGND sg13cmos5l_nor2_1
X_05242_ _05242_/Y _05242_/A _05242_/B VPWR VGND sg13cmos5l_nor2_1
X_08030_ _08030_/Y _08178_/A _08178_/B VPWR VGND sg13cmos5l_nand2_1
X_05173_ _05175_/D _05150_/Y _05194_/C _05176_/B VPWR VGND sg13cmos5l_nand3b_1
Xhold858 hold858/X hold858/A VPWR VGND sg13cmos5l_dlygate4sd3_1
Xhold869 hold869/X hold869/A VPWR VGND sg13cmos5l_dlygate4sd3_1
X_08932_ _09290_/D _08932_/A _08939_/B VPWR VGND sg13cmos5l_nor2_1
X_08863_ _08864_/B _09280_/Q _08863_/B VPWR VGND sg13cmos5l_xnor2_1
X_07814_ _07920_/D _09077_/Q _07818_/A _07829_/C VPWR VGND sg13cmos5l_and3_1
X_08794_ _08794_/Y hold983/X _08809_/B VPWR VGND sg13cmos5l_nand2_1
X_07745_ _07776_/B _07750_/B _07744_/Y VPWR VGND sg13cmos5l_nor2b_1
X_04957_ _07579_/B hold971/X VPWR VGND sg13cmos5l_inv_1
X_09415_ _09415_/Q clkload21/A _09415_/D _09415_/RESET_B VPWR VGND sg13cmos5l_dfrbpq_1
X_07676_ _07699_/B _07671_/Y _07673_/Y _07674_/X VPWR VGND sg13cmos5l_a21o_1
X_04888_ _08604_/A _09221_/Q VPWR VGND sg13cmos5l_inv_1
X_06627_ _09520_/D _06627_/A _06627_/B VPWR VGND sg13cmos5l_nor2_1
XFILLER_12_128 VPWR VGND sg13cmos5l_fill_2
X_09346_ hold991/A _09387_/CLK _09346_/D _09346_/RESET_B VPWR VGND sg13cmos5l_dfrbpq_1
X_06558_ _09515_/D _06558_/A _06558_/B VPWR VGND sg13cmos5l_and2_1
X_09277_ _09277_/Q _09288_/CLK _09277_/D _09277_/RESET_B VPWR VGND sg13cmos5l_dfrbpq_1
X_05509_ _05514_/A _05509_/A _05509_/B VPWR VGND sg13cmos5l_and2_1
X_06489_ _06498_/A hold1254/X _06495_/B _06527_/A VPWR VGND sg13cmos5l_a21o_1
X_08228_ _09181_/D _08228_/A _08227_/Y VPWR VGND sg13cmos5l_nor2b_1
X_08159_ _08197_/C hold987/A hold992/A _09173_/Q VPWR VGND sg13cmos5l_nand3_1
XFILLER_0_500 VPWR VGND sg13cmos5l_fill_1
XFILLER_17_957 VPWR VGND sg13cmos5l_fill_2
XFILLER_44_743 VPWR VGND sg13cmos5l_fill_1
XFILLER_40_982 VPWR VGND sg13cmos5l_fill_2
X_05860_ _05873_/B _09374_/Q _09375_/Q _09373_/Q _09372_/Q VPWR VGND sg13cmos5l_or4_1
X_05791_ _05832_/A _09409_/Q _05792_/B VPWR VGND sg13cmos5l_xnor2_1
X_07530_ _07530_/X _07501_/A _07528_/Y _07530_/S VPWR VGND sg13cmos5l_mux2_1
X_07461_ _09066_/D _07442_/B _07462_/S _07460_/Y VPWR VGND sg13cmos5l_a21oi_1
X_06412_ _06412_/X _06412_/A _06412_/B VPWR VGND sg13cmos5l_or2_1
X_09200_ _09200_/Q clkload2/A _09200_/D _09200_/RESET_B VPWR VGND sg13cmos5l_dfrbpq_1
X_07392_ _07392_/Y hold990/A hold865/A VPWR VGND sg13cmos5l_xnor2_1
X_06343_ _06367_/S _06349_/A _06349_/B _06349_/C VPWR VGND sg13cmos5l_or3_1
X_09131_ hold911/A clkload16/A _09131_/D _09131_/RESET_B VPWR VGND sg13cmos5l_dfrbpq_1
X_09062_ _09062_/Q clkload17/A _09062_/D _09062_/RESET_B VPWR VGND sg13cmos5l_dfrbpq_1
X_06274_ _06276_/B _06102_/B _06156_/B _06281_/B VPWR VGND sg13cmos5l_mux2_1
X_05225_ _05225_/Y _05134_/Y _05238_/B _05223_/Y VPWR VGND sg13cmos5l_a21oi_1
X_09067__412 _09067_/RESET_B VPWR VGND sg13cmos5l_tiehi
X_08013_ _08013_/Y _08037_/B _08038_/B VPWR VGND sg13cmos5l_nor2_1
X_05156_ _05159_/B _05156_/A _05156_/B VPWR VGND sg13cmos5l_xor2_1
X_05087_ _05111_/B _09293_/Q _05105_/B VPWR VGND sg13cmos5l_nand2b_1
Xhold1300 _05488_/A _09354_/Q VPWR VGND sg13cmos5l_dlygate4sd3_1
X_08915_ _08915_/Y _08911_/A _08911_/B _08914_/X VPWR VGND sg13cmos5l_o21ai_1
Xhold1311 _08524_/A _09246_/Q VPWR VGND sg13cmos5l_dlygate4sd3_1
X_08846_ _08846_/Y _08844_/Y _08845_/Y _08843_/Y VPWR VGND sg13cmos5l_a21oi_1
Xhold1322 _05244_/B _05243_/Y VPWR VGND sg13cmos5l_dlygate4sd3_1
Xhold1333 hold1333/X _09434_/Q VPWR VGND sg13cmos5l_dlygate4sd3_1
Xhold1377 _06894_/A _09527_/Q VPWR VGND sg13cmos5l_dlygate4sd3_1
Xhold1344 hold1344/X _06618_/Y VPWR VGND sg13cmos5l_dlygate4sd3_1
Xhold1355 _06517_/A _09506_/Q VPWR VGND sg13cmos5l_dlygate4sd3_1
Xhold1366 hold1366/X _09396_/Q VPWR VGND sg13cmos5l_dlygate4sd3_1
Xhold1388 hold1388/X _09298_/Q VPWR VGND sg13cmos5l_dlygate4sd3_1
X_08777_ _08913_/B _08741_/Y _08774_/B _05207_/A VPWR VGND sg13cmos5l_a21oi_1
Xhold1399 _05470_/A _09356_/Q VPWR VGND sg13cmos5l_dlygate4sd3_1
X_05989_ _06030_/A _06024_/A _05989_/B VPWR VGND sg13cmos5l_and2_1
X_07728_ _07746_/B _09109_/Q _09108_/Q _09110_/Q VPWR VGND sg13cmos5l_or3_1
X_09074__405 _09074_/RESET_B VPWR VGND sg13cmos5l_tiehi
X_07659_ _07660_/B _07661_/B hold1353/X VPWR VGND sg13cmos5l_nor2b_1
X_09329_ _09329_/Q clkload12/A _09329_/D _09329_/RESET_B VPWR VGND sg13cmos5l_dfrbpq_1
XFILLER_49_1022 VPWR VGND sg13cmos5l_decap_8
X_09603__524 _09603_/RESET_B VPWR VGND sg13cmos5l_tiehi
XFILLER_48_312 VPWR VGND sg13cmos5l_fill_1
XFILLER_16_220 VPWR VGND sg13cmos5l_fill_2
XFILLER_31_234 VPWR VGND sg13cmos5l_fill_1
XFILLER_8_463 VPWR VGND sg13cmos5l_fill_1
X_05010_ _05054_/A _05015_/A VPWR VGND sg13cmos5l_inv_1
X_09261__800 _09261_/RESET_B VPWR VGND sg13cmos5l_tiehi
X_06961_ _06961_/Y _06953_/X _06956_/Y _06960_/Y VPWR VGND sg13cmos5l_a21oi_1
X_08700_ _08701_/B _08672_/Y _08699_/B _08699_/Y VPWR VGND sg13cmos5l_a21oi_1
X_05912_ _05912_/Y _06219_/A _09379_/Q VPWR VGND sg13cmos5l_nor2_1
X_08631_ _08631_/Y _09196_/Q _09195_/Q _08643_/B VPWR VGND sg13cmos5l_nor3_1
XFILLER_12_0 VPWR VGND sg13cmos5l_fill_1
X_06892_ _06892_/Y _09529_/Q _09528_/Q _06905_/B VPWR VGND sg13cmos5l_nor3_1
X_05843_ _05843_/X _05843_/A _05847_/A _05843_/C _05847_/C VPWR VGND sg13cmos5l_and4_1
X_08562_ _08562_/Y _09199_/Q _08568_/B VPWR VGND sg13cmos5l_nand2_1
X_05774_ _09398_/D _05743_/A _05779_/A _05773_/Y VPWR VGND sg13cmos5l_a21oi_1
X_07513_ _09070_/D _07636_/B _07513_/B VPWR VGND sg13cmos5l_nor2_1
X_08493_ _08535_/A _08500_/B _08492_/Y VPWR VGND sg13cmos5l_nor2b_1
XFILLER_23_713 VPWR VGND sg13cmos5l_fill_1
X_07444_ _07444_/Y _07441_/Y _07443_/Y _07429_/Y VPWR VGND sg13cmos5l_a21oi_1
Xfanout38 _06716_/B _06723_/B VPWR VGND sg13cmos5l_buf_1
Xfanout27 _06456_/S _06447_/Y VPWR VGND sg13cmos5l_buf_1
Xfanout49 fanout49/X fanout52/X VPWR VGND sg13cmos5l_buf_1
X_07375_ _09051_/D _07383_/A hold957/X VPWR VGND sg13cmos5l_and2_1
X_09114_ _09114_/Q clkload6/A _09114_/D _09114_/RESET_B VPWR VGND sg13cmos5l_dfrbpq_1
X_06326_ _06646_/A _09513_/Q _09512_/Q VPWR VGND sg13cmos5l_xnor2_1
X_06257_ _06257_/Y _06257_/A _06281_/B VPWR VGND sg13cmos5l_nor2_1
X_09045_ hold971/A clkload16/A hold972/X _09045_/RESET_B VPWR VGND sg13cmos5l_dfrbpq_1
X_05208_ _05242_/A _08942_/A VPWR VGND sg13cmos5l_inv_1
X_06188_ _06188_/Y _04975_/Y _06182_/Y _06187_/Y _04974_/Y VPWR VGND sg13cmos5l_a22oi_1
X_05139_ _05139_/Y _09261_/Q _05146_/A VPWR VGND sg13cmos5l_xnor2_1
Xhold1130 _04984_/A _09382_/Q VPWR VGND sg13cmos5l_dlygate4sd3_1
Xhold1141 _09345_/D _05430_/Y VPWR VGND sg13cmos5l_dlygate4sd3_1
Xhold1174 _04904_/A _09104_/Q VPWR VGND sg13cmos5l_dlygate4sd3_1
Xhold1163 _04953_/A _09049_/Q VPWR VGND sg13cmos5l_dlygate4sd3_1
X_08829_ _09270_/D _08995_/A hold932/X VPWR VGND sg13cmos5l_and2_1
Xhold1152 _04972_/A _09459_/Q VPWR VGND sg13cmos5l_dlygate4sd3_1
Xhold1185 _04923_/A _09031_/Q VPWR VGND sg13cmos5l_dlygate4sd3_1
Xhold1196 _06957_/A _09591_/Q VPWR VGND sg13cmos5l_dlygate4sd3_1
X_09238__824 _09238_/RESET_B VPWR VGND sg13cmos5l_tiehi
XFILLER_13_201 VPWR VGND sg13cmos5l_fill_1
Xclkload19 clkload19/Y clkload19/A VPWR VGND sg13cmos5l_inv_2
XFILLER_5_455 VPWR VGND sg13cmos5l_fill_1
XFILLER_1_661 VPWR VGND sg13cmos5l_fill_2
X_09126__350 _09126_/RESET_B VPWR VGND sg13cmos5l_tiehi
XFILLER_48_153 VPWR VGND sg13cmos5l_fill_1
X_09538__562 _09538_/RESET_B VPWR VGND sg13cmos5l_tiehi
X_09057__422 _09057_/RESET_B VPWR VGND sg13cmos5l_tiehi
X_05490_ _05497_/B _05320_/B _05374_/B _05508_/B VPWR VGND sg13cmos5l_mux2_1
X_07160_ _07160_/Y _07164_/B _08870_/A VPWR VGND sg13cmos5l_nand2_1
X_06111_ _06111_/Y _06083_/Y _06084_/Y _06110_/Y VPWR VGND sg13cmos5l_a21oi_1
X_07091_ hold897/A hold896/X _07091_/B VPWR VGND sg13cmos5l_nor2_1
X_06042_ _09438_/D _06042_/A _06042_/B VPWR VGND sg13cmos5l_nor2_1
X_09064__415 _09064_/RESET_B VPWR VGND sg13cmos5l_tiehi
Xfanout206 fanout206/X fanout217/X VPWR VGND sg13cmos5l_buf_1
Xfanout217 fanout217/X input1/X VPWR VGND sg13cmos5l_buf_1
X_07993_ _07993_/Y _08315_/A _08033_/A _08038_/A _08314_/A VPWR VGND sg13cmos5l_a22oi_1
X_06944_ _06957_/B _09592_/Q _04964_/Y _06943_/Y VPWR VGND sg13cmos5l_a21oi_1
X_06875_ _07022_/A _06876_/B _06876_/C _06874_/Y VPWR VGND sg13cmos5l_a21o_1
X_05826_ _05826_/Y _05826_/A _05826_/B VPWR VGND sg13cmos5l_nor2_1
X_09594_ _09594_/Q _09595_/CLK _09594_/D _09594_/RESET_B VPWR VGND sg13cmos5l_dfrbpq_1
X_08614_ _08689_/C _09238_/Q _09209_/Q _09240_/Q VPWR VGND sg13cmos5l_nand3_1
XFILLER_42_318 VPWR VGND sg13cmos5l_fill_1
X_08545_ _08577_/B _09250_/Q _09202_/Q VPWR VGND sg13cmos5l_nor2_1
X_05757_ _05757_/Y _05739_/A _05739_/B _05750_/X _05755_/Y _05756_/Y VPWR VGND sg13cmos5l_a221oi_1
X_09071__408 _09071_/RESET_B VPWR VGND sg13cmos5l_tiehi
X_08476_ _08476_/Y _08461_/A _08476_/B _08476_/C VPWR VGND sg13cmos5l_nand3b_1
X_05688_ _09385_/D _04840_/Y fanout48/X _05687_/Y VPWR VGND sg13cmos5l_a21oi_1
X_07427_ _07429_/B _07326_/B _07447_/B _07426_/Y VPWR VGND sg13cmos5l_a21oi_1
X_07358_ _07358_/Y _04954_/Y _07353_/Y _07357_/Y VPWR VGND sg13cmos5l_o21ai_1
X_06309_ _06311_/B _09483_/Q _06323_/B VPWR VGND sg13cmos5l_nor2b_1
X_07289_ _07324_/A _09567_/Q _09566_/Q _07301_/B VPWR VGND sg13cmos5l_or3_1
XFILLER_3_915 VPWR VGND sg13cmos5l_fill_2
X_09028_ _09028_/Q clkload8/A _09028_/D _09028_/RESET_B VPWR VGND sg13cmos5l_dfrbpq_1
XFILLER_46_1025 VPWR VGND sg13cmos5l_decap_4
XFILLER_45_156 VPWR VGND sg13cmos5l_fill_1
X_09251__810 _09251_/RESET_B VPWR VGND sg13cmos5l_tiehi
X_09499__605 _09499_/RESET_B VPWR VGND sg13cmos5l_tiehi
X_04990_ _04990_/Y _04990_/A VPWR VGND sg13cmos5l_inv_1
Xinput6 input6/X ui_in[4] VPWR VGND sg13cmos5l_buf_1
Xheichips26_dna_sequencer_848 uio_oe[5] VPWR VGND sg13cmos5l_tiehi
X_06660_ _06660_/Y _06674_/A _06670_/C VPWR VGND sg13cmos5l_nand2_1
X_05611_ _05611_/Y _05322_/A _05630_/B _05609_/X _05286_/A VPWR VGND sg13cmos5l_a22oi_1
X_06591_ _06591_/X _06596_/B _06596_/C VPWR VGND sg13cmos5l_and2_1
X_08330_ _08427_/D _08302_/Y _08322_/Y _08019_/Y VPWR VGND sg13cmos5l_o21ai_1
XFILLER_32_340 VPWR VGND sg13cmos5l_fill_1
X_05542_ _05586_/A _05968_/A _05542_/B VPWR VGND sg13cmos5l_nand2_1
X_05473_ _05473_/Y _05509_/A _05508_/A VPWR VGND sg13cmos5l_nor2_1
X_08261_ _08293_/A _09188_/Q _08261_/B VPWR VGND sg13cmos5l_xor2_1
X_07212_ _07215_/B hold952/X _07212_/B VPWR VGND sg13cmos5l_xnor2_1
X_08192_ _08194_/B _08201_/A VPWR VGND sg13cmos5l_inv_1
X_09408__702 _09408_/RESET_B VPWR VGND sg13cmos5l_tiehi
X_07143_ _07143_/Y _07137_/X _08784_/B _07141_/Y _07142_/X VPWR VGND sg13cmos5l_a22oi_1
X_07074_ _09592_/D _07057_/Y _07073_/Y _07070_/A VPWR VGND sg13cmos5l_a21oi_1
X_06025_ _06025_/Y _06025_/A _06025_/B VPWR VGND sg13cmos5l_nand2_1
X_07976_ _07977_/C _09146_/Q _09147_/Q _09148_/Q VPWR VGND sg13cmos5l_o21ai_1
X_06927_ _06928_/B _06894_/X _06623_/B _06927_/S VPWR VGND sg13cmos5l_mux2_1
X_06858_ _06858_/Y _06850_/Y _06883_/B _06853_/Y VPWR VGND sg13cmos5l_a21oi_1
X_05809_ _05809_/X _09407_/Q _05809_/B VPWR VGND sg13cmos5l_xor2_1
X_09577_ _09577_/Q _09586_/CLK hold894/X _09577_/RESET_B VPWR VGND sg13cmos5l_dfrbpq_1
X_06789_ _06789_/Y _06789_/A _06798_/B _06789_/C VPWR VGND sg13cmos5l_nor3_1
X_08528_ _09223_/D _08603_/B _08528_/B VPWR VGND sg13cmos5l_nor2_1
X_08459_ _08464_/A _08459_/A _08434_/B VPWR VGND sg13cmos5l_nor2b_1
X_09116__360 _09116_/RESET_B VPWR VGND sg13cmos5l_tiehi
Xclkbuf_3_3__f_clk clkload0/A clkbuf_0_clk/X VPWR VGND sg13cmos5l_buf_8
XFILLER_2_288 VPWR VGND sg13cmos5l_fill_1
XFILLER_47_900 VPWR VGND sg13cmos5l_fill_1
X_09123__353 _09123_/RESET_B VPWR VGND sg13cmos5l_tiehi
XFILLER_18_134 VPWR VGND sg13cmos5l_fill_1
XFILLER_20_1017 VPWR VGND sg13cmos5l_fill_2
XFILLER_47_999 VPWR VGND sg13cmos5l_decap_4
XFILLER_46_454 VPWR VGND sg13cmos5l_decap_4
XFILLER_46_487 VPWR VGND sg13cmos5l_decap_4
X_09061__418 _09061_/RESET_B VPWR VGND sg13cmos5l_tiehi
X_07830_ _07950_/A _07528_/Y _07812_/Y _07829_/Y VPWR VGND sg13cmos5l_o21ai_1
X_07761_ _07920_/A _07772_/B _07772_/C _07760_/Y VPWR VGND sg13cmos5l_a21oi_1
XFILLER_38_922 VPWR VGND sg13cmos5l_fill_1
X_04973_ _06194_/A _06191_/B VPWR VGND sg13cmos5l_inv_1
X_06712_ _06723_/B _09535_/Q _06710_/B _06709_/X _06711_/Y VPWR VGND sg13cmos5l_a22oi_1
X_09500_ hold925/A _09503_/CLK _09500_/D _09500_/RESET_B VPWR VGND sg13cmos5l_dfrbpq_1
XFILLER_38_944 VPWR VGND sg13cmos5l_fill_1
X_07692_ _07695_/A _07692_/A _07698_/B _07692_/C VPWR VGND sg13cmos5l_nor3_1
XFILLER_24_104 VPWR VGND sg13cmos5l_fill_1
X_09431_ _09431_/Q clkload18/A _09431_/D _09431_/RESET_B VPWR VGND sg13cmos5l_dfrbpq_1
X_06643_ _06667_/B _09486_/Q _06643_/B VPWR VGND sg13cmos5l_xor2_1
X_06574_ _06624_/A _09520_/Q _06574_/B VPWR VGND sg13cmos5l_xor2_1
X_09362_ _09362_/Q clkload12/A _09362_/D _09362_/RESET_B VPWR VGND sg13cmos5l_dfrbpq_1
X_08313_ _08314_/B _09157_/Q _08313_/B VPWR VGND sg13cmos5l_xor2_1
X_05525_ _09362_/D _05486_/B _05517_/B _05524_/Y VPWR VGND sg13cmos5l_a21oi_1
X_09293_ _09293_/Q clkload10/A _09293_/D _09293_/RESET_B VPWR VGND sg13cmos5l_dfrbpq_1
XFILLER_20_310 VPWR VGND sg13cmos5l_fill_1
XFILLER_32_181 VPWR VGND sg13cmos5l_fill_1
X_08244_ _08271_/B _09189_/Q _08245_/B VPWR VGND sg13cmos5l_nor2b_1
X_05456_ _05487_/B _05466_/A _05466_/B VPWR VGND sg13cmos5l_and2_1
X_08175_ _08175_/Y _08175_/A _08175_/B _08175_/C _08175_/D VPWR VGND sg13cmos5l_nand4_1
XFILLER_20_376 VPWR VGND sg13cmos5l_fill_1
X_05387_ _05387_/Y _09359_/Q _05387_/B VPWR VGND sg13cmos5l_nand2_1
X_07126_ _07159_/B _07126_/A _07154_/A VPWR VGND sg13cmos5l_xnor2_1
X_07057_ _07057_/Y _07057_/A _07028_/B VPWR VGND sg13cmos5l_nor2b_1
XFILLER_0_726 VPWR VGND sg13cmos5l_fill_2
X_09241__820 _09241_/RESET_B VPWR VGND sg13cmos5l_tiehi
X_06008_ _06009_/B _06008_/A _06008_/B VPWR VGND sg13cmos5l_nor2_1
X_07959_ _07959_/Y _07955_/A _07972_/C _07959_/C VPWR VGND sg13cmos5l_nand3b_1
XFILLER_46_67 VPWR VGND sg13cmos5l_fill_2
XFILLER_44_925 VPWR VGND sg13cmos5l_fill_1
XFILLER_44_914 VPWR VGND sg13cmos5l_fill_1
XFILLER_44_947 VPWR VGND sg13cmos5l_decap_8
XFILLER_43_435 VPWR VGND sg13cmos5l_fill_2
XFILLER_43_446 VPWR VGND sg13cmos5l_decap_8
X_09489__615 _09489_/RESET_B VPWR VGND sg13cmos5l_tiehi
XFILLER_7_303 VPWR VGND sg13cmos5l_decap_4
X_09496__608 _09496_/RESET_B VPWR VGND sg13cmos5l_tiehi
X_09197__273 _09197_/RESET_B VPWR VGND sg13cmos5l_tiehi
XFILLER_35_925 VPWR VGND sg13cmos5l_fill_1
X_05310_ _05310_/Y _05310_/A _05331_/B VPWR VGND sg13cmos5l_nand2_1
X_06290_ _06290_/Y _06291_/B VPWR VGND sg13cmos5l_inv_1
X_05241_ _05241_/Y _05218_/Y _05235_/Y _05240_/X VPWR VGND sg13cmos5l_o21ai_1
X_05172_ _05175_/C _05176_/B _05194_/C _08761_/A VPWR VGND sg13cmos5l_a21o_1
X_09405__705 _09405_/RESET_B VPWR VGND sg13cmos5l_tiehi
XFILLER_42_0 VPWR VGND sg13cmos5l_fill_2
Xhold859 hold859/X hold859/A VPWR VGND sg13cmos5l_dlygate4sd3_1
X_08931_ _09289_/D _08931_/A _09001_/B VPWR VGND sg13cmos5l_nor2_1
X_08862_ _08928_/A _08907_/A _08862_/B VPWR VGND sg13cmos5l_and2_1
X_07813_ _07920_/C _07818_/A _07829_/C _07509_/Y VPWR VGND sg13cmos5l_a21oi_1
X_09106__370 _09106_/RESET_B VPWR VGND sg13cmos5l_tiehi
X_08793_ _08793_/Y _09288_/Q _05003_/Y _08792_/Y VPWR VGND sg13cmos5l_a21oi_1
X_07744_ _07744_/Y _09142_/Q _09141_/Q _09143_/Q VPWR VGND sg13cmos5l_o21ai_1
X_04956_ _04956_/Y _07590_/A VPWR VGND sg13cmos5l_inv_1
X_07675_ _07693_/S _07671_/Y _07673_/Y _07674_/X VPWR VGND sg13cmos5l_a21oi_1
XFILLER_26_958 VPWR VGND sg13cmos5l_fill_1
X_09414_ _09414_/Q clkload21/A _09414_/D _09414_/RESET_B VPWR VGND sg13cmos5l_dfrbpq_1
XFILLER_41_906 VPWR VGND sg13cmos5l_fill_2
X_04887_ _08601_/A _08358_/A VPWR VGND sg13cmos5l_inv_1
XFILLER_16_48 VPWR VGND sg13cmos5l_fill_1
X_06626_ _06626_/X _06630_/S _06624_/Y _06623_/Y VPWR VGND sg13cmos5l_a21o_1
XFILLER_13_619 VPWR VGND sg13cmos5l_fill_1
X_06557_ _06558_/B _06538_/B _06534_/Y _06557_/S VPWR VGND sg13cmos5l_mux2_1
Xclkbuf_leaf_32_clk clkload16/A clkbuf_3_4__f_clk/X VPWR VGND sg13cmos5l_buf_8
X_09345_ _09345_/Q clkload19/A _09345_/D _09345_/RESET_B VPWR VGND sg13cmos5l_dfrbpq_1
X_09276_ hold870/A _09608_/CLK _09276_/D _09276_/RESET_B VPWR VGND sg13cmos5l_dfrbpq_1
X_05508_ _05509_/B _05508_/A _05508_/B VPWR VGND sg13cmos5l_nand2_1
X_06488_ _06527_/A _06526_/B _06526_/C _06526_/A VPWR VGND sg13cmos5l_a21oi_1
X_08227_ _08227_/Y _08188_/B _08229_/B _08231_/A VPWR VGND sg13cmos5l_a21oi_1
X_05439_ hold942/A _04813_/Y fanout56/X _05438_/Y VPWR VGND sg13cmos5l_a21oi_1
X_09113__363 _09113_/RESET_B VPWR VGND sg13cmos5l_tiehi
X_09269__764 _09269_/RESET_B VPWR VGND sg13cmos5l_tiehi
XFILLER_4_339 VPWR VGND sg13cmos5l_fill_2
X_08158_ _08197_/B _09172_/Q _08171_/B VPWR VGND sg13cmos5l_nand2_1
X_08089_ _08089_/Y _08397_/A _09122_/Q VPWR VGND sg13cmos5l_nand2b_1
X_07109_ _07110_/A _09598_/Q _09597_/Q _09605_/Q VPWR VGND sg13cmos5l_o21ai_1
XFILLER_0_556 VPWR VGND sg13cmos5l_decap_8
X_09120__356 _09120_/RESET_B VPWR VGND sg13cmos5l_tiehi
XFILLER_29_763 VPWR VGND sg13cmos5l_fill_1
Xclkbuf_leaf_23_clk _09575_/CLK clkbuf_3_4__f_clk/X VPWR VGND sg13cmos5l_buf_8
XFILLER_25_991 VPWR VGND sg13cmos5l_fill_2
XFILLER_4_873 VPWR VGND sg13cmos5l_fill_1
XFILLER_3_372 VPWR VGND sg13cmos5l_decap_4
XFILLER_14_4 VPWR VGND sg13cmos5l_fill_2
X_05790_ _05792_/B _09406_/Q _09407_/Q _09408_/Q _05843_/A VPWR VGND sg13cmos5l_nor4_1
X_07460_ _07460_/Y _07442_/A _07462_/S _07464_/B1 VPWR VGND sg13cmos5l_o21ai_1
X_07391_ _07430_/A _09054_/Q hold876/A VPWR VGND sg13cmos5l_nand2_1
X_06411_ _09489_/D _06473_/B _06513_/A VPWR VGND sg13cmos5l_and2_1
X_06342_ _06349_/C _06325_/Y _06340_/Y _06341_/Y _06320_/B VPWR VGND sg13cmos5l_a22oi_1
X_09130_ hold916/A clkload16/A _09130_/D _09130_/RESET_B VPWR VGND sg13cmos5l_dfrbpq_1
Xclkbuf_leaf_14_clk clkload18/A clkbuf_3_6__f_clk/X VPWR VGND sg13cmos5l_buf_8
X_09061_ _09061_/Q clkload17/A _09061_/D _09061_/RESET_B VPWR VGND sg13cmos5l_dfrbpq_1
XFILLER_31_983 VPWR VGND sg13cmos5l_decap_4
XFILLER_33_1027 VPWR VGND sg13cmos5l_fill_2
X_06273_ _06273_/Y _06276_/A VPWR VGND sg13cmos5l_inv_1
X_08012_ _08174_/A _08026_/B _08012_/B VPWR VGND sg13cmos5l_nand2_1
X_05224_ _05224_/X _05134_/Y _05238_/B _05223_/Y VPWR VGND sg13cmos5l_a21o_1
X_05155_ _08742_/A _09000_/A _05155_/B VPWR VGND sg13cmos5l_xnor2_1
X_05086_ _05105_/B _09289_/Q _09290_/Q _09291_/Q _09292_/Q VPWR VGND sg13cmos5l_nor4_1
X_09479__625 _09479_/RESET_B VPWR VGND sg13cmos5l_tiehi
X_08914_ _08914_/X _08928_/A _08928_/B _08929_/A VPWR VGND sg13cmos5l_or3_1
Xhold1334 hold1334/X _09244_/Q VPWR VGND sg13cmos5l_dlygate4sd3_1
Xhold1323 _08683_/A _09240_/Q VPWR VGND sg13cmos5l_dlygate4sd3_1
X_08845_ _08845_/Y hold976/A hold891/A VPWR VGND sg13cmos5l_xnor2_1
Xhold1301 _05489_/B _05488_/Y VPWR VGND sg13cmos5l_dlygate4sd3_1
Xhold1312 _06009_/A _09430_/Q VPWR VGND sg13cmos5l_dlygate4sd3_1
X_08776_ _09255_/D _08784_/C _08873_/B VPWR VGND sg13cmos5l_nor2_1
Xhold1345 hold1345/X _09139_/Q VPWR VGND sg13cmos5l_dlygate4sd3_1
Xhold1356 _06518_/B _06517_/X VPWR VGND sg13cmos5l_dlygate4sd3_1
Xhold1367 _09400_/D _05778_/Y VPWR VGND sg13cmos5l_dlygate4sd3_1
Xhold1389 hold1389/X _09474_/Q VPWR VGND sg13cmos5l_dlygate4sd3_1
X_07727_ _07780_/A _08149_/A _07727_/B VPWR VGND sg13cmos5l_nand2_1
Xhold1378 _08014_/A _09146_/Q VPWR VGND sg13cmos5l_dlygate4sd3_1
XFILLER_27_47 VPWR VGND sg13cmos5l_fill_2
X_05988_ _05989_/B _05990_/B hold1333/X VPWR VGND sg13cmos5l_nor2b_1
X_04939_ _04939_/Y _08353_/B VPWR VGND sg13cmos5l_inv_1
X_07658_ _07658_/Y _07698_/B _07657_/X VPWR VGND sg13cmos5l_nor2b_1
XFILLER_40_224 VPWR VGND sg13cmos5l_fill_2
X_07589_ _07589_/Y _07589_/A _07589_/B VPWR VGND sg13cmos5l_nand2_1
X_06609_ _09517_/D _06609_/A _06818_/A VPWR VGND sg13cmos5l_nor2_1
XFILLER_43_57 VPWR VGND sg13cmos5l_fill_1
X_09486__618 _09486_/RESET_B VPWR VGND sg13cmos5l_tiehi
X_09328_ _09328_/Q clkload12/A _09328_/D _09328_/RESET_B VPWR VGND sg13cmos5l_dfrbpq_1
X_09259_ _09259_/Q clkload9/A _09259_/D _09259_/RESET_B VPWR VGND sg13cmos5l_dfrbpq_1
XFILLER_49_1001 VPWR VGND sg13cmos5l_decap_8
X_09187__283 _09187_/RESET_B VPWR VGND sg13cmos5l_tiehi
X_09347__769 _09347_/RESET_B VPWR VGND sg13cmos5l_tiehi
XFILLER_0_320 VPWR VGND sg13cmos5l_fill_1
XFILLER_49_869 VPWR VGND sg13cmos5l_decap_4
X_09194__276 _09194_/RESET_B VPWR VGND sg13cmos5l_tiehi
XFILLER_17_766 VPWR VGND sg13cmos5l_fill_1
XFILLER_44_585 VPWR VGND sg13cmos5l_fill_2
X_09402__708 _09402_/RESET_B VPWR VGND sg13cmos5l_tiehi
X_06960_ _06960_/Y _04960_/Y _06955_/Y _06959_/Y VPWR VGND sg13cmos5l_o21ai_1
Xclkbuf_leaf_3_clk _09347_/CLK clkbuf_leaf_4_clk/A VPWR VGND sg13cmos5l_buf_8
X_06891_ _06905_/B _09526_/Q _09527_/Q _09524_/Q _09525_/Q VPWR VGND sg13cmos5l_or4_1
X_05911_ _05911_/Y _09378_/Q _09435_/Q VPWR VGND sg13cmos5l_nor2b_1
X_05842_ _05842_/Y _06129_/A _05842_/B VPWR VGND sg13cmos5l_nand2_1
X_08630_ _08643_/B _09193_/Q _09194_/Q _09191_/Q _09192_/Q VPWR VGND sg13cmos5l_or4_1
X_09103__373 _09103_/RESET_B VPWR VGND sg13cmos5l_tiehi
X_08561_ _08566_/A _09230_/Q _08557_/Y _08560_/Y VPWR VGND sg13cmos5l_o21ai_1
X_05773_ _05773_/Y _05744_/X _05779_/A _05696_/B VPWR VGND sg13cmos5l_o21ai_1
X_07512_ _07513_/B _07664_/A _07664_/B VPWR VGND sg13cmos5l_and2_1
X_08492_ _08492_/Y _09247_/Q _08555_/A _09248_/Q VPWR VGND sg13cmos5l_o21ai_1
Xfanout28 _06041_/S _06034_/Y VPWR VGND sg13cmos5l_buf_1
X_07443_ _07443_/Y _07429_/A _07429_/B _07442_/Y VPWR VGND sg13cmos5l_a21oi_1
Xfanout39 fanout39/X _05949_/B VPWR VGND sg13cmos5l_buf_1
X_09113_ _09113_/Q clkload6/A _09113_/D _09113_/RESET_B VPWR VGND sg13cmos5l_dfrbpq_1
X_07374_ _07374_/Y _04952_/Y _07342_/B _07369_/A VPWR VGND sg13cmos5l_a21oi_1
X_06325_ _06325_/Y _06651_/A _06365_/B VPWR VGND sg13cmos5l_nand2b_1
X_06256_ _06256_/X _06266_/B _06266_/C VPWR VGND sg13cmos5l_or2_1
X_09044_ _09044_/Q _09573_/CLK _09044_/D _09044_/RESET_B VPWR VGND sg13cmos5l_dfrbpq_1
X_05207_ _08942_/A _05207_/A hold1332/X VPWR VGND sg13cmos5l_nor2b_1
X_09110__366 _09110_/RESET_B VPWR VGND sg13cmos5l_tiehi
X_06187_ _06187_/Y _06475_/A _06189_/B _06186_/Y VPWR VGND sg13cmos5l_o21ai_1
X_05138_ _05194_/B _09261_/Q _05146_/A VPWR VGND sg13cmos5l_xor2_1
X_05069_ _05230_/C hold941/A hold870/A _09316_/Q VPWR VGND sg13cmos5l_nand3_1
XFILLER_38_13 VPWR VGND sg13cmos5l_fill_1
Xhold1131 hold1131/X _09453_/Q VPWR VGND sg13cmos5l_dlygate4sd3_1
X_09295__429 _09295_/RESET_B VPWR VGND sg13cmos5l_tiehi
Xhold1142 _04995_/A _09304_/Q VPWR VGND sg13cmos5l_dlygate4sd3_1
Xhold1120 _09458_/D _06206_/Y VPWR VGND sg13cmos5l_dlygate4sd3_1
Xhold1175 _07473_/B _09107_/Q VPWR VGND sg13cmos5l_dlygate4sd3_1
Xhold1164 _09049_/D _07373_/Y VPWR VGND sg13cmos5l_dlygate4sd3_1
XFILLER_18_519 VPWR VGND sg13cmos5l_fill_2
X_08828_ _08828_/Y _04998_/Y _08813_/B _08824_/A VPWR VGND sg13cmos5l_a21oi_1
Xhold1153 _09459_/D _06207_/Y VPWR VGND sg13cmos5l_dlygate4sd3_1
X_08759_ _09251_/D _08759_/A _08783_/B VPWR VGND sg13cmos5l_nor2_1
Xhold1186 hold1186/X _09533_/Q VPWR VGND sg13cmos5l_dlygate4sd3_1
Xhold1197 _06737_/A _09511_/Q VPWR VGND sg13cmos5l_dlygate4sd3_1
XFILLER_14_747 VPWR VGND sg13cmos5l_fill_2
XFILLER_41_599 VPWR VGND sg13cmos5l_fill_1
XFILLER_9_228 VPWR VGND sg13cmos5l_fill_2
XFILLER_6_902 VPWR VGND sg13cmos5l_fill_1
XFILLER_10_953 VPWR VGND sg13cmos5l_decap_8
XFILLER_10_964 VPWR VGND sg13cmos5l_fill_1
XFILLER_5_489 VPWR VGND sg13cmos5l_fill_1
XFILLER_49_644 VPWR VGND sg13cmos5l_fill_1
XFILLER_36_316 VPWR VGND sg13cmos5l_fill_2
XFILLER_36_338 VPWR VGND sg13cmos5l_fill_2
X_09469__635 _09469_/RESET_B VPWR VGND sg13cmos5l_tiehi
XFILLER_20_717 VPWR VGND sg13cmos5l_fill_2
X_06110_ _06110_/Y _06394_/A _06390_/A VPWR VGND sg13cmos5l_nand2_1
X_07090_ _07091_/B _07079_/Y _07087_/Y _08479_/B VPWR VGND sg13cmos5l_o21ai_1
X_06041_ _06042_/B _06007_/A _06006_/Y _06041_/S VPWR VGND sg13cmos5l_mux2_1
X_07992_ _08314_/A _08400_/A _07992_/B VPWR VGND sg13cmos5l_xnor2_1
Xfanout207 _07383_/A fanout211/X VPWR VGND sg13cmos5l_buf_1
X_09476__628 _09476_/RESET_B VPWR VGND sg13cmos5l_tiehi
X_06943_ _06943_/Y _07390_/A _09535_/Q hold961/A _07389_/A _06942_/Y VPWR VGND sg13cmos5l_a221oi_1
X_06874_ _06874_/Y _07298_/A _06883_/B VPWR VGND sg13cmos5l_nand2_1
X_05825_ _05825_/Y _05818_/X _05822_/X _05816_/Y VPWR VGND sg13cmos5l_o21ai_1
XFILLER_39_187 VPWR VGND sg13cmos5l_fill_2
X_08613_ _08689_/B _09239_/Q _08622_/B VPWR VGND sg13cmos5l_nand2_1
X_09593_ _09593_/Q clkload3/A _09593_/D _09593_/RESET_B VPWR VGND sg13cmos5l_dfrbpq_1
X_09337__779 _09337_/RESET_B VPWR VGND sg13cmos5l_tiehi
X_05756_ _05756_/Y _05756_/A _05756_/B VPWR VGND sg13cmos5l_nor2_1
X_08544_ _09227_/D _08599_/B _08702_/A VPWR VGND sg13cmos5l_and2_1
XFILLER_36_861 VPWR VGND sg13cmos5l_fill_2
X_09177__293 _09177_/RESET_B VPWR VGND sg13cmos5l_tiehi
X_08475_ _09220_/D _08458_/B fanout21/X _08474_/Y VPWR VGND sg13cmos5l_a21oi_1
XFILLER_24_48 VPWR VGND sg13cmos5l_fill_2
X_05687_ _05687_/Y hold968/X fanout48/X _05693_/A VPWR VGND sg13cmos5l_o21ai_1
X_07426_ _07426_/Y _07426_/A _07447_/B VPWR VGND sg13cmos5l_nor2_1
X_07357_ _07357_/Y _07360_/B _09049_/Q VPWR VGND sg13cmos5l_nand2b_1
X_06308_ _06323_/B _09480_/Q _09479_/Q _09481_/Q _09482_/Q VPWR VGND sg13cmos5l_nor4_1
X_09027_ _09027_/Q clkload9/A _09027_/D _09027_/RESET_B VPWR VGND sg13cmos5l_dfrbpq_1
X_07288_ _07288_/Y _09567_/Q _09566_/Q _07301_/B VPWR VGND sg13cmos5l_nor3_1
X_06239_ _06279_/B _06288_/A _06238_/Y VPWR VGND sg13cmos5l_nor2b_1
XFILLER_2_437 VPWR VGND sg13cmos5l_fill_2
XFILLER_2_448 VPWR VGND sg13cmos5l_fill_1
X_09184__286 _09184_/RESET_B VPWR VGND sg13cmos5l_tiehi
X_09596__487 _09596_/RESET_B VPWR VGND sg13cmos5l_tiehi
XFILLER_45_102 VPWR VGND sg13cmos5l_fill_2
X_09191__279 _09191_/RESET_B VPWR VGND sg13cmos5l_tiehi
XFILLER_2_982 VPWR VGND sg13cmos5l_fill_1
Xinput7 input7/X ui_in[5] VPWR VGND sg13cmos5l_buf_1
Xheichips26_dna_sequencer_849 uio_oe[6] VPWR VGND sg13cmos5l_tiehi
X_05610_ _05610_/Y _09337_/Q _05610_/B VPWR VGND sg13cmos5l_xnor2_1
XFILLER_24_308 VPWR VGND sg13cmos5l_fill_2
X_09100__376 _09100_/RESET_B VPWR VGND sg13cmos5l_tiehi
X_06590_ _06596_/C _06589_/B _06589_/C _06589_/A VPWR VGND sg13cmos5l_a21o_1
X_05541_ _05887_/A _05968_/A _05542_/B VPWR VGND sg13cmos5l_and2_1
X_08260_ _08260_/Y _08289_/B _08259_/Y _08256_/Y VPWR VGND sg13cmos5l_o21ai_1
XFILLER_20_514 VPWR VGND sg13cmos5l_fill_1
X_05472_ _05486_/A _05503_/B _05472_/B VPWR VGND sg13cmos5l_nor2_1
X_08191_ _08201_/A _08207_/B _08191_/B VPWR VGND sg13cmos5l_nor2_1
X_07211_ _09025_/D _08234_/A _07211_/B _07211_/C VPWR VGND sg13cmos5l_nor3_1
X_07142_ _07142_/X _09011_/Q _07142_/B VPWR VGND sg13cmos5l_xor2_1
X_07073_ _07073_/Y _07073_/A _07073_/B VPWR VGND sg13cmos5l_nand2_1
X_06024_ _06027_/A _06024_/A _06024_/B _06024_/C VPWR VGND sg13cmos5l_nor3_1
X_07975_ _07987_/B _09146_/Q _09147_/Q _09148_/Q VPWR VGND sg13cmos5l_or3_1
X_06926_ _09564_/D _06932_/A _06926_/B VPWR VGND sg13cmos5l_nor2_1
X_06857_ _06857_/Y _06850_/Y _06855_/Y _06856_/Y VPWR VGND sg13cmos5l_a21oi_1
X_05808_ _05852_/B _09407_/Q _05809_/B VPWR VGND sg13cmos5l_xnor2_1
XFILLER_27_157 VPWR VGND sg13cmos5l_fill_1
XFILLER_43_639 VPWR VGND sg13cmos5l_fill_2
X_09576_ _09576_/Q clkload13/A hold914/X _09576_/RESET_B VPWR VGND sg13cmos5l_dfrbpq_1
X_06788_ _06789_/C _06788_/A _06788_/B _06788_/C VPWR VGND sg13cmos5l_and3_1
X_05739_ _05739_/Y _05739_/A _05739_/B VPWR VGND sg13cmos5l_nor2_1
X_08527_ _08528_/B _08661_/A _08661_/B VPWR VGND sg13cmos5l_and2_1
X_08458_ _08458_/Y _08458_/A _08458_/B VPWR VGND sg13cmos5l_nor2_1
X_07409_ _07436_/A _07430_/B _07446_/B _07409_/C VPWR VGND sg13cmos5l_nor3_1
X_08389_ _08389_/Y hold949/X fanout48/X _08394_/A VPWR VGND sg13cmos5l_o21ai_1
X_09528__573 _09528_/RESET_B VPWR VGND sg13cmos5l_tiehi
XFILLER_47_945 VPWR VGND sg13cmos5l_fill_1
XFILLER_46_444 VPWR VGND sg13cmos5l_fill_1
X_09535__566 _09535_/RESET_B VPWR VGND sg13cmos5l_tiehi
X_09054__426 _09054_/RESET_B VPWR VGND sg13cmos5l_tiehi
X_09466__638 _09466_/RESET_B VPWR VGND sg13cmos5l_tiehi
X_09327__789 _09327_/RESET_B VPWR VGND sg13cmos5l_tiehi
X_04972_ _04972_/Y _04972_/A VPWR VGND sg13cmos5l_inv_1
X_07760_ _07760_/Y _07847_/A _07780_/A VPWR VGND sg13cmos5l_nand2_1
X_06711_ _06711_/Y _04965_/Y _06724_/A _06710_/Y VPWR VGND sg13cmos5l_a21oi_1
X_07691_ _07692_/C _07691_/A _07691_/B _07691_/C VPWR VGND sg13cmos5l_and3_1
X_09430_ _09430_/Q _09575_/CLK _09430_/D _09430_/RESET_B VPWR VGND sg13cmos5l_dfrbpq_1
XFILLER_38_978 VPWR VGND sg13cmos5l_fill_1
X_06642_ _06645_/B _06738_/A _06642_/B VPWR VGND sg13cmos5l_nor2_1
X_06573_ _06589_/C _09517_/Q _09518_/Q _09519_/Q _09520_/Q VPWR VGND sg13cmos5l_nor4_1
X_09361_ _09361_/Q _09387_/CLK _09361_/D _09361_/RESET_B VPWR VGND sg13cmos5l_dfrbpq_1
X_09292_ _09292_/Q clkload10/A _09292_/D _09292_/RESET_B VPWR VGND sg13cmos5l_dfrbpq_1
X_08312_ _08316_/A _08305_/X _08309_/Y _08315_/B _08315_/A _08311_/X VPWR VGND sg13cmos5l_a221oi_1
X_09174__296 _09174_/RESET_B VPWR VGND sg13cmos5l_tiehi
XFILLER_21_801 VPWR VGND sg13cmos5l_fill_2
XFILLER_21_812 VPWR VGND sg13cmos5l_fill_1
X_05524_ _05524_/Y _05486_/A _05517_/B _05443_/B VPWR VGND sg13cmos5l_o21ai_1
X_08243_ _08245_/B _09188_/Q _08261_/B VPWR VGND sg13cmos5l_nor2b_1
X_05455_ _05494_/A _05455_/A _05466_/B VPWR VGND sg13cmos5l_xnor2_1
X_05386_ _09339_/D _05385_/A hold1073/X _05378_/A VPWR VGND sg13cmos5l_a21oi_1
X_08174_ _08174_/Y _08174_/A _08174_/B _08174_/C _08174_/D VPWR VGND sg13cmos5l_nand4_1
XFILLER_21_38 VPWR VGND sg13cmos5l_fill_1
X_07125_ _07163_/B _07138_/B _07124_/Y VPWR VGND sg13cmos5l_nor2b_1
X_07056_ _07056_/Y _07034_/Y _07050_/Y _07055_/X VPWR VGND sg13cmos5l_o21ai_1
XFILLER_0_705 VPWR VGND sg13cmos5l_decap_8
X_06007_ _06007_/Y _06007_/A _06007_/B VPWR VGND sg13cmos5l_nor2_1
XFILLER_0_716 VPWR VGND sg13cmos5l_fill_2
X_09181__289 _09181_/RESET_B VPWR VGND sg13cmos5l_tiehi
XFILLER_29_923 VPWR VGND sg13cmos5l_fill_2
X_07958_ _07959_/C _07958_/A _07972_/B VPWR VGND sg13cmos5l_or2_1
X_06909_ _06910_/B _09528_/Q _06905_/B hold1275/X VPWR VGND sg13cmos5l_o21ai_1
X_07889_ _09133_/D _07889_/A hold874/X VPWR VGND sg13cmos5l_and2_1
XFILLER_29_967 VPWR VGND sg13cmos5l_fill_2
X_09559_ _09559_/Q _09565_/CLK _09559_/D _09559_/RESET_B VPWR VGND sg13cmos5l_dfrbpq_1
XFILLER_8_827 VPWR VGND sg13cmos5l_fill_1
XFILLER_3_510 VPWR VGND sg13cmos5l_fill_2
X_09279__563 _09279_/RESET_B VPWR VGND sg13cmos5l_tiehi
XFILLER_46_285 VPWR VGND sg13cmos5l_decap_8
X_05240_ _05240_/X _05240_/A _05240_/B VPWR VGND sg13cmos5l_or2_1
X_05171_ _08761_/A _08728_/A _08751_/A VPWR VGND sg13cmos5l_nor2_1
X_08930_ _09288_/D _08930_/A _08930_/B VPWR VGND sg13cmos5l_nor2_1
X_08861_ _08862_/B _08863_/B _09282_/Q VPWR VGND sg13cmos5l_nor2b_1
X_07812_ _07812_/Y _07812_/A _07812_/B VPWR VGND sg13cmos5l_nor2_1
X_08792_ _08792_/Y _09001_/A _09018_/Q hold922/A _09000_/A _08791_/Y VPWR VGND sg13cmos5l_a221oi_1
X_07743_ _07743_/Y _07746_/B _08056_/A _07743_/C VPWR VGND sg13cmos5l_nand3_1
X_04955_ _07367_/A _04955_/A VPWR VGND sg13cmos5l_inv_1
X_04886_ _08603_/A _04886_/A VPWR VGND sg13cmos5l_inv_1
X_07674_ _07674_/X _07703_/A _07674_/B VPWR VGND sg13cmos5l_and2_1
X_09518__583 _09518_/RESET_B VPWR VGND sg13cmos5l_tiehi
X_09413_ _09413_/Q clkload21/A _09413_/D _09413_/RESET_B VPWR VGND sg13cmos5l_dfrbpq_1
X_06625_ _06627_/B _06630_/S _06624_/Y _06623_/Y VPWR VGND sg13cmos5l_a21oi_1
X_09344_ _09344_/Q clkload18/A _09344_/D _09344_/RESET_B VPWR VGND sg13cmos5l_dfrbpq_1
X_06556_ _09514_/D _06515_/A _06557_/S _06555_/Y VPWR VGND sg13cmos5l_a21oi_1
XFILLER_21_664 VPWR VGND sg13cmos5l_fill_2
X_09275_ hold862/A _09608_/CLK _09275_/D _09275_/RESET_B VPWR VGND sg13cmos5l_dfrbpq_1
X_06487_ _06526_/C hold936/A hold863/A _09506_/Q VPWR VGND sg13cmos5l_nand3_1
X_05507_ _05507_/X _05507_/A _05507_/B VPWR VGND sg13cmos5l_and2_1
X_08226_ _08228_/A _08226_/A _08229_/B VPWR VGND sg13cmos5l_nor2_1
X_05438_ _05438_/Y hold982/A fanout56/X _08134_/A VPWR VGND sg13cmos5l_o21ai_1
XFILLER_5_819 VPWR VGND sg13cmos5l_fill_1
XFILLER_4_307 VPWR VGND sg13cmos5l_fill_1
X_09607__832 _09607_/RESET_B VPWR VGND sg13cmos5l_tiehi
X_08157_ _08189_/B _08167_/A _08169_/A VPWR VGND sg13cmos5l_and2_1
X_05369_ _09334_/D _05378_/A _05369_/B VPWR VGND sg13cmos5l_nor2_1
X_07108_ _09598_/D _08234_/A _07108_/B VPWR VGND sg13cmos5l_nor2_1
X_08088_ _09158_/D _08132_/A _08183_/B VPWR VGND sg13cmos5l_nor2_1
X_09525__576 _09525_/RESET_B VPWR VGND sg13cmos5l_tiehi
XFILLER_0_513 VPWR VGND sg13cmos5l_fill_1
X_07039_ _07039_/X _06873_/B _07053_/B _07038_/Y VPWR VGND sg13cmos5l_a21o_1
XFILLER_43_200 VPWR VGND sg13cmos5l_fill_1
XFILLER_44_734 VPWR VGND sg13cmos5l_decap_8
XFILLER_28_285 VPWR VGND sg13cmos5l_fill_1
XFILLER_43_266 VPWR VGND sg13cmos5l_fill_1
X_09532__569 _09532_/RESET_B VPWR VGND sg13cmos5l_tiehi
XFILLER_19_1020 VPWR VGND sg13cmos5l_fill_1
XFILLER_32_929 VPWR VGND sg13cmos5l_fill_2
XFILLER_40_951 VPWR VGND sg13cmos5l_decap_8
XFILLER_40_995 VPWR VGND sg13cmos5l_fill_2
XFILLER_40_984 VPWR VGND sg13cmos5l_fill_1
XFILLER_3_362 VPWR VGND sg13cmos5l_fill_1
X_09309__261 _09309_/RESET_B VPWR VGND sg13cmos5l_tiehi
XFILLER_47_583 VPWR VGND sg13cmos5l_fill_1
XFILLER_19_296 VPWR VGND sg13cmos5l_fill_1
X_06410_ _06513_/A _06104_/Y _06413_/S _06409_/X VPWR VGND sg13cmos5l_o21ai_1
X_07390_ _09063_/D _07390_/A _07463_/A VPWR VGND sg13cmos5l_nor2_1
X_06341_ _06341_/Y _06341_/A _06652_/B VPWR VGND sg13cmos5l_nand2_1
X_09060_ _09060_/Q clkload17/A _09060_/D _09060_/RESET_B VPWR VGND sg13cmos5l_dfrbpq_1
X_09171__299 _09171_/RESET_B VPWR VGND sg13cmos5l_tiehi
X_06272_ _06276_/A _06272_/A _06279_/B _06272_/C VPWR VGND sg13cmos5l_nor3_1
X_05223_ _05223_/Y _08942_/A _05242_/B _05212_/Y _05206_/Y _08938_/A VPWR VGND sg13cmos5l_a221oi_1
X_08011_ _08012_/B _09178_/Q _08037_/B VPWR VGND sg13cmos5l_and2_1
X_05154_ _05163_/B _09285_/Q _08728_/A _09286_/Q _09287_/Q VPWR VGND sg13cmos5l_nor4_1
X_05085_ _05100_/B _09289_/Q _09290_/Q _09291_/Q VPWR VGND sg13cmos5l_or3_1
X_08913_ _08929_/A _08880_/A _08913_/B VPWR VGND sg13cmos5l_nand2b_1
Xhold1313 _05886_/A _09372_/Q VPWR VGND sg13cmos5l_dlygate4sd3_1
Xhold1324 _07917_/A _09137_/Q VPWR VGND sg13cmos5l_dlygate4sd3_1
X_08844_ _08844_/Y hold904/A hold867/A VPWR VGND sg13cmos5l_xnor2_1
Xhold1302 _06661_/A _09486_/Q VPWR VGND sg13cmos5l_dlygate4sd3_1
Xhold1357 _06132_/A _09414_/Q VPWR VGND sg13cmos5l_dlygate4sd3_1
Xhold1346 hold1346/X _09410_/Q VPWR VGND sg13cmos5l_dlygate4sd3_1
XFILLER_45_509 VPWR VGND sg13cmos5l_decap_4
X_08775_ _08873_/B _08774_/Y _05202_/Y _08775_/S VPWR VGND sg13cmos5l_mux2_1
Xhold1368 _08190_/A _09173_/Q VPWR VGND sg13cmos5l_dlygate4sd3_1
X_05987_ _06014_/A _06008_/B _06024_/B _05987_/C VPWR VGND sg13cmos5l_nor3_1
Xhold1335 hold1335/X _09469_/Q VPWR VGND sg13cmos5l_dlygate4sd3_1
X_07726_ _08065_/A _08149_/A _07727_/B VPWR VGND sg13cmos5l_and2_1
Xhold1379 _08018_/A _08016_/X VPWR VGND sg13cmos5l_dlygate4sd3_1
X_04938_ _04938_/Y input4/X VPWR VGND sg13cmos5l_inv_1
XFILLER_26_745 VPWR VGND sg13cmos5l_fill_1
X_07657_ _07657_/X _07657_/A _07657_/B VPWR VGND sg13cmos5l_xor2_1
X_04869_ _06740_/A _04869_/A VPWR VGND sg13cmos5l_inv_1
X_07588_ _07589_/B _09107_/Q _07588_/B VPWR VGND sg13cmos5l_nor2_1
XFILLER_13_439 VPWR VGND sg13cmos5l_fill_1
X_06608_ _06608_/Y hold915/X _07382_/A VPWR VGND sg13cmos5l_nand2b_1
X_09327_ _09327_/Q clkload10/A _09327_/D _09327_/RESET_B VPWR VGND sg13cmos5l_dfrbpq_1
X_06539_ _06539_/Y _06515_/Y _06532_/Y _06538_/Y VPWR VGND sg13cmos5l_o21ai_1
X_09258_ _09258_/Q clkload9/A _09258_/D _09258_/RESET_B VPWR VGND sg13cmos5l_dfrbpq_1
X_08209_ _08230_/A _08182_/B _08208_/B _08208_/Y VPWR VGND sg13cmos5l_a21oi_1
X_09189_ _09189_/Q clkload4/A _09189_/D _09189_/RESET_B VPWR VGND sg13cmos5l_dfrbpq_1
XFILLER_49_804 VPWR VGND sg13cmos5l_decap_4
XFILLER_49_837 VPWR VGND sg13cmos5l_fill_2
XFILLER_1_1026 VPWR VGND sg13cmos5l_fill_2
XFILLER_16_222 VPWR VGND sg13cmos5l_fill_1
XFILLER_13_984 VPWR VGND sg13cmos5l_decap_8
X_09508__593 _09508_/RESET_B VPWR VGND sg13cmos5l_tiehi
XFILLER_4_682 VPWR VGND sg13cmos5l_fill_2
X_06890_ _06923_/A _09526_/Q _09524_/Q _09525_/Q VPWR VGND sg13cmos5l_or3_1
X_05910_ _05910_/Y _06219_/A _09379_/Q VPWR VGND sg13cmos5l_nand2_1
X_05841_ _09404_/D _05898_/A _05841_/B VPWR VGND sg13cmos5l_nor2_1
X_08560_ _08560_/Y _08580_/A _09229_/Q VPWR VGND sg13cmos5l_nor2b_1
X_05772_ _09397_/D _05772_/A _05770_/Y VPWR VGND sg13cmos5l_nor2b_1
X_08491_ _08500_/B _09248_/Q _09247_/Q _08555_/A VPWR VGND sg13cmos5l_nor3_1
X_07511_ _07664_/B hold1408/X _07521_/B _07521_/C VPWR VGND sg13cmos5l_nand3b_1
X_07442_ _07442_/Y _07442_/A _07442_/B VPWR VGND sg13cmos5l_nor2_1
X_09515__586 _09515_/RESET_B VPWR VGND sg13cmos5l_tiehi
Xfanout29 _05779_/A _05769_/Y VPWR VGND sg13cmos5l_buf_1
X_07373_ _07373_/Y _07360_/A fanout33/X _07372_/Y VPWR VGND sg13cmos5l_a21oi_1
X_09112_ _09112_/Q clkload6/A _09112_/D _09112_/RESET_B VPWR VGND sg13cmos5l_dfrbpq_1
XFILLER_31_770 VPWR VGND sg13cmos5l_fill_2
X_06324_ _06651_/A _09515_/Q _06335_/A VPWR VGND sg13cmos5l_xnor2_1
X_06255_ _06281_/B _06266_/B _06266_/C VPWR VGND sg13cmos5l_nor2_1
X_09043_ _09043_/Q _09573_/CLK _09043_/D _09043_/RESET_B VPWR VGND sg13cmos5l_dfrbpq_1
X_05206_ _05206_/Y _05191_/Y _05197_/Y _05205_/Y VPWR VGND sg13cmos5l_o21ai_1
X_06186_ _06186_/Y _09419_/Q _06189_/B VPWR VGND sg13cmos5l_nand2_1
X_05137_ _05194_/A _05137_/A _05156_/A _05156_/B VPWR VGND sg13cmos5l_or3_1
X_09346__770 _09346_/RESET_B VPWR VGND sg13cmos5l_tiehi
X_09522__579 _09522_/RESET_B VPWR VGND sg13cmos5l_tiehi
X_05068_ _05230_/B _09315_/Q _05078_/B VPWR VGND sg13cmos5l_nand2_1
Xhold1132 hold1132/X _06415_/B VPWR VGND sg13cmos5l_dlygate4sd3_1
Xhold1110 _07725_/B _09145_/Q VPWR VGND sg13cmos5l_dlygate4sd3_1
X_09492__612 _09492_/RESET_B VPWR VGND sg13cmos5l_tiehi
Xhold1121 _04971_/A _09494_/Q VPWR VGND sg13cmos5l_dlygate4sd3_1
X_08827_ _08827_/Y _08827_/A _08827_/B VPWR VGND sg13cmos5l_nor2_1
Xhold1143 _04950_/A _09085_/Q VPWR VGND sg13cmos5l_dlygate4sd3_1
Xhold1154 _04990_/A _09342_/Q VPWR VGND sg13cmos5l_dlygate4sd3_1
Xhold1165 hold1165/X _09418_/Q VPWR VGND sg13cmos5l_dlygate4sd3_1
Xhold1176 _04872_/A _09513_/Q VPWR VGND sg13cmos5l_dlygate4sd3_1
Xhold1187 _09533_/D _06722_/Y VPWR VGND sg13cmos5l_dlygate4sd3_1
X_08758_ _08824_/A hold908/X _08995_/A VPWR VGND sg13cmos5l_nand2b_1
Xhold1198 _04841_/A _09324_/Q VPWR VGND sg13cmos5l_dlygate4sd3_1
X_07709_ _07709_/Y _07658_/Y _07715_/S _07634_/B VPWR VGND sg13cmos5l_o21ai_1
X_08689_ _08690_/C _08689_/A _08689_/B _08689_/C VPWR VGND sg13cmos5l_and3_1
XFILLER_6_925 VPWR VGND sg13cmos5l_decap_4
XFILLER_49_623 VPWR VGND sg13cmos5l_decap_8
XFILLER_1_663 VPWR VGND sg13cmos5l_fill_1
XFILLER_49_689 VPWR VGND sg13cmos5l_fill_2
XFILLER_44_372 VPWR VGND sg13cmos5l_fill_2
XFILLER_44_361 VPWR VGND sg13cmos5l_decap_8
XFILLER_9_785 VPWR VGND sg13cmos5l_fill_1
X_06040_ _09437_/D _06020_/B _06034_/Y _06039_/Y VPWR VGND sg13cmos5l_a21oi_1
XFILLER_5_991 VPWR VGND sg13cmos5l_fill_1
X_07991_ _07998_/B _09181_/Q _09182_/Q _07991_/C _09180_/Q VPWR VGND sg13cmos5l_nor4_1
Xfanout208 _07633_/A fanout211/X VPWR VGND sg13cmos5l_buf_1
X_06942_ _06942_/Y _09591_/Q _04965_/Y _04966_/Y _09590_/Q _06941_/Y VPWR VGND sg13cmos5l_a221oi_1
X_06873_ _09556_/D _06932_/A _06873_/B VPWR VGND sg13cmos5l_nor2_1
X_05824_ _05824_/Y _05852_/B _05816_/B _05826_/A _05826_/B VPWR VGND sg13cmos5l_a22oi_1
X_09592_ _09592_/Q clkload17/A _09592_/D _09592_/RESET_B VPWR VGND sg13cmos5l_dfrbpq_1
X_08612_ _08682_/B _08622_/A _08622_/B VPWR VGND sg13cmos5l_and2_1
XFILLER_27_339 VPWR VGND sg13cmos5l_fill_1
X_05755_ _05755_/Y _05743_/Y _05745_/X _05756_/A _05756_/B VPWR VGND sg13cmos5l_a22oi_1
X_08543_ _08702_/A _08510_/Y _08539_/C _08508_/B VPWR VGND sg13cmos5l_o21ai_1
X_08474_ _08474_/Y _08458_/A fanout21/X _08474_/B1 VPWR VGND sg13cmos5l_o21ai_1
XFILLER_24_16 VPWR VGND sg13cmos5l_fill_2
X_05686_ _09384_/D _06469_/A hold991/X VPWR VGND sg13cmos5l_and2_1
X_07425_ _07447_/B _07450_/A _07423_/B _07422_/Y _07424_/Y VPWR VGND sg13cmos5l_a22oi_1
X_07356_ _07360_/B _06974_/A _07355_/B _07355_/Y VPWR VGND sg13cmos5l_a21oi_1
X_06307_ _06337_/A _09480_/Q _09479_/Q _09481_/Q VPWR VGND sg13cmos5l_or3_1
X_07287_ _07301_/B _09564_/Q _09565_/Q _09562_/Q _09563_/Q VPWR VGND sg13cmos5l_or4_1
X_09026_ _09026_/Q clkload9/A _09026_/D _09026_/RESET_B VPWR VGND sg13cmos5l_dfrbpq_1
X_06238_ _06238_/Y _09471_/Q _06243_/B _06285_/B VPWR VGND sg13cmos5l_a21oi_1
XFILLER_3_917 VPWR VGND sg13cmos5l_fill_1
X_06169_ _06169_/Y _09417_/Q _06473_/A VPWR VGND sg13cmos5l_nor2b_1
XFILLER_6_799 VPWR VGND sg13cmos5l_fill_2
X_09505__596 _09505_/RESET_B VPWR VGND sg13cmos5l_tiehi
Xinput8 input8/X ui_in[6] VPWR VGND sg13cmos5l_buf_1
X_05540_ _05542_/B _09400_/Q hold997/A _09398_/Q _09399_/Q VPWR VGND sg13cmos5l_nor4_1
X_09336__780 _09336_/RESET_B VPWR VGND sg13cmos5l_tiehi
X_05471_ _05472_/B _05471_/A _05471_/B VPWR VGND sg13cmos5l_xnor2_1
X_09512__589 _09512_/RESET_B VPWR VGND sg13cmos5l_tiehi
X_08190_ _08191_/B _08190_/A _08190_/B VPWR VGND sg13cmos5l_xnor2_1
X_07210_ _07215_/A _07211_/B _07211_/C VPWR VGND sg13cmos5l_nor2_1
X_07141_ _07141_/Y _08784_/A _08880_/A VPWR VGND sg13cmos5l_nor2_1
X_09482__622 _09482_/RESET_B VPWR VGND sg13cmos5l_tiehi
X_07072_ _09591_/D _07055_/B _07069_/S _07071_/Y VPWR VGND sg13cmos5l_a21oi_1
XFILLER_10_29 VPWR VGND sg13cmos5l_fill_1
X_06023_ _06024_/C _06023_/A _06023_/B _06023_/C VPWR VGND sg13cmos5l_and3_1
X_09343__773 _09343_/RESET_B VPWR VGND sg13cmos5l_tiehi
X_07974_ _08311_/A _07991_/C _09180_/Q VPWR VGND sg13cmos5l_xnor2_1
X_06925_ _06926_/B _07022_/C _07022_/D VPWR VGND sg13cmos5l_nand2_1
X_06856_ _06856_/Y _06884_/A _06856_/B VPWR VGND sg13cmos5l_nor2_1
X_05807_ _05814_/A _05796_/X _05800_/Y _05804_/Y _05805_/X _05801_/X VPWR VGND sg13cmos5l_a221oi_1
X_09235__829 _09235_/RESET_B VPWR VGND sg13cmos5l_tiehi
X_09575_ hold995/A _09575_/CLK hold927/X _09575_/RESET_B VPWR VGND sg13cmos5l_dfrbpq_1
X_06787_ _06787_/X _06787_/A _06787_/B VPWR VGND sg13cmos5l_or2_1
X_05738_ _05739_/B _05730_/A _05760_/B _05737_/Y VPWR VGND sg13cmos5l_a21oi_1
X_08526_ _08661_/B _08485_/X _08530_/B _08530_/C VPWR VGND sg13cmos5l_nand3b_1
X_08457_ _08458_/B _08295_/Y _08456_/B _08456_/Y VPWR VGND sg13cmos5l_o21ai_1
X_05669_ _05669_/X _05660_/Y _05664_/Y _05668_/Y VPWR VGND sg13cmos5l_a21o_1
X_07408_ _07409_/C _07408_/A _07408_/B VPWR VGND sg13cmos5l_nor2_1
X_09190__280 _09190_/RESET_B VPWR VGND sg13cmos5l_tiehi
XFILLER_13_1015 VPWR VGND sg13cmos5l_decap_8
X_08388_ hold954/A _04821_/Y fanout53/X _08387_/Y VPWR VGND sg13cmos5l_a21oi_1
X_07339_ _07339_/Y _09064_/Q _07355_/B VPWR VGND sg13cmos5l_nor2_1
X_09009_ _09009_/Q clkload9/A _09009_/D _09009_/RESET_B VPWR VGND sg13cmos5l_dfrbpq_1
XFILLER_3_714 VPWR VGND sg13cmos5l_fill_2
XFILLER_20_1019 VPWR VGND sg13cmos5l_fill_1
XFILLER_46_478 VPWR VGND sg13cmos5l_decap_4
XFILLER_6_530 VPWR VGND sg13cmos5l_decap_8
X_04971_ _04971_/Y _04971_/A VPWR VGND sg13cmos5l_inv_1
X_06710_ _06710_/Y _09535_/Q _06710_/B VPWR VGND sg13cmos5l_nor2_1
X_07690_ _07690_/X _07690_/A _07690_/B VPWR VGND sg13cmos5l_or2_1
X_06641_ _06642_/B _09511_/Q _09486_/Q VPWR VGND sg13cmos5l_or2_1
X_06572_ _06622_/A _06991_/A _06572_/B VPWR VGND sg13cmos5l_xnor2_1
X_09360_ _09360_/Q _09387_/CLK _09360_/D _09360_/RESET_B VPWR VGND sg13cmos5l_dfrbpq_1
X_09291_ _09291_/Q clkload10/A _09291_/D _09291_/RESET_B VPWR VGND sg13cmos5l_dfrbpq_1
X_08311_ _08311_/X _08311_/A _08334_/A _08334_/B VPWR VGND sg13cmos5l_and3_1
X_05523_ _09361_/D _05499_/B _05517_/B _05522_/Y VPWR VGND sg13cmos5l_a21oi_1
XFILLER_36_1026 VPWR VGND sg13cmos5l_fill_2
X_08242_ _08261_/B _09184_/Q _09185_/Q _09186_/Q _09187_/Q VPWR VGND sg13cmos5l_nor4_1
X_05454_ _05502_/B _05454_/A _05466_/B VPWR VGND sg13cmos5l_nand2_1
X_05385_ _05508_/A _05385_/A _05385_/B VPWR VGND sg13cmos5l_nand2_1
X_08173_ _08226_/A _08207_/B _08173_/B VPWR VGND sg13cmos5l_nor2_1
X_07124_ _07124_/Y _09028_/Q _07154_/A _09029_/Q VPWR VGND sg13cmos5l_o21ai_1
X_07055_ _07055_/X _07055_/A _07055_/B VPWR VGND sg13cmos5l_or2_1
X_06006_ _06006_/Y _06007_/B VPWR VGND sg13cmos5l_inv_1
X_07957_ _07972_/C _07947_/Y _07952_/Y _07956_/Y VPWR VGND sg13cmos5l_o21ai_1
X_06908_ _06908_/Y _06896_/Y _06904_/Y _06907_/Y VPWR VGND sg13cmos5l_o21ai_1
X_07888_ _09132_/D _07889_/A hold880/X VPWR VGND sg13cmos5l_and2_1
X_06839_ _06839_/Y _09558_/Q _06840_/B VPWR VGND sg13cmos5l_xnor2_1
XFILLER_43_459 VPWR VGND sg13cmos5l_decap_4
X_09558_ _09558_/Q _09565_/CLK _09558_/D _09558_/RESET_B VPWR VGND sg13cmos5l_dfrbpq_1
X_08509_ _08516_/B _09227_/Q _08510_/B VPWR VGND sg13cmos5l_nor2b_1
XFILLER_24_662 VPWR VGND sg13cmos5l_fill_1
X_09489_ _09489_/Q clkload22/A _09489_/D _09489_/RESET_B VPWR VGND sg13cmos5l_dfrbpq_1
X_09326__790 _09326_/RESET_B VPWR VGND sg13cmos5l_tiehi
X_09502__599 _09502_/RESET_B VPWR VGND sg13cmos5l_tiehi
XFILLER_47_765 VPWR VGND sg13cmos5l_fill_2
X_09472__632 _09472_/RESET_B VPWR VGND sg13cmos5l_tiehi
X_09333__783 _09333_/RESET_B VPWR VGND sg13cmos5l_tiehi
XFILLER_42_492 VPWR VGND sg13cmos5l_fill_2
XFILLER_30_654 VPWR VGND sg13cmos5l_fill_2
X_05170_ _05203_/S _05176_/B _05194_/C VPWR VGND sg13cmos5l_nand2_1
XFILLER_42_2 VPWR VGND sg13cmos5l_fill_1
X_08860_ _08860_/Y hold1242/X _08850_/B _08859_/Y VPWR VGND sg13cmos5l_o21ai_1
X_07811_ _07829_/C _07804_/Y _07807_/Y _07809_/Y VPWR VGND sg13cmos5l_a21o_1
XFILLER_28_0 VPWR VGND sg13cmos5l_fill_2
X_09340__776 _09340_/RESET_B VPWR VGND sg13cmos5l_tiehi
X_09180__290 _09180_/RESET_B VPWR VGND sg13cmos5l_tiehi
X_08791_ _08791_/Y _09287_/Q _05004_/Y _07173_/B _09286_/Q _08790_/Y VPWR VGND sg13cmos5l_a221oi_1
X_07742_ _07742_/Y _07741_/B _07767_/A _07741_/X _09141_/Q _07738_/Y VPWR VGND sg13cmos5l_a221oi_1
X_04954_ _04954_/Y _07599_/A VPWR VGND sg13cmos5l_inv_1
XFILLER_37_242 VPWR VGND sg13cmos5l_fill_2
X_07673_ _07673_/Y _07699_/A _07575_/Y _07672_/Y VPWR VGND sg13cmos5l_a21oi_1
X_04885_ _08602_/A _04885_/A VPWR VGND sg13cmos5l_inv_1
X_09412_ _09412_/Q clkload20/A _09412_/D _09412_/RESET_B VPWR VGND sg13cmos5l_dfrbpq_1
X_06624_ _06624_/Y _06624_/A _06629_/B VPWR VGND sg13cmos5l_nor2_1
X_09343_ _09343_/Q clkload18/A _09343_/D _09343_/RESET_B VPWR VGND sg13cmos5l_dfrbpq_1
XFILLER_21_610 VPWR VGND sg13cmos5l_fill_1
XFILLER_34_982 VPWR VGND sg13cmos5l_fill_2
X_06555_ _06555_/Y _06515_/B _06557_/S _06558_/A VPWR VGND sg13cmos5l_o21ai_1
X_06486_ _06526_/B _06495_/A _06495_/B VPWR VGND sg13cmos5l_nand2_1
X_09274_ hold859/A _09608_/CLK _09274_/D _09274_/RESET_B VPWR VGND sg13cmos5l_dfrbpq_1
X_05506_ _05506_/X _05507_/A _05507_/B VPWR VGND sg13cmos5l_or2_1
X_08225_ _09180_/D _08231_/A _08225_/B VPWR VGND sg13cmos5l_nor2_1
X_05437_ hold910/A _04815_/Y fanout56/X _05436_/Y VPWR VGND sg13cmos5l_a21oi_1
X_05368_ _05368_/Y _05369_/B VPWR VGND sg13cmos5l_inv_1
XFILLER_20_197 VPWR VGND sg13cmos5l_fill_1
X_08156_ _08197_/A _09174_/Q _08169_/A VPWR VGND sg13cmos5l_xnor2_1
X_07107_ _07108_/B _07106_/A _07105_/X _07106_/Y _07102_/Y VPWR VGND sg13cmos5l_a22oi_1
X_05299_ _05304_/A _05331_/B _05764_/A VPWR VGND sg13cmos5l_nand2_1
X_08087_ _08183_/B _08087_/A _08087_/B VPWR VGND sg13cmos5l_and2_1
X_07038_ _07038_/Y _07019_/C _07019_/D _07025_/Y _07027_/Y _07028_/X VPWR VGND sg13cmos5l_a221oi_1
X_08989_ _08989_/Y hold909/X fanout55/X _08995_/A VPWR VGND sg13cmos5l_o21ai_1
XFILLER_25_971 VPWR VGND sg13cmos5l_decap_8
XFILLER_7_168 VPWR VGND sg13cmos5l_fill_1
XFILLER_14_6 VPWR VGND sg13cmos5l_fill_1
XFILLER_34_234 VPWR VGND sg13cmos5l_fill_2
X_06340_ _06340_/Y _06333_/Y _06338_/Y _06339_/Y VPWR VGND sg13cmos5l_o21ai_1
XFILLER_31_952 VPWR VGND sg13cmos5l_fill_2
XFILLER_31_963 VPWR VGND sg13cmos5l_decap_8
X_06271_ _06272_/C _06271_/A _06271_/B _06271_/C VPWR VGND sg13cmos5l_and3_1
X_08010_ _08026_/B _07994_/Y _08004_/Y _08008_/Y VPWR VGND sg13cmos5l_a21o_1
XFILLER_30_495 VPWR VGND sg13cmos5l_fill_2
X_05222_ _05222_/Y _05222_/A _05222_/B VPWR VGND sg13cmos5l_nand2_1
X_05153_ _05153_/Y _05194_/B _05143_/Y _05188_/A _05146_/X VPWR VGND sg13cmos5l_a22oi_1
X_05084_ _05218_/A _05222_/A _05084_/B VPWR VGND sg13cmos5l_nand2_1
X_08912_ _08928_/B _08858_/A _08862_/B _08858_/B VPWR VGND sg13cmos5l_o21ai_1
Xhold1325 _05365_/A _09296_/Q VPWR VGND sg13cmos5l_dlygate4sd3_1
Xhold1303 _07762_/A _09108_/Q VPWR VGND sg13cmos5l_dlygate4sd3_1
Xhold1314 _04934_/A _09044_/Q VPWR VGND sg13cmos5l_dlygate4sd3_1
X_08843_ _08843_/Y hold994/A hold892/A VPWR VGND sg13cmos5l_nand2_1
Xhold1347 _06147_/B _06266_/A VPWR VGND sg13cmos5l_dlygate4sd3_1
X_08774_ _08774_/Y _08742_/B _08774_/B VPWR VGND sg13cmos5l_nand2b_1
Xhold1358 _07549_/A _09043_/Q VPWR VGND sg13cmos5l_dlygate4sd3_1
Xhold1336 _08410_/A _09210_/Q VPWR VGND sg13cmos5l_dlygate4sd3_1
X_05986_ _05987_/C _05986_/A _05986_/B VPWR VGND sg13cmos5l_nor2_1
X_07725_ _08087_/A _07727_/B _07725_/B VPWR VGND sg13cmos5l_nand2b_1
Xhold1369 _06918_/A _09524_/Q VPWR VGND sg13cmos5l_dlygate4sd3_1
X_04937_ _04937_/Y input3/X VPWR VGND sg13cmos5l_inv_1
X_04868_ _06477_/A _06176_/A VPWR VGND sg13cmos5l_inv_1
X_07656_ _07663_/A _07698_/B VPWR VGND sg13cmos5l_inv_1
XFILLER_13_407 VPWR VGND sg13cmos5l_fill_2
XFILLER_43_37 VPWR VGND sg13cmos5l_fill_2
XFILLER_41_727 VPWR VGND sg13cmos5l_fill_2
X_09531__570 _09531_/RESET_B VPWR VGND sg13cmos5l_tiehi
X_07587_ _07587_/Y _07579_/B _07602_/B _07586_/Y VPWR VGND sg13cmos5l_a21oi_1
X_06607_ _06823_/A _07721_/A hold915/X VPWR VGND sg13cmos5l_nor2_1
X_09326_ _09326_/Q clkload7/A _09326_/D _09326_/RESET_B VPWR VGND sg13cmos5l_dfrbpq_1
X_06538_ _06538_/Y _06534_/Y _06538_/B VPWR VGND sg13cmos5l_nand2b_1
X_09257_ _09257_/Q clkload9/A _09257_/D _09257_/RESET_B VPWR VGND sg13cmos5l_dfrbpq_1
X_08208_ _08208_/Y _08208_/A _08208_/B VPWR VGND sg13cmos5l_nor2_1
X_06469_ _09502_/D _06469_/A hold860/X VPWR VGND sg13cmos5l_and2_1
X_09188_ _09188_/Q clkload4/A _09188_/D _09188_/RESET_B VPWR VGND sg13cmos5l_dfrbpq_1
X_08139_ _08139_/Y hold987/A fanout57/X _08394_/A VPWR VGND sg13cmos5l_o21ai_1
XFILLER_49_827 VPWR VGND sg13cmos5l_fill_1
X_09323__793 _09323_/RESET_B VPWR VGND sg13cmos5l_tiehi
XFILLER_1_1005 VPWR VGND sg13cmos5l_decap_8
XFILLER_44_587 VPWR VGND sg13cmos5l_fill_1
XFILLER_44_576 VPWR VGND sg13cmos5l_fill_2
XFILLER_12_462 VPWR VGND sg13cmos5l_fill_1
XFILLER_8_444 VPWR VGND sg13cmos5l_fill_2
XFILLER_9_967 VPWR VGND sg13cmos5l_fill_2
XFILLER_33_92 VPWR VGND sg13cmos5l_fill_2
X_09330__786 _09330_/RESET_B VPWR VGND sg13cmos5l_tiehi
X_05840_ _05841_/B _05994_/A _05994_/B VPWR VGND sg13cmos5l_and2_1
XFILLER_47_370 VPWR VGND sg13cmos5l_fill_2
X_07510_ _07664_/A _07503_/Y _07506_/X _07509_/Y VPWR VGND sg13cmos5l_o21ai_1
X_05771_ _05772_/A _05748_/Y _05779_/A _05696_/B VPWR VGND sg13cmos5l_o21ai_1
X_08490_ _08490_/Y _09225_/Q _08494_/B VPWR VGND sg13cmos5l_xnor2_1
X_07441_ _07441_/Y _07434_/Y _07436_/Y _07440_/Y VPWR VGND sg13cmos5l_o21ai_1
Xfanout19 _08823_/S _08815_/Y VPWR VGND sg13cmos5l_buf_1
X_07372_ _07372_/Y _07360_/B fanout33/X _07386_/B VPWR VGND sg13cmos5l_o21ai_1
X_06323_ _06323_/X _09483_/Q _06323_/B VPWR VGND sg13cmos5l_xor2_1
X_09111_ _09111_/Q clkload6/A _09111_/D _09111_/RESET_B VPWR VGND sg13cmos5l_dfrbpq_1
X_06254_ _06266_/C _06281_/A _06162_/X _06251_/Y _06252_/Y _06253_/Y VPWR VGND sg13cmos5l_a221oi_1
X_09042_ _09042_/Q _09573_/CLK _09042_/D _09042_/RESET_B VPWR VGND sg13cmos5l_dfrbpq_1
XFILLER_30_292 VPWR VGND sg13cmos5l_fill_2
X_05205_ _05205_/Y _05128_/Y _08940_/A _05200_/Y _08941_/A VPWR VGND sg13cmos5l_a22oi_1
X_06185_ _06185_/X _06185_/A _06185_/B VPWR VGND sg13cmos5l_or2_1
X_05136_ _05156_/B _09260_/Q _09261_/Q _09258_/Q _09259_/Q VPWR VGND sg13cmos5l_or4_1
X_05067_ _05230_/A _09317_/Q _05078_/B VPWR VGND sg13cmos5l_xnor2_1
Xhold1100 _04996_/A _09303_/Q VPWR VGND sg13cmos5l_dlygate4sd3_1
Xhold1122 _09494_/D _06455_/Y VPWR VGND sg13cmos5l_dlygate4sd3_1
Xhold1133 _05001_/A _09266_/Q VPWR VGND sg13cmos5l_dlygate4sd3_1
X_08826_ _08826_/Y _04999_/A _08815_/Y _08757_/Y VPWR VGND sg13cmos5l_o21ai_1
Xhold1111 _05909_/B _09383_/Q VPWR VGND sg13cmos5l_dlygate4sd3_1
Xhold1155 _07347_/A _09066_/Q VPWR VGND sg13cmos5l_dlygate4sd3_1
Xhold1144 _09085_/D _07616_/Y VPWR VGND sg13cmos5l_dlygate4sd3_1
Xhold1166 hold1166/X _09416_/Q VPWR VGND sg13cmos5l_dlygate4sd3_1
Xhold1177 _04928_/A _09200_/Q VPWR VGND sg13cmos5l_dlygate4sd3_1
X_05969_ _06008_/A hold960/A hold878/A VPWR VGND sg13cmos5l_nand2_1
Xhold1199 _04847_/A _09362_/Q VPWR VGND sg13cmos5l_dlygate4sd3_1
X_08757_ _08757_/Y _08757_/A hold908/X VPWR VGND sg13cmos5l_nor2_1
Xhold1188 _04842_/A _09325_/Q VPWR VGND sg13cmos5l_dlygate4sd3_1
X_07708_ _07708_/Y _07703_/Y _07719_/A _07719_/B VPWR VGND sg13cmos5l_o21ai_1
X_09219__248 _09219_/RESET_B VPWR VGND sg13cmos5l_tiehi
X_08688_ _08688_/Y _08623_/Y _08711_/A VPWR VGND sg13cmos5l_nand2b_1
X_07639_ _09101_/D _07639_/A _07639_/B VPWR VGND sg13cmos5l_nor2_1
X_09309_ hold888/A clkload3/A _09309_/D _09309_/RESET_B VPWR VGND sg13cmos5l_dfrbpq_1
XFILLER_45_885 VPWR VGND sg13cmos5l_fill_1
XFILLER_32_557 VPWR VGND sg13cmos5l_fill_2
X_07990_ _08038_/A _09150_/Q _07999_/C VPWR VGND sg13cmos5l_xnor2_1
Xfanout209 _06469_/A fanout211/X VPWR VGND sg13cmos5l_buf_1
X_06941_ _06941_/Y _07388_/A _09533_/Q _09532_/Q _07387_/A _06940_/Y VPWR VGND sg13cmos5l_a221oi_1
X_09521__580 _09521_/RESET_B VPWR VGND sg13cmos5l_tiehi
X_06872_ _06873_/B _07019_/A _07019_/B VPWR VGND sg13cmos5l_and2_1
X_08611_ _08689_/A _09241_/Q _08626_/B VPWR VGND sg13cmos5l_xnor2_1
X_05823_ _05826_/B _05842_/B _06165_/A VPWR VGND sg13cmos5l_nand2_1
X_09591_ _09591_/Q _09591_/CLK _09591_/D _09591_/RESET_B VPWR VGND sg13cmos5l_dfrbpq_1
XFILLER_27_329 VPWR VGND sg13cmos5l_fill_1
X_05754_ _05756_/B _05585_/B _05633_/B _05754_/S VPWR VGND sg13cmos5l_mux2_1
X_08542_ _09226_/D _08603_/B _08699_/A VPWR VGND sg13cmos5l_nor2_1
X_08473_ _09219_/D _08450_/B fanout21/X _08472_/Y VPWR VGND sg13cmos5l_a21oi_1
X_07424_ _07424_/Y _07447_/A _07328_/Y _07423_/Y VPWR VGND sg13cmos5l_a21oi_1
X_05685_ _05685_/Y _04983_/Y _05670_/B _05776_/A VPWR VGND sg13cmos5l_a21oi_1
X_07355_ _07355_/Y _07355_/A _07355_/B VPWR VGND sg13cmos5l_nor2_1
X_07286_ _07320_/A _09564_/Q _09562_/Q _09563_/Q VPWR VGND sg13cmos5l_or3_1
X_06306_ _06306_/Y hold912/X _06736_/A VPWR VGND sg13cmos5l_nand2b_1
X_09025_ hold892/A _09288_/CLK _09025_/D _09025_/RESET_B VPWR VGND sg13cmos5l_dfrbpq_1
X_06237_ _06285_/B _06278_/B _06278_/C _06278_/A VPWR VGND sg13cmos5l_a21oi_1
XFILLER_2_439 VPWR VGND sg13cmos5l_fill_1
X_06168_ _06168_/Y _09416_/Q _09473_/Q VPWR VGND sg13cmos5l_nor2b_1
XFILLER_49_25 VPWR VGND sg13cmos5l_fill_1
X_06099_ _06099_/X _06073_/A _06073_/B _06112_/A VPWR VGND sg13cmos5l_a21o_1
X_05119_ _05119_/Y _05199_/C _05366_/A _05115_/X _05209_/B VPWR VGND sg13cmos5l_a22oi_1
X_09299__386 _09299_/RESET_B VPWR VGND sg13cmos5l_tiehi
X_08809_ _08809_/Y _08809_/A _08809_/B VPWR VGND sg13cmos5l_nor2_1
XFILLER_5_277 VPWR VGND sg13cmos5l_fill_2
XFILLER_5_299 VPWR VGND sg13cmos5l_fill_2
XFILLER_2_962 VPWR VGND sg13cmos5l_fill_2
XFILLER_49_410 VPWR VGND sg13cmos5l_decap_4
XFILLER_49_454 VPWR VGND sg13cmos5l_fill_1
Xinput9 input9/X ui_in[7] VPWR VGND sg13cmos5l_buf_1
XFILLER_17_373 VPWR VGND sg13cmos5l_fill_1
X_05470_ _05471_/B _05470_/A _05470_/B VPWR VGND sg13cmos5l_xor2_1
XFILLER_32_365 VPWR VGND sg13cmos5l_fill_2
X_07140_ _08880_/A _08785_/A _08786_/A VPWR VGND sg13cmos5l_nor2_1
X_07071_ _07071_/Y _07055_/A _07069_/S _07071_/B1 VPWR VGND sg13cmos5l_o21ai_1
X_06022_ _06022_/Y _06019_/Y _06021_/Y _06007_/Y VPWR VGND sg13cmos5l_a21oi_1
X_09209__258 _09209_/RESET_B VPWR VGND sg13cmos5l_tiehi
X_07973_ _09145_/D _07958_/A _07972_/Y _07895_/B VPWR VGND sg13cmos5l_a21oi_1
X_06924_ _07022_/D _06892_/Y _06914_/Y _06616_/Y VPWR VGND sg13cmos5l_o21ai_1
X_06855_ _06855_/Y _06883_/B _07330_/A VPWR VGND sg13cmos5l_nand2_1
X_05806_ _05847_/B _05806_/A _05843_/A VPWR VGND sg13cmos5l_xnor2_1
X_09574_ hold957/A clkload13/A _09574_/D _09574_/RESET_B VPWR VGND sg13cmos5l_dfrbpq_1
X_08525_ _08661_/A _08539_/B _08539_/C _08524_/Y VPWR VGND sg13cmos5l_o21ai_1
X_06786_ _06787_/B _06609_/A _06665_/B _06799_/B VPWR VGND sg13cmos5l_mux2_1
X_05737_ _05737_/Y _05737_/A _05760_/B VPWR VGND sg13cmos5l_nor2_1
XFILLER_24_855 VPWR VGND sg13cmos5l_fill_1
X_08456_ _08456_/Y _08456_/A _08456_/B VPWR VGND sg13cmos5l_nand2_1
XFILLER_24_888 VPWR VGND sg13cmos5l_fill_1
X_05668_ _05668_/Y _04984_/Y _05682_/A _05667_/Y VPWR VGND sg13cmos5l_o21ai_1
X_07407_ _07446_/B _07407_/A _07407_/B VPWR VGND sg13cmos5l_and2_1
XFILLER_11_527 VPWR VGND sg13cmos5l_decap_4
X_08387_ _08387_/Y _09166_/Q fanout47/X _08394_/A VPWR VGND sg13cmos5l_o21ai_1
X_05599_ _05630_/A _09338_/Q _09339_/Q _05612_/B VPWR VGND sg13cmos5l_or3_1
X_07338_ _07347_/B _09069_/Q _04958_/Y _07337_/Y VPWR VGND sg13cmos5l_a21oi_1
X_07269_ _09033_/D _07389_/B _07269_/B VPWR VGND sg13cmos5l_nor2_1
X_09008_ _09008_/Q clkload9/A _09008_/D _09008_/RESET_B VPWR VGND sg13cmos5l_dfrbpq_1
X_09047__435 _09047_/RESET_B VPWR VGND sg13cmos5l_tiehi
X_09511__590 _09511_/RESET_B VPWR VGND sg13cmos5l_tiehi
XFILLER_29_1012 VPWR VGND sg13cmos5l_decap_8
X_04970_ _04970_/Y _04970_/A VPWR VGND sg13cmos5l_inv_1
X_06640_ _06645_/A _06670_/A _06670_/B _06646_/A VPWR VGND sg13cmos5l_a21oi_1
X_06571_ _06896_/A _09552_/Q _06572_/B VPWR VGND sg13cmos5l_xnor2_1
X_09290_ _09290_/Q clkload10/A _09290_/D _09290_/RESET_B VPWR VGND sg13cmos5l_dfrbpq_1
X_08310_ _08315_/B _08310_/A _08334_/A VPWR VGND sg13cmos5l_xor2_1
X_05522_ _05522_/Y hold1414/X _05517_/B _05443_/B VPWR VGND sg13cmos5l_o21ai_1
X_08241_ _08259_/B _09184_/Q _09185_/Q _09186_/Q VPWR VGND sg13cmos5l_or3_1
X_05453_ _05502_/A _09357_/Q _05466_/B VPWR VGND sg13cmos5l_xnor2_1
X_05384_ _09338_/D _05448_/B _05384_/B VPWR VGND sg13cmos5l_nor2_1
X_08172_ _08173_/B _08172_/A _08172_/B VPWR VGND sg13cmos5l_xnor2_1
X_07123_ _07123_/Y _07136_/B VPWR VGND sg13cmos5l_inv_1
X_07054_ _07055_/B _06931_/Y _07053_/B _07053_/Y VPWR VGND sg13cmos5l_o21ai_1
X_06005_ _06007_/B _05902_/B _06025_/B _06004_/Y VPWR VGND sg13cmos5l_a21oi_1
X_07956_ _07956_/Y _07952_/A _07952_/B _07958_/A _07972_/B VPWR VGND sg13cmos5l_a22oi_1
X_06907_ _06907_/Y _06896_/A _06896_/B _06906_/A _06628_/A VPWR VGND sg13cmos5l_a22oi_1
XFILLER_29_925 VPWR VGND sg13cmos5l_fill_1
X_07887_ _09131_/D _07889_/A hold883/X VPWR VGND sg13cmos5l_and2_1
X_06838_ _06843_/B _09555_/Q _09556_/Q _09557_/Q _09558_/Q VPWR VGND sg13cmos5l_nor4_1
X_09274__643 _09274_/RESET_B VPWR VGND sg13cmos5l_tiehi
X_09557_ _09557_/Q clkload17/A _09557_/D _09557_/RESET_B VPWR VGND sg13cmos5l_dfrbpq_1
X_06769_ _06769_/Y _06768_/A _06768_/B _06768_/C _06768_/D VPWR VGND sg13cmos5l_a22oi_1
X_09333__239 _09333_/D VPWR VGND sg13cmos5l_tielo
X_08508_ _08508_/Y _08518_/B _08508_/B VPWR VGND sg13cmos5l_nand2_1
Xclkbuf_leaf_35_clk clkload6/A clkbuf_leaf_4_clk/A VPWR VGND sg13cmos5l_buf_8
X_09488_ _09488_/Q clkload22/A _09488_/D _09488_/RESET_B VPWR VGND sg13cmos5l_dfrbpq_1
X_08439_ _08439_/Y _08439_/A _08439_/B VPWR VGND sg13cmos5l_xnor2_1
XFILLER_8_818 VPWR VGND sg13cmos5l_fill_2
XFILLER_46_254 VPWR VGND sg13cmos5l_fill_2
Xclkbuf_leaf_26_clk _09591_/CLK clkbuf_3_5__f_clk/X VPWR VGND sg13cmos5l_buf_8
X_09169__301 _09169_/RESET_B VPWR VGND sg13cmos5l_tiehi
XFILLER_7_840 VPWR VGND sg13cmos5l_fill_1
XFILLER_6_394 VPWR VGND sg13cmos5l_fill_1
X_07810_ _07812_/B _07804_/Y _07807_/Y _07809_/Y VPWR VGND sg13cmos5l_a21oi_1
X_08790_ _08790_/Y _08999_/A _09016_/Q hold920/A _08998_/A _08789_/Y VPWR VGND sg13cmos5l_a221oi_1
X_07741_ _07741_/X _09109_/Q _07741_/B VPWR VGND sg13cmos5l_or2_1
X_04953_ _07360_/A _04953_/A VPWR VGND sg13cmos5l_inv_1
X_04884_ _08506_/A _09250_/Q VPWR VGND sg13cmos5l_inv_1
X_07672_ _07672_/Y _07703_/A _07674_/B VPWR VGND sg13cmos5l_nor2_1
X_09411_ _09411_/Q clkload21/A _09411_/D _09411_/RESET_B VPWR VGND sg13cmos5l_dfrbpq_1
X_06623_ _06623_/Y _06623_/A _06623_/B VPWR VGND sg13cmos5l_nor2_1
Xclkbuf_leaf_17_clk clkload21/A clkbuf_3_6__f_clk/X VPWR VGND sg13cmos5l_buf_8
X_09342_ _09342_/Q clkload18/A _09342_/D _09342_/RESET_B VPWR VGND sg13cmos5l_dfrbpq_1
X_06554_ _09513_/D _06554_/A _06554_/B VPWR VGND sg13cmos5l_nor2_1
XFILLER_34_950 VPWR VGND sg13cmos5l_fill_1
X_09037__445 _09037_/RESET_B VPWR VGND sg13cmos5l_tiehi
X_05505_ _05507_/B _05383_/Y _05508_/B _05504_/Y VPWR VGND sg13cmos5l_a21oi_1
X_09273_ hold994/A _09608_/CLK _09273_/D _09273_/RESET_B VPWR VGND sg13cmos5l_dfrbpq_1
X_06485_ _06526_/A _09507_/Q _06495_/B VPWR VGND sg13cmos5l_xnor2_1
X_08224_ _08225_/B _08203_/B _08200_/X _08229_/B VPWR VGND sg13cmos5l_mux2_1
X_05436_ _05436_/Y hold977/A fanout55/X _08995_/A VPWR VGND sg13cmos5l_o21ai_1
X_05367_ _05369_/B _05475_/C _05475_/D VPWR VGND sg13cmos5l_nand2_1
X_08155_ _08206_/B _08171_/A _08169_/A VPWR VGND sg13cmos5l_nand2_1
X_07106_ _07106_/Y _07106_/A _07106_/B VPWR VGND sg13cmos5l_nand2_1
X_05298_ _05298_/X _05331_/B _05764_/A VPWR VGND sg13cmos5l_and2_1
X_08086_ _09157_/D _08132_/A _08182_/B VPWR VGND sg13cmos5l_nor2_1
X_07037_ _07037_/Y _07052_/B _07036_/Y VPWR VGND sg13cmos5l_nor2b_1
X_09044__438 _09044_/RESET_B VPWR VGND sg13cmos5l_tiehi
X_08988_ _09309_/D _04818_/Y fanout54/X _08987_/Y VPWR VGND sg13cmos5l_a21oi_1
X_07939_ _07940_/C _07939_/A _07939_/B _07939_/C VPWR VGND sg13cmos5l_and3_1
XFILLER_16_438 VPWR VGND sg13cmos5l_fill_1
XFILLER_43_235 VPWR VGND sg13cmos5l_fill_2
XFILLER_40_997 VPWR VGND sg13cmos5l_fill_1
XFILLER_26_1026 VPWR VGND sg13cmos5l_fill_2
XFILLER_21_8 VPWR VGND sg13cmos5l_fill_1
XFILLER_16_961 VPWR VGND sg13cmos5l_fill_1
X_06270_ _06270_/X _06263_/A _06264_/X _06269_/Y VPWR VGND sg13cmos5l_a21o_1
X_05221_ _05221_/Y _05237_/B _05222_/B VPWR VGND sg13cmos5l_nor2b_1
X_05152_ _05152_/Y _05152_/A _05152_/B _05152_/C VPWR VGND sg13cmos5l_nand3_1
Xclkbuf_leaf_6_clk clkload7/A clkbuf_leaf_9_clk/A VPWR VGND sg13cmos5l_buf_8
X_05083_ _05084_/B _05083_/A _05083_/B VPWR VGND sg13cmos5l_xnor2_1
X_08911_ _08911_/Y _08911_/A _08911_/B VPWR VGND sg13cmos5l_nand2_1
Xheichips26_dna_sequencer_220 uio_out[6] VPWR VGND sg13cmos5l_tielo
Xhold1304 _08622_/A _09239_/Q VPWR VGND sg13cmos5l_dlygate4sd3_1
Xhold1315 _06782_/A _09544_/Q VPWR VGND sg13cmos5l_dlygate4sd3_1
X_08842_ _09281_/D _08842_/A _08842_/B VPWR VGND sg13cmos5l_and2_1
X_08773_ _09254_/D _08783_/B _08773_/B VPWR VGND sg13cmos5l_nor2_1
Xhold1359 hold1359/X _09260_/Q VPWR VGND sg13cmos5l_dlygate4sd3_1
Xhold1348 hold1348/X _09327_/Q VPWR VGND sg13cmos5l_dlygate4sd3_1
Xhold1337 _08310_/A _09156_/Q VPWR VGND sg13cmos5l_dlygate4sd3_1
Xhold1326 _08887_/A _09278_/Q VPWR VGND sg13cmos5l_dlygate4sd3_1
X_05985_ _06024_/B _05985_/A _05985_/B VPWR VGND sg13cmos5l_nor2_1
X_07724_ _07727_/B _09143_/Q _09144_/Q _09142_/Q _09141_/Q VPWR VGND sg13cmos5l_nor4_1
X_04936_ _04936_/Y input2/X VPWR VGND sg13cmos5l_inv_1
X_07655_ _07698_/B _07655_/A _07655_/B VPWR VGND sg13cmos5l_nor2_1
X_04867_ _06474_/A _06181_/A VPWR VGND sg13cmos5l_inv_1
X_06606_ _06609_/A _06767_/A _06767_/B VPWR VGND sg13cmos5l_and2_1
X_07586_ _07586_/Y _09102_/Q _07602_/B VPWR VGND sg13cmos5l_nor2_1
XFILLER_25_279 VPWR VGND sg13cmos5l_fill_1
X_06537_ _06537_/Y _06538_/B VPWR VGND sg13cmos5l_inv_1
X_09325_ _09325_/Q clkload12/A _09325_/D _09325_/RESET_B VPWR VGND sg13cmos5l_dfrbpq_1
X_09256_ _09256_/Q clkload9/A _09256_/D _09256_/RESET_B VPWR VGND sg13cmos5l_dfrbpq_1
XFILLER_22_964 VPWR VGND sg13cmos5l_fill_2
X_06468_ _09501_/D _04835_/Y fanout59/X _06467_/Y VPWR VGND sg13cmos5l_a21oi_1
X_08207_ _08229_/A _08207_/A _08207_/B _08207_/C VPWR VGND sg13cmos5l_nor3_1
X_05419_ _05419_/Y _05401_/B _05421_/B _05443_/B VPWR VGND sg13cmos5l_o21ai_1
X_06399_ _06401_/B _06399_/A _06398_/X VPWR VGND sg13cmos5l_nor2b_1
X_09187_ _09187_/Q _09595_/CLK _09187_/D _09187_/RESET_B VPWR VGND sg13cmos5l_dfrbpq_1
XFILLER_49_1015 VPWR VGND sg13cmos5l_decap_8
X_08138_ _09167_/D _04825_/Y fanout58/X _08137_/Y VPWR VGND sg13cmos5l_a21oi_1
X_08069_ _08085_/S _08082_/A _08082_/C VPWR VGND sg13cmos5l_nand2_1
XFILLER_1_879 VPWR VGND sg13cmos5l_fill_2
XFILLER_17_703 VPWR VGND sg13cmos5l_fill_1
XFILLER_1_1028 VPWR VGND sg13cmos5l_fill_1
XFILLER_4_684 VPWR VGND sg13cmos5l_fill_1
XFILLER_4_673 VPWR VGND sg13cmos5l_fill_1
X_09027__455 _09027_/RESET_B VPWR VGND sg13cmos5l_tiehi
X_05770_ _05770_/Y _05759_/B _05720_/A _05779_/A VPWR VGND sg13cmos5l_o21ai_1
XFILLER_35_533 VPWR VGND sg13cmos5l_fill_1
X_07440_ _07440_/Y _07434_/A _07434_/B _07442_/A _07442_/B VPWR VGND sg13cmos5l_a22oi_1
X_07371_ _09048_/D _04954_/Y fanout33/X _07370_/Y VPWR VGND sg13cmos5l_a21oi_1
X_06322_ _06365_/B _09483_/Q _06323_/B VPWR VGND sg13cmos5l_xnor2_1
X_09110_ _09110_/Q clkload14/A _09110_/D _09110_/RESET_B VPWR VGND sg13cmos5l_dfrbpq_1
X_09034__448 _09034_/RESET_B VPWR VGND sg13cmos5l_tiehi
X_09041_ _09041_/Q _09565_/CLK _09041_/D _09041_/RESET_B VPWR VGND sg13cmos5l_dfrbpq_1
X_06253_ _06253_/Y _06253_/A _06246_/A VPWR VGND sg13cmos5l_nor2b_1
X_05204_ _05204_/Y _08941_/A VPWR VGND sg13cmos5l_inv_1
X_06184_ _06185_/B _04976_/Y _06178_/X _06183_/Y VPWR VGND sg13cmos5l_o21ai_1
X_05135_ _05146_/A _09260_/Q _09258_/Q _09259_/Q VPWR VGND sg13cmos5l_or3_1
X_05066_ _05236_/B _09318_/Q _05078_/B VPWR VGND sg13cmos5l_nand2_1
Xhold1101 _09303_/D _08978_/Y VPWR VGND sg13cmos5l_dlygate4sd3_1
Xhold1123 _04976_/A _09455_/Q VPWR VGND sg13cmos5l_dlygate4sd3_1
X_08825_ _08827_/A _08825_/A _08823_/S VPWR VGND sg13cmos5l_nor2b_1
Xhold1112 _09383_/D _05685_/Y VPWR VGND sg13cmos5l_dlygate4sd3_1
Xhold1167 _04926_/A _09202_/Q VPWR VGND sg13cmos5l_dlygate4sd3_1
Xhold1145 _04823_/A _09233_/Q VPWR VGND sg13cmos5l_dlygate4sd3_1
Xhold1156 hold1156/X _09125_/Q VPWR VGND sg13cmos5l_dlygate4sd3_1
Xhold1134 _04967_/A _09532_/Q VPWR VGND sg13cmos5l_dlygate4sd3_1
X_08756_ _08756_/X _08753_/Y _05177_/Y _08775_/S VPWR VGND sg13cmos5l_mux2_1
Xhold1189 hold1189/X _09419_/Q VPWR VGND sg13cmos5l_dlygate4sd3_1
Xhold1178 _05003_/A _09018_/Q VPWR VGND sg13cmos5l_dlygate4sd3_1
X_05968_ _09434_/D _05968_/A _06042_/A VPWR VGND sg13cmos5l_nor2_1
X_05899_ _05997_/C _05891_/A _05893_/A _05586_/Y VPWR VGND sg13cmos5l_o21ai_1
X_07707_ _07719_/B _07702_/Y _07706_/Y _07705_/A VPWR VGND sg13cmos5l_a21oi_1
X_08687_ _08711_/A _08522_/Y _08656_/X _08699_/B VPWR VGND sg13cmos5l_mux2_1
X_04919_ _06993_/A _06586_/B VPWR VGND sg13cmos5l_inv_1
X_07638_ _09100_/D _07638_/A _07639_/B VPWR VGND sg13cmos5l_nor2_1
X_07569_ _07570_/B _07668_/C _07668_/D VPWR VGND sg13cmos5l_nand2_1
X_09308_ hold903/A _09387_/CLK _09308_/D _09308_/RESET_B VPWR VGND sg13cmos5l_dfrbpq_1
XFILLER_10_934 VPWR VGND sg13cmos5l_fill_2
X_09239_ _09239_/Q clkload3/A _09239_/D _09239_/RESET_B VPWR VGND sg13cmos5l_dfrbpq_1
Xhold990 hold990/X hold990/A VPWR VGND sg13cmos5l_dlygate4sd3_1
XFILLER_44_341 VPWR VGND sg13cmos5l_decap_8
XFILLER_45_875 VPWR VGND sg13cmos5l_fill_1
XFILLER_44_396 VPWR VGND sg13cmos5l_fill_2
XFILLER_12_260 VPWR VGND sg13cmos5l_fill_2
XFILLER_13_783 VPWR VGND sg13cmos5l_fill_2
X_06940_ _06940_/Y _09589_/Q _04967_/Y _06937_/Y _06938_/Y _06939_/Y VPWR VGND sg13cmos5l_a221oi_1
X_06871_ _07019_/B _06876_/B _06876_/C _06869_/Y VPWR VGND sg13cmos5l_a21o_1
X_05822_ _05822_/X _05842_/B _06165_/A VPWR VGND sg13cmos5l_and2_1
X_08610_ _08697_/B _09242_/Q _08626_/B VPWR VGND sg13cmos5l_nand2_1
X_09590_ _09590_/Q _09591_/CLK _09590_/D _09590_/RESET_B VPWR VGND sg13cmos5l_dfrbpq_1
XFILLER_36_820 VPWR VGND sg13cmos5l_fill_2
X_05753_ _05753_/Y _05756_/A VPWR VGND sg13cmos5l_inv_1
X_08541_ _08541_/X _08536_/S _08538_/Y _08539_/Y VPWR VGND sg13cmos5l_a21o_1
X_08472_ _08472_/Y _08450_/A fanout21/X _08474_/B1 VPWR VGND sg13cmos5l_o21ai_1
X_05684_ _09382_/D _05684_/A _05684_/B VPWR VGND sg13cmos5l_nor2_1
X_07423_ _07423_/Y _07450_/A _07423_/B VPWR VGND sg13cmos5l_nor2_1
XFILLER_24_18 VPWR VGND sg13cmos5l_fill_1
X_09589__497 _09589_/RESET_B VPWR VGND sg13cmos5l_tiehi
X_07354_ _07354_/Y _07367_/A _07349_/A _07353_/Y _04954_/Y VPWR VGND sg13cmos5l_a22oi_1
X_07285_ _09037_/D _07386_/B _07450_/A VPWR VGND sg13cmos5l_and2_1
X_06305_ _06558_/A _07721_/A hold912/X VPWR VGND sg13cmos5l_nor2_1
X_09024_ hold891/A _09608_/CLK _09024_/D _09024_/RESET_B VPWR VGND sg13cmos5l_dfrbpq_1
X_06236_ _06278_/C _09470_/Q _06243_/B _06244_/A VPWR VGND sg13cmos5l_o21ai_1
XFILLER_2_418 VPWR VGND sg13cmos5l_fill_1
X_06167_ _06167_/Y _06473_/A _09417_/Q VPWR VGND sg13cmos5l_nand2b_1
X_05118_ _05118_/Y _05209_/B _05115_/X _05117_/Y VPWR VGND sg13cmos5l_o21ai_1
X_06098_ _06098_/Y _06098_/A _06387_/A VPWR VGND sg13cmos5l_nand2_1
X_09225__242 _09225_/RESET_B VPWR VGND sg13cmos5l_tiehi
X_05049_ _05049_/Y hold1285/X _05045_/Y _05047_/Y _05048_/Y VPWR VGND sg13cmos5l_a22oi_1
X_08808_ _08808_/Y _05001_/Y _08803_/A _08807_/A _05000_/Y _08804_/Y VPWR VGND sg13cmos5l_a221oi_1
X_08739_ _08746_/B _09256_/Q _09255_/Q _08739_/C VPWR VGND sg13cmos5l_or3_1
XFILLER_7_1001 VPWR VGND sg13cmos5l_fill_1
X_09024__458 _09024_/RESET_B VPWR VGND sg13cmos5l_tiehi
XFILLER_39_70 VPWR VGND sg13cmos5l_fill_1
XFILLER_29_190 VPWR VGND sg13cmos5l_fill_1
XFILLER_13_591 VPWR VGND sg13cmos5l_fill_2
X_07070_ _09590_/D _07070_/A _07070_/B VPWR VGND sg13cmos5l_nor2_1
X_06021_ _06021_/Y _06007_/A _06007_/B _06020_/Y VPWR VGND sg13cmos5l_a21oi_1
X_07972_ _07972_/Y _07955_/A _07972_/B _07972_/C VPWR VGND sg13cmos5l_nand3b_1
X_06923_ _07022_/C _06923_/A _06923_/B _06923_/C VPWR VGND sg13cmos5l_nand3_1
X_06854_ _07330_/A _06853_/B _06854_/B VPWR VGND sg13cmos5l_nand2b_1
X_05805_ _05805_/X _09406_/Q _05843_/A VPWR VGND sg13cmos5l_xor2_1
X_09573_ _09573_/Q _09573_/CLK _09573_/D _09573_/RESET_B VPWR VGND sg13cmos5l_dfrbpq_1
X_06785_ _06785_/X _06792_/A _06792_/B VPWR VGND sg13cmos5l_or2_1
X_05736_ _05760_/B _05746_/B _05746_/C VPWR VGND sg13cmos5l_or2_1
X_08524_ _08524_/Y _08524_/A _08538_/B VPWR VGND sg13cmos5l_nor2_1
X_05667_ _05667_/Y _09381_/Q _05667_/B VPWR VGND sg13cmos5l_nand2_1
X_08455_ _08458_/A _08455_/A _08455_/B _08455_/C VPWR VGND sg13cmos5l_nor3_1
X_05598_ _05612_/B _09336_/Q _09337_/Q _09335_/Q _09334_/Q VPWR VGND sg13cmos5l_or4_1
X_07406_ _07407_/B _07411_/C _07412_/B VPWR VGND sg13cmos5l_nor2b_1
X_08386_ _09203_/D _08393_/A hold877/X VPWR VGND sg13cmos5l_and2_1
X_07337_ _07337_/Y _07639_/A _09573_/Q _09572_/Q _07638_/A _07336_/Y VPWR VGND sg13cmos5l_a221oi_1
X_07268_ _07269_/B _07416_/A _07416_/B VPWR VGND sg13cmos5l_and2_1
X_09007_ _09007_/Q clkload9/A _09007_/D _09007_/RESET_B VPWR VGND sg13cmos5l_dfrbpq_1
X_07199_ _09019_/D _08838_/A _07199_/B VPWR VGND sg13cmos5l_and2_1
X_06219_ _09468_/D _06219_/A _06303_/A VPWR VGND sg13cmos5l_nor2_1
X_09459__648 _09459_/RESET_B VPWR VGND sg13cmos5l_tiehi
XFILLER_46_458 VPWR VGND sg13cmos5l_fill_2
XFILLER_42_620 VPWR VGND sg13cmos5l_fill_1
XFILLER_10_550 VPWR VGND sg13cmos5l_fill_2
XFILLER_10_561 VPWR VGND sg13cmos5l_fill_1
XFILLER_29_1002 VPWR VGND sg13cmos5l_fill_2
XFILLER_37_414 VPWR VGND sg13cmos5l_fill_2
X_09098__378 _09098_/RESET_B VPWR VGND sg13cmos5l_tiehi
X_06570_ _06581_/B _09552_/Q _09551_/Q _09550_/Q VPWR VGND sg13cmos5l_nor3_1
X_09234__831 _09234_/RESET_B VPWR VGND sg13cmos5l_tiehi
X_05521_ _09360_/D _05497_/B _05517_/B _05520_/Y VPWR VGND sg13cmos5l_a21oi_1
X_08240_ _08294_/A _08604_/A _08240_/B VPWR VGND sg13cmos5l_nand2_1
X_09215__252 _09215_/RESET_B VPWR VGND sg13cmos5l_tiehi
X_05452_ _05452_/Y _05450_/Y _05451_/Y _05487_/A VPWR VGND sg13cmos5l_a21oi_1
XFILLER_36_1028 VPWR VGND sg13cmos5l_fill_1
X_08171_ _08172_/B _08171_/A _08171_/B VPWR VGND sg13cmos5l_xor2_1
XFILLER_21_859 VPWR VGND sg13cmos5l_fill_2
X_07122_ _07136_/B _07122_/A _07128_/A VPWR VGND sg13cmos5l_xnor2_1
X_05383_ _05383_/Y _05384_/B VPWR VGND sg13cmos5l_inv_1
X_07053_ _07053_/Y _07053_/A _07053_/B VPWR VGND sg13cmos5l_nand2_1
X_06004_ _06004_/Y _06004_/A _06025_/B VPWR VGND sg13cmos5l_nor2_1
X_07955_ _07972_/B _07955_/A _07955_/B VPWR VGND sg13cmos5l_nor2_1
X_09222__245 _09222_/RESET_B VPWR VGND sg13cmos5l_tiehi
X_06906_ _06906_/Y _06906_/A VPWR VGND sg13cmos5l_inv_1
X_07886_ _09130_/D _04824_/Y fanout49/X _07885_/Y VPWR VGND sg13cmos5l_a21oi_1
X_06837_ _06880_/A _06846_/B _06836_/Y VPWR VGND sg13cmos5l_nor2b_1
X_09556_ _09556_/Q clkload17/A _09556_/D _09556_/RESET_B VPWR VGND sg13cmos5l_dfrbpq_1
X_06768_ _06768_/Y _06768_/A _06768_/B _06768_/C _06768_/D VPWR VGND sg13cmos5l_nand4_1
X_08507_ _08508_/B _08506_/B _08507_/B VPWR VGND sg13cmos5l_nand2b_1
X_06699_ _06699_/Y _09531_/Q _06694_/Y _06698_/Y _09532_/Q VPWR VGND sg13cmos5l_a22oi_1
X_05719_ _05720_/A _05719_/A _05719_/B VPWR VGND sg13cmos5l_xnor2_1
X_09487_ _09487_/Q clkload23/A _09487_/D _09487_/RESET_B VPWR VGND sg13cmos5l_dfrbpq_1
X_08438_ _08439_/B _08438_/A _08438_/B VPWR VGND sg13cmos5l_nor2_1
XFILLER_7_307 VPWR VGND sg13cmos5l_fill_2
X_08369_ _08369_/Y _04928_/Y _08364_/Y _08368_/Y VPWR VGND sg13cmos5l_o21ai_1
XFILLER_43_951 VPWR VGND sg13cmos5l_fill_1
X_04952_ _04952_/Y _07588_/B VPWR VGND sg13cmos5l_inv_1
X_07740_ _07767_/A _07740_/A _07762_/A VPWR VGND sg13cmos5l_xnor2_1
X_07671_ _07671_/Y _07667_/Y _07669_/Y _07670_/Y VPWR VGND sg13cmos5l_o21ai_1
X_04883_ _04883_/Y _09247_/Q VPWR VGND sg13cmos5l_inv_1
X_09410_ _09410_/Q clkload20/A _09410_/D _09410_/RESET_B VPWR VGND sg13cmos5l_dfrbpq_1
X_06622_ _06623_/B _06622_/A _06622_/B VPWR VGND sg13cmos5l_nand2_1
X_09341_ _09341_/Q clkload18/A _09341_/D _09341_/RESET_B VPWR VGND sg13cmos5l_dfrbpq_1
X_06553_ _06554_/B _06531_/B _06528_/Y _06557_/S VPWR VGND sg13cmos5l_mux2_1
X_05504_ _05504_/Y _05504_/A _05508_/B VPWR VGND sg13cmos5l_nor2_1
X_06484_ _06533_/B _09508_/Q _06495_/B VPWR VGND sg13cmos5l_nand2_1
X_09272_ hold976/A _09608_/CLK _09272_/D _09272_/RESET_B VPWR VGND sg13cmos5l_dfrbpq_1
XFILLER_32_18 VPWR VGND sg13cmos5l_fill_2
X_09449__658 _09449_/RESET_B VPWR VGND sg13cmos5l_tiehi
X_08223_ _09179_/D _08231_/A _08223_/B VPWR VGND sg13cmos5l_nor2_1
X_05435_ hold889/A _04817_/Y fanout55/X _05434_/Y VPWR VGND sg13cmos5l_a21oi_1
X_05366_ _05371_/B _05366_/A _05366_/B VPWR VGND sg13cmos5l_nor2_1
X_08154_ _08206_/A _09176_/Q _08169_/A VPWR VGND sg13cmos5l_xnor2_1
X_08085_ _08182_/B _08058_/X _07780_/Y _08085_/S VPWR VGND sg13cmos5l_mux2_1
X_07105_ _07105_/X _05009_/C _07101_/B _07098_/X VPWR VGND sg13cmos5l_a21o_1
X_05297_ _05297_/Y _05764_/A VPWR VGND sg13cmos5l_inv_1
X_07036_ _07036_/Y _07036_/A _07036_/B VPWR VGND sg13cmos5l_xnor2_1
X_08987_ _08987_/Y hold888/X fanout54/X _08987_/B1 VPWR VGND sg13cmos5l_o21ai_1
X_07938_ _07938_/Y _07938_/A _07938_/B VPWR VGND sg13cmos5l_nor2_1
X_07869_ _09121_/D _07869_/A _07869_/B VPWR VGND sg13cmos5l_nor2_1
X_09608_ _09608_/Q _09608_/CLK _09608_/D _09608_/RESET_B VPWR VGND sg13cmos5l_dfrbpq_1
X_09539_ hold893/A clkload24/A _09539_/D _09539_/RESET_B VPWR VGND sg13cmos5l_dfrbpq_1
XFILLER_24_461 VPWR VGND sg13cmos5l_fill_1
XFILLER_24_494 VPWR VGND sg13cmos5l_fill_2
XFILLER_12_656 VPWR VGND sg13cmos5l_fill_2
X_10245_ _10245_/X _10245_/A VPWR VGND sg13cmos5l_buf_1
XFILLER_3_376 VPWR VGND sg13cmos5l_fill_1
XFILLER_0_0 VPWR VGND sg13cmos5l_fill_2
Xfanout190 _08234_/A _08757_/A VPWR VGND sg13cmos5l_buf_1
XFILLER_47_92 VPWR VGND sg13cmos5l_fill_1
XFILLER_31_954 VPWR VGND sg13cmos5l_fill_1
X_09212__255 _09212_/RESET_B VPWR VGND sg13cmos5l_tiehi
X_05220_ _05222_/B _05220_/A _05220_/B VPWR VGND sg13cmos5l_xnor2_1
X_05151_ _05152_/C _08728_/A _05149_/B _05150_/Y VPWR VGND sg13cmos5l_o21ai_1
XFILLER_7_660 VPWR VGND sg13cmos5l_fill_1
XFILLER_7_693 VPWR VGND sg13cmos5l_fill_1
X_05082_ _05083_/B _09318_/Q _05082_/B VPWR VGND sg13cmos5l_xnor2_1
X_08910_ _08911_/B _08873_/B _08909_/B _08909_/Y VPWR VGND sg13cmos5l_o21ai_1
X_08841_ _09280_/D _08841_/A _08842_/B VPWR VGND sg13cmos5l_and2_1
XFILLER_33_0 VPWR VGND sg13cmos5l_fill_1
Xheichips26_dna_sequencer_221 uio_out[7] VPWR VGND sg13cmos5l_tielo
Xhold1316 _08439_/A _09211_/Q VPWR VGND sg13cmos5l_dlygate4sd3_1
Xhold1305 _04918_/A _09550_/Q VPWR VGND sg13cmos5l_dlygate4sd3_1
Xhold1327 _05176_/A _09258_/Q VPWR VGND sg13cmos5l_dlygate4sd3_1
X_08772_ _08773_/B _08772_/A VPWR VGND sg13cmos5l_inv_1
Xhold1349 hold1349/X _09177_/Q VPWR VGND sg13cmos5l_dlygate4sd3_1
Xhold1338 _04873_/A _09512_/Q VPWR VGND sg13cmos5l_dlygate4sd3_1
X_05984_ _05985_/B _09434_/Q _05990_/B VPWR VGND sg13cmos5l_nand2b_1
X_04935_ _07550_/A _09043_/Q VPWR VGND sg13cmos5l_inv_1
X_07723_ _07750_/B _09143_/Q _09142_/Q _09141_/Q VPWR VGND sg13cmos5l_nor3_1
X_07654_ _07655_/B _09101_/Q _07661_/B VPWR VGND sg13cmos5l_nand2b_1
X_04866_ _06476_/A _04866_/A VPWR VGND sg13cmos5l_inv_1
X_06605_ _06767_/B _06623_/A _06603_/B _06604_/Y VPWR VGND sg13cmos5l_o21ai_1
X_07585_ _07594_/B _09107_/Q _04952_/Y _07584_/Y VPWR VGND sg13cmos5l_a21oi_1
X_06536_ _06538_/B _06507_/B _06535_/B _06535_/Y VPWR VGND sg13cmos5l_o21ai_1
XFILLER_33_280 VPWR VGND sg13cmos5l_fill_2
X_09324_ _09324_/Q clkload12/A _09324_/D _09324_/RESET_B VPWR VGND sg13cmos5l_dfrbpq_1
X_09255_ _09255_/Q clkload8/A _09255_/D _09255_/RESET_B VPWR VGND sg13cmos5l_dfrbpq_1
X_06467_ _06467_/Y hold936/X fanout59/X _06470_/A VPWR VGND sg13cmos5l_o21ai_1
X_09050__432 _09050_/RESET_B VPWR VGND sg13cmos5l_tiehi
X_08206_ _08207_/C _08206_/A _08206_/B _08206_/C VPWR VGND sg13cmos5l_and3_1
X_05418_ _05418_/Y _05415_/Y _05417_/Y _05397_/Y VPWR VGND sg13cmos5l_o21ai_1
X_06398_ _06398_/X _06398_/A _06409_/A _06409_/C VPWR VGND sg13cmos5l_or3_1
X_09186_ _09186_/Q _09347_/CLK _09186_/D _09186_/RESET_B VPWR VGND sg13cmos5l_dfrbpq_1
X_05349_ _05376_/B _09297_/Q _09296_/Q hold1388/X VPWR VGND sg13cmos5l_o21ai_1
X_08137_ _08137_/Y hold949/X fanout58/X _08394_/A VPWR VGND sg13cmos5l_o21ai_1
X_09462__644 _09462_/RESET_B VPWR VGND sg13cmos5l_tiehi
X_08068_ _08082_/C _08061_/Y _08064_/Y _08066_/Y VPWR VGND sg13cmos5l_a21o_1
X_07019_ _07019_/Y _07019_/A _07019_/B _07019_/C _07019_/D VPWR VGND sg13cmos5l_nand4_1
XFILLER_44_512 VPWR VGND sg13cmos5l_decap_8
XFILLER_17_759 VPWR VGND sg13cmos5l_fill_2
X_09439__668 _09439_/RESET_B VPWR VGND sg13cmos5l_tiehi
X_07370_ _07370_/Y _07353_/Y fanout33/X _07386_/B VPWR VGND sg13cmos5l_o21ai_1
X_06321_ _06349_/B _09485_/Q _06341_/A VPWR VGND sg13cmos5l_and2_1
X_06252_ _06252_/Y _06257_/A _06160_/B _06164_/B _06114_/Y VPWR VGND sg13cmos5l_a22oi_1
X_09040_ _09040_/Q _09573_/CLK _09040_/D _09040_/RESET_B VPWR VGND sg13cmos5l_dfrbpq_1
X_05203_ _08941_/A _05159_/B _05202_/Y _05203_/S VPWR VGND sg13cmos5l_mux2_1
XFILLER_8_991 VPWR VGND sg13cmos5l_fill_1
X_06183_ _06183_/Y _06182_/Y _09456_/Q VPWR VGND sg13cmos5l_nand2b_1
X_05134_ _05134_/Y _08932_/A VPWR VGND sg13cmos5l_inv_1
X_05065_ _05236_/A _09319_/Q _05078_/B VPWR VGND sg13cmos5l_xnor2_1
Xhold1113 _07634_/A _09064_/Q VPWR VGND sg13cmos5l_dlygate4sd3_1
Xhold1102 _08396_/A _09178_/Q VPWR VGND sg13cmos5l_dlygate4sd3_1
Xhold1124 _09455_/D _06200_/Y VPWR VGND sg13cmos5l_dlygate4sd3_1
X_08824_ _09267_/D _08824_/A _08824_/B VPWR VGND sg13cmos5l_nor2_1
X_08755_ _08759_/A _05177_/Y _08775_/S _08754_/Y VPWR VGND sg13cmos5l_a21oi_1
Xhold1146 _09233_/D _08590_/Y VPWR VGND sg13cmos5l_dlygate4sd3_1
Xhold1157 _09125_/D _07878_/Y VPWR VGND sg13cmos5l_dlygate4sd3_1
Xhold1135 _09532_/D _06720_/Y VPWR VGND sg13cmos5l_dlygate4sd3_1
Xhold1168 _09202_/D _08385_/Y VPWR VGND sg13cmos5l_dlygate4sd3_1
X_07706_ _07706_/Y _07701_/A _07701_/B _07703_/Y _07719_/A VPWR VGND sg13cmos5l_a22oi_1
XFILLER_26_501 VPWR VGND sg13cmos5l_fill_2
X_05967_ _09433_/D _05967_/A _06042_/A VPWR VGND sg13cmos5l_nor2_1
Xhold1179 _09018_/D _07198_/Y VPWR VGND sg13cmos5l_dlygate4sd3_1
X_05898_ _09412_/D _05898_/A _05898_/B VPWR VGND sg13cmos5l_nor2_1
X_08686_ _08686_/X _08692_/A _08692_/B VPWR VGND sg13cmos5l_or2_1
X_04918_ _06989_/A _04918_/A VPWR VGND sg13cmos5l_inv_1
X_07637_ _09099_/D _07637_/A _07639_/B VPWR VGND sg13cmos5l_nor2_1
X_04849_ _05697_/A _05317_/A VPWR VGND sg13cmos5l_inv_1
X_07568_ _07668_/D _07568_/A _07568_/B _07571_/C VPWR VGND sg13cmos5l_nand3_1
X_06519_ _06519_/Y _06519_/A VPWR VGND sg13cmos5l_inv_1
X_09307_ _09307_/Q clkload12/A _09307_/D _09307_/RESET_B VPWR VGND sg13cmos5l_dfrbpq_1
X_07499_ _07499_/Y _07489_/Y _07494_/Y _07498_/Y VPWR VGND sg13cmos5l_o21ai_1
X_09238_ _09238_/Q _09347_/CLK hold965/X _09238_/RESET_B VPWR VGND sg13cmos5l_dfrbpq_1
X_09169_ hold879/A _09312_/CLK _09169_/D _09169_/RESET_B VPWR VGND sg13cmos5l_dfrbpq_1
Xhold980 hold980/X hold980/A VPWR VGND sg13cmos5l_dlygate4sd3_1
Xhold991 hold991/X hold991/A VPWR VGND sg13cmos5l_dlygate4sd3_1
XFILLER_0_143 VPWR VGND sg13cmos5l_fill_2
XFILLER_32_504 VPWR VGND sg13cmos5l_fill_2
XFILLER_13_740 VPWR VGND sg13cmos5l_fill_1
X_06870_ _07019_/A _06832_/X _06876_/B _06876_/C VPWR VGND sg13cmos5l_nand3b_1
X_05821_ _06165_/A _05820_/B _05909_/A VPWR VGND sg13cmos5l_nand2b_1
X_09040__442 _09040_/RESET_B VPWR VGND sg13cmos5l_tiehi
X_08540_ _08699_/A _08536_/S _08538_/Y _08539_/Y VPWR VGND sg13cmos5l_a21oi_1
X_05752_ _05756_/A _05752_/A _05759_/B _05752_/C VPWR VGND sg13cmos5l_nor3_1
X_08471_ _09218_/D _08451_/B _08465_/Y _08470_/Y VPWR VGND sg13cmos5l_a21oi_1
X_05683_ _05684_/B _04984_/A _05675_/B _05530_/Y VPWR VGND sg13cmos5l_o21ai_1
X_07422_ _07422_/Y _07418_/Y _07420_/Y _07421_/Y VPWR VGND sg13cmos5l_o21ai_1
XFILLER_10_209 VPWR VGND sg13cmos5l_fill_2
X_07353_ _07353_/Y _07637_/A _07355_/B _07352_/Y VPWR VGND sg13cmos5l_o21ai_1
X_06304_ _09478_/D hold1278/X _06290_/Y _06303_/A VPWR VGND sg13cmos5l_a21oi_1
X_07284_ _07450_/A _07232_/Y _07280_/C _07577_/A VPWR VGND sg13cmos5l_o21ai_1
X_09023_ hold867/A _09608_/CLK _09023_/D _09023_/RESET_B VPWR VGND sg13cmos5l_dfrbpq_1
X_06235_ _06244_/A hold1335/X _06232_/B _06272_/A VPWR VGND sg13cmos5l_a21o_1
X_06166_ _09453_/D _06165_/A hold1290/X _06164_/A VPWR VGND sg13cmos5l_a21oi_1
X_06097_ _09442_/D _06164_/A _06097_/B VPWR VGND sg13cmos5l_nor2_1
X_05117_ _05117_/Y _05117_/A _05198_/A VPWR VGND sg13cmos5l_nand2_1
X_05048_ _05048_/Y input8/X input9/X _07076_/A VPWR VGND sg13cmos5l_a21oi_1
X_08807_ _08807_/Y _08807_/A VPWR VGND sg13cmos5l_inv_1
X_06999_ _07051_/B _09584_/Q _07011_/B VPWR VGND sg13cmos5l_nand2_1
X_08738_ _08738_/Y _08731_/Y _08735_/Y _08737_/Y VPWR VGND sg13cmos5l_o21ai_1
XFILLER_42_802 VPWR VGND sg13cmos5l_fill_1
X_08669_ _08679_/A _08639_/Y _08671_/S _08668_/X VPWR VGND sg13cmos5l_o21ai_1
XFILLER_41_323 VPWR VGND sg13cmos5l_fill_1
X_09429__678 _09429_/RESET_B VPWR VGND sg13cmos5l_tiehi
X_09399__711 _09399_/RESET_B VPWR VGND sg13cmos5l_tiehi
XFILLER_2_953 VPWR VGND sg13cmos5l_decap_4
XFILLER_49_434 VPWR VGND sg13cmos5l_fill_2
XFILLER_18_810 VPWR VGND sg13cmos5l_fill_2
XFILLER_29_180 VPWR VGND sg13cmos5l_fill_1
X_06020_ _06020_/Y _06020_/A _06020_/B VPWR VGND sg13cmos5l_nor2_1
X_07971_ _09144_/D _07952_/B _07967_/B _07970_/Y VPWR VGND sg13cmos5l_a21oi_1
X_06922_ _09563_/D _06988_/B _07019_/C _07019_/D VPWR VGND sg13cmos5l_and3_1
X_06853_ _06853_/Y _07390_/A _06853_/B VPWR VGND sg13cmos5l_nor2_1
X_09572_ _09572_/Q _09573_/CLK _09572_/D _09572_/RESET_B VPWR VGND sg13cmos5l_dfrbpq_1
X_06784_ _06792_/B _06615_/B _06669_/B _06799_/B VPWR VGND sg13cmos5l_mux2_1
X_05804_ _05804_/Y _06221_/A _05804_/B VPWR VGND sg13cmos5l_xnor2_1
X_05735_ _05754_/S _05746_/B _05746_/C VPWR VGND sg13cmos5l_nor2_1
X_08523_ _09222_/D _08603_/B _08523_/B VPWR VGND sg13cmos5l_nor2_1
X_09315__823 _09315_/RESET_B VPWR VGND sg13cmos5l_tiehi
X_08454_ _08455_/C _08454_/A _08454_/B _08454_/C VPWR VGND sg13cmos5l_and3_1
X_05666_ _05682_/A _05416_/A _05665_/B _05665_/Y VPWR VGND sg13cmos5l_a21oi_1
X_05597_ _05610_/B _09336_/Q _09335_/Q _09334_/Q VPWR VGND sg13cmos5l_or3_1
X_08385_ _08385_/Y _04926_/Y _08354_/B _08380_/A VPWR VGND sg13cmos5l_a21oi_1
X_07405_ _07407_/A _09062_/Q _07412_/B _07446_/A VPWR VGND sg13cmos5l_a21oi_1
X_07336_ _07336_/Y _09068_/Q _06974_/A _04960_/Y _09067_/Q _07335_/Y VPWR VGND sg13cmos5l_a221oi_1
X_09006_ _09006_/Q clkload9/A _09006_/D _09006_/RESET_B VPWR VGND sg13cmos5l_dfrbpq_1
X_07267_ _07416_/B _07267_/A _07272_/B _07272_/C VPWR VGND sg13cmos5l_nand3_1
X_06218_ _09467_/D _06218_/A _06218_/B VPWR VGND sg13cmos5l_and2_1
X_07198_ _07198_/Y _08785_/A _05003_/Y _07197_/A VPWR VGND sg13cmos5l_a21oi_1
X_06149_ _06151_/B _05837_/Y _06144_/Y _06148_/Y VPWR VGND sg13cmos5l_a21o_1
XFILLER_15_868 VPWR VGND sg13cmos5l_fill_2
XFILLER_30_816 VPWR VGND sg13cmos5l_fill_1
XFILLER_6_544 VPWR VGND sg13cmos5l_decap_4
X_09030__452 _09030_/RESET_B VPWR VGND sg13cmos5l_tiehi
XFILLER_24_109 VPWR VGND sg13cmos5l_fill_1
X_05520_ _05520_/Y _05497_/A _05517_/B _05443_/B VPWR VGND sg13cmos5l_o21ai_1
XFILLER_33_654 VPWR VGND sg13cmos5l_fill_2
X_05451_ _05451_/Y hold977/A hold899/A VPWR VGND sg13cmos5l_xnor2_1
X_08170_ _08232_/A _08207_/A _08170_/B VPWR VGND sg13cmos5l_nand2_1
X_05382_ _05384_/B _05198_/Y _05342_/Y _05382_/S VPWR VGND sg13cmos5l_mux2_1
X_07121_ _07121_/X _08785_/A _08786_/A VPWR VGND sg13cmos5l_and2_1
X_07052_ _07055_/A _07052_/A _07052_/B _07052_/C VPWR VGND sg13cmos5l_nor3_1
X_06003_ _06025_/B _06028_/A _06001_/B _06000_/Y _06002_/Y VPWR VGND sg13cmos5l_a22oi_1
X_07954_ _07955_/B _07912_/A _07916_/B _07912_/B VPWR VGND sg13cmos5l_o21ai_1
X_07885_ _07885_/Y hold951/X fanout49/X _07889_/A VPWR VGND sg13cmos5l_o21ai_1
X_06905_ _06906_/A _09528_/Q _06905_/B VPWR VGND sg13cmos5l_xnor2_1
X_06836_ _06836_/Y _09589_/Q _07295_/A _09590_/Q VPWR VGND sg13cmos5l_o21ai_1
X_09555_ _09555_/Q clkload17/A _09555_/D _09555_/RESET_B VPWR VGND sg13cmos5l_dfrbpq_1
X_06767_ _06767_/Y _06767_/A _06767_/B _06767_/C _06767_/D VPWR VGND sg13cmos5l_nand4_1
X_08506_ _08506_/Y _08506_/A _08506_/B VPWR VGND sg13cmos5l_nor2_1
X_06698_ _06698_/Y _06698_/A VPWR VGND sg13cmos5l_inv_1
X_05718_ _05742_/A _05718_/A _05718_/B VPWR VGND sg13cmos5l_or2_1
X_09486_ _09486_/Q clkload22/A _09486_/D _09486_/RESET_B VPWR VGND sg13cmos5l_dfrbpq_1
X_08437_ _08450_/B _08292_/B _08338_/B _08456_/B VPWR VGND sg13cmos5l_mux2_1
X_09389__721 _09389_/RESET_B VPWR VGND sg13cmos5l_tiehi
X_05649_ _05650_/A _05401_/A _05661_/B _05648_/Y VPWR VGND sg13cmos5l_a21oi_1
X_08368_ _08368_/Y _08371_/B _09201_/Q VPWR VGND sg13cmos5l_nand2b_1
X_08299_ _09189_/D _08397_/B _08459_/A VPWR VGND sg13cmos5l_and2_1
X_07319_ _09040_/D _07369_/A _07319_/B VPWR VGND sg13cmos5l_nor2_1
X_09606__527 _09606_/RESET_B VPWR VGND sg13cmos5l_tiehi
XFILLER_3_503 VPWR VGND sg13cmos5l_fill_2
X_09396__714 _09396_/RESET_B VPWR VGND sg13cmos5l_tiehi
XFILLER_47_746 VPWR VGND sg13cmos5l_decap_4
XFILLER_6_385 VPWR VGND sg13cmos5l_fill_1
X_04951_ _04951_/Y hold978/X VPWR VGND sg13cmos5l_inv_1
X_04882_ _04882_/Y _09249_/Q VPWR VGND sg13cmos5l_inv_1
X_07670_ _07670_/Y _07677_/A _07573_/B _07576_/B _07530_/X VPWR VGND sg13cmos5l_a22oi_1
X_09592__494 _09592_/RESET_B VPWR VGND sg13cmos5l_tiehi
X_06621_ _09519_/D _06771_/A _06771_/B _06627_/A VPWR VGND sg13cmos5l_a21oi_1
X_09340_ hold966/A clkload18/A hold967/X _09340_/RESET_B VPWR VGND sg13cmos5l_dfrbpq_1
X_06552_ _09512_/D _06552_/A _06552_/B VPWR VGND sg13cmos5l_nor2_1
X_09271_ hold904/A _09608_/CLK _09271_/D _09271_/RESET_B VPWR VGND sg13cmos5l_dfrbpq_1
X_05503_ _05507_/A _05503_/A _05503_/B _05503_/C VPWR VGND sg13cmos5l_nor3_1
X_06483_ _06533_/A _09509_/Q _06495_/B VPWR VGND sg13cmos5l_xnor2_1
X_08222_ _08223_/B _08194_/B _08201_/B _08229_/B VPWR VGND sg13cmos5l_mux2_1
X_05434_ _05434_/Y hold968/A fanout55/X _08995_/A VPWR VGND sg13cmos5l_o21ai_1
X_05365_ _05475_/D _05365_/A _05366_/B _05376_/C VPWR VGND sg13cmos5l_nand3_1
X_08153_ _08153_/Y _08151_/Y _08152_/Y _08189_/A VPWR VGND sg13cmos5l_a21oi_1
X_08084_ _09156_/D _08084_/A _08186_/A VPWR VGND sg13cmos5l_nor2_1
X_07104_ _09597_/D _08478_/A _07104_/B VPWR VGND sg13cmos5l_nor2_1
X_07035_ _07036_/B _06994_/Y _07045_/B VPWR VGND sg13cmos5l_nand2b_1
X_05296_ _05764_/A _05295_/B _05396_/A VPWR VGND sg13cmos5l_nand2b_1
X_08986_ _09308_/D _08986_/A hold908/X VPWR VGND sg13cmos5l_and2_1
X_07937_ _07938_/B _07764_/B _07817_/B _07950_/B VPWR VGND sg13cmos5l_mux2_1
XFILLER_29_724 VPWR VGND sg13cmos5l_fill_1
X_07868_ _07869_/B hold1205/X _07874_/S _07890_/B VPWR VGND sg13cmos5l_o21ai_1
X_07799_ _07799_/Y _07799_/A _07822_/A _07822_/B VPWR VGND sg13cmos5l_nand3_1
X_09607_ _09607_/Q clkload3/A _09607_/D _09607_/RESET_B VPWR VGND sg13cmos5l_dfrbpq_1
X_06819_ _06821_/A _06819_/A _06817_/S VPWR VGND sg13cmos5l_nor2b_1
X_09538_ hold913/A clkload13/A _09538_/D _09538_/RESET_B VPWR VGND sg13cmos5l_dfrbpq_1
X_09469_ _09469_/Q _09503_/CLK _09469_/D _09469_/RESET_B VPWR VGND sg13cmos5l_dfrbpq_1
XFILLER_11_178 VPWR VGND sg13cmos5l_fill_1
XFILLER_4_823 VPWR VGND sg13cmos5l_fill_2
XFILLER_4_856 VPWR VGND sg13cmos5l_fill_2
X_10244_ _10244_/X _10244_/A VPWR VGND sg13cmos5l_buf_1
XFILLER_3_355 VPWR VGND sg13cmos5l_fill_2
XFILLER_26_1028 VPWR VGND sg13cmos5l_fill_1
Xfanout191 _07721_/A _08757_/A VPWR VGND sg13cmos5l_buf_1
Xfanout180 _05317_/A hold1342/X VPWR VGND sg13cmos5l_buf_1
XFILLER_16_974 VPWR VGND sg13cmos5l_fill_1
X_05150_ _05150_/Y _09258_/Q _09259_/Q VPWR VGND sg13cmos5l_xnor2_1
XFILLER_7_672 VPWR VGND sg13cmos5l_fill_1
X_05081_ _05244_/A _05237_/A _05081_/B VPWR VGND sg13cmos5l_and2_1
X_08840_ _09279_/D _08840_/A _08842_/B VPWR VGND sg13cmos5l_and2_1
Xhold1306 _07431_/A _09059_/Q VPWR VGND sg13cmos5l_dlygate4sd3_1
X_08771_ _08772_/A _08770_/Y _05192_/Y _08775_/S VPWR VGND sg13cmos5l_mux2_1
Xheichips26_dna_sequencer_222 uo_out[6] VPWR VGND sg13cmos5l_tielo
Xhold1328 _07312_/A _09562_/Q VPWR VGND sg13cmos5l_dlygate4sd3_1
Xhold1317 _08440_/B _08439_/Y VPWR VGND sg13cmos5l_dlygate4sd3_1
X_05983_ _05985_/A _09433_/Q _05990_/B _06024_/A VPWR VGND sg13cmos5l_a21o_1
Xhold1339 _06243_/A _09470_/Q VPWR VGND sg13cmos5l_dlygate4sd3_1
X_04934_ _07538_/A _04934_/A VPWR VGND sg13cmos5l_inv_1
X_07722_ _07722_/Y hold948/X _08393_/A VPWR VGND sg13cmos5l_nand2b_1
X_04865_ _06475_/A _04865_/A VPWR VGND sg13cmos5l_inv_1
X_07653_ _07655_/A _09100_/Q _07661_/B _07698_/A VPWR VGND sg13cmos5l_a21o_1
X_09455__652 _09455_/RESET_B VPWR VGND sg13cmos5l_tiehi
XFILLER_38_587 VPWR VGND sg13cmos5l_fill_2
X_06604_ _06604_/Y _06604_/A _06629_/B VPWR VGND sg13cmos5l_nor2_1
X_07584_ _07584_/Y _07895_/A _09050_/Q _09049_/Q _07894_/A _07583_/Y VPWR VGND sg13cmos5l_a221oi_1
X_09323_ _09323_/Q clkload10/A _09323_/D _09323_/RESET_B VPWR VGND sg13cmos5l_dfrbpq_1
X_06535_ _06535_/Y _06535_/A _06535_/B VPWR VGND sg13cmos5l_nand2_1
XFILLER_33_270 VPWR VGND sg13cmos5l_fill_1
X_09254_ _09254_/Q clkload9/A _09254_/D _09254_/RESET_B VPWR VGND sg13cmos5l_dfrbpq_1
X_06466_ _09500_/D _04836_/Y fanout59/X _06465_/Y VPWR VGND sg13cmos5l_a21oi_1
X_09185_ _09185_/Q _09347_/CLK _09185_/D _09185_/RESET_B VPWR VGND sg13cmos5l_dfrbpq_1
X_08205_ _08205_/Y _08202_/Y _08204_/Y _08188_/Y VPWR VGND sg13cmos5l_o21ai_1
XFILLER_22_999 VPWR VGND sg13cmos5l_fill_2
X_05417_ _05417_/Y _09345_/Q _05397_/B _05416_/Y VPWR VGND sg13cmos5l_o21ai_1
X_06397_ _06399_/A _06397_/A _06413_/S VPWR VGND sg13cmos5l_nor2_1
X_08136_ hold907/A _04826_/Y fanout57/X _08135_/Y VPWR VGND sg13cmos5l_a21oi_1
X_05348_ _05348_/Y _05348_/A _05379_/B VPWR VGND sg13cmos5l_nor2_1
X_05279_ _05279_/X _05283_/B _05322_/A _05279_/C VPWR VGND sg13cmos5l_and3_1
X_08067_ _08067_/Y _08061_/Y _08064_/Y _08066_/Y VPWR VGND sg13cmos5l_a21oi_1
X_07018_ _07018_/Y _07018_/A _07018_/B _07018_/C _07018_/D VPWR VGND sg13cmos5l_nand4_1
XFILLER_0_369 VPWR VGND sg13cmos5l_decap_4
X_08969_ _08969_/Y _08972_/B _08969_/B VPWR VGND sg13cmos5l_nand2b_1
X_09393__717 _09393_/RESET_B VPWR VGND sg13cmos5l_tiehi
XFILLER_1_1019 VPWR VGND sg13cmos5l_decap_8
X_09094__382 _09094_/RESET_B VPWR VGND sg13cmos5l_tiehi
XFILLER_9_926 VPWR VGND sg13cmos5l_fill_2
XFILLER_13_977 VPWR VGND sg13cmos5l_decap_8
X_06320_ _06349_/A _06369_/A _06320_/B _06656_/A VPWR VGND sg13cmos5l_nor3_1
X_06251_ _06251_/Y _06247_/Y _06249_/X _06250_/Y VPWR VGND sg13cmos5l_o21ai_1
X_05202_ _05202_/Y _08742_/A _08750_/A VPWR VGND sg13cmos5l_nand2_1
X_06182_ _06182_/Y _04982_/Y _06189_/B _06181_/Y VPWR VGND sg13cmos5l_a21oi_1
X_05133_ _08932_/A _05175_/A _05175_/B VPWR VGND sg13cmos5l_and2_1
X_05064_ _05082_/B _05062_/Y _05063_/Y _05061_/Y VPWR VGND sg13cmos5l_a21oi_1
Xhold1114 _04855_/A _09283_/Q VPWR VGND sg13cmos5l_dlygate4sd3_1
Xhold1103 _08592_/B _09203_/Q VPWR VGND sg13cmos5l_dlygate4sd3_1
X_08823_ _08823_/X _05000_/Y _08807_/Y _08823_/S VPWR VGND sg13cmos5l_mux2_1
X_08754_ _08754_/Y _08775_/S _08753_/Y VPWR VGND sg13cmos5l_nor2b_1
Xhold1147 hold1147/X _09232_/Q VPWR VGND sg13cmos5l_dlygate4sd3_1
Xhold1125 _08122_/A _09160_/Q VPWR VGND sg13cmos5l_dlygate4sd3_1
Xhold1136 _05696_/A _09359_/Q VPWR VGND sg13cmos5l_dlygate4sd3_1
X_05966_ _09432_/D _05966_/A _06042_/A VPWR VGND sg13cmos5l_nor2_1
Xhold1158 _04979_/A _09421_/Q VPWR VGND sg13cmos5l_dlygate4sd3_1
X_07705_ _07719_/A _07705_/A _07705_/B VPWR VGND sg13cmos5l_nor2_1
Xhold1169 _04891_/A _09180_/Q VPWR VGND sg13cmos5l_dlygate4sd3_1
X_04917_ _06990_/A _04917_/A VPWR VGND sg13cmos5l_inv_1
X_05897_ _05898_/B _05581_/X _05884_/Y _05896_/Y VPWR VGND sg13cmos5l_o21ai_1
X_08685_ _08692_/B _08528_/B _08660_/Y _08699_/B VPWR VGND sg13cmos5l_mux2_1
X_04848_ _05700_/A _05411_/A VPWR VGND sg13cmos5l_inv_1
X_07636_ _09098_/D _07636_/A _07636_/B VPWR VGND sg13cmos5l_nor2_1
X_07567_ _07668_/C _07537_/Y _07558_/Y _07270_/Y VPWR VGND sg13cmos5l_o21ai_1
X_09306_ _09306_/Q clkload12/A _09306_/D _09306_/RESET_B VPWR VGND sg13cmos5l_dfrbpq_1
XFILLER_34_590 VPWR VGND sg13cmos5l_fill_1
X_06518_ _06519_/A _06518_/A _06518_/B VPWR VGND sg13cmos5l_nand2_1
X_07498_ _07498_/Y _07792_/A _07493_/Y _07501_/A _07528_/B VPWR VGND sg13cmos5l_a22oi_1
XFILLER_10_936 VPWR VGND sg13cmos5l_fill_1
XFILLER_16_1027 VPWR VGND sg13cmos5l_fill_2
XFILLER_21_240 VPWR VGND sg13cmos5l_fill_2
X_09237_ _09237_/Q _09312_/CLK hold901/X _09237_/RESET_B VPWR VGND sg13cmos5l_dfrbpq_1
X_06449_ _06450_/B hold1149/X _06456_/S _06473_/B VPWR VGND sg13cmos5l_o21ai_1
X_09168_ hold987/A _09388_/CLK hold917/X _09168_/RESET_B VPWR VGND sg13cmos5l_dfrbpq_1
X_08119_ _08121_/B _08119_/A _08130_/B VPWR VGND sg13cmos5l_nor2b_1
X_09099_ _09099_/Q clkload15/A _09099_/D _09099_/RESET_B VPWR VGND sg13cmos5l_dfrbpq_1
Xhold981 hold981/X hold981/A VPWR VGND sg13cmos5l_dlygate4sd3_1
Xhold970 hold970/X hold970/A VPWR VGND sg13cmos5l_dlygate4sd3_1
Xhold992 hold992/X hold992/A VPWR VGND sg13cmos5l_dlygate4sd3_1
XFILLER_28_84 VPWR VGND sg13cmos5l_fill_2
XFILLER_45_844 VPWR VGND sg13cmos5l_fill_1
XFILLER_44_354 VPWR VGND sg13cmos5l_decap_8
XFILLER_12_240 VPWR VGND sg13cmos5l_fill_1
XFILLER_12_262 VPWR VGND sg13cmos5l_fill_1
XFILLER_40_593 VPWR VGND sg13cmos5l_decap_4
XFILLER_8_233 VPWR VGND sg13cmos5l_fill_1
X_09445__662 _09445_/RESET_B VPWR VGND sg13cmos5l_tiehi
X_05820_ _05842_/B _06223_/A _05820_/B VPWR VGND sg13cmos5l_nand2_1
X_05751_ _05752_/C _05751_/A _05751_/B _05751_/C VPWR VGND sg13cmos5l_and3_1
X_09452__655 _09452_/RESET_B VPWR VGND sg13cmos5l_tiehi
X_08470_ _08470_/Y _08451_/A _08465_/Y _08474_/B1 VPWR VGND sg13cmos5l_o21ai_1
X_05682_ _05684_/A _05682_/A _05675_/B VPWR VGND sg13cmos5l_nor2b_1
X_07421_ _07421_/Y _07426_/A _07326_/B _07329_/B _07282_/Y VPWR VGND sg13cmos5l_a22oi_1
X_07352_ _07352_/Y _07352_/A _07355_/B VPWR VGND sg13cmos5l_nand2_1
X_06303_ _09477_/D _06303_/A _06303_/B VPWR VGND sg13cmos5l_nor2_1
X_07283_ _09036_/D _07463_/A _07447_/A VPWR VGND sg13cmos5l_nor2_1
X_09022_ _09022_/Q _09288_/CLK _09022_/D _09022_/RESET_B VPWR VGND sg13cmos5l_dfrbpq_1
X_06234_ _06272_/A _06271_/B _06271_/C _06271_/A VPWR VGND sg13cmos5l_a21oi_1
X_06165_ _06246_/A _06165_/A _06165_/B VPWR VGND sg13cmos5l_nand2_1
X_05116_ _05116_/Y _05198_/B _05385_/A VPWR VGND sg13cmos5l_nand2_1
X_06096_ _06096_/X _06085_/X _06094_/Y _06093_/Y VPWR VGND sg13cmos5l_a21o_1
X_05047_ _05047_/Y _05047_/A _05047_/B VPWR VGND sg13cmos5l_nand2_1
X_08806_ _08807_/A _08999_/A _08809_/B _08805_/Y VPWR VGND sg13cmos5l_o21ai_1
X_06998_ _07051_/A _09585_/Q _07011_/B VPWR VGND sg13cmos5l_xnor2_1
X_08737_ _08737_/Y _05143_/Y _08770_/A _08742_/B _08742_/A VPWR VGND sg13cmos5l_a22oi_1
X_05949_ hold974/A hold973/X _05949_/B VPWR VGND sg13cmos5l_nor2_1
X_08668_ _08668_/X _08659_/C _08663_/C _08289_/Y VPWR VGND sg13cmos5l_a21o_1
XFILLER_42_847 VPWR VGND sg13cmos5l_fill_1
X_07619_ _09086_/D _07716_/A _07619_/B VPWR VGND sg13cmos5l_nor2_1
X_08599_ _08599_/X _08599_/A _08599_/B VPWR VGND sg13cmos5l_and2_1
XFILLER_14_42 VPWR VGND sg13cmos5l_fill_1
XFILLER_2_921 VPWR VGND sg13cmos5l_fill_1
X_09321__519 _09321_/RESET_B VPWR VGND sg13cmos5l_tiehi
XFILLER_39_61 VPWR VGND sg13cmos5l_fill_1
XFILLER_18_800 VPWR VGND sg13cmos5l_fill_1
XFILLER_45_641 VPWR VGND sg13cmos5l_fill_2
XFILLER_33_803 VPWR VGND sg13cmos5l_fill_1
XFILLER_5_770 VPWR VGND sg13cmos5l_fill_2
XFILLER_45_1020 VPWR VGND sg13cmos5l_decap_8
X_07970_ _07970_/Y _07952_/A _07967_/B _07890_/B VPWR VGND sg13cmos5l_o21ai_1
X_06921_ _07019_/D _06920_/A _06923_/C _06611_/B VPWR VGND sg13cmos5l_a21o_1
XFILLER_49_980 VPWR VGND sg13cmos5l_decap_8
X_06852_ _06883_/B _07390_/A _06853_/B VPWR VGND sg13cmos5l_nand2_1
X_09571_ _09571_/Q clkload15/A _09571_/D _09571_/RESET_B VPWR VGND sg13cmos5l_dfrbpq_1
X_06783_ _06792_/A _06798_/B _06783_/B VPWR VGND sg13cmos5l_nor2_1
X_05803_ _05848_/A _09438_/Q _05804_/B VPWR VGND sg13cmos5l_xnor2_1
X_05734_ _05746_/C _05764_/B _05734_/B VPWR VGND sg13cmos5l_nor2_1
X_08522_ _08522_/Y _08522_/A VPWR VGND sg13cmos5l_inv_1
X_08453_ _08453_/Y _08450_/A _08450_/B _08449_/Y _08452_/Y VPWR VGND sg13cmos5l_a22oi_1
X_07404_ _07446_/A _07445_/B _07445_/C _07445_/A VPWR VGND sg13cmos5l_a21oi_1
X_05665_ _05665_/Y hold997/X _05665_/B VPWR VGND sg13cmos5l_nor2_1
X_05596_ _09370_/D _05637_/A _05764_/B VPWR VGND sg13cmos5l_nor2_1
X_08384_ _08384_/Y _08371_/A _08373_/Y _08383_/Y VPWR VGND sg13cmos5l_a21oi_1
X_07335_ _07335_/Y _07637_/A _09571_/Q _09570_/Q _07636_/A _07334_/Y VPWR VGND sg13cmos5l_a221oi_1
X_07266_ _07416_/A _07280_/B _07280_/C _07265_/Y VPWR VGND sg13cmos5l_o21ai_1
XFILLER_13_1008 VPWR VGND sg13cmos5l_decap_8
X_09005_ _09031_/D _09005_/A _09005_/B VPWR VGND sg13cmos5l_nor2_1
X_06217_ _09466_/D _06736_/A hold873/X VPWR VGND sg13cmos5l_and2_1
X_07197_ hold924/A _07197_/A _07197_/B hold923/X VPWR VGND sg13cmos5l_nor3_1
X_06148_ _06148_/Y _06148_/A _06148_/B _06148_/C VPWR VGND sg13cmos5l_nor3_1
XFILLER_2_206 VPWR VGND sg13cmos5l_fill_2
X_06079_ _06079_/Y _06079_/A _06079_/B _06079_/C VPWR VGND sg13cmos5l_nand3_1
XFILLER_26_140 VPWR VGND sg13cmos5l_fill_1
X_09435__672 _09435_/RESET_B VPWR VGND sg13cmos5l_tiehi
XFILLER_41_143 VPWR VGND sg13cmos5l_fill_2
XFILLER_10_552 VPWR VGND sg13cmos5l_fill_1
X_09442__665 _09442_/RESET_B VPWR VGND sg13cmos5l_tiehi
Xclkbuf_leaf_29_clk _09573_/CLK clkbuf_3_5__f_clk/X VPWR VGND sg13cmos5l_buf_8
X_05450_ _05450_/Y hold968/A hold857/A VPWR VGND sg13cmos5l_xnor2_1
X_05381_ _09337_/D _05423_/A _05484_/A VPWR VGND sg13cmos5l_nor2_1
X_07120_ _08786_/A _08842_/A _07138_/B VPWR VGND sg13cmos5l_nor2b_1
X_07051_ _07052_/C _07051_/A _07051_/B _07051_/C VPWR VGND sg13cmos5l_and3_1
X_06002_ _06002_/Y _05856_/B _05905_/Y _06001_/Y VPWR VGND sg13cmos5l_a21oi_1
X_07953_ _07958_/A _07953_/A _07928_/B VPWR VGND sg13cmos5l_nor2b_1
X_07884_ _09129_/D _04825_/Y fanout49/X _07883_/Y VPWR VGND sg13cmos5l_a21oi_1
X_06904_ _06904_/Y _06902_/Y _06903_/Y _06898_/Y VPWR VGND sg13cmos5l_a21oi_1
X_06835_ _06846_/B _09590_/Q _09589_/Q _07295_/A VPWR VGND sg13cmos5l_nor3_1
X_09554_ _09554_/Q _09591_/CLK _09554_/D _09554_/RESET_B VPWR VGND sg13cmos5l_dfrbpq_1
X_06766_ _06794_/B _06759_/A _06759_/B _06765_/Y VPWR VGND sg13cmos5l_o21ai_1
X_09485_ _09485_/Q _09491_/CLK _09485_/D _09485_/RESET_B VPWR VGND sg13cmos5l_dfrbpq_1
X_08505_ _08518_/B _08506_/A _08506_/B VPWR VGND sg13cmos5l_nand2_1
X_06697_ _06698_/A _04971_/Y _06705_/B _06696_/Y VPWR VGND sg13cmos5l_a21oi_1
X_05717_ _05759_/B _05718_/A _05718_/B VPWR VGND sg13cmos5l_nor2_1
X_08436_ _08456_/B _08459_/A _08434_/B _08433_/Y _08435_/Y VPWR VGND sg13cmos5l_a22oi_1
XFILLER_12_817 VPWR VGND sg13cmos5l_fill_1
XFILLER_23_154 VPWR VGND sg13cmos5l_fill_2
XFILLER_23_165 VPWR VGND sg13cmos5l_fill_2
X_05648_ _05648_/Y _05963_/A _05661_/B VPWR VGND sg13cmos5l_nor2_1
X_08367_ _08371_/B _08113_/A _08366_/B _08366_/Y VPWR VGND sg13cmos5l_a21oi_1
X_05579_ _05579_/X _05593_/S _05575_/Y _05577_/Y VPWR VGND sg13cmos5l_a21o_1
X_07318_ _07319_/B _07416_/C _07416_/D VPWR VGND sg13cmos5l_nand2_1
X_08298_ _08459_/A _08245_/Y _08293_/C _08675_/A VPWR VGND sg13cmos5l_o21ai_1
XFILLER_20_883 VPWR VGND sg13cmos5l_fill_1
X_07249_ _07280_/A _09036_/Q _07249_/B VPWR VGND sg13cmos5l_xor2_1
XFILLER_3_537 VPWR VGND sg13cmos5l_fill_2
XFILLER_47_725 VPWR VGND sg13cmos5l_fill_1
XFILLER_46_213 VPWR VGND sg13cmos5l_fill_1
XFILLER_42_441 VPWR VGND sg13cmos5l_fill_2
XFILLER_14_165 VPWR VGND sg13cmos5l_fill_2
XFILLER_6_353 VPWR VGND sg13cmos5l_fill_2
X_04950_ _04950_/Y _04950_/A VPWR VGND sg13cmos5l_inv_1
XFILLER_37_213 VPWR VGND sg13cmos5l_fill_1
X_04881_ _04881_/Y _09248_/Q VPWR VGND sg13cmos5l_inv_1
X_06620_ _06620_/Y _06771_/A _06771_/B VPWR VGND sg13cmos5l_nand2_1
X_06551_ _06552_/B _06521_/X _06519_/A _06557_/S VPWR VGND sg13cmos5l_mux2_1
X_06482_ _06544_/B hold1249/X _06495_/B VPWR VGND sg13cmos5l_nand2b_1
X_09270_ hold908/A _09312_/CLK _09270_/D _09270_/RESET_B VPWR VGND sg13cmos5l_dfrbpq_1
X_05502_ _05503_/C _05502_/A _05502_/B _05502_/C VPWR VGND sg13cmos5l_and3_1
X_08221_ _09178_/D _08221_/A _08220_/Y VPWR VGND sg13cmos5l_nor2b_1
X_05433_ _05433_/X _05433_/A _05433_/B VPWR VGND sg13cmos5l_or2_1
XFILLER_20_146 VPWR VGND sg13cmos5l_fill_2
X_05364_ _05475_/C _05379_/A _05379_/C _05179_/Y VPWR VGND sg13cmos5l_o21ai_1
X_08152_ _08152_/Y hold949/A hold881/A VPWR VGND sg13cmos5l_xnor2_1
X_05295_ _05331_/B _05701_/A _05295_/B VPWR VGND sg13cmos5l_nand2_1
X_08083_ _08186_/A _07776_/Y _08085_/S _08082_/X VPWR VGND sg13cmos5l_a21oi_1
X_07103_ _07103_/Y _05009_/C _07098_/X _07102_/Y VPWR VGND sg13cmos5l_a21oi_1
Xclkbuf_leaf_9_clk clkload8/A clkbuf_leaf_9_clk/A VPWR VGND sg13cmos5l_buf_8
X_07034_ _07034_/Y _07034_/A _07034_/B VPWR VGND sg13cmos5l_nor2_1
X_08985_ _09307_/D _04992_/Y _08954_/B _08942_/B VPWR VGND sg13cmos5l_a21oi_1
X_07936_ _07936_/Y _07962_/A _07936_/B VPWR VGND sg13cmos5l_nor2_1
X_07867_ _07869_/A _07867_/A _07874_/S VPWR VGND sg13cmos5l_nor2b_1
XFILLER_17_909 VPWR VGND sg13cmos5l_fill_1
X_07798_ _07798_/Y _07891_/A _07795_/X _07818_/B _07797_/X VPWR VGND sg13cmos5l_a22oi_1
X_06818_ _09552_/D _06818_/A _06818_/B VPWR VGND sg13cmos5l_nor2_1
XFILLER_25_920 VPWR VGND sg13cmos5l_fill_1
X_09606_ _09606_/Q _09608_/CLK _09606_/D _09606_/RESET_B VPWR VGND sg13cmos5l_dfrbpq_1
XFILLER_37_780 VPWR VGND sg13cmos5l_fill_2
X_09537_ hold926/A _09575_/CLK _09537_/D _09537_/RESET_B VPWR VGND sg13cmos5l_dfrbpq_1
X_06749_ _06788_/A _06749_/A _06764_/B VPWR VGND sg13cmos5l_xnor2_1
X_09468_ _09468_/Q _09503_/CLK _09468_/D _09468_/RESET_B VPWR VGND sg13cmos5l_dfrbpq_1
X_09432__675 _09432_/RESET_B VPWR VGND sg13cmos5l_tiehi
X_08419_ _08420_/C _08419_/A _08419_/B VPWR VGND sg13cmos5l_nor2_1
X_09399_ _09399_/Q clkload20/A _09399_/D _09399_/RESET_B VPWR VGND sg13cmos5l_dfrbpq_1
X_10243_ _10243_/X _10243_/A VPWR VGND sg13cmos5l_buf_1
X_09205__264 _09205_/RESET_B VPWR VGND sg13cmos5l_tiehi
Xfanout181 _08997_/A hold1256/X VPWR VGND sg13cmos5l_buf_1
Xfanout192 _08757_/A _04875_/Y VPWR VGND sg13cmos5l_buf_1
Xfanout170 _05443_/B _05262_/Y VPWR VGND sg13cmos5l_buf_1
XFILLER_47_50 VPWR VGND sg13cmos5l_fill_1
XFILLER_43_761 VPWR VGND sg13cmos5l_fill_1
XFILLER_15_430 VPWR VGND sg13cmos5l_fill_2
XFILLER_16_986 VPWR VGND sg13cmos5l_fill_2
Xclkbuf_3_4__f_clk clkbuf_3_4__f_clk/X clkbuf_0_clk/X VPWR VGND sg13cmos5l_buf_8
XFILLER_31_923 VPWR VGND sg13cmos5l_fill_2
XFILLER_30_444 VPWR VGND sg13cmos5l_fill_2
XFILLER_30_477 VPWR VGND sg13cmos5l_fill_1
X_05080_ _05081_/B _05082_/B hold1321/X VPWR VGND sg13cmos5l_nor2b_1
Xhold1307 _07432_/B _07431_/Y VPWR VGND sg13cmos5l_dlygate4sd3_1
X_08770_ _08770_/Y _08770_/A _08770_/B VPWR VGND sg13cmos5l_nor2_1
Xheichips26_dna_sequencer_223 uo_out[7] VPWR VGND sg13cmos5l_tielo
Xhold1329 _08423_/A _09213_/Q VPWR VGND sg13cmos5l_dlygate4sd3_1
Xhold1318 hold1318/X _09586_/Q VPWR VGND sg13cmos5l_dlygate4sd3_1
X_05982_ _06024_/A _06023_/B _06023_/C _06023_/A VPWR VGND sg13cmos5l_a21oi_1
X_04933_ _06121_/B _04933_/A VPWR VGND sg13cmos5l_inv_1
X_07721_ _07890_/B _07721_/A hold948/X VPWR VGND sg13cmos5l_nor2_1
XFILLER_19_0 VPWR VGND sg13cmos5l_fill_2
X_07652_ _07698_/A _07697_/B _07697_/C _07697_/A VPWR VGND sg13cmos5l_a21oi_1
X_04864_ _06223_/A _05909_/A VPWR VGND sg13cmos5l_inv_1
X_07583_ _07583_/Y _09106_/Q _07360_/A _04954_/Y _09105_/Q _07582_/Y VPWR VGND sg13cmos5l_a221oi_1
X_06603_ _06630_/S _06623_/A _06603_/B VPWR VGND sg13cmos5l_or2_1
X_06534_ _06534_/Y _06542_/A _06534_/B _06534_/C VPWR VGND sg13cmos5l_nor3_1
X_09322_ _09322_/Q clkload10/A _09322_/D _09322_/RESET_B VPWR VGND sg13cmos5l_dfrbpq_1
X_09253_ _09253_/Q clkload9/A _09253_/D _09253_/RESET_B VPWR VGND sg13cmos5l_dfrbpq_1
X_06465_ _06465_/Y hold925/X fanout59/X _06727_/A VPWR VGND sg13cmos5l_o21ai_1
X_06396_ _06413_/S _06396_/A _06409_/C VPWR VGND sg13cmos5l_nor2_1
X_09184_ _09184_/Q _09347_/CLK _09184_/D _09184_/RESET_B VPWR VGND sg13cmos5l_dfrbpq_1
X_08204_ _08204_/Y _08226_/A _08188_/B _08203_/Y VPWR VGND sg13cmos5l_o21ai_1
X_05416_ _05416_/Y _05416_/A _05416_/B VPWR VGND sg13cmos5l_nand2_1
X_05347_ _05347_/Y _05107_/Y _05342_/A _05379_/B _05348_/A VPWR VGND sg13cmos5l_a22oi_1
X_08135_ _08135_/Y _09166_/Q fanout57/X _07889_/A VPWR VGND sg13cmos5l_o21ai_1
XFILLER_4_109 VPWR VGND sg13cmos5l_fill_2
X_05278_ _05278_/Y _05316_/B _05276_/Y _05277_/Y _05317_/A VPWR VGND sg13cmos5l_a22oi_1
X_08066_ _08066_/Y _07733_/Y _08063_/X _08065_/Y VPWR VGND sg13cmos5l_o21ai_1
X_07017_ _07034_/A _07017_/A _07017_/B VPWR VGND sg13cmos5l_nand2_1
X_08968_ _08972_/B _04999_/Y _08967_/B _08967_/Y VPWR VGND sg13cmos5l_a21oi_1
X_09159__314 _09159_/RESET_B VPWR VGND sg13cmos5l_tiehi
X_07919_ _07967_/A _07949_/B _07919_/B VPWR VGND sg13cmos5l_nor2_1
XFILLER_29_533 VPWR VGND sg13cmos5l_fill_2
X_08899_ _08899_/Y _08899_/A VPWR VGND sg13cmos5l_inv_1
XFILLER_16_205 VPWR VGND sg13cmos5l_fill_2
X_09166__307 _09166_/RESET_B VPWR VGND sg13cmos5l_tiehi
XFILLER_4_654 VPWR VGND sg13cmos5l_fill_2
XFILLER_3_142 VPWR VGND sg13cmos5l_fill_2
X_09578__508 _09578_/RESET_B VPWR VGND sg13cmos5l_tiehi
XFILLER_4_698 VPWR VGND sg13cmos5l_decap_4
XFILLER_0_860 VPWR VGND sg13cmos5l_fill_2
X_06250_ _06250_/Y _06102_/B _06155_/X _06159_/X _06109_/B VPWR VGND sg13cmos5l_a22oi_1
X_05201_ _08935_/A _05117_/A _05198_/Y _05201_/S VPWR VGND sg13cmos5l_mux2_1
X_06181_ _06181_/Y _06181_/A _06189_/B VPWR VGND sg13cmos5l_nor2_1
X_05132_ _05175_/B _05199_/C _05132_/B _05132_/C VPWR VGND sg13cmos5l_nand3_1
XFILLER_7_481 VPWR VGND sg13cmos5l_fill_2
XFILLER_7_470 VPWR VGND sg13cmos5l_decap_8
X_05063_ _05063_/Y hold909/A hold862/A VPWR VGND sg13cmos5l_xnor2_1
Xhold1104 hold1104/X _09230_/Q VPWR VGND sg13cmos5l_dlygate4sd3_1
X_08822_ _09266_/D _08803_/Y _08823_/S _08821_/Y VPWR VGND sg13cmos5l_a21oi_1
Xhold1115 _04860_/A _09439_/Q VPWR VGND sg13cmos5l_dlygate4sd3_1
X_09301__347 _09301_/RESET_B VPWR VGND sg13cmos5l_tiehi
X_08753_ _08753_/Y _08753_/A _08770_/B VPWR VGND sg13cmos5l_nor2_1
XFILLER_39_853 VPWR VGND sg13cmos5l_fill_1
Xhold1148 _09232_/D _08588_/Y VPWR VGND sg13cmos5l_dlygate4sd3_1
Xhold1126 _07355_/A _09068_/Q VPWR VGND sg13cmos5l_dlygate4sd3_1
Xhold1137 _04889_/A _09181_/Q VPWR VGND sg13cmos5l_dlygate4sd3_1
X_05965_ _09431_/D _05965_/A _06042_/A VPWR VGND sg13cmos5l_nor2_1
X_07704_ _07704_/Y _07655_/A _07655_/B _07660_/B VPWR VGND sg13cmos5l_a21oi_1
Xhold1159 _04897_/A _09142_/Q VPWR VGND sg13cmos5l_dlygate4sd3_1
X_04916_ _06992_/A _04916_/A VPWR VGND sg13cmos5l_inv_1
X_05896_ _05896_/Y _05896_/A _05896_/B _05903_/C VPWR VGND sg13cmos5l_nand3_1
X_08684_ _08692_/A _08698_/B _08684_/B VPWR VGND sg13cmos5l_nor2_1
X_04847_ _05699_/A _04847_/A VPWR VGND sg13cmos5l_inv_1
X_07635_ _09097_/D _07635_/A _07636_/B VPWR VGND sg13cmos5l_nor2_1
X_07566_ _09078_/D _07634_/B _07665_/C _07665_/D VPWR VGND sg13cmos5l_and3_1
X_09305_ _09305_/Q clkload18/A _09305_/D _09305_/RESET_B VPWR VGND sg13cmos5l_dfrbpq_1
X_06517_ _06517_/X _06517_/A _06517_/B VPWR VGND sg13cmos5l_xor2_1
X_07497_ _07497_/Y _07528_/B VPWR VGND sg13cmos5l_inv_1
X_09236_ hold956/A _09312_/CLK _09236_/D _09236_/RESET_B VPWR VGND sg13cmos5l_dfrbpq_1
X_06448_ _06450_/A _06448_/A _06456_/S VPWR VGND sg13cmos5l_nor2b_1
X_06379_ _06387_/C _09449_/Q _09448_/Q _09450_/Q VPWR VGND sg13cmos5l_o21ai_1
X_09167_ hold949/A _09388_/CLK _09167_/D _09167_/RESET_B VPWR VGND sg13cmos5l_dfrbpq_1
X_08118_ _08118_/Y _08353_/B _08116_/B _08115_/Y _08117_/Y VPWR VGND sg13cmos5l_a22oi_1
X_09098_ _09098_/Q clkload15/A _09098_/D _09098_/RESET_B VPWR VGND sg13cmos5l_dfrbpq_1
X_08049_ _08054_/A _08079_/A _08079_/B _08056_/A VPWR VGND sg13cmos5l_a21oi_1
Xhold971 hold971/X hold971/A VPWR VGND sg13cmos5l_dlygate4sd3_1
Xhold982 hold982/X hold982/A VPWR VGND sg13cmos5l_dlygate4sd3_1
Xhold960 hold960/X hold960/A VPWR VGND sg13cmos5l_dlygate4sd3_1
Xhold993 hold993/X hold993/A VPWR VGND sg13cmos5l_dlygate4sd3_1
Xheichips26_dna_sequencer uio_out[3] VPWR VGND sg13cmos5l_tielo
XFILLER_29_341 VPWR VGND sg13cmos5l_fill_2
XFILLER_45_823 VPWR VGND sg13cmos5l_fill_1
XFILLER_44_62 VPWR VGND sg13cmos5l_fill_2
XFILLER_4_495 VPWR VGND sg13cmos5l_fill_2
X_05750_ _05750_/X _05743_/A _05744_/X _05749_/Y VPWR VGND sg13cmos5l_a21o_1
XFILLER_39_1028 VPWR VGND sg13cmos5l_fill_1
X_05681_ _09381_/D _05667_/B _05672_/Y _05680_/Y VPWR VGND sg13cmos5l_a21oi_1
X_07420_ _07420_/Y _07426_/A _07326_/B _07419_/Y VPWR VGND sg13cmos5l_o21ai_1
XFILLER_35_366 VPWR VGND sg13cmos5l_fill_2
X_07351_ _07351_/Y _07340_/Y _07346_/Y _07350_/Y VPWR VGND sg13cmos5l_o21ai_1
X_06302_ _06303_/B _06283_/B _06280_/Y _06302_/S VPWR VGND sg13cmos5l_mux2_1
X_07282_ _07282_/Y _07277_/S _07279_/Y _07280_/Y VPWR VGND sg13cmos5l_a21oi_1
X_06233_ _06271_/C hold946/A hold873/A _09468_/Q VPWR VGND sg13cmos5l_nand3_1
X_09021_ hold993/A _09288_/CLK _09021_/D _09021_/RESET_B VPWR VGND sg13cmos5l_dfrbpq_1
X_06164_ _09452_/D _06164_/A _06164_/B VPWR VGND sg13cmos5l_nor2_1
X_09149__324 _09149_/RESET_B VPWR VGND sg13cmos5l_tiehi
X_05115_ _05115_/X _05198_/B _05385_/A VPWR VGND sg13cmos5l_and2_1
X_06095_ _06097_/B _06085_/X _06094_/Y _06093_/Y VPWR VGND sg13cmos5l_a21oi_1
X_05046_ _05047_/B _09603_/Q _09607_/Q VPWR VGND sg13cmos5l_nand2_1
X_08805_ _08805_/Y _09016_/Q _08809_/B VPWR VGND sg13cmos5l_nand2_1
X_06997_ _07015_/B _06995_/Y _06996_/Y _06994_/Y VPWR VGND sg13cmos5l_a21oi_1
X_08736_ _08742_/B _09255_/Q _08739_/C VPWR VGND sg13cmos5l_xor2_1
XFILLER_26_322 VPWR VGND sg13cmos5l_fill_2
X_05948_ _05948_/Y _05932_/B fanout39/X _05947_/Y VPWR VGND sg13cmos5l_a21oi_1
X_05879_ _05879_/Y _05547_/Y _05878_/X _05876_/Y VPWR VGND sg13cmos5l_a21oi_1
X_09156__317 _09156_/RESET_B VPWR VGND sg13cmos5l_tiehi
X_08667_ _08667_/Y _08667_/A _08667_/B _08667_/C _08667_/D VPWR VGND sg13cmos5l_nand4_1
X_07618_ _07619_/B _07600_/Y _07620_/B _07617_/Y VPWR VGND sg13cmos5l_o21ai_1
XFILLER_14_539 VPWR VGND sg13cmos5l_fill_1
X_08598_ hold965/A _04819_/Y fanout55/X _08597_/Y VPWR VGND sg13cmos5l_a21oi_1
XFILLER_41_369 VPWR VGND sg13cmos5l_fill_2
X_07549_ _07549_/Y _07549_/A _07550_/B VPWR VGND sg13cmos5l_xnor2_1
XFILLER_22_572 VPWR VGND sg13cmos5l_fill_2
X_09017__468 _09017_/RESET_B VPWR VGND sg13cmos5l_tiehi
X_09219_ _09219_/Q _09347_/CLK _09219_/D _09219_/RESET_B VPWR VGND sg13cmos5l_dfrbpq_1
XFILLER_30_42 VPWR VGND sg13cmos5l_fill_1
XFILLER_49_414 VPWR VGND sg13cmos5l_fill_2
X_06920_ _07019_/C _06920_/A _06920_/B _06923_/C VPWR VGND sg13cmos5l_nand3_1
X_06851_ _07307_/A _07390_/A _06853_/B VPWR VGND sg13cmos5l_and2_1
X_05802_ _05812_/B _09438_/Q _09437_/Q _09436_/Q VPWR VGND sg13cmos5l_nor3_1
X_09570_ _09570_/Q clkload13/A _09570_/D _09570_/RESET_B VPWR VGND sg13cmos5l_dfrbpq_1
X_06782_ _06783_/B _06782_/A _06782_/B VPWR VGND sg13cmos5l_xnor2_1
X_05733_ _05746_/B _05764_/B _05734_/B _05729_/Y _05731_/Y _05732_/Y VPWR VGND sg13cmos5l_a221oi_1
X_08521_ _08522_/A _08657_/A _08657_/B VPWR VGND sg13cmos5l_and2_1
X_08452_ _08452_/Y _08452_/A _08452_/B VPWR VGND sg13cmos5l_nor2_1
XFILLER_24_815 VPWR VGND sg13cmos5l_fill_2
X_07403_ _07445_/C _09061_/Q _07408_/B _07413_/A VPWR VGND sg13cmos5l_o21ai_1
X_05664_ _05664_/Y _04986_/Y _05658_/A _05663_/A _04985_/Y VPWR VGND sg13cmos5l_a22oi_1
X_05595_ _05764_/B _05592_/A _05568_/B _05545_/Y VPWR VGND sg13cmos5l_a21oi_1
X_08383_ _08383_/Y _08371_/B _08373_/Y _08397_/B VPWR VGND sg13cmos5l_o21ai_1
XFILLER_23_369 VPWR VGND sg13cmos5l_fill_1
X_07334_ _07334_/Y _09066_/Q _06969_/A _04962_/Y _09065_/Q _07333_/Y VPWR VGND sg13cmos5l_a221oi_1
X_07265_ _07265_/Y _09065_/Q _07556_/A VPWR VGND sg13cmos5l_nor2_1
XFILLER_31_391 VPWR VGND sg13cmos5l_fill_2
X_06216_ _09465_/D _06727_/A hold852/X VPWR VGND sg13cmos5l_and2_1
X_09004_ _09030_/D _09005_/A _07216_/C VPWR VGND sg13cmos5l_nor2b_1
X_07196_ hold923/A hold922/X _07196_/B VPWR VGND sg13cmos5l_nor2_1
X_06147_ _09448_/D _06218_/B _06147_/B VPWR VGND sg13cmos5l_and2_1
X_06078_ _06079_/C _09442_/Q _06077_/A _06473_/A VPWR VGND sg13cmos5l_o21ai_1
X_05029_ _09602_/D _07096_/B _05028_/Y _08478_/A VPWR VGND sg13cmos5l_a21oi_1
XFILLER_46_428 VPWR VGND sg13cmos5l_fill_2
X_08719_ _09248_/D _08681_/B fanout20/X _08718_/Y VPWR VGND sg13cmos5l_a21oi_1
XFILLER_15_804 VPWR VGND sg13cmos5l_fill_1
XFILLER_41_100 VPWR VGND sg13cmos5l_fill_1
XFILLER_41_166 VPWR VGND sg13cmos5l_fill_2
XFILLER_46_995 VPWR VGND sg13cmos5l_fill_2
X_09139__334 _09139_/RESET_B VPWR VGND sg13cmos5l_tiehi
XFILLER_45_494 VPWR VGND sg13cmos5l_fill_2
XFILLER_33_623 VPWR VGND sg13cmos5l_fill_2
X_05380_ _05484_/A _05122_/Y _05363_/Y _05379_/Y VPWR VGND sg13cmos5l_a21o_1
XFILLER_9_351 VPWR VGND sg13cmos5l_fill_2
X_07050_ _07050_/Y _07034_/A _07034_/B _07044_/X _07048_/Y _07049_/Y VPWR VGND sg13cmos5l_a221oi_1
X_06001_ _06001_/Y _06028_/A _06001_/B VPWR VGND sg13cmos5l_nor2_1
X_09146__327 _09146_/RESET_B VPWR VGND sg13cmos5l_tiehi
X_07952_ _07952_/Y _07952_/A _07952_/B VPWR VGND sg13cmos5l_nor2_1
X_07883_ _07883_/Y hold996/X fanout49/X _07889_/A VPWR VGND sg13cmos5l_o21ai_1
X_06903_ _06903_/Y _06903_/A _06923_/A _06923_/B VPWR VGND sg13cmos5l_nand3_1
X_09007__478 _09007_/RESET_B VPWR VGND sg13cmos5l_tiehi
X_06834_ _06834_/Y _06826_/X _06876_/A _06831_/Y _07386_/A _06833_/Y VPWR VGND sg13cmos5l_a221oi_1
X_09553_ _09553_/Q _09591_/CLK _09553_/D _09553_/RESET_B VPWR VGND sg13cmos5l_dfrbpq_1
X_08504_ _08538_/B _08506_/A _08506_/B VPWR VGND sg13cmos5l_and2_1
X_06765_ _06765_/Y _06765_/A _06765_/B VPWR VGND sg13cmos5l_xnor2_1
X_09484_ _09484_/Q _09491_/CLK _09484_/D _09484_/RESET_B VPWR VGND sg13cmos5l_dfrbpq_1
X_06696_ _06696_/Y _09551_/Q _06705_/B VPWR VGND sg13cmos5l_nor2_1
XFILLER_24_634 VPWR VGND sg13cmos5l_fill_1
X_05716_ _05718_/B hold1366/X _05722_/B VPWR VGND sg13cmos5l_nand2b_1
X_08435_ _08435_/Y _08297_/B _08340_/Y _08434_/Y VPWR VGND sg13cmos5l_a21oi_1
X_05647_ _05665_/B _05651_/A _04987_/Y _05646_/Y VPWR VGND sg13cmos5l_a21oi_1
X_08366_ _08366_/Y _09220_/Q _08366_/B VPWR VGND sg13cmos5l_nor2_1
X_05578_ _05580_/B _05593_/S _05575_/Y _05577_/Y VPWR VGND sg13cmos5l_a21oi_1
X_07317_ _07416_/D _07288_/Y _07309_/Y _06869_/Y VPWR VGND sg13cmos5l_o21ai_1
X_08297_ _09188_/D _08380_/A _08297_/B VPWR VGND sg13cmos5l_nor2_1
X_07248_ _07248_/Y _09036_/Q _07249_/B VPWR VGND sg13cmos5l_xnor2_1
XFILLER_3_505 VPWR VGND sg13cmos5l_fill_1
X_07179_ _07179_/Y _09030_/Q _05004_/Y _07178_/Y VPWR VGND sg13cmos5l_o21ai_1
XFILLER_15_612 VPWR VGND sg13cmos5l_fill_1
X_09290__482 _09290_/RESET_B VPWR VGND sg13cmos5l_tiehi
XFILLER_30_648 VPWR VGND sg13cmos5l_fill_1
XFILLER_7_855 VPWR VGND sg13cmos5l_fill_2
XFILLER_6_376 VPWR VGND sg13cmos5l_fill_1
X_04880_ _07211_/B input7/X VPWR VGND sg13cmos5l_inv_1
X_06550_ _09511_/D _06496_/Y _06557_/S _06549_/Y VPWR VGND sg13cmos5l_a21oi_1
X_06481_ _06481_/Y _06479_/Y _06480_/Y _06478_/Y VPWR VGND sg13cmos5l_a21oi_1
X_05501_ _05501_/Y _05498_/Y _05500_/Y _05486_/Y VPWR VGND sg13cmos5l_o21ai_1
X_08220_ _08220_/Y _08196_/B _08229_/B _08231_/A VPWR VGND sg13cmos5l_a21oi_1
X_05432_ _05432_/Y _05433_/A _05433_/B VPWR VGND sg13cmos5l_nor2_1
X_05363_ _05363_/Y _05366_/B _05376_/C VPWR VGND sg13cmos5l_nand2_1
X_08151_ _08151_/Y _09166_/Q hold911/A VPWR VGND sg13cmos5l_xnor2_1
X_08082_ _08082_/X _08082_/A _08082_/B _08082_/C VPWR VGND sg13cmos5l_and3_1
X_07102_ _07102_/Y _07106_/B _07101_/Y _07100_/A VPWR VGND sg13cmos5l_a21oi_1
X_05294_ _05327_/B _05701_/A _05295_/B VPWR VGND sg13cmos5l_and2_1
X_07033_ _07033_/Y _07034_/B VPWR VGND sg13cmos5l_inv_1
X_09425__683 _09425_/RESET_B VPWR VGND sg13cmos5l_tiehi
X_08984_ _08984_/Y _08972_/A _08974_/Y _08983_/Y VPWR VGND sg13cmos5l_a21oi_1
X_07935_ _07936_/B _07769_/B _07821_/B _07950_/B VPWR VGND sg13cmos5l_mux2_1
X_07866_ _07874_/S _09126_/Q _07864_/B _07863_/X _07865_/Y VPWR VGND sg13cmos5l_a22oi_1
X_09605_ _09605_/Q clkload3/A _09605_/D _09605_/RESET_B VPWR VGND sg13cmos5l_dfrbpq_1
XFILLER_29_748 VPWR VGND sg13cmos5l_fill_1
X_07797_ _07797_/X _09102_/Q _09077_/Q VPWR VGND sg13cmos5l_or2_1
XFILLER_16_409 VPWR VGND sg13cmos5l_fill_2
X_06817_ _06818_/B _06794_/B _06780_/B _06817_/S VPWR VGND sg13cmos5l_mux2_1
X_09536_ hold915/A clkload13/A _09536_/D _09536_/RESET_B VPWR VGND sg13cmos5l_dfrbpq_1
X_06748_ _06797_/B _09546_/Q _06764_/B VPWR VGND sg13cmos5l_nand2_1
X_09467_ _09467_/Q _09503_/CLK _09467_/D _09467_/RESET_B VPWR VGND sg13cmos5l_dfrbpq_1
X_08418_ _08455_/B _08418_/A _08418_/B VPWR VGND sg13cmos5l_nor2_1
X_06679_ _09528_/D _06818_/A _06775_/B VPWR VGND sg13cmos5l_nor2_1
X_09398_ _09398_/Q clkload20/A _09398_/D _09398_/RESET_B VPWR VGND sg13cmos5l_dfrbpq_1
X_08349_ _08349_/Y _09220_/Q _08113_/A _04941_/Y _09219_/Q _08348_/Y VPWR VGND sg13cmos5l_a221oi_1
XFILLER_4_858 VPWR VGND sg13cmos5l_fill_1
XFILLER_3_357 VPWR VGND sg13cmos5l_fill_1
Xfanout160 _06042_/A _05951_/A VPWR VGND sg13cmos5l_buf_1
Xfanout182 _08728_/A _09284_/Q VPWR VGND sg13cmos5l_buf_1
Xfanout171 _09001_/B _08942_/B VPWR VGND sg13cmos5l_buf_1
Xfanout193 _08479_/B _08987_/B1 VPWR VGND sg13cmos5l_buf_1
X_09136__337 _09136_/RESET_B VPWR VGND sg13cmos5l_tiehi
XFILLER_31_946 VPWR VGND sg13cmos5l_fill_2
X_09231__837 _09231_/RESET_B VPWR VGND sg13cmos5l_tiehi
XFILLER_8_67 VPWR VGND sg13cmos5l_fill_2
XFILLER_11_692 VPWR VGND sg13cmos5l_fill_1
XFILLER_40_4 VPWR VGND sg13cmos5l_fill_1
Xhold1308 _04898_/A _09141_/Q VPWR VGND sg13cmos5l_dlygate4sd3_1
X_07720_ _09107_/D _07703_/Y _07719_/Y _07639_/B VPWR VGND sg13cmos5l_a21oi_1
Xhold1319 _07059_/B _07058_/Y VPWR VGND sg13cmos5l_dlygate4sd3_1
X_05981_ _06023_/C _09432_/Q _05986_/B _05991_/A VPWR VGND sg13cmos5l_o21ai_1
X_04932_ _06133_/A _09414_/Q VPWR VGND sg13cmos5l_inv_1
X_04863_ _06219_/A _04863_/A VPWR VGND sg13cmos5l_inv_1
X_07651_ _07697_/C _09099_/Q _07661_/B _07662_/A VPWR VGND sg13cmos5l_o21ai_1
X_07582_ _07582_/Y _07893_/A _09048_/Q _09047_/Q _07892_/A _07581_/Y VPWR VGND sg13cmos5l_a221oi_1
X_06602_ _06603_/B _06622_/B _06629_/B VPWR VGND sg13cmos5l_nor2_1
X_06533_ _06534_/C _06533_/A _06533_/B _06533_/C VPWR VGND sg13cmos5l_and3_1
X_09321_ _09321_/Q clkload10/A _09321_/D _09321_/RESET_B VPWR VGND sg13cmos5l_dfrbpq_1
X_09252_ _09252_/Q clkload9/A _09252_/D _09252_/RESET_B VPWR VGND sg13cmos5l_dfrbpq_1
X_06464_ _09499_/D _04837_/Y fanout61/X _06463_/Y VPWR VGND sg13cmos5l_a21oi_1
X_06395_ _06409_/C _06063_/B _06378_/Y _06392_/X _06393_/Y _06394_/Y VPWR VGND sg13cmos5l_a221oi_1
X_09183_ _09183_/Q _09214_/CLK _09183_/D _09183_/RESET_B VPWR VGND sg13cmos5l_dfrbpq_1
X_08203_ _08203_/Y _08200_/X _08203_/B VPWR VGND sg13cmos5l_nand2b_1
X_09386__726 _09386_/RESET_B VPWR VGND sg13cmos5l_tiehi
X_05415_ _05415_/Y _05407_/Y _05410_/Y _05414_/Y VPWR VGND sg13cmos5l_a21oi_1
X_05346_ _05379_/B _09299_/Q _05376_/A VPWR VGND sg13cmos5l_xnor2_1
X_08134_ _09165_/D _08134_/A hold948/X VPWR VGND sg13cmos5l_and2_1
XFILLER_49_1008 VPWR VGND sg13cmos5l_decap_8
X_05277_ _05277_/Y _09328_/Q _09327_/Q _09359_/Q VPWR VGND sg13cmos5l_nand3b_1
X_08065_ _08065_/Y _08065_/A _08082_/A VPWR VGND sg13cmos5l_nand2_1
X_07016_ _07017_/B _07016_/A _07016_/B VPWR VGND sg13cmos5l_xnor2_1
XFILLER_0_316 VPWR VGND sg13cmos5l_decap_4
X_08967_ _08967_/Y _09325_/Q _08967_/B VPWR VGND sg13cmos5l_nor2_1
X_07918_ _07919_/B _07918_/A _07918_/B VPWR VGND sg13cmos5l_xnor2_1
X_08898_ _08899_/A _08898_/A _08907_/B _08898_/C VPWR VGND sg13cmos5l_nor3_1
X_07849_ _07849_/Y _09122_/Q _07846_/Y _09121_/Q VPWR VGND sg13cmos5l_o21ai_1
XFILLER_44_548 VPWR VGND sg13cmos5l_fill_2
XFILLER_44_559 VPWR VGND sg13cmos5l_fill_2
XFILLER_25_751 VPWR VGND sg13cmos5l_fill_2
X_09519_ _09519_/Q clkload23/A _09519_/D _09519_/RESET_B VPWR VGND sg13cmos5l_dfrbpq_1
XFILLER_12_445 VPWR VGND sg13cmos5l_fill_2
XFILLER_9_928 VPWR VGND sg13cmos5l_fill_1
XFILLER_12_456 VPWR VGND sg13cmos5l_fill_1
XFILLER_33_86 VPWR VGND sg13cmos5l_fill_1
XFILLER_4_666 VPWR VGND sg13cmos5l_fill_1
X_05200_ _05200_/Y _05125_/X _05198_/Y _05199_/Y VPWR VGND sg13cmos5l_o21ai_1
X_06180_ _06185_/A _04976_/Y _06178_/X _06179_/Y VPWR VGND sg13cmos5l_a21oi_1
X_05131_ _05175_/A _05199_/C _05132_/C _05130_/Y VPWR VGND sg13cmos5l_a21o_1
X_05062_ _05062_/Y hold888/A hold859/A VPWR VGND sg13cmos5l_xnor2_1
X_08821_ _08821_/Y _05001_/A _08823_/S _08842_/B VPWR VGND sg13cmos5l_o21ai_1
Xhold1105 _09230_/D _08584_/Y VPWR VGND sg13cmos5l_dlygate4sd3_1
X_08752_ _08775_/S _08761_/B _08761_/C VPWR VGND sg13cmos5l_nor2_1
Xhold1138 _07352_/A _09571_/Q VPWR VGND sg13cmos5l_dlygate4sd3_1
Xhold1127 _04962_/A _09569_/Q VPWR VGND sg13cmos5l_dlygate4sd3_1
Xhold1149 hold1149/X _09492_/Q VPWR VGND sg13cmos5l_dlygate4sd3_1
Xhold1116 _05918_/A _09379_/Q VPWR VGND sg13cmos5l_dlygate4sd3_1
X_05964_ _09430_/D _05964_/A _06042_/A VPWR VGND sg13cmos5l_nor2_1
X_07703_ _07703_/Y _07703_/A _07674_/B VPWR VGND sg13cmos5l_nor2b_1
X_04915_ _06991_/A _04915_/A VPWR VGND sg13cmos5l_inv_1
X_08683_ _08684_/B _08683_/A _08683_/B VPWR VGND sg13cmos5l_xnor2_1
X_05895_ _09411_/D _05898_/A _05895_/B VPWR VGND sg13cmos5l_nor2_1
XFILLER_0_1010 VPWR VGND sg13cmos5l_decap_8
X_07634_ _09096_/D _07634_/A _07634_/B VPWR VGND sg13cmos5l_and2_1
X_04846_ _05448_/A _08953_/A VPWR VGND sg13cmos5l_inv_1
X_07565_ _07665_/D _07571_/A _07565_/B _07571_/C VPWR VGND sg13cmos5l_nand3_1
X_07496_ _07528_/B _09106_/Q _07496_/B VPWR VGND sg13cmos5l_xnor2_1
X_09304_ _09304_/Q clkload18/A _09304_/D _09304_/RESET_B VPWR VGND sg13cmos5l_dfrbpq_1
X_06516_ _06517_/B _09505_/Q _06495_/B _06478_/Y VPWR VGND sg13cmos5l_a21oi_1
X_09235_ _10245_/A _09595_/CLK _09235_/D _09235_/RESET_B VPWR VGND sg13cmos5l_dfrbpq_1
X_06447_ _06447_/Y _06691_/B _06445_/B _06444_/Y _06446_/Y VPWR VGND sg13cmos5l_a22oi_1
XFILLER_21_297 VPWR VGND sg13cmos5l_fill_2
X_06378_ _06378_/Y _06409_/A _06415_/B VPWR VGND sg13cmos5l_nand2b_1
XFILLER_5_408 VPWR VGND sg13cmos5l_fill_2
X_09166_ _09166_/Q _09388_/CLK hold907/X _09166_/RESET_B VPWR VGND sg13cmos5l_dfrbpq_1
X_08117_ _08117_/Y _08113_/A _08131_/A _08116_/Y VPWR VGND sg13cmos5l_a21oi_1
X_09097_ _09097_/Q clkload13/A _09097_/D _09097_/RESET_B VPWR VGND sg13cmos5l_dfrbpq_1
X_05329_ _09330_/D _05443_/B _05329_/B VPWR VGND sg13cmos5l_and2_1
X_08048_ _08079_/B _09115_/Q _09116_/Q hold1407/X VPWR VGND sg13cmos5l_o21ai_1
Xhold961 hold961/X hold961/A VPWR VGND sg13cmos5l_dlygate4sd3_1
Xhold972 hold972/X hold972/A VPWR VGND sg13cmos5l_dlygate4sd3_1
Xhold950 hold950/X hold950/A VPWR VGND sg13cmos5l_dlygate4sd3_1
Xhold983 hold983/X hold983/A VPWR VGND sg13cmos5l_dlygate4sd3_1
Xhold994 hold994/X hold994/A VPWR VGND sg13cmos5l_dlygate4sd3_1
XFILLER_45_813 VPWR VGND sg13cmos5l_fill_1
X_09202__268 _09202_/RESET_B VPWR VGND sg13cmos5l_tiehi
XFILLER_44_312 VPWR VGND sg13cmos5l_fill_1
XFILLER_44_378 VPWR VGND sg13cmos5l_fill_1
X_09584__502 _09584_/RESET_B VPWR VGND sg13cmos5l_tiehi
XFILLER_8_279 VPWR VGND sg13cmos5l_fill_1
XFILLER_8_257 VPWR VGND sg13cmos5l_decap_4
XFILLER_5_964 VPWR VGND sg13cmos5l_fill_2
XFILLER_5_57 VPWR VGND sg13cmos5l_fill_2
XFILLER_4_485 VPWR VGND sg13cmos5l_decap_4
X_09265__796 _09265_/RESET_B VPWR VGND sg13cmos5l_tiehi
X_05680_ _05680_/Y _05928_/A _05672_/Y _05530_/Y VPWR VGND sg13cmos5l_o21ai_1
X_07350_ _07350_/Y _09046_/Q _07345_/Y _07349_/Y _09047_/Q VPWR VGND sg13cmos5l_a22oi_1
X_06301_ _09476_/D _06259_/A _06302_/S _06300_/Y VPWR VGND sg13cmos5l_a21oi_1
X_07281_ _07447_/A _07277_/S _07279_/Y _07280_/Y VPWR VGND sg13cmos5l_a21o_1
X_09020_ hold952/A _09608_/CLK _09020_/D _09020_/RESET_B VPWR VGND sg13cmos5l_dfrbpq_1
X_06232_ _06271_/B _09467_/Q _06232_/B VPWR VGND sg13cmos5l_nand2_1
X_06163_ _06164_/B _05853_/Y _06162_/S _06161_/Y VPWR VGND sg13cmos5l_o21ai_1
X_05114_ _05385_/A _05113_/B _08953_/A VPWR VGND sg13cmos5l_nand2b_1
X_06094_ _06094_/Y _06112_/A _06077_/B VPWR VGND sg13cmos5l_nor2b_1
X_05045_ _05045_/Y _05015_/Y _07096_/B VPWR VGND sg13cmos5l_nand2b_1
X_09500__603 _09500_/RESET_B VPWR VGND sg13cmos5l_tiehi
X_08804_ _08804_/Y _09265_/Q _08799_/B _08803_/Y _09266_/Q _08800_/Y VPWR VGND sg13cmos5l_a221oi_1
X_08735_ _08735_/Y _05143_/Y _08770_/A _08734_/X VPWR VGND sg13cmos5l_o21ai_1
X_06996_ _06996_/Y _09576_/Q hold853/A VPWR VGND sg13cmos5l_xnor2_1
X_05947_ _05947_/Y hold1189/X fanout39/X _05785_/Y VPWR VGND sg13cmos5l_o21ai_1
X_05878_ _05878_/X _05903_/A _05878_/B VPWR VGND sg13cmos5l_and2_1
X_08666_ _08666_/Y _08657_/Y _08661_/Y _08664_/Y _08532_/Y _08665_/Y VPWR VGND sg13cmos5l_a221oi_1
X_07617_ _07617_/Y _07617_/A _07620_/B VPWR VGND sg13cmos5l_nand2_1
X_04829_ _04829_/Y hold990/X VPWR VGND sg13cmos5l_inv_1
X_08597_ _08597_/Y _09238_/Q fanout55/X _08994_/A VPWR VGND sg13cmos5l_o21ai_1
X_07548_ _07548_/Y _07276_/B _07571_/B _07547_/Y VPWR VGND sg13cmos5l_o21ai_1
X_07479_ _07808_/A _07895_/A _07480_/B VPWR VGND sg13cmos5l_and2_1
X_09091__387 _09091_/RESET_B VPWR VGND sg13cmos5l_tiehi
X_09218_ _09218_/Q _09347_/CLK _09218_/D _09218_/RESET_B VPWR VGND sg13cmos5l_dfrbpq_1
XFILLER_5_205 VPWR VGND sg13cmos5l_fill_2
X_09149_ _09149_/Q clkload6/A _09149_/D _09149_/RESET_B VPWR VGND sg13cmos5l_dfrbpq_1
XFILLER_5_238 VPWR VGND sg13cmos5l_fill_1
XFILLER_49_448 VPWR VGND sg13cmos5l_fill_2
XFILLER_49_459 VPWR VGND sg13cmos5l_fill_2
XFILLER_18_846 VPWR VGND sg13cmos5l_fill_1
XFILLER_17_378 VPWR VGND sg13cmos5l_fill_2
XFILLER_41_893 VPWR VGND sg13cmos5l_fill_1
X_06850_ _06850_/Y _09560_/Q _06850_/B VPWR VGND sg13cmos5l_xnor2_1
X_05801_ _05801_/X _05843_/A _06129_/A _05843_/C VPWR VGND sg13cmos5l_and3_1
X_06781_ _06782_/B _06781_/A _06781_/B VPWR VGND sg13cmos5l_nor2_1
XFILLER_36_610 VPWR VGND sg13cmos5l_fill_2
X_05732_ _05732_/Y _05732_/A _05760_/A VPWR VGND sg13cmos5l_nor2_1
X_08520_ _08657_/B hold1383/X _08530_/B _08530_/C VPWR VGND sg13cmos5l_nand3b_1
X_08451_ _08452_/B _08451_/A _08451_/B VPWR VGND sg13cmos5l_nor2_1
X_05663_ _05667_/B _05663_/A VPWR VGND sg13cmos5l_inv_1
X_07402_ _07413_/A _09060_/Q _07408_/B _07438_/A VPWR VGND sg13cmos5l_a21o_1
X_05594_ _09369_/D _05696_/B _05732_/A VPWR VGND sg13cmos5l_and2_1
X_08382_ _09200_/D _04928_/Y _08378_/B _08381_/Y VPWR VGND sg13cmos5l_a21oi_1
X_07333_ _07333_/Y _07635_/A _09569_/Q _07332_/Y VPWR VGND sg13cmos5l_a21oi_1
X_07264_ _09032_/D _07389_/B _07264_/B VPWR VGND sg13cmos5l_nor2_1
X_06215_ _09464_/D _06469_/A hold868/X VPWR VGND sg13cmos5l_and2_1
X_09003_ _09029_/D _09005_/A _07216_/B VPWR VGND sg13cmos5l_nor2b_1
X_07195_ _07197_/B _09030_/Q _07196_/B VPWR VGND sg13cmos5l_nor2b_1
X_06146_ _06266_/A hold1346/X _06162_/S _06145_/Y VPWR VGND sg13cmos5l_a21oi_1
X_06077_ _06079_/B _06077_/A _06077_/B VPWR VGND sg13cmos5l_nand2_1
X_09162__311 _09162_/RESET_B VPWR VGND sg13cmos5l_tiehi
X_05028_ _05028_/Y hold1266/X _05028_/B VPWR VGND sg13cmos5l_nand2b_1
X_06979_ _06979_/Y hold995/A fanout59/X _07383_/A VPWR VGND sg13cmos5l_o21ai_1
X_08718_ _08718_/Y _08681_/A fanout20/X _08723_/A VPWR VGND sg13cmos5l_o21ai_1
X_08649_ _08649_/Y _08649_/A _08659_/C VPWR VGND sg13cmos5l_nand2_1
XFILLER_14_304 VPWR VGND sg13cmos5l_fill_2
XFILLER_42_668 VPWR VGND sg13cmos5l_fill_2
XFILLER_25_76 VPWR VGND sg13cmos5l_fill_1
XFILLER_10_521 VPWR VGND sg13cmos5l_fill_2
X_09581__505 _09581_/RESET_B VPWR VGND sg13cmos5l_tiehi
XFILLER_6_558 VPWR VGND sg13cmos5l_fill_1
X_09262__799 _09262_/RESET_B VPWR VGND sg13cmos5l_tiehi
XFILLER_49_245 VPWR VGND sg13cmos5l_fill_2
XFILLER_14_882 VPWR VGND sg13cmos5l_fill_2
X_06000_ _06000_/Y _05996_/Y _05998_/Y _05999_/Y VPWR VGND sg13cmos5l_o21ai_1
X_07951_ _07952_/B _07782_/Y _07950_/B _07950_/Y VPWR VGND sg13cmos5l_o21ai_1
X_06902_ _06902_/Y _06989_/A _06899_/X _06920_/B _06901_/X VPWR VGND sg13cmos5l_a22oi_1
X_07882_ _09128_/D _04826_/Y fanout49/X _07881_/Y VPWR VGND sg13cmos5l_a21oi_1
X_06833_ _06833_/Y _09587_/Q _09555_/Q _06832_/X VPWR VGND sg13cmos5l_a21oi_1
XFILLER_49_790 VPWR VGND sg13cmos5l_fill_1
X_09552_ _09552_/Q _09586_/CLK _09552_/D _09552_/RESET_B VPWR VGND sg13cmos5l_dfrbpq_1
X_06764_ _06765_/B _09546_/Q _06764_/B VPWR VGND sg13cmos5l_xnor2_1
X_08503_ _08503_/Y _08488_/Y _08495_/Y _08502_/Y VPWR VGND sg13cmos5l_o21ai_1
X_05715_ _05718_/A _09395_/Q _05722_/B _05759_/A VPWR VGND sg13cmos5l_a21o_1
XFILLER_36_462 VPWR VGND sg13cmos5l_fill_1
X_09483_ _09483_/Q _09491_/CLK _09483_/D _09483_/RESET_B VPWR VGND sg13cmos5l_dfrbpq_1
X_06695_ _06695_/Y _09531_/Q _06694_/Y _09530_/Q VPWR VGND sg13cmos5l_o21ai_1
X_08434_ _08434_/Y _08459_/A _08434_/B VPWR VGND sg13cmos5l_nor2_1
X_05646_ _05646_/Y _05968_/A _09345_/Q _09344_/Q _05967_/A _05645_/Y VPWR VGND sg13cmos5l_a221oi_1
X_05577_ _05577_/Y _05567_/Y _05569_/Y _05576_/Y VPWR VGND sg13cmos5l_a21oi_1
X_08365_ _08365_/Y _08378_/A _08359_/Y _08364_/Y _04928_/Y VPWR VGND sg13cmos5l_a22oi_1
XFILLER_23_167 VPWR VGND sg13cmos5l_fill_1
X_07316_ _07416_/C _07293_/Y _07324_/C _07324_/A VPWR VGND sg13cmos5l_nand3b_1
X_08296_ _08297_/B _08290_/S _08294_/Y _08293_/Y VPWR VGND sg13cmos5l_a21o_1
X_07247_ _07247_/Y _07276_/B _07246_/Y _07243_/Y VPWR VGND sg13cmos5l_o21ai_1
X_07178_ _07178_/Y _09029_/Q _09016_/Q VPWR VGND sg13cmos5l_nand2b_1
X_06129_ _06129_/Y _06129_/A _06153_/A _06153_/B VPWR VGND sg13cmos5l_nand3_1
XFILLER_3_539 VPWR VGND sg13cmos5l_fill_1
XFILLER_43_922 VPWR VGND sg13cmos5l_decap_4
XFILLER_15_624 VPWR VGND sg13cmos5l_fill_2
XFILLER_36_86 VPWR VGND sg13cmos5l_fill_1
XFILLER_15_679 VPWR VGND sg13cmos5l_fill_2
XFILLER_30_605 VPWR VGND sg13cmos5l_fill_2
XFILLER_14_167 VPWR VGND sg13cmos5l_fill_1
XFILLER_18_451 VPWR VGND sg13cmos5l_fill_1
X_06480_ _06480_/Y hold925/A hold866/A VPWR VGND sg13cmos5l_xnor2_1
X_05500_ _05500_/Y _05486_/A _05486_/B _05499_/X VPWR VGND sg13cmos5l_o21ai_1
X_09152__321 _09152_/RESET_B VPWR VGND sg13cmos5l_tiehi
X_05431_ _09346_/D _08134_/A hold903/X VPWR VGND sg13cmos5l_and2_1
X_08150_ _08189_/A hold987/A hold992/A VPWR VGND sg13cmos5l_nand2_1
X_05362_ _05382_/S _05379_/A _05379_/C VPWR VGND sg13cmos5l_nor2_1
X_07101_ _07101_/Y _05009_/C _07101_/B VPWR VGND sg13cmos5l_nand2b_1
X_05293_ _05293_/Y _05330_/B _05617_/A VPWR VGND sg13cmos5l_nand2_1
X_08081_ _09155_/D _08081_/A _08081_/B VPWR VGND sg13cmos5l_nor2_1
X_07032_ _07034_/B _06928_/B _07047_/S _07031_/Y VPWR VGND sg13cmos5l_a21oi_1
X_09013__472 _09013_/RESET_B VPWR VGND sg13cmos5l_tiehi
X_08983_ _08983_/Y _08972_/B _08974_/Y _05248_/Y VPWR VGND sg13cmos5l_o21ai_1
X_07934_ _07962_/A _07949_/B _07934_/B VPWR VGND sg13cmos5l_nor2_1
X_07865_ _07865_/Y _04944_/Y _07876_/A _07864_/Y VPWR VGND sg13cmos5l_a21oi_1
X_09604_ _09604_/Q _09608_/CLK _09604_/D _09604_/RESET_B VPWR VGND sg13cmos5l_dfrbpq_1
X_07796_ _07818_/B _09077_/Q _09078_/Q VPWR VGND sg13cmos5l_xor2_1
X_06816_ _09551_/D _06791_/Y _06817_/S _06815_/Y VPWR VGND sg13cmos5l_a21oi_1
X_09535_ _09535_/Q clkload17/A _09535_/D _09535_/RESET_B VPWR VGND sg13cmos5l_dfrbpq_1
XFILLER_24_410 VPWR VGND sg13cmos5l_fill_2
X_09020__465 _09020_/RESET_B VPWR VGND sg13cmos5l_tiehi
X_06747_ _06797_/A _09547_/Q _06764_/B VPWR VGND sg13cmos5l_xnor2_1
X_09466_ hold863/A _09503_/CLK _09466_/D _09466_/RESET_B VPWR VGND sg13cmos5l_dfrbpq_1
X_06678_ _06775_/B _06651_/B _06660_/Y _06677_/X VPWR VGND sg13cmos5l_o21ai_1
X_05629_ _05632_/A _05630_/A _05630_/C _05322_/X VPWR VGND sg13cmos5l_a21o_1
X_08417_ _08418_/B hold1361/X _08423_/B VPWR VGND sg13cmos5l_nand2b_1
XFILLER_40_958 VPWR VGND sg13cmos5l_decap_4
X_09397_ _09397_/Q clkload19/A _09397_/D _09397_/RESET_B VPWR VGND sg13cmos5l_dfrbpq_1
X_08348_ _08348_/Y _08602_/A hold980/A _09161_/Q _08601_/A _08347_/Y VPWR VGND sg13cmos5l_a221oi_1
X_08279_ _08427_/A _08293_/B _08293_/C _08278_/Y VPWR VGND sg13cmos5l_o21ai_1
XFILLER_3_347 VPWR VGND sg13cmos5l_decap_4
Xfanout172 _08939_/B _08942_/B VPWR VGND sg13cmos5l_buf_1
Xfanout161 _05951_/A _05786_/Y VPWR VGND sg13cmos5l_buf_1
Xfanout183 _08555_/A _09246_/Q VPWR VGND sg13cmos5l_buf_1
Xfanout150 _06737_/B _06823_/A VPWR VGND sg13cmos5l_buf_1
Xfanout194 _08834_/B1 _08987_/B1 VPWR VGND sg13cmos5l_buf_1
XFILLER_19_259 VPWR VGND sg13cmos5l_fill_2
XFILLER_16_955 VPWR VGND sg13cmos5l_fill_1
XFILLER_43_785 VPWR VGND sg13cmos5l_fill_1
X_05980_ _05991_/A _09431_/Q _05986_/B _06016_/A VPWR VGND sg13cmos5l_a21o_1
X_09379__734 _09379_/RESET_B VPWR VGND sg13cmos5l_tiehi
X_04931_ _08547_/B _04931_/A VPWR VGND sg13cmos5l_inv_1
Xhold1309 _07411_/C _09063_/Q VPWR VGND sg13cmos5l_dlygate4sd3_1
XFILLER_19_2 VPWR VGND sg13cmos5l_fill_1
X_07650_ _07662_/A _09098_/Q _07657_/B _07692_/A VPWR VGND sg13cmos5l_a21o_1
X_04862_ _06220_/A _05923_/A VPWR VGND sg13cmos5l_inv_1
X_07581_ _07581_/Y _09104_/Q _07367_/A _04956_/Y _09103_/Q _07580_/Y VPWR VGND sg13cmos5l_a221oi_1
X_06601_ _06767_/A _06600_/Y _06617_/C VPWR VGND sg13cmos5l_nand2b_1
XFILLER_46_590 VPWR VGND sg13cmos5l_fill_1
X_09076__230 _09076_/D VPWR VGND sg13cmos5l_tielo
X_09320_ _09320_/Q clkload8/A _09320_/D _09320_/RESET_B VPWR VGND sg13cmos5l_dfrbpq_1
X_06532_ _06532_/Y _06515_/A _06515_/B _06525_/X _06530_/Y _06531_/Y VPWR VGND sg13cmos5l_a221oi_1
X_09251_ _09251_/Q clkload9/A _09251_/D _09251_/RESET_B VPWR VGND sg13cmos5l_dfrbpq_1
X_08202_ _08202_/Y _08194_/Y _08196_/X _08199_/A _08200_/X _08201_/X VPWR VGND sg13cmos5l_a221oi_1
X_06463_ _06463_/Y hold937/X fanout61/X _07383_/A VPWR VGND sg13cmos5l_o21ai_1
X_06394_ _06394_/Y _06394_/A _06409_/A VPWR VGND sg13cmos5l_xnor2_1
X_09182_ _09182_/Q _09214_/CLK _09182_/D _09182_/RESET_B VPWR VGND sg13cmos5l_dfrbpq_1
X_05414_ _05414_/Y _04989_/Y _05409_/Y _05413_/Y VPWR VGND sg13cmos5l_o21ai_1
X_05345_ _05345_/Y _05198_/A _05342_/Y _05344_/X _05116_/Y VPWR VGND sg13cmos5l_a22oi_1
X_08133_ _08133_/Y _04939_/Y _08116_/B _08132_/A VPWR VGND sg13cmos5l_a21oi_1
X_08064_ _08064_/Y _07780_/B _08058_/X _08063_/X _07733_/Y VPWR VGND sg13cmos5l_a22oi_1
X_05276_ _05276_/Y _09359_/Q _09327_/Q VPWR VGND sg13cmos5l_nand2_1
X_07015_ _07016_/B _09584_/Q _07015_/B VPWR VGND sg13cmos5l_xnor2_1
X_09087__392 _09087_/RESET_B VPWR VGND sg13cmos5l_tiehi
X_08966_ _08966_/Y _04995_/Y _08960_/Y _08965_/Y _04994_/Y VPWR VGND sg13cmos5l_a22oi_1
X_07917_ _07918_/B _07917_/A _07917_/B VPWR VGND sg13cmos5l_xor2_1
X_08897_ _08898_/C _08897_/A _08897_/B _08897_/C VPWR VGND sg13cmos5l_and3_1
X_07848_ _07867_/A _04951_/Y _07855_/B _07847_/Y VPWR VGND sg13cmos5l_a21oi_1
X_07779_ _09111_/D _07892_/B _07779_/B VPWR VGND sg13cmos5l_nor2_1
X_09518_ _09518_/Q clkload23/A _09518_/D _09518_/RESET_B VPWR VGND sg13cmos5l_dfrbpq_1
X_09449_ _09449_/Q _09491_/CLK _09449_/D _09449_/RESET_B VPWR VGND sg13cmos5l_dfrbpq_1
XFILLER_48_800 VPWR VGND sg13cmos5l_fill_1
X_09142__331 _09142_/RESET_B VPWR VGND sg13cmos5l_tiehi
XFILLER_47_376 VPWR VGND sg13cmos5l_fill_1
XFILLER_15_284 VPWR VGND sg13cmos5l_fill_1
Xclkbuf_leaf_10_clk clkload9/A clkbuf_leaf_9_clk/A VPWR VGND sg13cmos5l_buf_8
X_05130_ _05130_/Y _08945_/A _05198_/B VPWR VGND sg13cmos5l_nand2_1
X_05061_ _05061_/Y hold941/A hold870/A VPWR VGND sg13cmos5l_nand2_1
X_09010__475 _09010_/RESET_B VPWR VGND sg13cmos5l_tiehi
X_08820_ _09265_/D _08799_/B _08823_/S _08819_/Y VPWR VGND sg13cmos5l_a21oi_1
XFILLER_24_0 VPWR VGND sg13cmos5l_fill_1
Xhold1106 _05413_/B _09344_/Q VPWR VGND sg13cmos5l_dlygate4sd3_1
X_08751_ _08751_/Y _08751_/A _08774_/B VPWR VGND sg13cmos5l_nand2_1
Xhold1117 hold1117/X _09231_/Q VPWR VGND sg13cmos5l_dlygate4sd3_1
Xhold1139 _09571_/D _06973_/Y VPWR VGND sg13cmos5l_dlygate4sd3_1
X_05963_ _09429_/D _05963_/A _05963_/B VPWR VGND sg13cmos5l_and2_1
Xhold1128 _04986_/A _09380_/Q VPWR VGND sg13cmos5l_dlygate4sd3_1
X_05894_ _05895_/B _05994_/C _05994_/D VPWR VGND sg13cmos5l_nand2_1
X_07702_ _07702_/Y _07680_/Y _07696_/Y _07701_/X VPWR VGND sg13cmos5l_o21ai_1
X_04914_ _07390_/A _06854_/B VPWR VGND sg13cmos5l_inv_1
X_08682_ _08683_/B _08682_/A _08682_/B VPWR VGND sg13cmos5l_nor2_1
X_04845_ _08945_/A _04845_/A VPWR VGND sg13cmos5l_inv_1
X_07633_ _09095_/D _07633_/A hold885/X VPWR VGND sg13cmos5l_and2_1
X_07564_ _07665_/C _07571_/A _07571_/C _07265_/Y VPWR VGND sg13cmos5l_a21o_1
X_07495_ _07501_/A _07495_/A _07495_/B VPWR VGND sg13cmos5l_xor2_1
X_09303_ _09303_/Q _09387_/CLK _09303_/D _09303_/RESET_B VPWR VGND sg13cmos5l_dfrbpq_1
X_06515_ _06515_/Y _06515_/A _06515_/B VPWR VGND sg13cmos5l_nor2_1
X_09234_ hold958/A clkload2/A hold959/X _09234_/RESET_B VPWR VGND sg13cmos5l_dfrbpq_1
X_06446_ _06446_/Y _04969_/Y _06458_/A _06445_/Y VPWR VGND sg13cmos5l_a21oi_1
X_09165_ hold877/A _09312_/CLK _09165_/D _09165_/RESET_B VPWR VGND sg13cmos5l_dfrbpq_1
X_06377_ _06377_/Y _06409_/A _06415_/B VPWR VGND sg13cmos5l_nor2b_1
X_08116_ _08116_/Y _08353_/B _08116_/B VPWR VGND sg13cmos5l_nor2_1
X_05328_ _05329_/B _05284_/Y _05327_/Y _05328_/S VPWR VGND sg13cmos5l_mux2_1
X_09096_ _09096_/Q clkload15/A _09096_/D _09096_/RESET_B VPWR VGND sg13cmos5l_dfrbpq_1
X_08047_ _08082_/A _09120_/Q _09119_/Q _08059_/B VPWR VGND sg13cmos5l_or3_1
Xhold940 hold940/X hold940/A VPWR VGND sg13cmos5l_dlygate4sd3_1
X_05259_ _09325_/D _05240_/B _05247_/Y _05258_/Y VPWR VGND sg13cmos5l_a21oi_1
Xhold962 hold962/X hold962/A VPWR VGND sg13cmos5l_dlygate4sd3_1
Xhold951 hold951/X hold951/A VPWR VGND sg13cmos5l_dlygate4sd3_1
Xhold973 hold973/X hold973/A VPWR VGND sg13cmos5l_dlygate4sd3_1
Xhold995 hold995/X hold995/A VPWR VGND sg13cmos5l_dlygate4sd3_1
X_09577__510 _09577_/RESET_B VPWR VGND sg13cmos5l_tiehi
Xhold984 hold984/X hold984/A VPWR VGND sg13cmos5l_dlygate4sd3_1
X_08949_ _08949_/Y _05448_/A _09269_/Q _09268_/Q _05447_/A _08948_/Y VPWR VGND sg13cmos5l_a221oi_1
XFILLER_17_505 VPWR VGND sg13cmos5l_fill_2
XFILLER_44_368 VPWR VGND sg13cmos5l_fill_1
XFILLER_12_210 VPWR VGND sg13cmos5l_fill_2
XFILLER_13_722 VPWR VGND sg13cmos5l_fill_1
X_09369__744 _09369_/RESET_B VPWR VGND sg13cmos5l_tiehi
X_09287__488 _09287_/RESET_B VPWR VGND sg13cmos5l_tiehi
XFILLER_5_921 VPWR VGND sg13cmos5l_fill_1
XFILLER_4_442 VPWR VGND sg13cmos5l_fill_2
X_09376__737 _09376_/RESET_B VPWR VGND sg13cmos5l_tiehi
XFILLER_39_1008 VPWR VGND sg13cmos5l_fill_2
X_06300_ _06300_/Y _06259_/B _06302_/S _06218_/B VPWR VGND sg13cmos5l_o21ai_1
X_07280_ _07280_/Y _07280_/A _07280_/B _07280_/C VPWR VGND sg13cmos5l_nor3_1
XFILLER_31_596 VPWR VGND sg13cmos5l_fill_1
X_06231_ _06271_/A _09469_/Q _06232_/B VPWR VGND sg13cmos5l_xnor2_1
X_06162_ _06162_/X _05853_/Y _06133_/Y _06162_/S VPWR VGND sg13cmos5l_mux2_1
X_06093_ _06093_/Y _06083_/Y _06084_/Y _06092_/Y VPWR VGND sg13cmos5l_a21oi_1
X_05113_ _05198_/B _05448_/A _05113_/B VPWR VGND sg13cmos5l_nand2_1
X_05044_ _05054_/C _07101_/B _05015_/A _05043_/Y hold1279/X hold955/X VPWR VGND sg13cmos5l_a221oi_1
X_09084__395 _09084_/RESET_B VPWR VGND sg13cmos5l_tiehi
X_08803_ _08803_/Y _08803_/A VPWR VGND sg13cmos5l_inv_1
X_08734_ _08734_/X _08733_/B _08726_/B _05188_/A VPWR VGND sg13cmos5l_a21o_1
X_06995_ _06995_/Y hold995/A hold858/A VPWR VGND sg13cmos5l_xnor2_1
XFILLER_22_1001 VPWR VGND sg13cmos5l_fill_1
X_09277__602 _09277_/RESET_B VPWR VGND sg13cmos5l_tiehi
X_05946_ _09418_/D _05925_/Y fanout39/X _05945_/Y VPWR VGND sg13cmos5l_a21oi_1
X_05877_ _05878_/B _09376_/Q _05873_/B hold1273/X VPWR VGND sg13cmos5l_o21ai_1
X_08665_ _08665_/Y _08661_/A _08661_/B _08661_/C _08661_/D VPWR VGND sg13cmos5l_a22oi_1
X_07616_ _07616_/Y _04950_/Y _07609_/Y _07615_/Y VPWR VGND sg13cmos5l_a21oi_1
X_04828_ _04828_/Y _04828_/A VPWR VGND sg13cmos5l_inv_1
X_08596_ hold901/A _04820_/Y fanout58/X _08595_/Y VPWR VGND sg13cmos5l_a21oi_1
X_07547_ _07547_/Y _07547_/A _07568_/A _07568_/B VPWR VGND sg13cmos5l_nand3_1
X_07478_ _07478_/Y _09075_/Q _07478_/B VPWR VGND sg13cmos5l_xnor2_1
X_09132__341 _09132_/RESET_B VPWR VGND sg13cmos5l_tiehi
X_09217_ _09217_/Q _09347_/CLK _09217_/D _09217_/RESET_B VPWR VGND sg13cmos5l_dfrbpq_1
X_06429_ _06429_/Y _06429_/A VPWR VGND sg13cmos5l_inv_1
X_09148_ _09148_/Q clkload6/A _09148_/D _09148_/RESET_B VPWR VGND sg13cmos5l_dfrbpq_1
X_09079_ _09079_/Q clkload14/A _09079_/D _09079_/RESET_B VPWR VGND sg13cmos5l_dfrbpq_1
XFILLER_2_957 VPWR VGND sg13cmos5l_fill_1
XFILLER_49_405 VPWR VGND sg13cmos5l_fill_1
XFILLER_49_427 VPWR VGND sg13cmos5l_fill_1
XFILLER_18_836 VPWR VGND sg13cmos5l_fill_1
XFILLER_44_121 VPWR VGND sg13cmos5l_fill_2
XFILLER_44_198 VPWR VGND sg13cmos5l_decap_8
XFILLER_32_338 VPWR VGND sg13cmos5l_fill_2
XFILLER_4_294 VPWR VGND sg13cmos5l_fill_1
X_05800_ _05800_/Y _05839_/B _05798_/Y _05799_/Y _09436_/Q VPWR VGND sg13cmos5l_a22oi_1
XFILLER_49_994 VPWR VGND sg13cmos5l_decap_8
X_06780_ _06780_/Y _06794_/B _06780_/B VPWR VGND sg13cmos5l_nand2b_1
X_05731_ _05731_/Y _05732_/A _05760_/A _05730_/Y VPWR VGND sg13cmos5l_a21oi_1
X_08450_ _08452_/A _08450_/A _08450_/B VPWR VGND sg13cmos5l_nor2_1
X_05662_ _05663_/A _05966_/A _05661_/B _05661_/Y VPWR VGND sg13cmos5l_o21ai_1
X_08381_ _08381_/Y _08364_/Y _08378_/B _08397_/B VPWR VGND sg13cmos5l_o21ai_1
X_07401_ _07438_/A _07437_/B _07437_/C _07437_/A VPWR VGND sg13cmos5l_a21oi_1
XFILLER_35_176 VPWR VGND sg13cmos5l_fill_1
X_05593_ _05732_/A _05591_/Y _05592_/X _05593_/S VPWR VGND sg13cmos5l_mux2_1
X_07332_ _07332_/Y _09064_/Q _07332_/B VPWR VGND sg13cmos5l_nand2_1
X_09567__531 _09567_/RESET_B VPWR VGND sg13cmos5l_tiehi
X_07263_ _07264_/B _07415_/A _07415_/B VPWR VGND sg13cmos5l_and2_1
X_06214_ _09463_/D _04835_/Y fanout50/X _06213_/Y VPWR VGND sg13cmos5l_a21oi_1
X_07194_ _09016_/D _09005_/A _07194_/B _07194_/C VPWR VGND sg13cmos5l_nor3_1
X_09002_ _09028_/D _09005_/A _07216_/A VPWR VGND sg13cmos5l_nor2b_1
X_06145_ _06145_/Y _06144_/A _06161_/B _05831_/X VPWR VGND sg13cmos5l_a21oi_1
X_06076_ _06077_/B _09442_/Q _09441_/Q VPWR VGND sg13cmos5l_xnor2_1
X_05027_ _07096_/C hold1265/X hold1428/X input8/X VPWR VGND sg13cmos5l_o21ai_1
XFILLER_47_909 VPWR VGND sg13cmos5l_decap_4
X_06978_ _09574_/D _07382_/A hold915/X VPWR VGND sg13cmos5l_and2_1
X_09359__754 _09359_/RESET_B VPWR VGND sg13cmos5l_tiehi
X_08717_ _09247_/D _08694_/B fanout20/X _08716_/Y VPWR VGND sg13cmos5l_a21oi_1
X_05929_ _05930_/A _06221_/A _05933_/B _05928_/Y VPWR VGND sg13cmos5l_o21ai_1
X_08648_ _08648_/Y _08294_/B _08642_/X _08647_/X _08246_/Y VPWR VGND sg13cmos5l_a22oi_1
X_08579_ _08579_/Y hold958/X _08577_/B _08576_/Y _08578_/Y VPWR VGND sg13cmos5l_a22oi_1
X_09366__747 _09366_/RESET_B VPWR VGND sg13cmos5l_tiehi
XFILLER_6_537 VPWR VGND sg13cmos5l_decap_8
XFILLER_2_787 VPWR VGND sg13cmos5l_fill_2
XFILLER_45_463 VPWR VGND sg13cmos5l_fill_2
XFILLER_46_997 VPWR VGND sg13cmos5l_fill_1
XFILLER_45_496 VPWR VGND sg13cmos5l_fill_1
XFILLER_9_397 VPWR VGND sg13cmos5l_fill_1
X_07950_ _07950_/Y _07950_/A _07950_/B VPWR VGND sg13cmos5l_nand2_1
X_06901_ _06901_/X _09549_/Q _09524_/Q VPWR VGND sg13cmos5l_or2_1
X_07881_ _07881_/Y hold944/X fanout49/X _07889_/A VPWR VGND sg13cmos5l_o21ai_1
X_06832_ _06832_/X _09555_/Q _09556_/Q VPWR VGND sg13cmos5l_xor2_1
X_09081__398 _09081_/RESET_B VPWR VGND sg13cmos5l_tiehi
X_09551_ _09551_/Q _09586_/CLK _09551_/D _09551_/RESET_B VPWR VGND sg13cmos5l_dfrbpq_1
X_06763_ _06810_/A _06798_/A _06763_/B VPWR VGND sg13cmos5l_nand2_1
X_08502_ _08502_/Y _08490_/Y _08535_/A _08498_/X _08538_/A VPWR VGND sg13cmos5l_a22oi_1
X_05714_ _05759_/A _05758_/B _05758_/C _05758_/A VPWR VGND sg13cmos5l_a21oi_1
X_09482_ _09482_/Q _09491_/CLK _09482_/D _09482_/RESET_B VPWR VGND sg13cmos5l_dfrbpq_1
X_06694_ _06694_/Y _06694_/A VPWR VGND sg13cmos5l_inv_1
XFILLER_37_997 VPWR VGND sg13cmos5l_fill_2
X_08433_ _08433_/Y _08429_/Y _08431_/Y _08432_/Y VPWR VGND sg13cmos5l_o21ai_1
X_05645_ _05645_/Y hold997/A _05416_/A _04989_/Y _09400_/Q _05644_/Y VPWR VGND sg13cmos5l_a221oi_1
X_05576_ _05576_/Y _05964_/A _05586_/A VPWR VGND sg13cmos5l_nand2_1
X_08364_ _08364_/Y _08602_/A _08366_/B _08363_/Y VPWR VGND sg13cmos5l_o21ai_1
X_07315_ _09039_/D _07389_/B _07315_/B VPWR VGND sg13cmos5l_nor2_1
X_08295_ _08295_/Y _08290_/S _08294_/Y _08293_/Y VPWR VGND sg13cmos5l_a21oi_1
X_07246_ _07246_/Y _09035_/Q _07246_/B VPWR VGND sg13cmos5l_xnor2_1
X_07177_ _07180_/B _07174_/Y _07176_/Y _07173_/Y VPWR VGND sg13cmos5l_o21ai_1
X_06128_ _06130_/C _09436_/Q _06127_/B _06148_/B VPWR VGND sg13cmos5l_o21ai_1
X_06059_ _06415_/A hold1431/X _06065_/B _06176_/A VPWR VGND sg13cmos5l_o21ai_1
XFILLER_28_964 VPWR VGND sg13cmos5l_decap_4
XFILLER_36_32 VPWR VGND sg13cmos5l_fill_1
XFILLER_14_102 VPWR VGND sg13cmos5l_fill_2
XFILLER_36_65 VPWR VGND sg13cmos5l_fill_1
XFILLER_23_680 VPWR VGND sg13cmos5l_fill_1
XFILLER_6_334 VPWR VGND sg13cmos5l_fill_1
XFILLER_2_540 VPWR VGND sg13cmos5l_decap_8
X_09557__541 _09557_/RESET_B VPWR VGND sg13cmos5l_tiehi
X_09418__692 _09418_/RESET_B VPWR VGND sg13cmos5l_tiehi
XFILLER_45_293 VPWR VGND sg13cmos5l_decap_4
X_09273__682 _09273_/RESET_B VPWR VGND sg13cmos5l_tiehi
X_05430_ _05430_/Y _04987_/Y _05397_/B _05423_/A VPWR VGND sg13cmos5l_a21oi_1
X_05361_ _05376_/C _05345_/Y _05357_/Y _05359_/Y VPWR VGND sg13cmos5l_a21o_1
X_09564__534 _09564_/RESET_B VPWR VGND sg13cmos5l_tiehi
X_07100_ _07100_/X _07100_/A _07106_/B VPWR VGND sg13cmos5l_or2_1
X_05292_ _05292_/X _05292_/A _05292_/B _05292_/C VPWR VGND sg13cmos5l_or3_1
X_08080_ _08081_/B _08178_/C _08178_/D VPWR VGND sg13cmos5l_nand2_1
X_07031_ _07031_/Y _07031_/A _07047_/S VPWR VGND sg13cmos5l_nor2_1
XFILLER_6_890 VPWR VGND sg13cmos5l_fill_2
X_08982_ _08982_/Y _04994_/Y fanout35/X _08981_/Y VPWR VGND sg13cmos5l_a21oi_1
X_07933_ _07934_/B _07933_/A _07933_/B VPWR VGND sg13cmos5l_xnor2_1
X_07864_ _07864_/Y _09126_/Q _07864_/B VPWR VGND sg13cmos5l_nor2_1
X_09603_ _09603_/Q _09608_/CLK _09603_/D _09603_/RESET_B VPWR VGND sg13cmos5l_dfrbpq_1
X_06815_ _06815_/Y _06789_/Y _06817_/S _06823_/A VPWR VGND sg13cmos5l_o21ai_1
XFILLER_28_216 VPWR VGND sg13cmos5l_fill_2
X_07795_ _07795_/X _09102_/Q _09077_/Q _09078_/Q VPWR VGND sg13cmos5l_or3_1
X_09356__757 _09356_/RESET_B VPWR VGND sg13cmos5l_tiehi
X_09534_ hold961/A clkload17/A hold963/X _09534_/RESET_B VPWR VGND sg13cmos5l_dfrbpq_1
X_06746_ _06746_/Y _06744_/Y _06745_/Y _06781_/A VPWR VGND sg13cmos5l_a21oi_1
XFILLER_36_271 VPWR VGND sg13cmos5l_fill_1
X_09465_ hold866/A _09503_/CLK _09465_/D _09465_/RESET_B VPWR VGND sg13cmos5l_dfrbpq_1
X_06677_ _06677_/X _06674_/A _06670_/C _06366_/Y VPWR VGND sg13cmos5l_a21o_1
X_05628_ _09373_/D _05637_/A _05628_/B VPWR VGND sg13cmos5l_nor2_1
X_08416_ _08418_/A _09214_/Q _08423_/B _08455_/A VPWR VGND sg13cmos5l_a21o_1
XFILLER_19_1028 VPWR VGND sg13cmos5l_fill_1
X_09396_ _09396_/Q clkload12/A _09396_/D _09396_/RESET_B VPWR VGND sg13cmos5l_dfrbpq_1
X_08347_ _08347_/Y _09218_/Q _04942_/Y _08344_/Y _08345_/Y _08346_/Y VPWR VGND sg13cmos5l_a221oi_1
X_05559_ _05586_/B _05966_/A _05559_/B VPWR VGND sg13cmos5l_xnor2_1
X_08278_ _08278_/Y _08278_/A _08649_/A VPWR VGND sg13cmos5l_nor2_1
X_07229_ _07249_/B _09032_/Q _09033_/Q _09034_/Q _09035_/Q VPWR VGND sg13cmos5l_nor4_1
X_09129__346 _09129_/RESET_B VPWR VGND sg13cmos5l_tiehi
Xfanout140 _09005_/A _07197_/A VPWR VGND sg13cmos5l_buf_1
Xfanout162 _05963_/B _05785_/Y VPWR VGND sg13cmos5l_buf_1
Xfanout173 _08942_/B _05249_/Y VPWR VGND sg13cmos5l_buf_1
Xfanout151 _06552_/A _06554_/A VPWR VGND sg13cmos5l_buf_1
XFILLER_47_525 VPWR VGND sg13cmos5l_fill_2
Xfanout184 _08278_/A _09217_/Q VPWR VGND sg13cmos5l_buf_1
Xfanout195 _08838_/A _08987_/B1 VPWR VGND sg13cmos5l_buf_1
XFILLER_43_731 VPWR VGND sg13cmos5l_fill_2
XFILLER_15_488 VPWR VGND sg13cmos5l_fill_1
XFILLER_31_948 VPWR VGND sg13cmos5l_fill_1
XFILLER_10_182 VPWR VGND sg13cmos5l_fill_1
XFILLER_7_698 VPWR VGND sg13cmos5l_fill_2
X_04930_ _04930_/Y _04930_/A VPWR VGND sg13cmos5l_inv_1
XFILLER_26_4 VPWR VGND sg13cmos5l_fill_1
XFILLER_38_514 VPWR VGND sg13cmos5l_fill_1
X_04861_ _08999_/A _04861_/A VPWR VGND sg13cmos5l_inv_1
X_07580_ _07580_/Y _07891_/A _09046_/Q _07579_/Y VPWR VGND sg13cmos5l_a21oi_1
X_06600_ _06600_/Y _06988_/A _06622_/B VPWR VGND sg13cmos5l_nand2_1
XFILLER_46_580 VPWR VGND sg13cmos5l_fill_2
X_06531_ _06531_/Y _06531_/A _06531_/B VPWR VGND sg13cmos5l_nor2_1
X_09250_ _09250_/Q _09595_/CLK _09250_/D _09250_/RESET_B VPWR VGND sg13cmos5l_dfrbpq_1
X_08201_ _08201_/X _08201_/A _08201_/B VPWR VGND sg13cmos5l_and2_1
X_06462_ _09498_/D _06470_/A hold898/X VPWR VGND sg13cmos5l_and2_1
X_06393_ _06393_/Y _06061_/Y _06377_/Y _06412_/B _06390_/A VPWR VGND sg13cmos5l_a22oi_1
X_09181_ _09181_/Q _09347_/CLK _09181_/D _09181_/RESET_B VPWR VGND sg13cmos5l_dfrbpq_1
X_05413_ _05413_/Y _05416_/B _05413_/B VPWR VGND sg13cmos5l_nand2b_1
X_05344_ _05344_/X _05366_/B _05385_/B VPWR VGND sg13cmos5l_and2_1
X_08132_ hold970/A _08132_/A _08132_/B _08132_/C VPWR VGND sg13cmos5l_nor3_1
X_05275_ _05316_/B _09328_/Q _09327_/Q VPWR VGND sg13cmos5l_xnor2_1
X_08063_ _08063_/X _08082_/A _08063_/B VPWR VGND sg13cmos5l_and2_1
X_07014_ _07059_/A _07052_/A _07014_/B VPWR VGND sg13cmos5l_and2_1
XFILLER_0_329 VPWR VGND sg13cmos5l_fill_2
X_08965_ _08965_/Y _05446_/A _08964_/B _08964_/Y VPWR VGND sg13cmos5l_o21ai_1
X_07916_ _07955_/A _07949_/A _07916_/B VPWR VGND sg13cmos5l_and2_1
X_08896_ _08896_/Y _08895_/A _08895_/B _08860_/Y VPWR VGND sg13cmos5l_o21ai_1
X_07847_ _07847_/Y _07847_/A _07855_/B VPWR VGND sg13cmos5l_nor2_1
X_07778_ _07779_/B _07778_/A VPWR VGND sg13cmos5l_inv_1
XFILLER_17_34 VPWR VGND sg13cmos5l_fill_2
XFILLER_17_89 VPWR VGND sg13cmos5l_fill_2
X_06729_ _09537_/D _04834_/Y fanout51/X _06728_/Y VPWR VGND sg13cmos5l_a21oi_1
X_09517_ _09517_/Q clkload23/A _09517_/D _09517_/RESET_B VPWR VGND sg13cmos5l_dfrbpq_1
XFILLER_37_591 VPWR VGND sg13cmos5l_fill_1
X_09448_ _09448_/Q clkload22/A _09448_/D _09448_/RESET_B VPWR VGND sg13cmos5l_dfrbpq_1
X_09379_ _09379_/Q _09575_/CLK _09379_/D _09379_/RESET_B VPWR VGND sg13cmos5l_dfrbpq_1
XFILLER_32_1025 VPWR VGND sg13cmos5l_decap_4
X_09547__551 _09547_/RESET_B VPWR VGND sg13cmos5l_tiehi
X_09554__544 _09554_/RESET_B VPWR VGND sg13cmos5l_tiehi
X_09415__695 _09415_/RESET_B VPWR VGND sg13cmos5l_tiehi
XFILLER_8_930 VPWR VGND sg13cmos5l_fill_2
XFILLER_8_952 VPWR VGND sg13cmos5l_decap_4
X_09561__537 _09561_/RESET_B VPWR VGND sg13cmos5l_tiehi
X_09602__523 _09602_/RESET_B VPWR VGND sg13cmos5l_tiehi
X_05060_ _10243_/A _05060_/A _07199_/B _05060_/C VPWR VGND sg13cmos5l_nor3_1
X_09422__688 _09422_/RESET_B VPWR VGND sg13cmos5l_tiehi
X_08750_ _08761_/C _08750_/A _08770_/B VPWR VGND sg13cmos5l_nor2_1
Xhold1118 _09231_/D _08586_/Y VPWR VGND sg13cmos5l_dlygate4sd3_1
X_05962_ _09428_/D _06469_/A hold878/X VPWR VGND sg13cmos5l_and2_1
Xhold1129 _09380_/D _05679_/Y VPWR VGND sg13cmos5l_dlygate4sd3_1
Xhold1107 _09344_/D _05429_/Y VPWR VGND sg13cmos5l_dlygate4sd3_1
X_05893_ _05994_/D _05893_/A _05893_/B _05893_/C VPWR VGND sg13cmos5l_or3_1
X_07701_ _07701_/X _07701_/A _07701_/B VPWR VGND sg13cmos5l_or2_1
X_04913_ _07387_/A _04913_/A VPWR VGND sg13cmos5l_inv_1
X_08681_ _08681_/Y _08681_/A _08681_/B VPWR VGND sg13cmos5l_nand2_1
XFILLER_17_0 VPWR VGND sg13cmos5l_fill_1
X_07632_ _09094_/D _07889_/A hold884/X VPWR VGND sg13cmos5l_and2_1
X_04844_ _05445_/A _08959_/A VPWR VGND sg13cmos5l_inv_1
X_07563_ _09077_/D _07634_/B _07664_/C _07664_/D VPWR VGND sg13cmos5l_and3_1
X_09302_ hold998/A _09387_/CLK hold999/X _09302_/RESET_B VPWR VGND sg13cmos5l_dfrbpq_1
X_06514_ _06515_/B _06364_/B _06535_/B _06513_/Y VPWR VGND sg13cmos5l_a21oi_1
X_07494_ _07494_/Y _07792_/A _07493_/Y _07490_/Y VPWR VGND sg13cmos5l_o21ai_1
X_09233_ _09233_/Q clkload2/A _09233_/D _09233_/RESET_B VPWR VGND sg13cmos5l_dfrbpq_1
X_06445_ _06445_/Y _06691_/B _06445_/B VPWR VGND sg13cmos5l_nor2_1
X_09164_ _09164_/Q clkload4/A _09164_/D _09164_/RESET_B VPWR VGND sg13cmos5l_dfrbpq_1
XFILLER_21_277 VPWR VGND sg13cmos5l_fill_2
X_06376_ _06415_/B _09452_/Q _06389_/B hold1131/X VPWR VGND sg13cmos5l_o21ai_1
X_08115_ _08115_/Y _04941_/Y _08127_/A _08114_/Y VPWR VGND sg13cmos5l_o21ai_1
X_05327_ _05327_/Y _05327_/A _05327_/B VPWR VGND sg13cmos5l_nor2_1
X_09095_ hold874/A clkload16/A _09095_/D _09095_/RESET_B VPWR VGND sg13cmos5l_dfrbpq_1
X_08046_ _08046_/Y _09120_/Q _09119_/Q _08059_/B VPWR VGND sg13cmos5l_nor3_1
Xhold930 hold930/X hold930/A VPWR VGND sg13cmos5l_dlygate4sd3_1
X_05258_ _05258_/Y _05240_/A _05256_/S _08997_/B VPWR VGND sg13cmos5l_o21ai_1
X_05189_ _08939_/A _05146_/X _05188_/Y _05203_/S VPWR VGND sg13cmos5l_mux2_1
Xhold963 hold963/X hold963/A VPWR VGND sg13cmos5l_dlygate4sd3_1
Xhold941 hold941/X hold941/A VPWR VGND sg13cmos5l_dlygate4sd3_1
Xhold952 hold952/X hold952/A VPWR VGND sg13cmos5l_dlygate4sd3_1
XFILLER_0_104 VPWR VGND sg13cmos5l_fill_2
Xhold996 hold996/X hold996/A VPWR VGND sg13cmos5l_dlygate4sd3_1
Xhold985 hold985/X hold985/A VPWR VGND sg13cmos5l_dlygate4sd3_1
Xhold974 hold974/X hold974/A VPWR VGND sg13cmos5l_dlygate4sd3_1
X_08948_ _08948_/Y _09325_/Q _04999_/Y _05000_/Y _09324_/Q _08947_/Y VPWR VGND sg13cmos5l_a221oi_1
X_08879_ _08893_/C _08880_/A _08913_/B VPWR VGND sg13cmos5l_nor2_1
XFILLER_28_33 VPWR VGND sg13cmos5l_fill_2
XFILLER_9_716 VPWR VGND sg13cmos5l_fill_1
XFILLER_5_966 VPWR VGND sg13cmos5l_fill_1
XFILLER_47_174 VPWR VGND sg13cmos5l_fill_2
X_06230_ _06278_/B _09470_/Q _06243_/B VPWR VGND sg13cmos5l_nand2_1
X_06161_ _06161_/Y _06161_/A _06161_/B VPWR VGND sg13cmos5l_nand2_1
X_06092_ _06092_/Y _06091_/A _06098_/A VPWR VGND sg13cmos5l_nand2b_1
X_05112_ _05366_/A _05448_/A _05113_/B VPWR VGND sg13cmos5l_and2_1
X_05043_ _05043_/Y _07096_/B _05043_/B VPWR VGND sg13cmos5l_nand2_1
X_06994_ _06994_/Y _09577_/Q hold887/A VPWR VGND sg13cmos5l_nand2_1
X_08802_ _08803_/A _07174_/B _08809_/B _08801_/Y VPWR VGND sg13cmos5l_a21oi_1
X_08733_ _08770_/A _09254_/Q _08733_/B VPWR VGND sg13cmos5l_xor2_1
X_05945_ _05945_/Y hold1165/X fanout39/X _05785_/Y VPWR VGND sg13cmos5l_o21ai_1
X_05876_ _05876_/Y _05876_/A _05903_/B VPWR VGND sg13cmos5l_nor2_1
X_08664_ _08664_/Y _08667_/C _08667_/D VPWR VGND sg13cmos5l_nand2_1
X_07615_ _07615_/Y _07596_/A _07609_/Y _07717_/B1 VPWR VGND sg13cmos5l_o21ai_1
X_04827_ _04827_/Y _04827_/A VPWR VGND sg13cmos5l_inv_1
X_08595_ _08595_/Y _09237_/Q fanout58/X _08394_/A VPWR VGND sg13cmos5l_o21ai_1
XFILLER_41_328 VPWR VGND sg13cmos5l_decap_4
X_07546_ _07571_/B _09042_/Q _07568_/A VPWR VGND sg13cmos5l_xnor2_1
X_07477_ _07506_/B _09075_/Q _07478_/B VPWR VGND sg13cmos5l_nor2b_1
X_09216_ _09216_/Q _09347_/CLK _09216_/D _09216_/RESET_B VPWR VGND sg13cmos5l_dfrbpq_1
XFILLER_10_737 VPWR VGND sg13cmos5l_fill_1
X_06428_ _06429_/A _06738_/A _06437_/B _06427_/Y VPWR VGND sg13cmos5l_o21ai_1
X_06359_ _06503_/A _06354_/Y _06356_/X _06367_/S VPWR VGND sg13cmos5l_mux2_1
X_09147_ _09147_/Q clkload6/A _09147_/D _09147_/RESET_B VPWR VGND sg13cmos5l_dfrbpq_1
X_09078_ _09078_/Q clkload14/A _09078_/D _09078_/RESET_B VPWR VGND sg13cmos5l_dfrbpq_1
X_09544__554 _09544_/RESET_B VPWR VGND sg13cmos5l_tiehi
X_08029_ _08031_/B _08178_/A _08178_/B VPWR VGND sg13cmos5l_and2_1
X_09551__547 _09551_/RESET_B VPWR VGND sg13cmos5l_tiehi
XFILLER_13_542 VPWR VGND sg13cmos5l_fill_1
X_09412__698 _09412_/RESET_B VPWR VGND sg13cmos5l_tiehi
X_09382__731 _09382_/RESET_B VPWR VGND sg13cmos5l_tiehi
XFILLER_5_785 VPWR VGND sg13cmos5l_fill_2
XFILLER_1_991 VPWR VGND sg13cmos5l_decap_8
XFILLER_49_973 VPWR VGND sg13cmos5l_decap_8
X_05730_ _05730_/Y _05730_/A _05737_/A VPWR VGND sg13cmos5l_nor2_1
X_05661_ _05661_/Y _05661_/A _05661_/B VPWR VGND sg13cmos5l_nand2_1
X_08380_ _09199_/D _08380_/A _08380_/B VPWR VGND sg13cmos5l_nor2_1
X_07400_ _07437_/C _09054_/Q hold876/A _09059_/Q VPWR VGND sg13cmos5l_nand3_1
X_05592_ _05592_/X _05592_/A _05592_/B VPWR VGND sg13cmos5l_and2_1
X_07331_ _09044_/D _07463_/A _07423_/B VPWR VGND sg13cmos5l_nor2_1
XFILLER_32_873 VPWR VGND sg13cmos5l_fill_1
X_07262_ _07415_/B hold1352/X _07272_/B _07272_/C VPWR VGND sg13cmos5l_nand3b_1
X_09001_ _09320_/D _09001_/A _09001_/B VPWR VGND sg13cmos5l_nor2_1
X_06213_ _06213_/Y hold960/X fanout51/X _06469_/A VPWR VGND sg13cmos5l_o21ai_1
X_07193_ _07194_/C _07193_/A _07193_/B VPWR VGND sg13cmos5l_nor2_1
X_06144_ _06144_/Y _06144_/A _06161_/B VPWR VGND sg13cmos5l_nand2_1
X_06075_ _06077_/A _09473_/Q _09441_/Q VPWR VGND sg13cmos5l_nand2_1
X_05026_ _07096_/B _05021_/B _05026_/B VPWR VGND sg13cmos5l_nand2b_1
X_06977_ _06977_/Y _04958_/Y _06936_/B _06990_/B VPWR VGND sg13cmos5l_a21oi_1
X_08716_ _08716_/Y _08694_/A fanout20/X _08723_/A VPWR VGND sg13cmos5l_o21ai_1
X_05928_ _05928_/Y _05928_/A _05933_/B VPWR VGND sg13cmos5l_nand2_1
X_05859_ _05896_/A _09374_/Q _09373_/Q _09372_/Q VPWR VGND sg13cmos5l_or3_1
X_08647_ _08647_/X _08659_/C _08675_/B VPWR VGND sg13cmos5l_and2_1
X_08578_ _08578_/Y _04823_/Y _08574_/A _08577_/Y VPWR VGND sg13cmos5l_a21oi_1
X_07529_ _07529_/Y _07808_/A _07528_/B _07530_/S VPWR VGND sg13cmos5l_o21ai_1
XFILLER_10_589 VPWR VGND sg13cmos5l_fill_2
XFILLER_29_1019 VPWR VGND sg13cmos5l_fill_1
XFILLER_49_247 VPWR VGND sg13cmos5l_fill_1
XFILLER_17_100 VPWR VGND sg13cmos5l_fill_2
Xhold1290 hold1290/X _06165_/B VPWR VGND sg13cmos5l_dlygate4sd3_1
XFILLER_33_648 VPWR VGND sg13cmos5l_fill_1
X_06900_ _06920_/B _09524_/Q _09525_/Q VPWR VGND sg13cmos5l_xor2_1
X_07880_ _09127_/D _08393_/A hold945/X VPWR VGND sg13cmos5l_and2_1
X_06831_ _06831_/Y _09556_/Q _09555_/Q _09587_/Q VPWR VGND sg13cmos5l_nand3b_1
X_09550_ _09550_/Q _09591_/CLK _09550_/D _09550_/RESET_B VPWR VGND sg13cmos5l_dfrbpq_1
X_06762_ _06763_/B _06762_/A hold1227/X VPWR VGND sg13cmos5l_nor2b_1
X_09481_ _09481_/Q _09491_/CLK _09481_/D _09481_/RESET_B VPWR VGND sg13cmos5l_dfrbpq_1
X_08501_ _08501_/Y _08538_/A VPWR VGND sg13cmos5l_inv_1
X_05713_ _05758_/C _09394_/Q _05719_/B _05723_/A VPWR VGND sg13cmos5l_o21ai_1
XFILLER_37_987 VPWR VGND sg13cmos5l_fill_2
X_08432_ _08432_/Y _08291_/A _08338_/B _08456_/A _08295_/Y VPWR VGND sg13cmos5l_a22oi_1
X_06693_ _06694_/A _06989_/A _06705_/B _06692_/Y VPWR VGND sg13cmos5l_o21ai_1
X_05644_ _05644_/Y _05966_/A _09343_/Q _09342_/Q _05965_/A _05643_/Y VPWR VGND sg13cmos5l_a221oi_1
X_05575_ _05575_/Y _05588_/A _05575_/B VPWR VGND sg13cmos5l_nor2_1
X_08363_ _08363_/Y hold980/X _08366_/B VPWR VGND sg13cmos5l_nand2_1
X_08294_ _08294_/Y _08294_/A _08294_/B VPWR VGND sg13cmos5l_nand2_1
X_07314_ _07315_/B _07415_/C _07415_/D VPWR VGND sg13cmos5l_nand2_1
XFILLER_32_692 VPWR VGND sg13cmos5l_fill_1
X_07245_ _07276_/B _07251_/B _07244_/Y VPWR VGND sg13cmos5l_nor2b_1
X_07176_ _07176_/Y _09028_/Q _07174_/B _05007_/Y _07154_/A _07175_/Y VPWR VGND sg13cmos5l_a221oi_1
X_06127_ _06130_/B _09436_/Q _06127_/B VPWR VGND sg13cmos5l_nand2_1
X_09541__557 _09541_/RESET_B VPWR VGND sg13cmos5l_tiehi
X_06058_ _06058_/Y _06112_/A _06098_/A VPWR VGND sg13cmos5l_nor2_1
X_05009_ _05015_/A hold933/X _07106_/A _05009_/C VPWR VGND sg13cmos5l_nor3_1
X_09257__804 _09257_/RESET_B VPWR VGND sg13cmos5l_tiehi
X_09372__741 _09372_/RESET_B VPWR VGND sg13cmos5l_tiehi
XFILLER_43_957 VPWR VGND sg13cmos5l_decap_4
XFILLER_46_740 VPWR VGND sg13cmos5l_decap_8
X_05360_ _05379_/C _05345_/Y _05357_/Y _05359_/Y VPWR VGND sg13cmos5l_a21oi_1
XFILLER_33_489 VPWR VGND sg13cmos5l_fill_1
X_05291_ _05291_/Y _05292_/A _05292_/B _05292_/C VPWR VGND sg13cmos5l_nor3_1
X_07030_ _07053_/B _07025_/Y _07027_/Y _07028_/X VPWR VGND sg13cmos5l_a21o_1
X_09349__765 _09349_/RESET_B VPWR VGND sg13cmos5l_tiehi
X_08981_ _08981_/Y _08965_/Y fanout35/X _05248_/Y VPWR VGND sg13cmos5l_o21ai_1
X_07932_ _07933_/B _07932_/A _07932_/B VPWR VGND sg13cmos5l_nor2_1
X_07863_ _07863_/X _07854_/Y _07858_/Y _07862_/Y VPWR VGND sg13cmos5l_a21o_1
X_09602_ _09602_/Q clkload3/A _09602_/D _09602_/RESET_B VPWR VGND sg13cmos5l_dfrbpq_1
X_06814_ _09550_/D _06792_/B _06817_/S _06813_/Y VPWR VGND sg13cmos5l_a21oi_1
X_07794_ _07794_/Y _07822_/A _07822_/B _07799_/A VPWR VGND sg13cmos5l_a21oi_1
X_09533_ _09533_/Q _09586_/CLK _09533_/D _09533_/RESET_B VPWR VGND sg13cmos5l_dfrbpq_1
X_06745_ _06745_/Y hold913/A hold851/A VPWR VGND sg13cmos5l_xnor2_1
X_06676_ _09527_/D _06818_/A _06676_/B VPWR VGND sg13cmos5l_nor2_1
X_09464_ hold860/A _09575_/CLK _09464_/D _09464_/RESET_B VPWR VGND sg13cmos5l_dfrbpq_1
X_05627_ _05627_/X _05606_/Y _05317_/Y _05636_/S VPWR VGND sg13cmos5l_mux2_1
X_08415_ _08455_/A _08454_/B _08454_/C _08454_/A VPWR VGND sg13cmos5l_a21oi_1
X_09395_ _09395_/Q clkload12/A _09395_/D _09395_/RESET_B VPWR VGND sg13cmos5l_dfrbpq_1
X_08346_ _08346_/Y _09160_/Q _08278_/A VPWR VGND sg13cmos5l_nor2b_1
XFILLER_12_629 VPWR VGND sg13cmos5l_fill_1
X_05558_ _05864_/A _09400_/Q _05559_/B VPWR VGND sg13cmos5l_xnor2_1
X_08277_ _09184_/D _08400_/B _08277_/B VPWR VGND sg13cmos5l_nor2_1
X_05489_ _05497_/A _05503_/B _05489_/B VPWR VGND sg13cmos5l_nor2_1
X_07228_ _07246_/B _09032_/Q _09033_/Q _09034_/Q VPWR VGND sg13cmos5l_or3_1
X_07159_ _08782_/A _07158_/A _07159_/B VPWR VGND sg13cmos5l_nand2b_1
Xfanout130 _07636_/B _07469_/Y VPWR VGND sg13cmos5l_buf_1
Xfanout163 _05637_/A _05784_/A VPWR VGND sg13cmos5l_buf_1
Xfanout152 _06554_/A _06306_/Y VPWR VGND sg13cmos5l_buf_1
Xfanout174 _08997_/B _05248_/Y VPWR VGND sg13cmos5l_buf_1
Xfanout141 _07197_/A _07220_/A VPWR VGND sg13cmos5l_buf_1
Xfanout185 _08600_/A hold1211/X VPWR VGND sg13cmos5l_buf_1
XFILLER_19_228 VPWR VGND sg13cmos5l_fill_1
Xfanout196 _08987_/B1 fanout217/X VPWR VGND sg13cmos5l_buf_1
XFILLER_28_740 VPWR VGND sg13cmos5l_fill_2
XFILLER_27_272 VPWR VGND sg13cmos5l_fill_1
XFILLER_7_611 VPWR VGND sg13cmos5l_fill_2
XFILLER_3_883 VPWR VGND sg13cmos5l_fill_1
XFILLER_3_861 VPWR VGND sg13cmos5l_fill_1
X_09297__425 _09297_/RESET_B VPWR VGND sg13cmos5l_tiehi
X_04860_ _06222_/A _04860_/A VPWR VGND sg13cmos5l_inv_1
X_06530_ _06530_/Y _06519_/Y _06521_/X _06531_/A _06531_/B VPWR VGND sg13cmos5l_a22oi_1
X_06461_ _06461_/Y _04968_/Y _06445_/B _06477_/B VPWR VGND sg13cmos5l_a21oi_1
X_08200_ _08200_/X _08031_/B _08081_/B _08208_/B VPWR VGND sg13cmos5l_mux2_1
X_05412_ _05416_/B _08972_/A _05411_/B _05411_/Y VPWR VGND sg13cmos5l_a21oi_1
X_06392_ _06392_/X _06392_/A _06392_/B _06392_/C VPWR VGND sg13cmos5l_or3_1
X_09180_ _09180_/Q _09347_/CLK _09180_/D _09180_/RESET_B VPWR VGND sg13cmos5l_dfrbpq_1
X_05343_ _05385_/B _09300_/Q _05341_/B hold1072/X VPWR VGND sg13cmos5l_o21ai_1
X_08131_ _08132_/C _08131_/A _08130_/B VPWR VGND sg13cmos5l_nor2b_1
X_05274_ _05274_/X _05283_/B _05279_/C _05322_/A VPWR VGND sg13cmos5l_a21o_1
X_08062_ _08063_/B _09119_/Q _08059_/B hold1283/X VPWR VGND sg13cmos5l_o21ai_1
X_09247__814 _09247_/RESET_B VPWR VGND sg13cmos5l_tiehi
X_07013_ _07014_/B _07015_/B hold1318/X VPWR VGND sg13cmos5l_nor2b_1
X_09362__751 _09362_/RESET_B VPWR VGND sg13cmos5l_tiehi
X_08964_ _08964_/Y _09267_/Q _08964_/B VPWR VGND sg13cmos5l_nand2_1
X_07915_ _07916_/B _07917_/B hold1345/X VPWR VGND sg13cmos5l_nor2b_1
X_08895_ _08895_/X _08895_/A _08895_/B VPWR VGND sg13cmos5l_or2_1
X_07846_ _07846_/Y _07846_/A VPWR VGND sg13cmos5l_inv_1
X_09254__807 _09254_/RESET_B VPWR VGND sg13cmos5l_tiehi
X_07777_ _07778_/A _07746_/Y _07776_/Y _07777_/S VPWR VGND sg13cmos5l_mux2_1
X_04989_ _04989_/Y _05661_/A VPWR VGND sg13cmos5l_inv_1
X_06728_ _06728_/Y hold937/X fanout51/X _07383_/A VPWR VGND sg13cmos5l_o21ai_1
X_09516_ _09516_/Q clkload23/A _09516_/D _09516_/RESET_B VPWR VGND sg13cmos5l_dfrbpq_1
X_09447_ _09447_/Q _09491_/CLK _09447_/D _09447_/RESET_B VPWR VGND sg13cmos5l_dfrbpq_1
X_06659_ _06670_/C _06650_/Y _06655_/Y _06657_/Y VPWR VGND sg13cmos5l_a21o_1
XFILLER_40_779 VPWR VGND sg13cmos5l_fill_2
X_09378_ _09378_/Q _09503_/CLK _09378_/D _09378_/RESET_B VPWR VGND sg13cmos5l_dfrbpq_1
X_08329_ _08427_/C _08308_/Y _08334_/C _08329_/C VPWR VGND sg13cmos5l_nand3b_1
XFILLER_47_345 VPWR VGND sg13cmos5l_fill_2
XFILLER_47_334 VPWR VGND sg13cmos5l_fill_2
XFILLER_16_732 VPWR VGND sg13cmos5l_fill_1
XFILLER_43_595 VPWR VGND sg13cmos5l_fill_1
XFILLER_12_960 VPWR VGND sg13cmos5l_fill_1
XFILLER_7_463 VPWR VGND sg13cmos5l_decap_8
XFILLER_48_1011 VPWR VGND sg13cmos5l_decap_8
X_09598__483 _09598_/RESET_B VPWR VGND sg13cmos5l_tiehi
XFILLER_39_824 VPWR VGND sg13cmos5l_fill_2
X_07700_ _07701_/B _07575_/Y _07699_/B _07699_/Y VPWR VGND sg13cmos5l_o21ai_1
X_05961_ _09427_/D _05961_/A hold861/X VPWR VGND sg13cmos5l_and2_1
Xhold1119 _06191_/B _09458_/Q VPWR VGND sg13cmos5l_dlygate4sd3_1
Xhold1108 _08840_/A _09028_/Q VPWR VGND sg13cmos5l_dlygate4sd3_1
X_05892_ _05994_/C _05893_/A _05893_/B _05576_/Y VPWR VGND sg13cmos5l_o21ai_1
X_08680_ _08681_/B _08537_/B _08699_/B _08679_/Y VPWR VGND sg13cmos5l_o21ai_1
X_04912_ _07389_/A _06957_/A VPWR VGND sg13cmos5l_inv_1
XFILLER_38_323 VPWR VGND sg13cmos5l_fill_1
X_07631_ _09093_/D _07633_/A hold882/X VPWR VGND sg13cmos5l_and2_1
X_04843_ _08998_/A _08801_/A VPWR VGND sg13cmos5l_inv_1
X_07562_ _07664_/D _07537_/Y _07558_/Y _07260_/Y VPWR VGND sg13cmos5l_o21ai_1
XFILLER_0_60 VPWR VGND sg13cmos5l_fill_1
XFILLER_0_1024 VPWR VGND sg13cmos5l_decap_4
X_09301_ _09301_/Q clkload10/A _09301_/D _09301_/RESET_B VPWR VGND sg13cmos5l_dfrbpq_1
X_06513_ _06513_/Y _06513_/A _06535_/B VPWR VGND sg13cmos5l_nor2_1
X_09119__357 _09119_/RESET_B VPWR VGND sg13cmos5l_tiehi
X_07493_ _07493_/Y _09073_/Q _07493_/B VPWR VGND sg13cmos5l_xnor2_1
X_09232_ _09232_/Q clkload2/A _09232_/D _09232_/RESET_B VPWR VGND sg13cmos5l_dfrbpq_1
X_06444_ _06444_/Y _04969_/Y _06458_/A _06443_/Y VPWR VGND sg13cmos5l_o21ai_1
X_06375_ _06396_/A _06394_/A _06409_/A VPWR VGND sg13cmos5l_and2_1
X_09163_ hold969/A clkload4/A hold970/X _09163_/RESET_B VPWR VGND sg13cmos5l_dfrbpq_1
X_05326_ _09329_/D _05378_/A _05326_/B VPWR VGND sg13cmos5l_nor2_1
X_08114_ _08114_/Y _08107_/Y _08110_/Y _08113_/Y VPWR VGND sg13cmos5l_a21oi_1
X_09094_ hold880/A clkload16/A _09094_/D _09094_/RESET_B VPWR VGND sg13cmos5l_dfrbpq_1
X_05257_ _09324_/D _09001_/B _05257_/B VPWR VGND sg13cmos5l_nor2_1
X_09282__513 _09282_/RESET_B VPWR VGND sg13cmos5l_tiehi
X_08045_ _08059_/B _09117_/Q _09118_/Q _09115_/Q _09116_/Q VPWR VGND sg13cmos5l_or4_1
Xhold931 hold931/X hold931/A VPWR VGND sg13cmos5l_dlygate4sd3_1
Xhold920 hold920/X hold920/A VPWR VGND sg13cmos5l_dlygate4sd3_1
X_05188_ _05188_/Y _05188_/A _08750_/A VPWR VGND sg13cmos5l_nand2_1
Xhold953 hold953/X hold953/A VPWR VGND sg13cmos5l_dlygate4sd3_1
Xhold964 hold964/X hold964/A VPWR VGND sg13cmos5l_dlygate4sd3_1
Xhold942 hold942/X hold942/A VPWR VGND sg13cmos5l_dlygate4sd3_1
Xhold986 hold986/X hold986/A VPWR VGND sg13cmos5l_dlygate4sd3_1
Xhold975 hold975/X hold975/A VPWR VGND sg13cmos5l_dlygate4sd3_1
Xhold997 hold997/X hold997/A VPWR VGND sg13cmos5l_dlygate4sd3_1
X_08947_ _08947_/Y _05446_/A _09267_/Q _09266_/Q _05445_/A _08946_/Y VPWR VGND sg13cmos5l_a221oi_1
X_08878_ _08889_/B _08872_/X _08874_/Y _08876_/Y VPWR VGND sg13cmos5l_a21o_1
X_07829_ _07829_/Y _07829_/A _07829_/B _07829_/C VPWR VGND sg13cmos5l_nand3_1
XFILLER_44_348 VPWR VGND sg13cmos5l_fill_2
XFILLER_12_212 VPWR VGND sg13cmos5l_fill_1
XFILLER_12_267 VPWR VGND sg13cmos5l_fill_2
XFILLER_4_422 VPWR VGND sg13cmos5l_fill_1
XFILLER_10_8 VPWR VGND sg13cmos5l_fill_1
X_09300__384 _09300_/RESET_B VPWR VGND sg13cmos5l_tiehi
X_09352__761 _09352_/RESET_B VPWR VGND sg13cmos5l_tiehi
XFILLER_31_521 VPWR VGND sg13cmos5l_fill_1
X_06160_ _09451_/D _06164_/A _06160_/B VPWR VGND sg13cmos5l_nor2_1
X_05111_ _05209_/B _09294_/Q _05111_/B VPWR VGND sg13cmos5l_xnor2_1
X_06091_ _06091_/Y _06091_/A _06103_/A VPWR VGND sg13cmos5l_nor2_1
X_09244__817 _09244_/RESET_B VPWR VGND sg13cmos5l_tiehi
X_05042_ _05043_/B _09603_/Q _05047_/A _07101_/B VPWR VGND sg13cmos5l_a21oi_1
X_06993_ _09586_/D _06993_/A _07070_/A VPWR VGND sg13cmos5l_nor2_1
X_08801_ _08801_/Y _08801_/A _08809_/B VPWR VGND sg13cmos5l_nor2_1
X_08732_ _08739_/C _09251_/Q _09252_/Q _09253_/Q _09254_/Q VPWR VGND sg13cmos5l_or4_1
X_05944_ _09417_/D _05920_/Y fanout39/X _05943_/Y VPWR VGND sg13cmos5l_a21oi_1
X_08663_ _08667_/D _08663_/A _08663_/B _08663_/C VPWR VGND sg13cmos5l_nand3_1
X_05875_ _05875_/Y _05864_/Y _05872_/Y _05874_/Y VPWR VGND sg13cmos5l_o21ai_1
X_07614_ _09084_/D _07716_/A _07614_/B _07614_/C VPWR VGND sg13cmos5l_nor3_1
X_04826_ _04826_/Y hold906/X VPWR VGND sg13cmos5l_inv_1
X_08594_ _09236_/D _04821_/Y fanout56/X _08593_/Y VPWR VGND sg13cmos5l_a21oi_1
X_09318__645 _09318_/RESET_B VPWR VGND sg13cmos5l_tiehi
X_07545_ _07545_/Y _07545_/A _07545_/B _07545_/C VPWR VGND sg13cmos5l_nor3_1
X_07476_ _07478_/B _09074_/Q _07495_/B VPWR VGND sg13cmos5l_nor2b_1
X_09215_ _09215_/Q _09347_/CLK _09215_/D _09215_/RESET_B VPWR VGND sg13cmos5l_dfrbpq_1
X_06427_ _06427_/Y _09455_/Q _06437_/B VPWR VGND sg13cmos5l_nand2_1
X_06358_ _06360_/B _06367_/S _06356_/X _06355_/Y VPWR VGND sg13cmos5l_a21oi_1
X_09146_ _09146_/Q clkload6/A _09146_/D _09146_/RESET_B VPWR VGND sg13cmos5l_dfrbpq_1
X_06289_ _06291_/B _06246_/A _06281_/B _06253_/A VPWR VGND sg13cmos5l_a21o_1
X_05309_ _05309_/Y _05696_/A _05331_/B VPWR VGND sg13cmos5l_nand2_1
X_09077_ _09077_/Q _09573_/CLK _09077_/D _09077_/RESET_B VPWR VGND sg13cmos5l_dfrbpq_1
X_09286__490 _09286_/RESET_B VPWR VGND sg13cmos5l_tiehi
X_08028_ _08178_/B _08009_/Y _08013_/Y _08027_/Y VPWR VGND sg13cmos5l_o21ai_1
XFILLER_39_55 VPWR VGND sg13cmos5l_fill_1
XFILLER_39_99 VPWR VGND sg13cmos5l_fill_1
XFILLER_17_348 VPWR VGND sg13cmos5l_fill_1
XFILLER_4_252 VPWR VGND sg13cmos5l_fill_1
X_09109__367 _09109_/RESET_B VPWR VGND sg13cmos5l_tiehi
XFILLER_49_952 VPWR VGND sg13cmos5l_decap_8
X_09079__400 _09079_/RESET_B VPWR VGND sg13cmos5l_tiehi
X_05660_ _05660_/Y _05650_/A _05655_/Y _05659_/Y VPWR VGND sg13cmos5l_o21ai_1
X_05591_ _05591_/Y _05887_/A _05876_/A VPWR VGND sg13cmos5l_nor2_1
XFILLER_44_690 VPWR VGND sg13cmos5l_fill_1
X_07330_ _07423_/B _07330_/A _07330_/B VPWR VGND sg13cmos5l_and2_1
X_07261_ _07415_/A _07272_/B _07272_/C _07260_/Y VPWR VGND sg13cmos5l_a21o_1
X_09000_ _09319_/D _09000_/A _09001_/B VPWR VGND sg13cmos5l_nor2_1
X_06212_ _09462_/D _04836_/Y fanout51/X _06211_/Y VPWR VGND sg13cmos5l_a21oi_1
X_07192_ _07194_/B _08841_/A _07193_/B VPWR VGND sg13cmos5l_nor2b_1
X_06143_ _06162_/S _06148_/A _06148_/C VPWR VGND sg13cmos5l_nor2_1
X_06074_ _06079_/A _06073_/A _06073_/B _06387_/A VPWR VGND sg13cmos5l_a21o_1
X_05025_ _09605_/D _05025_/A VPWR VGND sg13cmos5l_inv_1
X_09574__515 _09574_/RESET_B VPWR VGND sg13cmos5l_tiehi
X_06976_ _09572_/D _06990_/B _06976_/B VPWR VGND sg13cmos5l_nor2_1
X_08715_ _09246_/D _08692_/B fanout20/X _08714_/Y VPWR VGND sg13cmos5l_a21oi_1
X_05927_ _05927_/Y _05940_/A _05922_/Y _05926_/Y VPWR VGND sg13cmos5l_o21ai_1
X_05858_ _09408_/D _05963_/B _06028_/A VPWR VGND sg13cmos5l_and2_1
X_08646_ _08675_/B _09195_/Q _08643_/B _09196_/Q VPWR VGND sg13cmos5l_o21ai_1
XFILLER_27_646 VPWR VGND sg13cmos5l_fill_1
X_05789_ _05818_/B _09407_/Q _05809_/B VPWR VGND sg13cmos5l_nor2b_1
X_08577_ _08577_/Y hold958/X _08577_/B VPWR VGND sg13cmos5l_nor2_1
X_07528_ _07528_/Y _07808_/A _07528_/B VPWR VGND sg13cmos5l_nor2_1
X_07459_ _09065_/D _07434_/B _07462_/S _07458_/Y VPWR VGND sg13cmos5l_a21oi_1
XFILLER_41_56 VPWR VGND sg13cmos5l_fill_1
X_09129_ hold950/A clkload16/A _09129_/D _09129_/RESET_B VPWR VGND sg13cmos5l_dfrbpq_1
XFILLER_2_789 VPWR VGND sg13cmos5l_fill_1
XFILLER_17_112 VPWR VGND sg13cmos5l_fill_2
Xhold1291 hold1291/X _09567_/Q VPWR VGND sg13cmos5l_dlygate4sd3_1
Xhold1280 _07933_/A _09135_/Q VPWR VGND sg13cmos5l_dlygate4sd3_1
XFILLER_17_189 VPWR VGND sg13cmos5l_fill_1
XFILLER_40_170 VPWR VGND sg13cmos5l_fill_2
X_06830_ _06876_/A _06840_/B _06840_/C VPWR VGND sg13cmos5l_nand2_1
X_06761_ _06787_/A _06781_/B _06798_/B _06761_/C VPWR VGND sg13cmos5l_nor3_1
XFILLER_37_911 VPWR VGND sg13cmos5l_fill_2
X_09480_ _09480_/Q _09491_/CLK _09480_/D _09480_/RESET_B VPWR VGND sg13cmos5l_dfrbpq_1
X_08500_ _08538_/A _09249_/Q _08500_/B VPWR VGND sg13cmos5l_xnor2_1
X_06692_ _06692_/Y _06692_/A _06705_/B VPWR VGND sg13cmos5l_nand2_1
X_05712_ _05723_/A _09393_/Q _05719_/B _05752_/A VPWR VGND sg13cmos5l_a21o_1
X_08431_ _08431_/Y _08291_/A _08338_/B _08430_/Y VPWR VGND sg13cmos5l_o21ai_1
X_05643_ _05643_/Y _09399_/Q _04990_/Y _05640_/Y _05641_/Y _05642_/Y VPWR VGND sg13cmos5l_a221oi_1
X_05574_ _09365_/D _05637_/A _05574_/B VPWR VGND sg13cmos5l_nor2_1
X_08362_ _08362_/X _08362_/A _08362_/B VPWR VGND sg13cmos5l_or2_1
X_07313_ _07415_/D _07288_/Y _07309_/Y _06864_/Y VPWR VGND sg13cmos5l_o21ai_1
X_08293_ _08293_/Y _08293_/A _08293_/B _08293_/C VPWR VGND sg13cmos5l_nor3_1
XFILLER_32_682 VPWR VGND sg13cmos5l_fill_2
X_07244_ _07244_/Y _09066_/Q _09065_/Q _09067_/Q VPWR VGND sg13cmos5l_o21ai_1
X_07175_ _07175_/Y _08839_/A _09014_/Q hold983/A _08779_/A VPWR VGND sg13cmos5l_a22oi_1
X_06126_ _06148_/B _09411_/Q _09410_/Q VPWR VGND sg13cmos5l_xnor2_1
X_06057_ _06394_/A _06475_/A _06476_/A _06477_/A _06068_/B VPWR VGND sg13cmos5l_nand4_1
X_05008_ _09604_/D hold955/X _08479_/B VPWR VGND sg13cmos5l_and2_1
X_06959_ _06959_/Y _06962_/B _09572_/Q VPWR VGND sg13cmos5l_nand2b_1
XFILLER_14_104 VPWR VGND sg13cmos5l_fill_1
X_08629_ _08663_/A _09193_/Q _09191_/Q _09192_/Q VPWR VGND sg13cmos5l_or3_1
XFILLER_6_369 VPWR VGND sg13cmos5l_fill_1
X_09069__410 _09069_/RESET_B VPWR VGND sg13cmos5l_tiehi
XFILLER_7_0 VPWR VGND sg13cmos5l_fill_2
XFILLER_46_763 VPWR VGND sg13cmos5l_decap_4
X_09076__403 _09076_/RESET_B VPWR VGND sg13cmos5l_tiehi
XFILLER_33_424 VPWR VGND sg13cmos5l_fill_2
XFILLER_33_446 VPWR VGND sg13cmos5l_fill_2
XFILLER_41_490 VPWR VGND sg13cmos5l_fill_2
X_05290_ _05292_/C _05330_/B _05617_/A VPWR VGND sg13cmos5l_nor2_1
XFILLER_9_185 VPWR VGND sg13cmos5l_fill_1
X_08980_ _09304_/D _04995_/Y fanout35/X _08979_/Y VPWR VGND sg13cmos5l_a21oi_1
X_07931_ _07944_/B _07779_/B _07828_/B _07950_/B VPWR VGND sg13cmos5l_mux2_1
X_07862_ _07862_/Y _04944_/Y _07876_/A _07859_/Y VPWR VGND sg13cmos5l_o21ai_1
X_09571__518 _09571_/RESET_B VPWR VGND sg13cmos5l_tiehi
X_09601_ hold955/A _09608_/CLK _09601_/D _09601_/RESET_B VPWR VGND sg13cmos5l_dfrbpq_1
X_06813_ _06813_/Y _06792_/A _06817_/S _06737_/B VPWR VGND sg13cmos5l_o21ai_1
X_07793_ _07822_/B _09077_/Q _09078_/Q _09079_/Q VPWR VGND sg13cmos5l_o21ai_1
X_09532_ _09532_/Q _09586_/CLK _09532_/D _09532_/RESET_B VPWR VGND sg13cmos5l_dfrbpq_1
X_06744_ _06744_/Y hold926/A hold864/A VPWR VGND sg13cmos5l_xnor2_1
X_09463_ hold946/A _09503_/CLK _09463_/D _09463_/RESET_B VPWR VGND sg13cmos5l_dfrbpq_1
X_06675_ _06676_/B _06674_/Y _06361_/X _06675_/S VPWR VGND sg13cmos5l_mux2_1
X_05626_ _05628_/B _05606_/Y _05636_/S _05625_/X VPWR VGND sg13cmos5l_o21ai_1
X_08414_ _08454_/C _09213_/Q _08423_/B _08424_/A VPWR VGND sg13cmos5l_o21ai_1
X_09394_ _09394_/Q clkload18/A _09394_/D _09394_/RESET_B VPWR VGND sg13cmos5l_dfrbpq_1
X_05557_ _05557_/X _05557_/A _05557_/B _05557_/C VPWR VGND sg13cmos5l_or3_1
X_08345_ _08345_/Y _09159_/Q _09216_/Q VPWR VGND sg13cmos5l_nor2b_1
Xclkbuf_leaf_31_clk clkload15/A clkbuf_3_4__f_clk/X VPWR VGND sg13cmos5l_buf_8
X_08276_ _08277_/B _08426_/A _08426_/B VPWR VGND sg13cmos5l_nor2_1
XFILLER_22_47 VPWR VGND sg13cmos5l_fill_1
X_05488_ _05488_/Y _05488_/A _05488_/B VPWR VGND sg13cmos5l_xnor2_1
X_07227_ _07233_/B _07639_/A _07227_/B VPWR VGND sg13cmos5l_nand2_1
X_07158_ _08870_/A _07158_/A _07159_/B VPWR VGND sg13cmos5l_nor2b_1
X_06109_ _09444_/D _06164_/A _06109_/B VPWR VGND sg13cmos5l_nor2_1
X_07089_ hold896/A _07079_/B _07088_/Y hold895/X VPWR VGND sg13cmos5l_a21oi_1
Xfanout131 _07639_/B _07716_/A VPWR VGND sg13cmos5l_buf_1
Xfanout120 _08474_/B1 _08234_/Y VPWR VGND sg13cmos5l_buf_1
Xfanout142 _07070_/A _06990_/B VPWR VGND sg13cmos5l_buf_1
Xfanout153 _06477_/B _06306_/Y VPWR VGND sg13cmos5l_buf_1
Xfanout164 _05784_/A _05776_/A VPWR VGND sg13cmos5l_buf_1
XFILLER_47_527 VPWR VGND sg13cmos5l_fill_1
Xfanout186 _07991_/C _08397_/A VPWR VGND sg13cmos5l_buf_1
Xfanout175 _07101_/B hold1207/X VPWR VGND sg13cmos5l_buf_1
Xfanout197 _08995_/A _08994_/A VPWR VGND sg13cmos5l_buf_1
XFILLER_28_774 VPWR VGND sg13cmos5l_fill_1
XFILLER_31_939 VPWR VGND sg13cmos5l_decap_8
Xclkbuf_leaf_22_clk _09503_/CLK clkbuf_3_6__f_clk/X VPWR VGND sg13cmos5l_buf_8
XFILLER_46_571 VPWR VGND sg13cmos5l_fill_1
XFILLER_18_295 VPWR VGND sg13cmos5l_fill_1
X_06460_ _06460_/Y _06460_/A _06460_/B VPWR VGND sg13cmos5l_nor2_1
X_05411_ _05411_/Y _05411_/A _05411_/B VPWR VGND sg13cmos5l_nor2_1
X_06391_ _06392_/C _06391_/A _06409_/B VPWR VGND sg13cmos5l_nor2_1
X_08130_ _08132_/B hold969/X _08130_/B VPWR VGND sg13cmos5l_nor2_1
Xclkbuf_leaf_13_clk clkload12/A clkload0/A VPWR VGND sg13cmos5l_buf_8
X_05342_ _05342_/Y _05342_/A VPWR VGND sg13cmos5l_inv_1
XFILLER_30_961 VPWR VGND sg13cmos5l_fill_2
X_05273_ _05321_/B _05283_/B _05279_/C VPWR VGND sg13cmos5l_nand2_1
X_08061_ _08061_/Y _08054_/Y _08057_/Y _08060_/Y VPWR VGND sg13cmos5l_o21ai_1
X_07012_ _07012_/Y _07052_/B _07011_/X VPWR VGND sg13cmos5l_nor2b_1
X_08963_ _08963_/X _08963_/A _08963_/B VPWR VGND sg13cmos5l_or2_1
X_07914_ _07938_/A _07932_/B _07949_/B _07914_/C VPWR VGND sg13cmos5l_nor3_1
X_08894_ _08895_/B _08889_/B _08889_/C _08759_/A VPWR VGND sg13cmos5l_a21oi_1
X_07845_ _07846_/A _08145_/A _07855_/B _07844_/Y VPWR VGND sg13cmos5l_o21ai_1
XFILLER_44_519 VPWR VGND sg13cmos5l_decap_4
X_07776_ _07776_/Y _08065_/A _07776_/B VPWR VGND sg13cmos5l_nor2_1
X_09059__420 _09059_/RESET_B VPWR VGND sg13cmos5l_tiehi
XFILLER_17_36 VPWR VGND sg13cmos5l_fill_1
X_04988_ _05416_/A _05413_/B VPWR VGND sg13cmos5l_inv_1
X_06727_ _09536_/D _06727_/A hold912/X VPWR VGND sg13cmos5l_and2_1
X_09515_ _09515_/Q clkload23/A _09515_/D _09515_/RESET_B VPWR VGND sg13cmos5l_dfrbpq_1
X_09446_ _09446_/Q _09491_/CLK _09446_/D _09446_/RESET_B VPWR VGND sg13cmos5l_dfrbpq_1
X_06658_ _06658_/Y _06650_/Y _06655_/Y _06657_/Y VPWR VGND sg13cmos5l_a21oi_1
X_05609_ _05609_/X _09337_/Q _05610_/B VPWR VGND sg13cmos5l_xor2_1
X_09377_ _09377_/Q clkload11/A _09377_/D _09377_/RESET_B VPWR VGND sg13cmos5l_dfrbpq_1
X_06589_ _06596_/B _06589_/A _06589_/B _06589_/C VPWR VGND sg13cmos5l_nand3_1
X_08328_ _09191_/D _08380_/A _08328_/B VPWR VGND sg13cmos5l_nor2_1
X_08259_ _08259_/Y _09187_/Q _08259_/B VPWR VGND sg13cmos5l_xnor2_1
X_09066__413 _09066_/RESET_B VPWR VGND sg13cmos5l_tiehi
XFILLER_16_711 VPWR VGND sg13cmos5l_fill_1
XFILLER_28_571 VPWR VGND sg13cmos5l_fill_2
X_09073__406 _09073_/RESET_B VPWR VGND sg13cmos5l_tiehi
XFILLER_8_921 VPWR VGND sg13cmos5l_fill_1
XFILLER_11_471 VPWR VGND sg13cmos5l_fill_2
XFILLER_31_4 VPWR VGND sg13cmos5l_fill_2
Xhold1109 _07844_/A _09084_/Q VPWR VGND sg13cmos5l_dlygate4sd3_1
Xclkbuf_leaf_2_clk clkload3/A clkbuf_leaf_2_clk/A VPWR VGND sg13cmos5l_buf_8
X_05960_ _09426_/D _05961_/A hold855/X VPWR VGND sg13cmos5l_and2_1
X_05891_ _05893_/C _05891_/A _05891_/B VPWR VGND sg13cmos5l_nor2_1
X_04911_ _07388_/A _04911_/A VPWR VGND sg13cmos5l_inv_1
X_04842_ _05447_/A _04842_/A VPWR VGND sg13cmos5l_inv_1
X_07630_ _09092_/D _04827_/Y fanout59/X _07629_/Y VPWR VGND sg13cmos5l_a21oi_1
X_07561_ _07664_/C _07561_/A _07571_/A _07571_/C VPWR VGND sg13cmos5l_nand3_1
XFILLER_0_1003 VPWR VGND sg13cmos5l_decap_8
X_09300_ _09300_/Q clkload10/A _09300_/D _09300_/RESET_B VPWR VGND sg13cmos5l_dfrbpq_1
X_06512_ _06535_/B _06512_/A _06512_/B VPWR VGND sg13cmos5l_nand2_1
X_07492_ _07792_/A _07496_/B _07491_/Y VPWR VGND sg13cmos5l_nor2b_1
X_09231_ _09231_/Q clkload2/A _09231_/D _09231_/RESET_B VPWR VGND sg13cmos5l_dfrbpq_1
X_06443_ _06443_/Y _09495_/Q _06439_/Y _06440_/Y _06436_/Y VPWR VGND sg13cmos5l_a22oi_1
X_06374_ _06412_/A _09452_/Q _09453_/Q _06389_/B VPWR VGND sg13cmos5l_nor3_1
X_09162_ hold980/A clkload4/A hold981/X _09162_/RESET_B VPWR VGND sg13cmos5l_dfrbpq_1
X_05325_ _05325_/Y _05478_/A _05478_/B VPWR VGND sg13cmos5l_nand2_1
X_08113_ _08113_/Y _08113_/A _08131_/A VPWR VGND sg13cmos5l_nor2_1
X_09093_ hold883/A clkload16/A _09093_/D _09093_/RESET_B VPWR VGND sg13cmos5l_dfrbpq_1
X_08044_ _08079_/A _09117_/Q _09115_/Q _09116_/Q VPWR VGND sg13cmos5l_or3_1
Xhold910 hold910/X hold910/A VPWR VGND sg13cmos5l_dlygate4sd3_1
Xhold921 hold921/X hold921/A VPWR VGND sg13cmos5l_dlygate4sd3_1
X_05256_ _05257_/B _05218_/A _05217_/A _05256_/S VPWR VGND sg13cmos5l_mux2_1
X_05187_ _08933_/A _05093_/X _05184_/Y _05201_/S VPWR VGND sg13cmos5l_mux2_1
Xhold954 hold954/X hold954/A VPWR VGND sg13cmos5l_dlygate4sd3_1
Xhold932 hold932/X hold932/A VPWR VGND sg13cmos5l_dlygate4sd3_1
Xhold943 hold943/X hold943/A VPWR VGND sg13cmos5l_dlygate4sd3_1
X_09260__801 _09260_/RESET_B VPWR VGND sg13cmos5l_tiehi
Xhold965 hold965/X hold965/A VPWR VGND sg13cmos5l_dlygate4sd3_1
Xhold987 hold987/X hold987/A VPWR VGND sg13cmos5l_dlygate4sd3_1
Xhold976 hold976/X hold976/A VPWR VGND sg13cmos5l_dlygate4sd3_1
Xhold998 hold998/X hold998/A VPWR VGND sg13cmos5l_dlygate4sd3_1
X_08946_ _08946_/Y _09323_/Q _05001_/Y _08943_/Y _08944_/Y _08945_/Y VPWR VGND sg13cmos5l_a221oi_1
X_08877_ _08893_/B _08872_/X _08874_/Y _08876_/Y VPWR VGND sg13cmos5l_a21oi_1
X_07828_ _09118_/D _07875_/A _07828_/B VPWR VGND sg13cmos5l_nor2_1
XFILLER_29_357 VPWR VGND sg13cmos5l_fill_2
X_07759_ _07777_/S _07772_/B _07772_/C VPWR VGND sg13cmos5l_nand2_1
X_09429_ _09429_/Q clkload18/A _09429_/D _09429_/RESET_B VPWR VGND sg13cmos5l_dfrbpq_1
XFILLER_4_489 VPWR VGND sg13cmos5l_fill_2
XFILLER_47_176 VPWR VGND sg13cmos5l_fill_1
X_05110_ _05110_/Y _05126_/B _05348_/A _05104_/Y _05098_/Y _05109_/Y VPWR VGND sg13cmos5l_a221oi_1
X_06090_ _09441_/D _06164_/A _06090_/B VPWR VGND sg13cmos5l_nor2_1
X_05041_ _05047_/A input8/X input9/X VPWR VGND sg13cmos5l_nor2_1
X_08800_ _08800_/Y _08800_/A _08816_/A _08800_/C VPWR VGND sg13cmos5l_nor3_1
X_09125__351 _09125_/RESET_B VPWR VGND sg13cmos5l_tiehi
X_06992_ _09585_/D _06992_/A _07070_/A VPWR VGND sg13cmos5l_nor2_1
XFILLER_22_0 VPWR VGND sg13cmos5l_fill_1
X_08731_ _08731_/Y _05188_/A _08765_/A _08728_/Y _08730_/Y VPWR VGND sg13cmos5l_a22oi_1
X_05943_ _05943_/Y hold1213/X fanout39/X _05963_/B VPWR VGND sg13cmos5l_o21ai_1
XFILLER_38_110 VPWR VGND sg13cmos5l_fill_2
X_08662_ _08667_/C _08631_/Y _08651_/Y _08283_/Y VPWR VGND sg13cmos5l_o21ai_1
X_05874_ _05874_/Y _05864_/A _05864_/B _05903_/B _05876_/A VPWR VGND sg13cmos5l_a22oi_1
X_07613_ _07614_/C _07844_/A _07620_/B VPWR VGND sg13cmos5l_nor2b_1
XFILLER_38_165 VPWR VGND sg13cmos5l_fill_1
X_08593_ _08593_/Y hold956/X fanout56/X _08393_/A VPWR VGND sg13cmos5l_o21ai_1
X_04825_ _04825_/Y hold950/X VPWR VGND sg13cmos5l_inv_1
X_07544_ _07545_/C _07635_/A _07544_/B VPWR VGND sg13cmos5l_nor2_1
X_09056__423 _09056_/RESET_B VPWR VGND sg13cmos5l_tiehi
XFILLER_34_360 VPWR VGND sg13cmos5l_fill_2
X_07475_ _07495_/B _09070_/Q _09071_/Q _09072_/Q _09073_/Q VPWR VGND sg13cmos5l_nor4_1
X_09214_ _09214_/Q _09214_/CLK _09214_/D _09214_/RESET_B VPWR VGND sg13cmos5l_dfrbpq_1
X_06426_ _06445_/B _09516_/Q _09459_/Q VPWR VGND sg13cmos5l_nor2_1
X_09145_ _09145_/Q _09214_/CLK _09145_/D _09145_/RESET_B VPWR VGND sg13cmos5l_dfrbpq_1
X_06357_ _06357_/Y _06652_/B _06646_/A VPWR VGND sg13cmos5l_nand2_1
X_05308_ _05328_/S _05330_/A _05330_/C VPWR VGND sg13cmos5l_nand2_1
X_06288_ _06291_/A _06288_/A _06288_/B _06288_/C VPWR VGND sg13cmos5l_nand3_1
X_09076_ _09076_/Q clkload14/A _09076_/D _09076_/RESET_B VPWR VGND sg13cmos5l_dfrbpq_1
X_05239_ _05240_/B _05204_/Y _05238_/B _05238_/Y VPWR VGND sg13cmos5l_o21ai_1
X_08027_ _08027_/Y _07987_/B _07977_/C _08038_/B VPWR VGND sg13cmos5l_a21oi_1
X_09063__416 _09063_/RESET_B VPWR VGND sg13cmos5l_tiehi
X_08929_ _08930_/B _08929_/A _08929_/B VPWR VGND sg13cmos5l_nor2_1
X_09293__462 _09293_/RESET_B VPWR VGND sg13cmos5l_tiehi
X_09070__409 _09070_/RESET_B VPWR VGND sg13cmos5l_tiehi
XFILLER_49_931 VPWR VGND sg13cmos5l_decap_8
XFILLER_0_470 VPWR VGND sg13cmos5l_fill_1
X_05590_ _09368_/D _05637_/A _05730_/A VPWR VGND sg13cmos5l_nor2_1
X_09250__811 _09250_/RESET_B VPWR VGND sg13cmos5l_tiehi
XFILLER_17_894 VPWR VGND sg13cmos5l_fill_1
X_07260_ _07260_/Y _07556_/A _09064_/Q VPWR VGND sg13cmos5l_nand2b_1
X_06211_ _06211_/Y hold947/X fanout51/X _06469_/A VPWR VGND sg13cmos5l_o21ai_1
X_07191_ hold921/A _09005_/A _07191_/B _07191_/C VPWR VGND sg13cmos5l_nor3_1
X_06142_ _06161_/B _06135_/Y _06138_/Y _06140_/Y VPWR VGND sg13cmos5l_a21o_1
X_06073_ _06073_/X _06073_/A _06073_/B VPWR VGND sg13cmos5l_and2_1
X_05024_ _05025_/A _05023_/Y _08479_/B VPWR VGND sg13cmos5l_nand2b_1
X_09498__606 _09498_/RESET_B VPWR VGND sg13cmos5l_tiehi
X_06975_ _06976_/B _06962_/B _06974_/B _06974_/Y VPWR VGND sg13cmos5l_o21ai_1
X_08714_ _08714_/Y _08692_/A fanout20/X _08723_/A VPWR VGND sg13cmos5l_o21ai_1
XFILLER_39_496 VPWR VGND sg13cmos5l_fill_2
X_09199__271 _09199_/RESET_B VPWR VGND sg13cmos5l_tiehi
XFILLER_26_102 VPWR VGND sg13cmos5l_fill_2
X_05926_ _05926_/Y _09417_/Q _05920_/Y _05925_/Y _09418_/Q VPWR VGND sg13cmos5l_a22oi_1
X_05857_ _06028_/A _05852_/A _05826_/A _06165_/A VPWR VGND sg13cmos5l_o21ai_1
X_08645_ _08645_/Y _08638_/Y _08641_/Y _08644_/Y VPWR VGND sg13cmos5l_o21ai_1
X_08576_ _08576_/Y _08567_/Y _08571_/Y _08575_/Y VPWR VGND sg13cmos5l_o21ai_1
X_05788_ _05809_/B _09404_/Q _09403_/Q _09405_/Q _09406_/Q VPWR VGND sg13cmos5l_nor4_1
X_07527_ _09073_/D _07634_/B _07677_/A VPWR VGND sg13cmos5l_and2_1
X_07458_ _07458_/Y _07434_/A _07462_/S _07464_/B1 VPWR VGND sg13cmos5l_o21ai_1
XFILLER_10_514 VPWR VGND sg13cmos5l_fill_1
X_06409_ _06409_/X _06409_/A _06409_/B _06409_/C VPWR VGND sg13cmos5l_or3_1
X_07389_ _09062_/D _07389_/A _07389_/B VPWR VGND sg13cmos5l_nor2_1
X_09128_ hold906/A clkload16/A _09128_/D _09128_/RESET_B VPWR VGND sg13cmos5l_dfrbpq_1
X_09407__703 _09407_/RESET_B VPWR VGND sg13cmos5l_tiehi
X_09059_ _09059_/Q clkload13/A _09059_/D _09059_/RESET_B VPWR VGND sg13cmos5l_dfrbpq_1
Xhold1270 _05022_/B _05040_/A VPWR VGND sg13cmos5l_dlygate4sd3_1
Xhold1292 _04903_/A _09103_/Q VPWR VGND sg13cmos5l_dlygate4sd3_1
Xhold1281 _08419_/A _09210_/Q VPWR VGND sg13cmos5l_dlygate4sd3_1
XFILLER_45_477 VPWR VGND sg13cmos5l_fill_2
XFILLER_17_157 VPWR VGND sg13cmos5l_fill_1
X_09115__361 _09115_/RESET_B VPWR VGND sg13cmos5l_tiehi
XFILLER_5_584 VPWR VGND sg13cmos5l_fill_2
XFILLER_49_761 VPWR VGND sg13cmos5l_decap_8
XFILLER_37_901 VPWR VGND sg13cmos5l_fill_2
X_09122__354 _09122_/RESET_B VPWR VGND sg13cmos5l_tiehi
X_06760_ _06761_/C _06760_/A _06764_/B VPWR VGND sg13cmos5l_nor2_1
XFILLER_48_282 VPWR VGND sg13cmos5l_fill_1
X_06691_ _06710_/B _09554_/Q _06691_/B VPWR VGND sg13cmos5l_nor2_1
X_05711_ _05752_/A _05751_/B _05751_/C _05751_/A VPWR VGND sg13cmos5l_a21oi_1
X_08430_ _08430_/Y _08430_/A _08430_/B _08430_/C _08430_/D VPWR VGND sg13cmos5l_nand4_1
XFILLER_24_628 VPWR VGND sg13cmos5l_fill_1
X_05642_ _05642_/Y _05964_/A _09341_/Q VPWR VGND sg13cmos5l_nor2_1
X_05573_ _05574_/B _05572_/Y _05571_/Y _05593_/S VPWR VGND sg13cmos5l_mux2_1
X_08361_ _08362_/B _04930_/Y _08355_/X _08360_/Y VPWR VGND sg13cmos5l_o21ai_1
X_07312_ _07415_/C _07312_/A _07324_/A _07324_/C VPWR VGND sg13cmos5l_nand3_1
X_08292_ _09187_/D _08380_/A _08292_/B VPWR VGND sg13cmos5l_nor2_1
X_07243_ _07243_/Y _07246_/B _07547_/A _07243_/C VPWR VGND sg13cmos5l_nand3_1
X_07174_ _07174_/Y _09028_/Q _07174_/B VPWR VGND sg13cmos5l_nor2_1
X_06125_ _06127_/B _09435_/Q _09410_/Q VPWR VGND sg13cmos5l_nor2_1
X_06056_ _06103_/A _09477_/Q _09478_/Q _06065_/B VPWR VGND sg13cmos5l_nor3_1
X_05007_ _05007_/Y _09014_/Q VPWR VGND sg13cmos5l_inv_1
X_09060__419 _09060_/RESET_B VPWR VGND sg13cmos5l_tiehi
X_06958_ _06962_/B _04965_/Y _06957_/B _06957_/Y VPWR VGND sg13cmos5l_a21oi_1
X_05909_ _05937_/B _05909_/A _05909_/B VPWR VGND sg13cmos5l_nor2_1
XFILLER_43_926 VPWR VGND sg13cmos5l_fill_1
X_06889_ _09560_/D _06988_/B _07057_/A VPWR VGND sg13cmos5l_and2_1
X_08628_ _08681_/A _08698_/B _08628_/B VPWR VGND sg13cmos5l_nor2_1
X_08559_ _08580_/A _08547_/B _08568_/B _08558_/Y VPWR VGND sg13cmos5l_a21oi_1
XFILLER_35_1003 VPWR VGND sg13cmos5l_fill_2
XFILLER_22_160 VPWR VGND sg13cmos5l_fill_1
XFILLER_10_344 VPWR VGND sg13cmos5l_fill_2
XFILLER_42_1007 VPWR VGND sg13cmos5l_fill_1
X_09240__821 _09240_/RESET_B VPWR VGND sg13cmos5l_tiehi
XFILLER_45_230 VPWR VGND sg13cmos5l_fill_1
X_09488__616 _09488_/RESET_B VPWR VGND sg13cmos5l_tiehi
XFILLER_9_164 VPWR VGND sg13cmos5l_fill_2
X_09189__281 _09189_/RESET_B VPWR VGND sg13cmos5l_tiehi
XFILLER_6_860 VPWR VGND sg13cmos5l_fill_2
X_09523__234 _09523_/D VPWR VGND sg13cmos5l_tielo
X_07930_ _07950_/B _07953_/A _07928_/B _07927_/Y _07929_/Y VPWR VGND sg13cmos5l_a22oi_1
X_09304__306 _09304_/RESET_B VPWR VGND sg13cmos5l_tiehi
X_09495__609 _09495_/RESET_B VPWR VGND sg13cmos5l_tiehi
X_07861_ _07876_/A _07607_/A _07860_/B _07860_/Y VPWR VGND sg13cmos5l_a21oi_1
X_07792_ _07792_/Y _07792_/A _07826_/A VPWR VGND sg13cmos5l_nor2_1
XFILLER_3_1012 VPWR VGND sg13cmos5l_decap_8
X_09600_ hold938/A clkload3/A _09600_/D _09600_/RESET_B VPWR VGND sg13cmos5l_dfrbpq_1
X_06812_ _09549_/D _06787_/B _06817_/S _06811_/Y VPWR VGND sg13cmos5l_a21oi_1
X_09531_ _09531_/Q clkload13/A _09531_/D _09531_/RESET_B VPWR VGND sg13cmos5l_dfrbpq_1
X_06743_ _06781_/A hold893/A hold854/A VPWR VGND sg13cmos5l_nand2_1
X_09196__274 _09196_/RESET_B VPWR VGND sg13cmos5l_tiehi
XFILLER_25_948 VPWR VGND sg13cmos5l_fill_2
X_09462_ hold943/A _09503_/CLK _09462_/D _09462_/RESET_B VPWR VGND sg13cmos5l_dfrbpq_1
X_06674_ _06674_/Y _06674_/A _06674_/B VPWR VGND sg13cmos5l_nand2_1
X_05625_ _05625_/X _05630_/A _05630_/C _05317_/Y VPWR VGND sg13cmos5l_a21o_1
X_08413_ _08424_/A _09212_/Q _08419_/B _08446_/A VPWR VGND sg13cmos5l_a21o_1
X_09393_ _09393_/Q clkload18/A _09393_/D _09393_/RESET_B VPWR VGND sg13cmos5l_dfrbpq_1
X_05556_ _05557_/C _09398_/Q _09366_/Q VPWR VGND sg13cmos5l_and2_1
X_08344_ _08344_/Y _08278_/A _09160_/Q VPWR VGND sg13cmos5l_nand2b_1
X_08275_ _08426_/B _08275_/A _08293_/B _08293_/C VPWR VGND sg13cmos5l_nor3_1
X_05487_ _05488_/B _05487_/A _05487_/B VPWR VGND sg13cmos5l_nor2_1
X_07226_ _07556_/A _07639_/A _07227_/B VPWR VGND sg13cmos5l_and2_1
X_07157_ _09007_/D _07197_/A _07217_/A VPWR VGND sg13cmos5l_nor2_1
X_09404__706 _09404_/RESET_B VPWR VGND sg13cmos5l_tiehi
X_06108_ _06257_/A _06085_/X _06106_/Y _06105_/Y VPWR VGND sg13cmos5l_a21o_1
X_07088_ _07088_/Y _05020_/B _09602_/Q VPWR VGND sg13cmos5l_nand2b_1
Xfanout110 _08784_/C _08930_/A VPWR VGND sg13cmos5l_buf_1
Xfanout121 _08132_/A _08017_/Y VPWR VGND sg13cmos5l_buf_1
X_06039_ _06039_/Y _06020_/A _06041_/S _05963_/B VPWR VGND sg13cmos5l_o21ai_1
Xfanout143 _06932_/A _06990_/B VPWR VGND sg13cmos5l_buf_1
Xfanout132 _07716_/A _07469_/Y VPWR VGND sg13cmos5l_buf_1
Xfanout154 _06473_/B _06558_/A VPWR VGND sg13cmos5l_buf_1
Xfanout165 _05776_/A _05531_/Y VPWR VGND sg13cmos5l_buf_1
Xfanout176 _07295_/A _07386_/A VPWR VGND sg13cmos5l_buf_1
Xfanout187 _08397_/A hold1220/X VPWR VGND sg13cmos5l_buf_1
Xfanout198 _08994_/A _08986_/A VPWR VGND sg13cmos5l_buf_1
X_09105__371 _09105_/RESET_B VPWR VGND sg13cmos5l_tiehi
XFILLER_27_252 VPWR VGND sg13cmos5l_fill_1
XFILLER_42_200 VPWR VGND sg13cmos5l_decap_4
XFILLER_15_436 VPWR VGND sg13cmos5l_fill_2
XFILLER_6_134 VPWR VGND sg13cmos5l_fill_1
X_09112__364 _09112_/RESET_B VPWR VGND sg13cmos5l_tiehi
XFILLER_6_189 VPWR VGND sg13cmos5l_fill_1
XFILLER_2_351 VPWR VGND sg13cmos5l_fill_2
Xheichips26_dna_sequencer_218 uio_out[4] VPWR VGND sg13cmos5l_tielo
XFILLER_18_285 VPWR VGND sg13cmos5l_fill_2
XFILLER_33_200 VPWR VGND sg13cmos5l_fill_2
XFILLER_34_756 VPWR VGND sg13cmos5l_fill_1
XFILLER_15_970 VPWR VGND sg13cmos5l_fill_2
X_05410_ _05410_/Y _04990_/Y _05405_/A _05409_/Y _04989_/Y VPWR VGND sg13cmos5l_a22oi_1
X_06390_ _06392_/B _06390_/A _06412_/B VPWR VGND sg13cmos5l_nor2_1
X_05341_ _05342_/A _05341_/A _05341_/B VPWR VGND sg13cmos5l_xnor2_1
X_05272_ _05279_/C _09328_/Q _09327_/Q hold1422/X VPWR VGND sg13cmos5l_o21ai_1
X_08060_ _08060_/Y _07776_/B _08082_/B _08059_/Y _07753_/B VPWR VGND sg13cmos5l_a22oi_1
X_07011_ _07011_/X _07011_/A _07011_/B VPWR VGND sg13cmos5l_xor2_1
X_09228__226 _09228_/D VPWR VGND sg13cmos5l_tielo
X_08962_ _08963_/B _04996_/Y _08956_/Y _08961_/Y VPWR VGND sg13cmos5l_o21ai_1
X_08893_ _08895_/A _08893_/A _08893_/B _08893_/C VPWR VGND sg13cmos5l_nor3_1
X_07913_ _07914_/C _07913_/A _07913_/B VPWR VGND sg13cmos5l_nor2_1
X_07844_ _07844_/Y _07844_/A _07855_/B VPWR VGND sg13cmos5l_nand2_1
X_07775_ _09110_/D _07892_/B _07775_/B VPWR VGND sg13cmos5l_nor2_1
X_04987_ _04987_/Y _05651_/B VPWR VGND sg13cmos5l_inv_1
X_06726_ _06726_/Y _04964_/Y _06710_/B _06742_/B VPWR VGND sg13cmos5l_a21oi_1
X_09514_ _09514_/Q clkload23/A _09514_/D _09514_/RESET_B VPWR VGND sg13cmos5l_dfrbpq_1
X_09445_ _09445_/Q _09491_/CLK _09445_/D _09445_/RESET_B VPWR VGND sg13cmos5l_dfrbpq_1
X_06657_ _06657_/Y _06652_/Y _06654_/X _06656_/Y VPWR VGND sg13cmos5l_o21ai_1
X_05608_ _05608_/X _05604_/X _05607_/Y _05602_/Y VPWR VGND sg13cmos5l_a21o_1
X_09376_ _09376_/Q clkload20/A _09376_/D _09376_/RESET_B VPWR VGND sg13cmos5l_dfrbpq_1
X_06588_ _06596_/A _06993_/A _06588_/B VPWR VGND sg13cmos5l_xnor2_1
XFILLER_33_36 VPWR VGND sg13cmos5l_fill_2
X_05539_ _05563_/B _09400_/Q _09398_/Q _09399_/Q VPWR VGND sg13cmos5l_nor3_1
X_08327_ _08328_/B _08426_/C _08426_/D VPWR VGND sg13cmos5l_or2_1
X_08258_ _08289_/B _08263_/B _08257_/Y VPWR VGND sg13cmos5l_nor2b_1
X_07209_ _09024_/D _08478_/A _07209_/B _07211_/C VPWR VGND sg13cmos5l_nor3_1
X_08189_ _08190_/B _08189_/A _08189_/B VPWR VGND sg13cmos5l_nor2_1
X_09478__626 _09478_/RESET_B VPWR VGND sg13cmos5l_tiehi
XFILLER_48_859 VPWR VGND sg13cmos5l_fill_1
XFILLER_47_347 VPWR VGND sg13cmos5l_fill_1
X_09339__777 _09339_/RESET_B VPWR VGND sg13cmos5l_tiehi
X_09179__291 _09179_/RESET_B VPWR VGND sg13cmos5l_tiehi
X_09485__619 _09485_/RESET_B VPWR VGND sg13cmos5l_tiehi
XFILLER_12_984 VPWR VGND sg13cmos5l_decap_4
XFILLER_7_454 VPWR VGND sg13cmos5l_fill_1
XFILLER_8_999 VPWR VGND sg13cmos5l_fill_2
X_09186__284 _09186_/RESET_B VPWR VGND sg13cmos5l_tiehi
X_04910_ _07639_/A _07341_/A VPWR VGND sg13cmos5l_inv_1
X_05890_ _09410_/D _05898_/A _05890_/B VPWR VGND sg13cmos5l_nor2_1
X_04841_ _05446_/A _04841_/A VPWR VGND sg13cmos5l_inv_1
X_07560_ _07574_/S _07571_/A _07571_/C VPWR VGND sg13cmos5l_nand2_1
X_06511_ _06529_/S _06512_/A _06512_/B VPWR VGND sg13cmos5l_and2_1
X_09230_ _09230_/Q clkload5/A _09230_/D _09230_/RESET_B VPWR VGND sg13cmos5l_dfrbpq_1
X_09193__277 _09193_/RESET_B VPWR VGND sg13cmos5l_tiehi
X_07491_ _07491_/Y _09103_/Q _09104_/Q _09105_/Q VPWR VGND sg13cmos5l_o21ai_1
XFILLER_21_203 VPWR VGND sg13cmos5l_fill_2
X_06442_ _06458_/A _06194_/A _06441_/B _06441_/Y VPWR VGND sg13cmos5l_a21oi_1
X_06373_ _06389_/B _09450_/Q _09451_/Q _09449_/Q _09448_/Q VPWR VGND sg13cmos5l_or4_1
X_09161_ _09161_/Q clkload4/A _09161_/D _09161_/RESET_B VPWR VGND sg13cmos5l_dfrbpq_1
XFILLER_21_247 VPWR VGND sg13cmos5l_fill_2
X_05324_ _05326_/B _05478_/A _05478_/B VPWR VGND sg13cmos5l_and2_1
X_08112_ _08131_/A _04944_/Y _08111_/B _08111_/Y VPWR VGND sg13cmos5l_a21oi_1
X_09092_ hold951/A clkload13/A _09092_/D _09092_/RESET_B VPWR VGND sg13cmos5l_dfrbpq_1
X_08043_ _09151_/D _08084_/A _08211_/A VPWR VGND sg13cmos5l_nor2b_1
Xhold900 hold900/X hold900/A VPWR VGND sg13cmos5l_dlygate4sd3_1
Xhold911 hold911/X hold911/A VPWR VGND sg13cmos5l_dlygate4sd3_1
Xhold922 hold922/X hold922/A VPWR VGND sg13cmos5l_dlygate4sd3_1
X_05255_ _09323_/D _05234_/B _05256_/S _05254_/Y VPWR VGND sg13cmos5l_a21oi_1
X_05186_ _05186_/Y _05093_/X _05201_/S _05185_/X VPWR VGND sg13cmos5l_o21ai_1
Xhold944 hold944/X hold944/A VPWR VGND sg13cmos5l_dlygate4sd3_1
Xhold933 hold933/X hold933/A VPWR VGND sg13cmos5l_dlygate4sd3_1
Xhold955 hold955/X hold955/A VPWR VGND sg13cmos5l_dlygate4sd3_1
Xhold988 hold988/X hold988/A VPWR VGND sg13cmos5l_dlygate4sd3_1
Xhold977 hold977/X hold977/A VPWR VGND sg13cmos5l_dlygate4sd3_1
Xhold966 hold966/X hold966/A VPWR VGND sg13cmos5l_dlygate4sd3_1
Xhold999 hold999/X hold999/A VPWR VGND sg13cmos5l_dlygate4sd3_1
X_09401__709 _09401_/RESET_B VPWR VGND sg13cmos5l_tiehi
X_08945_ _08945_/Y _08945_/A _09265_/Q VPWR VGND sg13cmos5l_nor2_1
X_08876_ _08876_/Y _08876_/A VPWR VGND sg13cmos5l_inv_1
XFILLER_45_829 VPWR VGND sg13cmos5l_fill_2
X_07827_ _07828_/B _07525_/Y _07815_/Y _07826_/X _07818_/A VPWR VGND sg13cmos5l_a22oi_1
X_09102__374 _09102_/RESET_B VPWR VGND sg13cmos5l_tiehi
X_07758_ _07781_/C _09114_/Q _07758_/B VPWR VGND sg13cmos5l_xor2_1
X_06709_ _06709_/X _06700_/Y _06704_/Y _06708_/Y VPWR VGND sg13cmos5l_a21o_1
X_07689_ _07690_/B _07663_/A _07657_/X _07699_/B _07513_/B _07687_/Y VPWR VGND sg13cmos5l_a221oi_1
X_09428_ hold873/A _09503_/CLK _09428_/D _09428_/RESET_B VPWR VGND sg13cmos5l_dfrbpq_1
XFILLER_12_269 VPWR VGND sg13cmos5l_fill_1
X_09359_ _09359_/Q clkload7/A _09359_/D _09359_/RESET_B VPWR VGND sg13cmos5l_dfrbpq_1
XFILLER_0_663 VPWR VGND sg13cmos5l_fill_2
XFILLER_47_144 VPWR VGND sg13cmos5l_fill_2
X_09237__826 _09237_/RESET_B VPWR VGND sg13cmos5l_tiehi
XFILLER_15_1001 VPWR VGND sg13cmos5l_fill_1
XFILLER_8_785 VPWR VGND sg13cmos5l_fill_2
X_05040_ _05433_/A _05040_/A _05040_/B _05040_/C _05040_/D VPWR VGND sg13cmos5l_nand4_1
X_06991_ _09584_/D _06991_/A _07070_/A VPWR VGND sg13cmos5l_nor2_1
X_08730_ _08730_/Y _08728_/A _08728_/B _08729_/Y VPWR VGND sg13cmos5l_o21ai_1
X_05942_ _09416_/D _05942_/A _05942_/B VPWR VGND sg13cmos5l_nor2_1
X_05873_ _05903_/B _09376_/Q _05873_/B VPWR VGND sg13cmos5l_xnor2_1
X_08661_ _08661_/Y _08661_/A _08661_/B _08661_/C _08661_/D VPWR VGND sg13cmos5l_nand4_1
X_09537__564 _09537_/RESET_B VPWR VGND sg13cmos5l_tiehi
XFILLER_15_0 VPWR VGND sg13cmos5l_fill_2
X_07612_ _07614_/B _07612_/A _07620_/B VPWR VGND sg13cmos5l_nor2_1
X_04824_ _04824_/Y hold916/X VPWR VGND sg13cmos5l_inv_1
X_08592_ _09235_/D _08838_/A _08592_/B VPWR VGND sg13cmos5l_and2_1
X_07543_ _07545_/B _07635_/A _07544_/B _07565_/B VPWR VGND sg13cmos5l_a21oi_1
Xclkbuf_3_5__f_clk clkbuf_3_5__f_clk/X clkbuf_0_clk/X VPWR VGND sg13cmos5l_buf_8
X_07474_ _07493_/B _09070_/Q _09071_/Q _09072_/Q VPWR VGND sg13cmos5l_or3_1
X_09213_ _09213_/Q _09347_/CLK _09213_/D _09213_/RESET_B VPWR VGND sg13cmos5l_dfrbpq_1
X_06425_ _06448_/A _06417_/B _06437_/B _06424_/Y VPWR VGND sg13cmos5l_a21oi_1
X_09468__636 _09468_/RESET_B VPWR VGND sg13cmos5l_tiehi
X_09144_ _09144_/Q _09214_/CLK _09144_/D _09144_/RESET_B VPWR VGND sg13cmos5l_dfrbpq_1
X_06356_ _06356_/X _06652_/B _06646_/A VPWR VGND sg13cmos5l_and2_1
X_05307_ _05330_/C _05291_/Y _05303_/Y _05305_/Y VPWR VGND sg13cmos5l_o21ai_1
X_06287_ _06288_/C _06228_/A _06232_/B _06238_/Y VPWR VGND sg13cmos5l_o21ai_1
X_09075_ _09075_/Q clkload14/A _09075_/D _09075_/RESET_B VPWR VGND sg13cmos5l_dfrbpq_1
X_09329__787 _09329_/RESET_B VPWR VGND sg13cmos5l_tiehi
X_05238_ _05238_/Y _08935_/A _05238_/B VPWR VGND sg13cmos5l_nand2_1
X_08026_ _08178_/A _08025_/Y _08026_/B VPWR VGND sg13cmos5l_nand2b_1
X_05169_ _05194_/C _05158_/Y _05167_/Y _05168_/Y VPWR VGND sg13cmos5l_o21ai_1
XFILLER_1_438 VPWR VGND sg13cmos5l_fill_1
X_09475__629 _09475_/RESET_B VPWR VGND sg13cmos5l_tiehi
X_08928_ _08929_/B _08928_/A _08928_/B _08928_/C VPWR VGND sg13cmos5l_nor3_1
Xhold1430 _05454_/A _09356_/Q VPWR VGND sg13cmos5l_dlygate4sd3_1
X_08859_ _08859_/Y hold1242/X _08850_/B _08907_/B VPWR VGND sg13cmos5l_a21oi_1
XFILLER_26_840 VPWR VGND sg13cmos5l_fill_1
X_09176__294 _09176_/RESET_B VPWR VGND sg13cmos5l_tiehi
XFILLER_40_342 VPWR VGND sg13cmos5l_fill_1
XFILLER_9_516 VPWR VGND sg13cmos5l_fill_1
XFILLER_5_777 VPWR VGND sg13cmos5l_fill_2
X_09183__287 _09183_/RESET_B VPWR VGND sg13cmos5l_tiehi
XFILLER_45_1027 VPWR VGND sg13cmos5l_fill_2
XFILLER_49_987 VPWR VGND sg13cmos5l_decap_8
X_09485__235 _09485_/D VPWR VGND sg13cmos5l_tielo
X_06210_ hold940/A _04837_/Y fanout49/X _06209_/Y VPWR VGND sg13cmos5l_a21oi_1
X_07190_ _07191_/C hold920/X _07193_/B VPWR VGND sg13cmos5l_nor2_1
X_06141_ _06148_/C _06135_/Y _06138_/Y _06140_/Y VPWR VGND sg13cmos5l_a21oi_1
X_06072_ _06073_/B _09442_/Q _09441_/Q _09443_/Q VPWR VGND sg13cmos5l_o21ai_1
X_05023_ _05023_/Y input9/X _07078_/A _05015_/Y VPWR VGND sg13cmos5l_a21oi_1
XFILLER_6_1010 VPWR VGND sg13cmos5l_fill_2
X_06974_ _06974_/Y _06974_/A _06974_/B VPWR VGND sg13cmos5l_nand2_1
X_08713_ _09245_/D _08713_/A _08713_/B VPWR VGND sg13cmos5l_nor2_1
X_05925_ _05925_/Y _05925_/A VPWR VGND sg13cmos5l_inv_1
X_05856_ _09407_/D _05898_/A _05856_/B VPWR VGND sg13cmos5l_nor2_1
X_08644_ _08644_/Y _08289_/B _08639_/Y _08643_/Y _08266_/B VPWR VGND sg13cmos5l_a22oi_1
X_05787_ _05843_/A _09404_/Q _09403_/Q _09405_/Q VPWR VGND sg13cmos5l_or3_1
X_08575_ _08575_/Y _09232_/Q _08570_/Y _08574_/Y _04823_/A VPWR VGND sg13cmos5l_a22oi_1
X_07526_ _07677_/A _07493_/Y _07525_/Y _07530_/S VPWR VGND sg13cmos5l_mux2_1
X_07457_ _09064_/D _07436_/B _07462_/S _07456_/Y VPWR VGND sg13cmos5l_a21oi_1
XFILLER_6_508 VPWR VGND sg13cmos5l_fill_2
X_07388_ _09061_/D _07388_/A _07389_/B VPWR VGND sg13cmos5l_nor2_1
X_06408_ _09488_/D _06554_/A _06503_/B VPWR VGND sg13cmos5l_nor2_1
X_06339_ _06339_/Y _06323_/X _06651_/A _06361_/B _06362_/B VPWR VGND sg13cmos5l_a22oi_1
X_09127_ hold948/A _09312_/CLK _09127_/D _09127_/RESET_B VPWR VGND sg13cmos5l_dfrbpq_1
X_09058_ _09058_/Q _09573_/CLK _09058_/D _09058_/RESET_B VPWR VGND sg13cmos5l_dfrbpq_1
X_08009_ _08009_/Y _07994_/Y _08004_/Y _08008_/Y VPWR VGND sg13cmos5l_a21oi_1
XFILLER_2_714 VPWR VGND sg13cmos5l_fill_1
XFILLER_49_217 VPWR VGND sg13cmos5l_fill_2
Xhold1260 _07833_/B _07806_/B VPWR VGND sg13cmos5l_dlygate4sd3_1
Xhold1271 hold1271/X _09491_/Q VPWR VGND sg13cmos5l_dlygate4sd3_1
Xhold1282 _06760_/A _09543_/Q VPWR VGND sg13cmos5l_dlygate4sd3_1
Xhold1293 _05719_/A _09391_/Q VPWR VGND sg13cmos5l_dlygate4sd3_1
X_09527__574 _09527_/RESET_B VPWR VGND sg13cmos5l_tiehi
XFILLER_5_563 VPWR VGND sg13cmos5l_fill_2
XFILLER_49_795 VPWR VGND sg13cmos5l_decap_4
X_06690_ _06713_/A _06988_/A hold1149/X _06705_/B VPWR VGND sg13cmos5l_mux2_1
X_05710_ _05751_/C hold930/A hold890/A _09392_/Q VPWR VGND sg13cmos5l_nand3_1
XFILLER_36_445 VPWR VGND sg13cmos5l_fill_1
XFILLER_37_946 VPWR VGND sg13cmos5l_fill_1
X_09534__567 _09534_/RESET_B VPWR VGND sg13cmos5l_tiehi
X_05641_ _05641_/Y hold966/A _09397_/Q VPWR VGND sg13cmos5l_nor2b_1
X_08360_ _08360_/Y _08359_/Y _09199_/Q VPWR VGND sg13cmos5l_nand2b_1
X_05572_ _05572_/Y _05963_/A _05586_/A VPWR VGND sg13cmos5l_nand2_1
X_07311_ _07327_/S _07324_/A _07324_/C VPWR VGND sg13cmos5l_nand2_1
X_08291_ _08292_/B _08291_/A VPWR VGND sg13cmos5l_inv_1
X_07242_ _07242_/Y _07241_/B _07267_/A _07241_/X _09065_/Q _07238_/Y VPWR VGND sg13cmos5l_a221oi_1
X_09465__639 _09465_/RESET_B VPWR VGND sg13cmos5l_tiehi
X_07173_ _07173_/Y _09029_/Q _07173_/B VPWR VGND sg13cmos5l_nand2_1
X_06124_ _06130_/A _06153_/A _06153_/B _06129_/A VPWR VGND sg13cmos5l_a21o_1
X_06055_ _06065_/B _09476_/Q _06473_/A _09475_/Q VPWR VGND sg13cmos5l_or3_1
X_05006_ _07174_/B hold920/X VPWR VGND sg13cmos5l_inv_1
X_06957_ _06957_/Y _06957_/A _06957_/B VPWR VGND sg13cmos5l_nor2_1
X_05908_ _09415_/D _05951_/A _06001_/B VPWR VGND sg13cmos5l_nor2_1
X_06888_ _07057_/A _06850_/Y _06884_/C _07330_/A VPWR VGND sg13cmos5l_o21ai_1
XFILLER_28_968 VPWR VGND sg13cmos5l_fill_1
X_05839_ _05994_/B _05847_/A _05839_/B _05847_/C VPWR VGND sg13cmos5l_nand3_1
XFILLER_15_607 VPWR VGND sg13cmos5l_fill_1
X_08627_ _08628_/B _08627_/A _08627_/B VPWR VGND sg13cmos5l_xnor2_1
XFILLER_14_128 VPWR VGND sg13cmos5l_fill_1
X_08558_ _08558_/Y _09245_/Q _08568_/B VPWR VGND sg13cmos5l_nor2_1
X_07509_ _07509_/Y _07509_/A VPWR VGND sg13cmos5l_inv_1
X_08489_ _08498_/B _09222_/Q _09223_/Q _09224_/Q _09225_/Q VPWR VGND sg13cmos5l_nor4_1
X_09173__297 _09173_/RESET_B VPWR VGND sg13cmos5l_tiehi
Xhold1090 _06437_/A _09457_/Q VPWR VGND sg13cmos5l_dlygate4sd3_1
XFILLER_6_883 VPWR VGND sg13cmos5l_decap_8
X_07860_ _07860_/Y _09144_/Q _07860_/B VPWR VGND sg13cmos5l_nor2_1
X_07791_ _07826_/A _09080_/Q _07822_/A VPWR VGND sg13cmos5l_xnor2_1
X_06811_ _06811_/Y _06787_/A _06817_/S _06737_/B VPWR VGND sg13cmos5l_o21ai_1
XFILLER_49_581 VPWR VGND sg13cmos5l_decap_4
X_09530_ _09530_/Q _09586_/CLK _09530_/D _09530_/RESET_B VPWR VGND sg13cmos5l_dfrbpq_1
X_06742_ _09548_/D _06742_/A _06742_/B VPWR VGND sg13cmos5l_nor2_1
X_09461_ hold939/A _09575_/CLK hold940/X _09461_/RESET_B VPWR VGND sg13cmos5l_dfrbpq_1
X_06673_ _09526_/D _06818_/A _06790_/A VPWR VGND sg13cmos5l_nor2_1
X_05624_ _09372_/D _05696_/B _05746_/A VPWR VGND sg13cmos5l_and2_1
X_08412_ _08446_/A _08445_/B _08445_/C _08445_/A VPWR VGND sg13cmos5l_a21oi_1
X_09392_ _09392_/Q clkload18/A _09392_/D _09392_/RESET_B VPWR VGND sg13cmos5l_dfrbpq_1
X_05555_ _05557_/B _05560_/B _05554_/B _05871_/A VPWR VGND sg13cmos5l_a21oi_1
X_08343_ _09196_/D _08380_/A _08434_/B VPWR VGND sg13cmos5l_nor2_1
X_08274_ _08426_/A _08285_/B _08285_/C _08273_/Y VPWR VGND sg13cmos5l_a21oi_1
X_07225_ _07577_/A _07227_/B _07341_/A VPWR VGND sg13cmos5l_nand2b_1
X_05486_ _05486_/Y _05486_/A _05486_/B VPWR VGND sg13cmos5l_nand2_1
X_07156_ _07217_/A _07130_/Y _07149_/Y _08868_/A _07164_/B VPWR VGND sg13cmos5l_a22oi_1
X_06107_ _06109_/B _06085_/X _06106_/Y _06105_/Y VPWR VGND sg13cmos5l_a21oi_1
X_07087_ _07087_/Y hold895/X _05018_/Y _04877_/Y VPWR VGND sg13cmos5l_a21oi_1
X_06038_ _09436_/D _06012_/B _06041_/S _06037_/Y VPWR VGND sg13cmos5l_a21oi_1
Xfanout100 _06098_/A _06394_/A VPWR VGND sg13cmos5l_buf_1
Xfanout122 _08084_/A _08017_/Y VPWR VGND sg13cmos5l_buf_1
Xfanout111 _08930_/A _08824_/A VPWR VGND sg13cmos5l_buf_1
Xfanout155 _06164_/A _06299_/A VPWR VGND sg13cmos5l_buf_1
Xfanout133 _07634_/B _07717_/B1 VPWR VGND sg13cmos5l_buf_1
Xfanout144 _06990_/B _06825_/Y VPWR VGND sg13cmos5l_buf_1
Xfanout188 _07154_/A _07155_/A VPWR VGND sg13cmos5l_buf_1
Xfanout177 _07386_/A hold1226/X VPWR VGND sg13cmos5l_buf_1
Xfanout199 _08393_/A _08134_/A VPWR VGND sg13cmos5l_buf_1
Xfanout166 _05696_/B _05530_/Y VPWR VGND sg13cmos5l_buf_1
X_07989_ _07989_/Y _08315_/A _08033_/A _07988_/X VPWR VGND sg13cmos5l_o21ai_1
X_09517__584 _09517_/RESET_B VPWR VGND sg13cmos5l_tiehi
XFILLER_42_234 VPWR VGND sg13cmos5l_fill_2
XFILLER_42_289 VPWR VGND sg13cmos5l_fill_1
X_09311__834 _09311_/RESET_B VPWR VGND sg13cmos5l_tiehi
X_09268__766 _09268_/RESET_B VPWR VGND sg13cmos5l_tiehi
X_09524__577 _09524_/RESET_B VPWR VGND sg13cmos5l_tiehi
X_09494__610 _09494_/RESET_B VPWR VGND sg13cmos5l_tiehi
Xheichips26_dna_sequencer_219 uio_out[5] VPWR VGND sg13cmos5l_tielo
X_09316__723 _09316_/RESET_B VPWR VGND sg13cmos5l_tiehi
X_05340_ _05366_/B _09300_/Q _09301_/Q _05341_/B VPWR VGND sg13cmos5l_or3_1
X_05271_ _05322_/A _05317_/A _09361_/Q VPWR VGND sg13cmos5l_xnor2_1
X_07010_ _07017_/A _07052_/B VPWR VGND sg13cmos5l_inv_1
XFILLER_5_190 VPWR VGND sg13cmos5l_fill_2
X_08961_ _08961_/Y _08960_/Y _09304_/Q VPWR VGND sg13cmos5l_nand2b_1
X_08892_ _08892_/Y _08892_/A _08892_/B _08892_/C VPWR VGND sg13cmos5l_nand3_1
X_07912_ _07949_/B _07912_/A _07912_/B VPWR VGND sg13cmos5l_nor2_1
XFILLER_25_1003 VPWR VGND sg13cmos5l_fill_2
X_07843_ _07860_/B _07725_/B _04947_/Y _07842_/Y VPWR VGND sg13cmos5l_a21oi_1
X_07774_ _07775_/B _07924_/A _07924_/B VPWR VGND sg13cmos5l_and2_1
X_04986_ _04986_/Y _04986_/A VPWR VGND sg13cmos5l_inv_1
X_06725_ hold963/A _06742_/B hold962/X _06725_/C VPWR VGND sg13cmos5l_nor3_1
X_09513_ _09513_/Q clkload23/A _09513_/D _09513_/RESET_B VPWR VGND sg13cmos5l_dfrbpq_1
X_09444_ _09444_/Q _09491_/CLK _09444_/D _09444_/RESET_B VPWR VGND sg13cmos5l_dfrbpq_1
X_06656_ _06656_/Y _06656_/A _06656_/B VPWR VGND sg13cmos5l_nand2_1
X_09410__700 _09410_/RESET_B VPWR VGND sg13cmos5l_tiehi
X_05607_ _05607_/Y _09359_/Q _09334_/Q _05606_/A VPWR VGND sg13cmos5l_o21ai_1
XFILLER_13_919 VPWR VGND sg13cmos5l_fill_2
X_09375_ _09375_/Q clkload20/A _09375_/D _09375_/RESET_B VPWR VGND sg13cmos5l_dfrbpq_1
X_06587_ _06587_/X _06622_/B _06933_/A VPWR VGND sg13cmos5l_and2_1
X_05538_ _05559_/B _09398_/Q _09399_/Q VPWR VGND sg13cmos5l_nor2_1
X_08326_ _08426_/D _08329_/C _08334_/C _08012_/B VPWR VGND sg13cmos5l_a21oi_1
X_08257_ _08257_/Y _09218_/Q _08278_/A _09219_/Q VPWR VGND sg13cmos5l_o21ai_1
X_05469_ _05516_/A _05503_/A _05511_/A VPWR VGND sg13cmos5l_and2_1
X_08188_ _08188_/Y _08226_/A _08188_/B VPWR VGND sg13cmos5l_nand2_1
X_07208_ _07214_/B _07209_/B _07211_/C VPWR VGND sg13cmos5l_nor2_1
X_07139_ _07139_/Y _07137_/X _08784_/B _07136_/Y VPWR VGND sg13cmos5l_o21ai_1
XFILLER_4_639 VPWR VGND sg13cmos5l_fill_2
XFILLER_0_801 VPWR VGND sg13cmos5l_fill_1
XFILLER_0_823 VPWR VGND sg13cmos5l_fill_1
XFILLER_28_573 VPWR VGND sg13cmos5l_fill_1
XFILLER_43_565 VPWR VGND sg13cmos5l_fill_2
XFILLER_31_705 VPWR VGND sg13cmos5l_fill_1
XFILLER_31_727 VPWR VGND sg13cmos5l_fill_2
XFILLER_8_901 VPWR VGND sg13cmos5l_fill_2
XFILLER_8_945 VPWR VGND sg13cmos5l_decap_8
XFILLER_8_956 VPWR VGND sg13cmos5l_fill_1
XFILLER_8_989 VPWR VGND sg13cmos5l_fill_2
XFILLER_7_477 VPWR VGND sg13cmos5l_decap_4
XFILLER_48_1025 VPWR VGND sg13cmos5l_decap_4
X_04840_ _04840_/Y hold928/X VPWR VGND sg13cmos5l_inv_1
X_06510_ _06512_/B _06540_/B _06540_/A VPWR VGND sg13cmos5l_nand2b_1
X_07490_ _07490_/Y _07493_/B _07799_/A _07490_/C VPWR VGND sg13cmos5l_nand3_1
X_06441_ _06441_/Y _06441_/A _06441_/B VPWR VGND sg13cmos5l_nor2_1
X_06372_ _06387_/B _09450_/Q _09449_/Q _09448_/Q VPWR VGND sg13cmos5l_or3_1
X_09160_ _09160_/Q clkload4/A _09160_/D _09160_/RESET_B VPWR VGND sg13cmos5l_dfrbpq_1
X_05323_ _05478_/B _05310_/A _05306_/Y _05322_/X VPWR VGND sg13cmos5l_o21ai_1
X_08111_ _08111_/Y _09182_/Q _08111_/B VPWR VGND sg13cmos5l_nor2_1
X_09091_ hold996/A _09575_/CLK _09091_/D _09091_/RESET_B VPWR VGND sg13cmos5l_dfrbpq_1
X_08042_ _08211_/A _08001_/X _08038_/B _08342_/A VPWR VGND sg13cmos5l_o21ai_1
X_05254_ _05254_/Y _05234_/A _05256_/S _08997_/B VPWR VGND sg13cmos5l_o21ai_1
Xhold901 hold901/X hold901/A VPWR VGND sg13cmos5l_dlygate4sd3_1
Xhold912 hold912/X hold912/A VPWR VGND sg13cmos5l_dlygate4sd3_1
X_05185_ _05185_/X _05199_/B _05125_/B _05184_/Y VPWR VGND sg13cmos5l_a21o_1
Xhold934 hold934/X hold934/A VPWR VGND sg13cmos5l_dlygate4sd3_1
Xhold945 hold945/X hold945/A VPWR VGND sg13cmos5l_dlygate4sd3_1
Xhold923 hold923/X hold923/A VPWR VGND sg13cmos5l_dlygate4sd3_1
X_09507__594 _09507_/RESET_B VPWR VGND sg13cmos5l_tiehi
Xhold989 hold989/X hold989/A VPWR VGND sg13cmos5l_dlygate4sd3_1
Xhold978 hold978/X hold978/A VPWR VGND sg13cmos5l_dlygate4sd3_1
Xhold956 hold956/X hold956/A VPWR VGND sg13cmos5l_dlygate4sd3_1
Xhold967 hold967/X hold967/A VPWR VGND sg13cmos5l_dlygate4sd3_1
X_08944_ _08944_/Y _09264_/Q _09321_/Q VPWR VGND sg13cmos5l_nor2b_1
X_08875_ _08876_/A _08909_/A _08873_/B _08913_/B _08880_/A VPWR VGND sg13cmos5l_a22oi_1
X_07826_ _07826_/X _07826_/A _07829_/C VPWR VGND sg13cmos5l_and2_1
XFILLER_29_359 VPWR VGND sg13cmos5l_fill_1
XFILLER_44_318 VPWR VGND sg13cmos5l_fill_2
X_07757_ _07772_/C _09114_/Q _07758_/B VPWR VGND sg13cmos5l_xnor2_1
X_04969_ _04969_/Y _09496_/Q VPWR VGND sg13cmos5l_inv_1
X_06708_ _06708_/Y _04965_/Y _06724_/A _06707_/Y VPWR VGND sg13cmos5l_o21ai_1
X_07688_ _07688_/X _07513_/B _07699_/B _07687_/Y VPWR VGND sg13cmos5l_a21o_1
X_09514__587 _09514_/RESET_B VPWR VGND sg13cmos5l_tiehi
XFILLER_12_226 VPWR VGND sg13cmos5l_fill_1
X_09427_ hold852/A _09575_/CLK _09427_/D _09427_/RESET_B VPWR VGND sg13cmos5l_dfrbpq_1
X_06639_ _06670_/B _09486_/Q _09487_/Q hold1385/X VPWR VGND sg13cmos5l_o21ai_1
X_09358_ _09358_/Q clkload12/A _09358_/D _09358_/RESET_B VPWR VGND sg13cmos5l_dfrbpq_1
X_09484__620 _09484_/RESET_B VPWR VGND sg13cmos5l_tiehi
X_08309_ _08309_/Y _08306_/Y _08307_/Y _08308_/Y _07991_/C VPWR VGND sg13cmos5l_a22oi_1
X_09289_ _09289_/Q clkload10/A _09289_/D _09289_/RESET_B VPWR VGND sg13cmos5l_dfrbpq_1
XFILLER_5_937 VPWR VGND sg13cmos5l_fill_1
X_09345__771 _09345_/RESET_B VPWR VGND sg13cmos5l_tiehi
X_09491__613 _09491_/RESET_B VPWR VGND sg13cmos5l_tiehi
XFILLER_43_395 VPWR VGND sg13cmos5l_fill_2
XFILLER_34_91 VPWR VGND sg13cmos5l_fill_1
X_06990_ _09583_/D _06990_/A _06990_/B VPWR VGND sg13cmos5l_nor2_1
X_09400__710 _09400_/RESET_B VPWR VGND sg13cmos5l_tiehi
XFILLER_39_624 VPWR VGND sg13cmos5l_fill_1
X_05941_ _05942_/B hold1166/X fanout39/X _05963_/B VPWR VGND sg13cmos5l_o21ai_1
X_05872_ _05872_/Y _05870_/Y _05871_/Y _05866_/Y VPWR VGND sg13cmos5l_a21oi_1
X_08660_ _08660_/Y _08661_/C _08661_/D VPWR VGND sg13cmos5l_nand2_1
X_04823_ _04823_/Y _04823_/A VPWR VGND sg13cmos5l_inv_1
X_07611_ hold979/A _04951_/Y _07620_/B _07610_/Y VPWR VGND sg13cmos5l_a21oi_1
X_08591_ hold959/A _04822_/Y _08577_/B _08603_/B VPWR VGND sg13cmos5l_a21oi_1
XFILLER_19_370 VPWR VGND sg13cmos5l_fill_1
X_07542_ _07544_/B _09064_/Q _09039_/Q VPWR VGND sg13cmos5l_or2_1
X_07473_ _07833_/A _07480_/B _07473_/B VPWR VGND sg13cmos5l_nand2b_1
XFILLER_34_362 VPWR VGND sg13cmos5l_fill_1
X_09212_ _09212_/Q _09347_/CLK _09212_/D _09212_/RESET_B VPWR VGND sg13cmos5l_dfrbpq_1
X_06424_ _06424_/Y _09511_/Q _06437_/B VPWR VGND sg13cmos5l_nor2_1
X_06355_ _06355_/Y _06367_/S _06355_/B VPWR VGND sg13cmos5l_nor2_1
X_09143_ _09143_/Q _09214_/CLK _09143_/D _09143_/RESET_B VPWR VGND sg13cmos5l_dfrbpq_1
X_05306_ _05306_/Y _05330_/A _05327_/B _05302_/Y _05292_/X _05304_/Y VPWR VGND sg13cmos5l_a221oi_1
X_06286_ _06286_/Y _06288_/B VPWR VGND sg13cmos5l_inv_1
X_09074_ _09074_/Q clkload14/A _09074_/D _09074_/RESET_B VPWR VGND sg13cmos5l_dfrbpq_1
X_08025_ _08025_/Y _08311_/A _08037_/B VPWR VGND sg13cmos5l_nand2_1
X_05237_ _05240_/A _05237_/A _05237_/B _05237_/C VPWR VGND sg13cmos5l_nor3_1
X_05168_ _05168_/Y _05176_/B _08751_/A _05164_/Y _05166_/Y VPWR VGND sg13cmos5l_a22oi_1
X_05099_ _05099_/X _09292_/Q _05100_/B VPWR VGND sg13cmos5l_xor2_1
XFILLER_39_36 VPWR VGND sg13cmos5l_fill_1
X_08927_ _09287_/D _08911_/A _08924_/S _08926_/Y VPWR VGND sg13cmos5l_a21oi_1
Xhold1420 _06122_/A _09413_/Q VPWR VGND sg13cmos5l_dlygate4sd3_1
Xhold1431 hold1431/X _09477_/Q VPWR VGND sg13cmos5l_dlygate4sd3_1
X_08858_ _08907_/B _08858_/A _08858_/B VPWR VGND sg13cmos5l_nor2_1
XFILLER_29_123 VPWR VGND sg13cmos5l_fill_1
X_07809_ _07809_/Y _07500_/Y _07806_/X _07808_/Y VPWR VGND sg13cmos5l_o21ai_1
X_08789_ _08789_/Y _09285_/Q _07174_/B _05007_/Y _08997_/A _08788_/Y VPWR VGND sg13cmos5l_a221oi_1
XFILLER_38_1024 VPWR VGND sg13cmos5l_decap_4
XFILLER_1_940 VPWR VGND sg13cmos5l_fill_1
XFILLER_1_984 VPWR VGND sg13cmos5l_decap_8
X_09595__489 _09595_/RESET_B VPWR VGND sg13cmos5l_tiehi
XFILLER_49_966 VPWR VGND sg13cmos5l_decap_8
XFILLER_0_483 VPWR VGND sg13cmos5l_fill_2
X_06140_ _06140_/Y _05826_/B _06137_/X _06139_/Y VPWR VGND sg13cmos5l_o21ai_1
X_06071_ _06387_/A _06473_/A _09475_/Q VPWR VGND sg13cmos5l_xnor2_1
X_05022_ _07078_/A _05017_/Y _05022_/B VPWR VGND sg13cmos5l_nand2b_1
X_09504__597 _09504_/RESET_B VPWR VGND sg13cmos5l_tiehi
X_06973_ _06973_/Y _04960_/Y _06974_/B _06972_/Y VPWR VGND sg13cmos5l_a21oi_1
XFILLER_39_421 VPWR VGND sg13cmos5l_fill_2
X_08712_ _08713_/B _08623_/Y fanout20/X _08723_/A VPWR VGND sg13cmos5l_o21ai_1
X_05924_ _05925_/A _04986_/Y _05933_/B _05923_/Y VPWR VGND sg13cmos5l_a21oi_1
X_09474__630 _09474_/RESET_B VPWR VGND sg13cmos5l_tiehi
X_05855_ _05855_/X _05830_/Y _05853_/Y _05852_/Y VPWR VGND sg13cmos5l_a21o_1
X_08643_ _08643_/Y _09195_/Q _08643_/B VPWR VGND sg13cmos5l_xnor2_1
X_08574_ _08574_/Y _08574_/A VPWR VGND sg13cmos5l_inv_1
X_05786_ _05786_/Y hold886/X _06469_/A VPWR VGND sg13cmos5l_nand2b_1
XFILLER_41_129 VPWR VGND sg13cmos5l_fill_1
X_07525_ _07525_/Y _07808_/A _07792_/A VPWR VGND sg13cmos5l_nor2_1
XFILLER_23_822 VPWR VGND sg13cmos5l_fill_2
X_09335__781 _09335_/RESET_B VPWR VGND sg13cmos5l_tiehi
X_07456_ _07456_/Y _07436_/A _07462_/S _07464_/B1 VPWR VGND sg13cmos5l_o21ai_1
X_06407_ _06503_/B _06098_/Y _06406_/X _06413_/S VPWR VGND sg13cmos5l_mux2_1
X_07387_ _09060_/D _07387_/A _07463_/A VPWR VGND sg13cmos5l_nor2_1
X_09481__623 _09481_/RESET_B VPWR VGND sg13cmos5l_tiehi
X_06338_ _06338_/Y _06361_/B _06362_/B _06337_/Y VPWR VGND sg13cmos5l_o21ai_1
X_09126_ _09126_/Q _09214_/CLK _09126_/D _09126_/RESET_B VPWR VGND sg13cmos5l_dfrbpq_1
X_06269_ _06269_/Y _06242_/A _06242_/B _06256_/X _06090_/B _06266_/Y VPWR VGND sg13cmos5l_a221oi_1
X_09057_ hold885/A clkload13/A _09057_/D _09057_/RESET_B VPWR VGND sg13cmos5l_dfrbpq_1
X_08008_ _08008_/Y _08320_/A _08021_/B _08007_/Y VPWR VGND sg13cmos5l_o21ai_1
X_09342__774 _09342_/RESET_B VPWR VGND sg13cmos5l_tiehi
Xhold1250 _07130_/A _09006_/Q VPWR VGND sg13cmos5l_dlygate4sd3_1
XFILLER_46_914 VPWR VGND sg13cmos5l_fill_1
Xhold1261 _07130_/B _09007_/Q VPWR VGND sg13cmos5l_dlygate4sd3_1
Xhold1283 hold1283/X _09120_/Q VPWR VGND sg13cmos5l_dlygate4sd3_1
Xhold1294 _07408_/A _09058_/Q VPWR VGND sg13cmos5l_dlygate4sd3_1
Xhold1272 _06680_/B _06654_/B VPWR VGND sg13cmos5l_dlygate4sd3_1
XFILLER_49_774 VPWR VGND sg13cmos5l_fill_2
X_05640_ _05640_/Y _05964_/A _09341_/Q VPWR VGND sg13cmos5l_nand2_1
X_05571_ _05571_/Y hold1373/X _05592_/A VPWR VGND sg13cmos5l_nand2b_1
XFILLER_17_671 VPWR VGND sg13cmos5l_fill_2
XFILLER_17_682 VPWR VGND sg13cmos5l_fill_2
X_07310_ _07324_/C _07303_/Y _07306_/Y _07308_/Y VPWR VGND sg13cmos5l_a21o_1
X_08290_ _08291_/A _08259_/Y _08289_/Y _08290_/S VPWR VGND sg13cmos5l_mux2_1
X_09053__428 _09053_/RESET_B VPWR VGND sg13cmos5l_tiehi
XFILLER_32_663 VPWR VGND sg13cmos5l_fill_2
X_07241_ _07241_/X _09033_/Q _07241_/B VPWR VGND sg13cmos5l_or2_1
X_07172_ _09011_/D _07220_/A _09005_/B VPWR VGND sg13cmos5l_nor2_1
X_06123_ _06153_/B _09411_/Q _09410_/Q _09412_/Q VPWR VGND sg13cmos5l_o21ai_1
X_06054_ _06068_/B _06473_/A _09475_/Q VPWR VGND sg13cmos5l_nor2_1
X_05005_ _07173_/B _09016_/Q VPWR VGND sg13cmos5l_inv_1
X_06956_ _06956_/Y _06969_/A _06950_/Y _06955_/Y _04960_/Y VPWR VGND sg13cmos5l_a22oi_1
X_05907_ _06001_/B _05907_/A _05907_/B VPWR VGND sg13cmos5l_and2_1
X_06887_ _09559_/D _06932_/A _07053_/A VPWR VGND sg13cmos5l_nor2_1
XFILLER_28_936 VPWR VGND sg13cmos5l_fill_1
X_05838_ _05994_/A _05847_/A _05847_/C _05837_/Y VPWR VGND sg13cmos5l_a21o_1
X_08626_ _08627_/B _09242_/Q _08626_/B VPWR VGND sg13cmos5l_xor2_1
XFILLER_42_405 VPWR VGND sg13cmos5l_fill_1
X_08557_ _08557_/Y _08557_/A VPWR VGND sg13cmos5l_inv_1
Xclkbuf_leaf_34_clk _09214_/CLK clkbuf_leaf_4_clk/A VPWR VGND sg13cmos5l_buf_8
X_05769_ _05769_/Y _05759_/A _05721_/Y _05763_/Y _05767_/Y _05768_/X VPWR VGND sg13cmos5l_a221oi_1
X_07508_ _07509_/A _09102_/Q _07519_/A VPWR VGND sg13cmos5l_nand2_1
X_08488_ _08488_/Y _08529_/A _08530_/A _08487_/Y _08555_/A _08486_/Y VPWR VGND sg13cmos5l_a221oi_1
XFILLER_35_1005 VPWR VGND sg13cmos5l_fill_1
X_07439_ _07442_/B _07275_/B _07323_/B _07447_/B VPWR VGND sg13cmos5l_mux2_1
XFILLER_11_858 VPWR VGND sg13cmos5l_fill_1
X_09109_ _09109_/Q clkload14/A _09109_/D _09109_/RESET_B VPWR VGND sg13cmos5l_dfrbpq_1
Xhold1080 _09496_/D _06460_/Y VPWR VGND sg13cmos5l_dlygate4sd3_1
Xhold1091 _09457_/D _06204_/Y VPWR VGND sg13cmos5l_dlygate4sd3_1
XFILLER_27_991 VPWR VGND sg13cmos5l_fill_2
Xclkbuf_leaf_25_clk _09586_/CLK clkbuf_3_5__f_clk/X VPWR VGND sg13cmos5l_buf_8
XFILLER_42_972 VPWR VGND sg13cmos5l_fill_1
XFILLER_41_460 VPWR VGND sg13cmos5l_decap_4
X_09464__640 _09464_/RESET_B VPWR VGND sg13cmos5l_tiehi
XFILLER_6_862 VPWR VGND sg13cmos5l_fill_1
XFILLER_47_4 VPWR VGND sg13cmos5l_fill_2
X_09325__791 _09325_/RESET_B VPWR VGND sg13cmos5l_tiehi
X_07790_ _07829_/A _07790_/A _09081_/Q _07802_/B VPWR VGND sg13cmos5l_or3_1
X_06810_ _06810_/Y _06810_/A _06810_/B _06810_/C VPWR VGND sg13cmos5l_nand3_1
XFILLER_49_593 VPWR VGND sg13cmos5l_fill_2
X_06741_ _09547_/D _06741_/A _06742_/B VPWR VGND sg13cmos5l_nor2_1
X_09471__633 _09471_/RESET_B VPWR VGND sg13cmos5l_tiehi
X_09460_ hold898/A _09503_/CLK _09460_/D _09460_/RESET_B VPWR VGND sg13cmos5l_dfrbpq_1
XFILLER_36_243 VPWR VGND sg13cmos5l_fill_1
X_08411_ _08445_/C hold964/A hold871/A _09211_/Q VPWR VGND sg13cmos5l_nand3_1
X_06672_ _06790_/A _06771_/C _06771_/D VPWR VGND sg13cmos5l_nand2_1
XFILLER_37_799 VPWR VGND sg13cmos5l_fill_2
Xclkbuf_leaf_16_clk clkload20/A clkbuf_3_6__f_clk/X VPWR VGND sg13cmos5l_buf_8
X_05623_ _05746_/A _05309_/Y _05636_/S _05622_/X VPWR VGND sg13cmos5l_a21oi_1
X_09391_ _09391_/Q clkload18/A _09391_/D _09391_/RESET_B VPWR VGND sg13cmos5l_dfrbpq_1
X_05554_ _05554_/X _05560_/B _05554_/B VPWR VGND sg13cmos5l_and2_1
X_08342_ _08434_/B _08342_/A _08342_/B VPWR VGND sg13cmos5l_and2_1
X_09332__784 _09332_/RESET_B VPWR VGND sg13cmos5l_tiehi
X_08273_ _08273_/Y _08599_/A _08294_/A VPWR VGND sg13cmos5l_nand2_1
X_05485_ _05486_/B _05329_/B _05508_/B _05484_/Y VPWR VGND sg13cmos5l_o21ai_1
X_07224_ _07227_/B _09067_/Q _09068_/Q _09066_/Q _09065_/Q VPWR VGND sg13cmos5l_nor4_1
X_07155_ _08889_/A _07155_/A _07158_/A VPWR VGND sg13cmos5l_or2_1
X_06106_ _06106_/Y _06112_/A _06106_/B VPWR VGND sg13cmos5l_nor2_1
X_07086_ _07086_/Y _07086_/A _07086_/B VPWR VGND sg13cmos5l_nor2_1
X_06037_ _06037_/Y _06012_/A _06041_/S _05963_/B VPWR VGND sg13cmos5l_o21ai_1
Xfanout101 _05986_/B _05972_/Y VPWR VGND sg13cmos5l_buf_1
Xfanout112 _08842_/B _08757_/Y VPWR VGND sg13cmos5l_buf_1
Xfanout145 _06988_/B _06824_/Y VPWR VGND sg13cmos5l_buf_1
Xfanout123 _08231_/A _08081_/A VPWR VGND sg13cmos5l_buf_1
Xfanout134 _07717_/B1 _07468_/Y VPWR VGND sg13cmos5l_buf_1
Xfanout156 _06303_/A _06048_/Y VPWR VGND sg13cmos5l_buf_1
Xfanout178 _06473_/A _06091_/A VPWR VGND sg13cmos5l_buf_1
Xfanout167 _05378_/A _05448_/B VPWR VGND sg13cmos5l_buf_1
X_07988_ _07988_/X _07987_/B _07977_/C _08311_/A VPWR VGND sg13cmos5l_a21o_1
Xfanout189 _08478_/A _08234_/A VPWR VGND sg13cmos5l_buf_1
X_06939_ _06939_/Y _09531_/Q _07386_/A VPWR VGND sg13cmos5l_nor2b_1
X_09589_ _09589_/Q clkload17/A _09589_/D _09589_/RESET_B VPWR VGND sg13cmos5l_dfrbpq_1
X_08609_ _08697_/A _09243_/Q _08626_/B VPWR VGND sg13cmos5l_xnor2_1
XFILLER_19_799 VPWR VGND sg13cmos5l_fill_2
XFILLER_34_703 VPWR VGND sg13cmos5l_fill_1
X_05270_ _05282_/B _05317_/A _09361_/Q VPWR VGND sg13cmos5l_nor2_1
Xclkbuf_leaf_5_clk _09387_/CLK clkload0/A VPWR VGND sg13cmos5l_buf_8
X_08960_ _08960_/Y _05001_/Y _08964_/B _08959_/Y VPWR VGND sg13cmos5l_a21oi_1
X_09308__263 _09308_/RESET_B VPWR VGND sg13cmos5l_tiehi
X_07911_ _07912_/B hold1345/X _07917_/B VPWR VGND sg13cmos5l_nand2b_1
XFILLER_38_0 VPWR VGND sg13cmos5l_fill_1
X_08891_ _08891_/Y _08892_/B _08892_/C VPWR VGND sg13cmos5l_nand2_1
X_07842_ _07842_/Y _08149_/A _09088_/Q _09087_/Q _08148_/A _07841_/Y VPWR VGND sg13cmos5l_a221oi_1
XFILLER_25_1026 VPWR VGND sg13cmos5l_fill_2
X_07773_ _07773_/Y _07924_/A _07924_/B VPWR VGND sg13cmos5l_nand2_1
X_04985_ _04985_/Y _09381_/Q VPWR VGND sg13cmos5l_inv_1
X_09512_ _09512_/Q clkload23/A _09512_/D _09512_/RESET_B VPWR VGND sg13cmos5l_dfrbpq_1
X_06724_ _06725_/C _06724_/A _06723_/B VPWR VGND sg13cmos5l_nor2b_1
X_09443_ _09443_/Q clkload21/A _09443_/D _09443_/RESET_B VPWR VGND sg13cmos5l_dfrbpq_1
X_06655_ _06655_/Y _06652_/Y _06654_/X _06651_/Y VPWR VGND sg13cmos5l_a21oi_1
X_05606_ _05606_/Y _05606_/A VPWR VGND sg13cmos5l_inv_1
X_09374_ _09374_/Q clkload20/A _09374_/D _09374_/RESET_B VPWR VGND sg13cmos5l_dfrbpq_1
X_08325_ _08426_/C _08325_/A _08329_/C _08334_/C VPWR VGND sg13cmos5l_and3_1
X_06586_ _06933_/A _06588_/B _06586_/B VPWR VGND sg13cmos5l_nand2b_1
X_05537_ _05588_/A _09371_/Q _05537_/B VPWR VGND sg13cmos5l_xor2_1
XFILLER_32_1019 VPWR VGND sg13cmos5l_fill_1
X_08256_ _08256_/Y _08259_/B _08640_/A _08256_/C VPWR VGND sg13cmos5l_nand3_1
X_05468_ _05511_/A _05470_/B _05464_/A VPWR VGND sg13cmos5l_nor2b_1
X_08187_ _08188_/B _08035_/Y _08208_/B _08186_/Y VPWR VGND sg13cmos5l_o21ai_1
X_07207_ _09023_/D _08478_/A _07207_/B _07211_/C VPWR VGND sg13cmos5l_nor3_1
X_05399_ _05421_/A _05697_/A _05408_/B _05398_/Y VPWR VGND sg13cmos5l_o21ai_1
X_07138_ _08784_/B _08842_/A _07138_/B VPWR VGND sg13cmos5l_xnor2_1
X_07069_ _07070_/B _07034_/A _07033_/Y _07069_/S VPWR VGND sg13cmos5l_mux2_1
X_09530__571 _09530_/RESET_B VPWR VGND sg13cmos5l_tiehi
XFILLER_48_1004 VPWR VGND sg13cmos5l_decap_8
X_09322__794 _09322_/RESET_B VPWR VGND sg13cmos5l_tiehi
XFILLER_17_5 VPWR VGND sg13cmos5l_fill_2
XFILLER_47_872 VPWR VGND sg13cmos5l_fill_1
XFILLER_0_1017 VPWR VGND sg13cmos5l_decap_8
XFILLER_0_1028 VPWR VGND sg13cmos5l_fill_1
X_06440_ _06440_/Y _04971_/Y _06434_/A _06439_/A _04970_/Y VPWR VGND sg13cmos5l_a22oi_1
XFILLER_21_205 VPWR VGND sg13cmos5l_fill_1
XFILLER_21_216 VPWR VGND sg13cmos5l_fill_2
XFILLER_34_588 VPWR VGND sg13cmos5l_fill_2
X_06371_ _09484_/D _06552_/A _06371_/B VPWR VGND sg13cmos5l_nor2_1
XFILLER_21_249 VPWR VGND sg13cmos5l_fill_1
X_05322_ _05322_/X _05322_/A _05331_/B VPWR VGND sg13cmos5l_and2_1
X_08110_ _08110_/Y _04942_/Y _08105_/A _08127_/A _04941_/Y VPWR VGND sg13cmos5l_a22oi_1
X_09090_ hold944/A _09575_/CLK _09090_/D _09090_/RESET_B VPWR VGND sg13cmos5l_dfrbpq_1
X_05253_ _09322_/D _05225_/Y _05256_/S _05252_/Y VPWR VGND sg13cmos5l_a21oi_1
X_08041_ _09150_/D _08084_/A _08208_/A VPWR VGND sg13cmos5l_nor2b_1
Xhold902 hold902/X hold902/A VPWR VGND sg13cmos5l_dlygate4sd3_1
Xhold913 hold913/X hold913/A VPWR VGND sg13cmos5l_dlygate4sd3_1
X_05184_ _05184_/Y _05355_/A _05198_/B VPWR VGND sg13cmos5l_nand2_1
Xhold935 hold935/X hold935/A VPWR VGND sg13cmos5l_dlygate4sd3_1
Xhold946 hold946/X hold946/A VPWR VGND sg13cmos5l_dlygate4sd3_1
Xhold924 hold924/X hold924/A VPWR VGND sg13cmos5l_dlygate4sd3_1
Xhold979 hold979/X hold979/A VPWR VGND sg13cmos5l_dlygate4sd3_1
Xhold957 hold957/X hold957/A VPWR VGND sg13cmos5l_dlygate4sd3_1
Xhold968 hold968/X hold968/A VPWR VGND sg13cmos5l_dlygate4sd3_1
X_08943_ _08943_/Y _08945_/A _09265_/Q VPWR VGND sg13cmos5l_nand2_1
X_08874_ _08874_/Y _08882_/A _08772_/A _08873_/Y VPWR VGND sg13cmos5l_a21oi_1
X_07825_ _09117_/D _07875_/A _07825_/B VPWR VGND sg13cmos5l_nor2_1
X_07756_ _07772_/B _07752_/Y _07754_/Y _07734_/Y VPWR VGND sg13cmos5l_a21o_1
X_04968_ _04968_/Y _06691_/B VPWR VGND sg13cmos5l_inv_1
X_06707_ _06707_/Y _09533_/Q _06707_/B VPWR VGND sg13cmos5l_nand2_1
X_04899_ _08149_/A _07725_/B VPWR VGND sg13cmos5l_inv_1
X_07687_ _07687_/Y _07664_/C _07664_/D _07671_/Y _07673_/Y _07674_/X VPWR VGND sg13cmos5l_a221oi_1
X_09426_ hold868/A _09575_/CLK _09426_/D _09426_/RESET_B VPWR VGND sg13cmos5l_dfrbpq_1
X_06638_ _06674_/B _06638_/A _06670_/A VPWR VGND sg13cmos5l_xnor2_1
X_06569_ _06569_/Y _06569_/A _06569_/B _06569_/C VPWR VGND sg13cmos5l_nor3_1
X_09357_ _09357_/Q clkload12/A _09357_/D _09357_/RESET_B VPWR VGND sg13cmos5l_dfrbpq_1
X_08308_ _08308_/Y _09153_/Q _09154_/Q VPWR VGND sg13cmos5l_xnor2_1
X_09288_ _09288_/Q _09288_/CLK _09288_/D _09288_/RESET_B VPWR VGND sg13cmos5l_dfrbpq_1
X_08239_ _08649_/A _08604_/A _08240_/B VPWR VGND sg13cmos5l_and2_1
XFILLER_4_448 VPWR VGND sg13cmos5l_decap_8
XFILLER_0_665 VPWR VGND sg13cmos5l_fill_1
XFILLER_47_146 VPWR VGND sg13cmos5l_fill_1
X_09218__249 _09218_/RESET_B VPWR VGND sg13cmos5l_tiehi
XFILLER_16_577 VPWR VGND sg13cmos5l_fill_1
XFILLER_16_599 VPWR VGND sg13cmos5l_fill_2
XFILLER_8_732 VPWR VGND sg13cmos5l_fill_2
X_09049__433 _09049_/RESET_B VPWR VGND sg13cmos5l_tiehi
XFILLER_3_481 VPWR VGND sg13cmos5l_fill_1
X_05940_ _05942_/A _05940_/A fanout39/X VPWR VGND sg13cmos5l_nor2b_1
X_05871_ _05871_/Y _05871_/A _05896_/A _05896_/B VPWR VGND sg13cmos5l_nand3_1
X_08590_ _08590_/Y _08574_/Y _08579_/Y _08589_/Y VPWR VGND sg13cmos5l_a21oi_1
X_04822_ _04822_/Y hold958/X VPWR VGND sg13cmos5l_inv_1
X_07610_ _07610_/Y _07587_/Y _07620_/B _07717_/B1 VPWR VGND sg13cmos5l_o21ai_1
X_07541_ _07565_/B _09039_/Q _07541_/B VPWR VGND sg13cmos5l_xor2_1
XFILLER_34_330 VPWR VGND sg13cmos5l_fill_2
X_07472_ _07472_/Y _07895_/A _07480_/B VPWR VGND sg13cmos5l_nor2_1
XFILLER_22_503 VPWR VGND sg13cmos5l_fill_2
X_09211_ _09211_/Q _09347_/CLK _09211_/D _09211_/RESET_B VPWR VGND sg13cmos5l_dfrbpq_1
X_06423_ _06441_/B _09516_/Q _04972_/Y _06422_/Y VPWR VGND sg13cmos5l_a21oi_1
X_06354_ _06354_/Y _06355_/B VPWR VGND sg13cmos5l_inv_1
X_09142_ _09142_/Q _09214_/CLK _09142_/D _09142_/RESET_B VPWR VGND sg13cmos5l_dfrbpq_1
X_05305_ _05305_/Y _05330_/A _05327_/B _05298_/X _05301_/X VPWR VGND sg13cmos5l_a22oi_1
X_06285_ _06288_/B _06232_/B _06285_/B _06285_/C VPWR VGND sg13cmos5l_nand3b_1
X_09073_ _09073_/Q clkload14/A _09073_/D _09073_/RESET_B VPWR VGND sg13cmos5l_dfrbpq_1
X_08024_ _09147_/D _08081_/A _08024_/B VPWR VGND sg13cmos5l_nor2_1
X_05236_ _05237_/C _05236_/A _05236_/B _05236_/C VPWR VGND sg13cmos5l_and3_1
X_05167_ _05167_/Y _05164_/Y _05166_/Y _05159_/Y VPWR VGND sg13cmos5l_o21ai_1
XFILLER_2_919 VPWR VGND sg13cmos5l_fill_2
X_05098_ _05098_/Y _05355_/A _05093_/X _05097_/Y VPWR VGND sg13cmos5l_o21ai_1
Xhold1410 hold1410/X _09555_/Q VPWR VGND sg13cmos5l_dlygate4sd3_1
X_09520__581 _09520_/RESET_B VPWR VGND sg13cmos5l_tiehi
X_08926_ _08926_/Y _08911_/B _08924_/S _08842_/B VPWR VGND sg13cmos5l_o21ai_1
Xhold1421 _06638_/A _09489_/Q VPWR VGND sg13cmos5l_dlygate4sd3_1
XFILLER_29_113 VPWR VGND sg13cmos5l_fill_1
X_08857_ _08858_/B _09282_/Q _08863_/B VPWR VGND sg13cmos5l_nand2b_1
X_07808_ _07808_/Y _07808_/A _07818_/A VPWR VGND sg13cmos5l_nand2_1
X_08788_ _08788_/Y _08996_/A hold983/A _08788_/C VPWR VGND sg13cmos5l_nor3_1
X_07739_ _07741_/B _09140_/Q _09108_/Q VPWR VGND sg13cmos5l_nand2_1
X_09409_ _09409_/Q clkload21/A _09409_/D _09409_/RESET_B VPWR VGND sg13cmos5l_dfrbpq_1
XFILLER_5_702 VPWR VGND sg13cmos5l_fill_1
XFILLER_5_779 VPWR VGND sg13cmos5l_fill_1
XFILLER_0_462 VPWR VGND sg13cmos5l_fill_1
XFILLER_49_945 VPWR VGND sg13cmos5l_decap_8
XFILLER_36_628 VPWR VGND sg13cmos5l_fill_2
XFILLER_43_160 VPWR VGND sg13cmos5l_fill_2
X_09190__227 _09190_/D VPWR VGND sg13cmos5l_tielo
XFILLER_16_374 VPWR VGND sg13cmos5l_fill_1
XFILLER_8_573 VPWR VGND sg13cmos5l_fill_2
X_06070_ _06070_/Y _09444_/Q _06073_/A VPWR VGND sg13cmos5l_xnor2_1
X_05021_ _05040_/A _09602_/Q _05021_/B VPWR VGND sg13cmos5l_nand2_1
XFILLER_6_96 VPWR VGND sg13cmos5l_fill_2
XFILLER_6_1012 VPWR VGND sg13cmos5l_fill_1
X_06972_ _06972_/Y _06955_/Y _06974_/B _06988_/B VPWR VGND sg13cmos5l_o21ai_1
X_08711_ _08713_/A _08711_/A fanout20/X VPWR VGND sg13cmos5l_nor2b_1
XFILLER_20_0 VPWR VGND sg13cmos5l_fill_2
X_05923_ _05923_/Y _05923_/A _05933_/B VPWR VGND sg13cmos5l_nor2_1
X_08642_ _08642_/X _09195_/Q _08643_/B VPWR VGND sg13cmos5l_xor2_1
X_05854_ _05856_/B _05830_/Y _05853_/Y hold1403/X VPWR VGND sg13cmos5l_a21oi_1
X_08573_ _08574_/A _04882_/Y _08572_/B _08572_/Y VPWR VGND sg13cmos5l_o21ai_1
X_05785_ _05785_/Y _07721_/A hold886/X VPWR VGND sg13cmos5l_nor2_1
X_07524_ _09072_/D _07636_/B _07524_/B VPWR VGND sg13cmos5l_nor2_1
X_07455_ _07455_/Y _07466_/A _07466_/C _07455_/C VPWR VGND sg13cmos5l_nand3_1
X_06406_ _06406_/X _06387_/B _06387_/C _06409_/A VPWR VGND sg13cmos5l_a21o_1
X_07386_ _09059_/D _07386_/A _07386_/B VPWR VGND sg13cmos5l_and2_1
X_06337_ _06337_/Y _06337_/A _06646_/A _06337_/C VPWR VGND sg13cmos5l_nand3_1
X_09125_ _09125_/Q _09214_/CLK _09125_/D _09125_/RESET_B VPWR VGND sg13cmos5l_dfrbpq_1
X_06268_ _06268_/Y _06268_/A VPWR VGND sg13cmos5l_inv_1
X_09056_ hold884/A clkload16/A _09056_/D _09056_/RESET_B VPWR VGND sg13cmos5l_dfrbpq_1
X_08007_ _08007_/Y _08007_/A _08007_/B _08007_/C VPWR VGND sg13cmos5l_nand3_1
X_05219_ _05220_/B _05061_/Y _05230_/B VPWR VGND sg13cmos5l_nand2b_1
X_06199_ _06199_/Y _06178_/X fanout43/X _06218_/B VPWR VGND sg13cmos5l_o21ai_1
X_09208__259 _09208_/RESET_B VPWR VGND sg13cmos5l_tiehi
X_08909_ _08909_/Y _08909_/A _08909_/B VPWR VGND sg13cmos5l_nand2_1
Xhold1251 _04929_/A _09199_/Q VPWR VGND sg13cmos5l_dlygate4sd3_1
Xhold1240 _06495_/A _09505_/Q VPWR VGND sg13cmos5l_dlygate4sd3_1
Xhold1273 hold1273/X _09377_/Q VPWR VGND sg13cmos5l_dlygate4sd3_1
Xhold1284 _08087_/B _08063_/B VPWR VGND sg13cmos5l_dlygate4sd3_1
Xhold1262 _07118_/A _09012_/Q VPWR VGND sg13cmos5l_dlygate4sd3_1
Xhold1295 _08275_/A _09184_/Q VPWR VGND sg13cmos5l_dlygate4sd3_1
X_09039__443 _09039_/RESET_B VPWR VGND sg13cmos5l_tiehi
XFILLER_13_366 VPWR VGND sg13cmos5l_fill_2
XFILLER_5_532 VPWR VGND sg13cmos5l_decap_8
XFILLER_5_565 VPWR VGND sg13cmos5l_fill_1
XFILLER_5_543 VPWR VGND sg13cmos5l_fill_1
X_09046__436 _09046_/RESET_B VPWR VGND sg13cmos5l_tiehi
X_05570_ _05593_/S _05567_/Y _05569_/Y _05543_/Y VPWR VGND sg13cmos5l_a21o_1
X_09510__591 _09510_/RESET_B VPWR VGND sg13cmos5l_tiehi
X_07240_ _07267_/A _09032_/Q _07240_/B VPWR VGND sg13cmos5l_xnor2_1
X_07171_ _07213_/B hold1263/X _07142_/X _08880_/A VPWR VGND sg13cmos5l_a21oi_1
X_06122_ _06122_/Y _06122_/A _06153_/A VPWR VGND sg13cmos5l_xnor2_1
X_06053_ _06112_/A _09447_/Q _06053_/B VPWR VGND sg13cmos5l_xor2_1
X_05004_ _05004_/Y hold922/X VPWR VGND sg13cmos5l_inv_1
X_06955_ _06955_/Y _07388_/A _06957_/B _06954_/Y VPWR VGND sg13cmos5l_o21ai_1
X_05906_ _09414_/D _05951_/A _06025_/A VPWR VGND sg13cmos5l_nor2_1
X_06886_ _07053_/A _06881_/S _06883_/Y _06884_/Y VPWR VGND sg13cmos5l_a21o_1
X_05837_ _05837_/Y _06219_/A _05842_/B VPWR VGND sg13cmos5l_nand2_1
X_08625_ _08710_/A _08698_/A _08625_/B VPWR VGND sg13cmos5l_nand2_1
XFILLER_27_458 VPWR VGND sg13cmos5l_fill_1
X_08556_ _08557_/A _04930_/Y _08568_/B _08555_/Y VPWR VGND sg13cmos5l_a21oi_1
X_07507_ _07530_/S _07521_/B _07521_/C VPWR VGND sg13cmos5l_nand2_1
X_05768_ _05768_/X _05783_/A _05768_/B VPWR VGND sg13cmos5l_and2_1
X_08487_ _08487_/Y _09223_/Q _09222_/Q _09245_/Q VPWR VGND sg13cmos5l_nand3b_1
XFILLER_35_1028 VPWR VGND sg13cmos5l_fill_1
X_05699_ _09394_/D _05699_/A _05784_/A VPWR VGND sg13cmos5l_nor2_1
X_07438_ _07442_/A _07438_/A _07446_/B _07438_/C VPWR VGND sg13cmos5l_nor3_1
X_07369_ _09047_/D _07369_/A _07369_/B VPWR VGND sg13cmos5l_nor2_1
X_09108_ _09108_/Q clkload14/A _09108_/D _09108_/RESET_B VPWR VGND sg13cmos5l_dfrbpq_1
X_09039_ _09039_/Q _09565_/CLK _09039_/D _09039_/RESET_B VPWR VGND sg13cmos5l_dfrbpq_1
XFILLER_45_211 VPWR VGND sg13cmos5l_fill_1
XFILLER_46_767 VPWR VGND sg13cmos5l_fill_2
Xhold1081 _06935_/B _09535_/Q VPWR VGND sg13cmos5l_dlygate4sd3_1
Xhold1070 _09493_/D _06453_/Y VPWR VGND sg13cmos5l_dlygate4sd3_1
Xhold1092 _06218_/A _09435_/Q VPWR VGND sg13cmos5l_dlygate4sd3_1
XFILLER_41_450 VPWR VGND sg13cmos5l_fill_1
XFILLER_9_145 VPWR VGND sg13cmos5l_fill_2
X_09605__526 _09605_/RESET_B VPWR VGND sg13cmos5l_tiehi
XFILLER_5_384 VPWR VGND sg13cmos5l_fill_1
XFILLER_3_1026 VPWR VGND sg13cmos5l_fill_2
X_06740_ _09546_/D _06740_/A _06742_/B VPWR VGND sg13cmos5l_nor2_1
X_06671_ _06771_/D _06636_/Y _06658_/Y _06357_/Y VPWR VGND sg13cmos5l_o21ai_1
X_05622_ _05622_/X _05622_/A _05630_/A _05630_/C VPWR VGND sg13cmos5l_and3_1
X_08410_ _08445_/B _08410_/A _08419_/B VPWR VGND sg13cmos5l_nand2_1
X_09390_ hold878/A _09575_/CLK _09390_/D _09390_/RESET_B VPWR VGND sg13cmos5l_dfrbpq_1
X_05553_ _05554_/B _09366_/Q _09365_/Q _09367_/Q VPWR VGND sg13cmos5l_o21ai_1
X_08341_ _09195_/D _08380_/A _08456_/A VPWR VGND sg13cmos5l_nor2_1
X_08272_ _08290_/S _08285_/B _08285_/C VPWR VGND sg13cmos5l_nand2_1
X_05484_ _05484_/Y _05484_/A _05508_/B VPWR VGND sg13cmos5l_nand2_1
X_07223_ _07251_/B _09067_/Q _09066_/Q _09065_/Q VPWR VGND sg13cmos5l_nor3_1
X_07154_ _08868_/A _07154_/A _07158_/A VPWR VGND sg13cmos5l_nor2_1
X_06105_ _06105_/Y _06083_/Y _06084_/Y _06104_/Y VPWR VGND sg13cmos5l_a21oi_1
X_07085_ _07086_/B _07083_/A _07079_/B _08479_/B VPWR VGND sg13cmos5l_o21ai_1
X_06036_ _09435_/D _06014_/B _06041_/S _06035_/Y VPWR VGND sg13cmos5l_a21oi_1
X_09029__453 _09029_/RESET_B VPWR VGND sg13cmos5l_tiehi
Xfanout113 _08603_/B _08604_/B VPWR VGND sg13cmos5l_buf_1
Xfanout102 _05990_/B _05972_/Y VPWR VGND sg13cmos5l_buf_1
Xfanout146 _07071_/B1 _06824_/Y VPWR VGND sg13cmos5l_buf_1
Xfanout135 _07389_/B _07463_/A VPWR VGND sg13cmos5l_buf_1
Xfanout124 _08149_/B _08081_/A VPWR VGND sg13cmos5l_buf_1
Xfanout179 _06091_/A hold1389/X VPWR VGND sg13cmos5l_buf_1
Xfanout157 _06299_/A _06048_/Y VPWR VGND sg13cmos5l_buf_1
X_07987_ _08033_/A _09149_/Q _07987_/B VPWR VGND sg13cmos5l_xor2_1
Xfanout168 _05448_/B _05423_/A VPWR VGND sg13cmos5l_buf_1
X_06938_ _06938_/Y _09530_/Q _09587_/Q VPWR VGND sg13cmos5l_nor2b_1
X_06869_ _06869_/Y _07295_/A _06883_/B VPWR VGND sg13cmos5l_nand2b_1
XFILLER_43_737 VPWR VGND sg13cmos5l_fill_1
XFILLER_42_214 VPWR VGND sg13cmos5l_fill_2
X_09588_ _09588_/Q _09591_/CLK _09588_/D _09588_/RESET_B VPWR VGND sg13cmos5l_dfrbpq_1
X_08608_ _08608_/Y _08606_/Y _08607_/Y _08682_/A VPWR VGND sg13cmos5l_a21oi_1
X_08539_ _08539_/Y _08539_/A _08539_/B _08539_/C VPWR VGND sg13cmos5l_nor3_1
X_09036__446 _09036_/RESET_B VPWR VGND sg13cmos5l_tiehi
X_09043__439 _09043_/RESET_B VPWR VGND sg13cmos5l_tiehi
XFILLER_46_586 VPWR VGND sg13cmos5l_decap_4
XFILLER_18_266 VPWR VGND sg13cmos5l_fill_1
X_08890_ _08892_/C _08893_/B _08893_/C _08763_/B VPWR VGND sg13cmos5l_o21ai_1
X_07910_ _07912_/A _09138_/Q _07917_/B _07949_/A VPWR VGND sg13cmos5l_a21o_1
X_07841_ _07841_/Y _09144_/Q _07607_/A _07617_/A _09143_/Q _07840_/Y VPWR VGND sg13cmos5l_a221oi_1
X_07772_ _07924_/B _07772_/A _07772_/B _07772_/C VPWR VGND sg13cmos5l_nand3_1
X_04984_ _04984_/Y _04984_/A VPWR VGND sg13cmos5l_inv_1
X_06723_ hold962/A hold961/X _06723_/B VPWR VGND sg13cmos5l_nor2_1
X_09511_ _09511_/Q clkload23/A _09511_/D _09511_/RESET_B VPWR VGND sg13cmos5l_dfrbpq_1
X_09442_ _09442_/Q clkload21/A _09442_/D _09442_/RESET_B VPWR VGND sg13cmos5l_dfrbpq_1
X_06654_ _06654_/X _06674_/A _06654_/B VPWR VGND sg13cmos5l_and2_1
X_05605_ _05606_/A _09335_/Q _09334_/Q VPWR VGND sg13cmos5l_xor2_1
X_09373_ _09373_/Q clkload20/A _09373_/D _09373_/RESET_B VPWR VGND sg13cmos5l_dfrbpq_1
X_06585_ _06622_/B _06993_/A _06588_/B VPWR VGND sg13cmos5l_nand2_1
X_05536_ _05592_/A _09371_/Q _05537_/B VPWR VGND sg13cmos5l_xnor2_1
X_08324_ _08339_/S _08329_/C _08334_/C VPWR VGND sg13cmos5l_nand2_1
X_08255_ _08255_/Y _08254_/B _08280_/A _08254_/X _08600_/A _08251_/Y VPWR VGND sg13cmos5l_a221oi_1
X_05467_ _05517_/A _05487_/B _05503_/B _05467_/C VPWR VGND sg13cmos5l_nor3_1
X_08186_ _08186_/Y _08186_/A _08208_/B VPWR VGND sg13cmos5l_nand2_1
X_07206_ _07212_/B _07207_/B _07211_/C VPWR VGND sg13cmos5l_nor2_1
X_05398_ _05398_/Y _09303_/Q _05408_/B VPWR VGND sg13cmos5l_nand2_1
X_07137_ _07137_/X _09010_/Q _07137_/B VPWR VGND sg13cmos5l_xor2_1
X_07068_ _09589_/D _07049_/B _07069_/S _07067_/Y VPWR VGND sg13cmos5l_a21oi_1
X_06019_ _06019_/Y _06012_/Y _06014_/Y _06018_/Y VPWR VGND sg13cmos5l_o21ai_1
XFILLER_28_520 VPWR VGND sg13cmos5l_fill_2
XFILLER_43_501 VPWR VGND sg13cmos5l_fill_1
XFILLER_15_269 VPWR VGND sg13cmos5l_fill_1
XFILLER_8_969 VPWR VGND sg13cmos5l_fill_1
XFILLER_23_83 VPWR VGND sg13cmos5l_fill_1
X_09227__240 _09227_/RESET_B VPWR VGND sg13cmos5l_tiehi
XFILLER_3_663 VPWR VGND sg13cmos5l_decap_4
XFILLER_48_91 VPWR VGND sg13cmos5l_fill_2
XFILLER_0_32 VPWR VGND sg13cmos5l_fill_2
XFILLER_15_781 VPWR VGND sg13cmos5l_fill_1
X_06370_ _06540_/A _06341_/A _06365_/A _06680_/A VPWR VGND sg13cmos5l_o21ai_1
X_05321_ _05478_/A _05330_/A _05321_/B _05330_/C VPWR VGND sg13cmos5l_nand3_1
X_05252_ _05252_/Y _05221_/Y _05256_/S _08997_/B VPWR VGND sg13cmos5l_o21ai_1
X_08040_ _08208_/A _08009_/Y _08037_/Y _08039_/Y VPWR VGND sg13cmos5l_o21ai_1
Xhold903 hold903/X hold903/A VPWR VGND sg13cmos5l_dlygate4sd3_1
X_05183_ _05183_/Y _08937_/A _08937_/B _05183_/C _05183_/D VPWR VGND sg13cmos5l_nand4_1
Xhold914 hold914/X hold914/A VPWR VGND sg13cmos5l_dlygate4sd3_1
Xhold925 hold925/X hold925/A VPWR VGND sg13cmos5l_dlygate4sd3_1
Xhold936 hold936/X hold936/A VPWR VGND sg13cmos5l_dlygate4sd3_1
Xhold958 hold958/X hold958/A VPWR VGND sg13cmos5l_dlygate4sd3_1
Xhold969 hold969/X hold969/A VPWR VGND sg13cmos5l_dlygate4sd3_1
Xhold947 hold947/X hold947/A VPWR VGND sg13cmos5l_dlygate4sd3_1
X_08942_ _09301_/D _08942_/A _08942_/B VPWR VGND sg13cmos5l_nor2_1
X_09026__456 _09026_/RESET_B VPWR VGND sg13cmos5l_tiehi
X_08873_ _08873_/Y _08909_/A _08873_/B VPWR VGND sg13cmos5l_nor2_1
X_07824_ _07825_/B _07924_/C _07924_/D VPWR VGND sg13cmos5l_nand2_1
X_07755_ _07781_/B _07752_/Y _07754_/Y _07734_/Y VPWR VGND sg13cmos5l_a21oi_1
X_04967_ _04967_/Y _04967_/A VPWR VGND sg13cmos5l_inv_1
X_07686_ _07690_/A _07518_/B _07699_/B _07682_/Y _07663_/A _07684_/Y VPWR VGND sg13cmos5l_a221oi_1
X_06706_ _06724_/A _04969_/Y _06689_/Y _06705_/Y VPWR VGND sg13cmos5l_a21oi_1
X_04898_ _08145_/A _04898_/A VPWR VGND sg13cmos5l_inv_1
X_09425_ hold960/A clkload18/A hold931/X _09425_/RESET_B VPWR VGND sg13cmos5l_dfrbpq_1
X_06637_ _06656_/B _09491_/Q _09490_/Q _06648_/B VPWR VGND sg13cmos5l_or3_1
X_06568_ _06569_/C _09550_/Q _06566_/B _06612_/A VPWR VGND sg13cmos5l_a21oi_1
X_09356_ _09356_/Q clkload7/A _09356_/D _09356_/RESET_B VPWR VGND sg13cmos5l_dfrbpq_1
X_08307_ _08307_/Y _09178_/Q _09153_/Q VPWR VGND sg13cmos5l_nor2_1
X_05519_ _09359_/D _05519_/A _05519_/B VPWR VGND sg13cmos5l_nor2_1
X_09287_ _09287_/Q clkload8/A _09287_/D _09287_/RESET_B VPWR VGND sg13cmos5l_dfrbpq_1
X_06499_ _06515_/A _06518_/A _06499_/B VPWR VGND sg13cmos5l_nand2_1
X_08238_ _08675_/A _08240_/B _08238_/B VPWR VGND sg13cmos5l_nand2b_1
X_09033__449 _09033_/RESET_B VPWR VGND sg13cmos5l_tiehi
XFILLER_5_917 VPWR VGND sg13cmos5l_decap_4
X_08169_ _08170_/B _08169_/A hold1349/X VPWR VGND sg13cmos5l_nor2b_1
XFILLER_48_626 VPWR VGND sg13cmos5l_fill_1
XFILLER_8_700 VPWR VGND sg13cmos5l_fill_1
XFILLER_4_994 VPWR VGND sg13cmos5l_fill_2
XFILLER_39_615 VPWR VGND sg13cmos5l_fill_1
X_05870_ _05870_/Y _05964_/A _05867_/X _05891_/B _05869_/X VPWR VGND sg13cmos5l_a22oi_1
X_04821_ _04821_/Y hold953/X VPWR VGND sg13cmos5l_inv_1
XFILLER_47_670 VPWR VGND sg13cmos5l_fill_2
X_07540_ _07545_/A _07568_/A _07568_/B _07547_/A VPWR VGND sg13cmos5l_a21oi_1
XFILLER_34_342 VPWR VGND sg13cmos5l_fill_2
X_07471_ _07480_/B _09106_/Q _09105_/Q _09103_/Q _09104_/Q VPWR VGND sg13cmos5l_nor4_1
X_09210_ _09210_/Q _09312_/CLK _09210_/D _09210_/RESET_B VPWR VGND sg13cmos5l_dfrbpq_1
X_06422_ _06422_/Y _06742_/A _09459_/Q _09458_/Q _06741_/A _06421_/Y VPWR VGND sg13cmos5l_a221oi_1
X_06353_ _06355_/B _06337_/A _06337_/C _06365_/A VPWR VGND sg13cmos5l_a21o_1
X_09141_ _09141_/Q clkload14/A _09141_/D _09141_/RESET_B VPWR VGND sg13cmos5l_dfrbpq_1
X_05304_ _05304_/Y _05304_/A _05304_/B VPWR VGND sg13cmos5l_nor2_1
X_09072_ _09072_/Q clkload14/A _09072_/D _09072_/RESET_B VPWR VGND sg13cmos5l_dfrbpq_1
X_06284_ _06284_/Y _06259_/Y _06277_/Y _06283_/X VPWR VGND sg13cmos5l_o21ai_1
X_08023_ _08024_/B _08175_/A _08175_/B VPWR VGND sg13cmos5l_and2_1
X_05235_ _05235_/Y _05218_/A _05218_/B _05229_/X _05233_/Y _05234_/Y VPWR VGND sg13cmos5l_a221oi_1
X_05166_ _05166_/Y _05176_/B _05166_/B VPWR VGND sg13cmos5l_nand2_1
X_05097_ _05097_/Y _05094_/Y _05132_/B _05096_/Y _09322_/Q VPWR VGND sg13cmos5l_a22oi_1
Xhold1400 _07122_/A _09009_/Q VPWR VGND sg13cmos5l_dlygate4sd3_1
X_08925_ _09286_/D _08930_/A _08925_/B VPWR VGND sg13cmos5l_nor2_1
Xhold1422 hold1422/X _09329_/Q VPWR VGND sg13cmos5l_dlygate4sd3_1
Xhold1411 _08051_/B _09116_/Q VPWR VGND sg13cmos5l_dlygate4sd3_1
X_08856_ _08858_/A _09281_/Q _08863_/B _08907_/A VPWR VGND sg13cmos5l_a21o_1
X_07807_ _07807_/Y _07497_/Y _07829_/B _07806_/X _07500_/Y VPWR VGND sg13cmos5l_a22oi_1
XFILLER_29_169 VPWR VGND sg13cmos5l_fill_1
X_05999_ _05999_/Y _06004_/A _05902_/B _06025_/A _05855_/X VPWR VGND sg13cmos5l_a22oi_1
X_08787_ _08788_/C _08997_/A _09014_/Q VPWR VGND sg13cmos5l_nor2b_1
X_07738_ _07738_/Y _07746_/B _07743_/C _08056_/A VPWR VGND sg13cmos5l_a21oi_1
X_07669_ _07669_/Y _07677_/A _07573_/B _07668_/Y VPWR VGND sg13cmos5l_o21ai_1
X_09408_ _09408_/Q clkload19/A _09408_/D _09408_/RESET_B VPWR VGND sg13cmos5l_dfrbpq_1
X_09217__250 _09217_/RESET_B VPWR VGND sg13cmos5l_tiehi
XFILLER_25_397 VPWR VGND sg13cmos5l_fill_2
X_09339_ _09339_/Q clkload11/A _09339_/D _09339_/RESET_B VPWR VGND sg13cmos5l_dfrbpq_1
X_09588__498 _09588_/RESET_B VPWR VGND sg13cmos5l_tiehi
XFILLER_1_920 VPWR VGND sg13cmos5l_decap_8
XFILLER_1_931 VPWR VGND sg13cmos5l_fill_2
X_09224__243 _09224_/RESET_B VPWR VGND sg13cmos5l_tiehi
XFILLER_49_924 VPWR VGND sg13cmos5l_decap_8
XFILLER_49_913 VPWR VGND sg13cmos5l_fill_2
X_09298__388 _09298_/RESET_B VPWR VGND sg13cmos5l_tiehi
XFILLER_32_824 VPWR VGND sg13cmos5l_fill_1
XFILLER_8_541 VPWR VGND sg13cmos5l_fill_1
X_05020_ _05021_/B _05020_/A _05020_/B VPWR VGND sg13cmos5l_and2_1
X_06971_ _09570_/D _06990_/B _06971_/B VPWR VGND sg13cmos5l_nor2_1
X_08710_ _08710_/Y _08710_/A _08710_/B _08710_/C VPWR VGND sg13cmos5l_nand3_1
X_05922_ _05922_/Y _09417_/Q _05920_/Y _09416_/Q VPWR VGND sg13cmos5l_o21ai_1
X_05853_ _05853_/Y _05853_/A _06139_/A VPWR VGND sg13cmos5l_nor2_1
X_08641_ _08641_/Y _08289_/B _08639_/Y _08640_/Y VPWR VGND sg13cmos5l_o21ai_1
X_09023__459 _09023_/RESET_B VPWR VGND sg13cmos5l_tiehi
XFILLER_48_990 VPWR VGND sg13cmos5l_decap_8
X_08572_ _08572_/Y _08572_/A _08572_/B VPWR VGND sg13cmos5l_nand2_1
X_05784_ _09402_/D _05784_/A _05784_/B VPWR VGND sg13cmos5l_nor2_1
X_07523_ _07524_/B _07668_/A _07668_/B VPWR VGND sg13cmos5l_and2_1
X_07454_ _07455_/C _07454_/A _07466_/B VPWR VGND sg13cmos5l_or2_1
XFILLER_22_334 VPWR VGND sg13cmos5l_fill_1
X_06405_ _09487_/D _06554_/A _06405_/B VPWR VGND sg13cmos5l_nor2_1
X_07385_ _09058_/D _07385_/A _07386_/B VPWR VGND sg13cmos5l_and2_1
X_06336_ _06362_/B _09482_/Q _06337_/A VPWR VGND sg13cmos5l_xnor2_1
X_09124_ _09124_/Q _09214_/CLK _09124_/D _09124_/RESET_B VPWR VGND sg13cmos5l_dfrbpq_1
X_06267_ _06268_/A _06090_/B _06256_/X _06266_/Y VPWR VGND sg13cmos5l_a21o_1
X_09055_ hold882/A _09575_/CLK _09055_/D _09055_/RESET_B VPWR VGND sg13cmos5l_dfrbpq_1
X_08006_ _08038_/B _09152_/Q _08007_/B VPWR VGND sg13cmos5l_xnor2_1
X_05218_ _05218_/Y _05218_/A _05218_/B VPWR VGND sg13cmos5l_nor2_1
XFILLER_9_8 VPWR VGND sg13cmos5l_fill_1
X_06198_ hold986/A _06417_/B fanout43/X _06197_/Y VPWR VGND sg13cmos5l_a21oi_1
X_05149_ _05152_/B _08997_/A _05149_/B VPWR VGND sg13cmos5l_nand2_1
X_08908_ _08911_/A _08908_/A _08908_/B VPWR VGND sg13cmos5l_nand2_1
Xhold1252 _08380_/B _08379_/Y VPWR VGND sg13cmos5l_dlygate4sd3_1
X_09594__491 _09594_/RESET_B VPWR VGND sg13cmos5l_tiehi
Xhold1230 _06749_/A _09545_/Q VPWR VGND sg13cmos5l_dlygate4sd3_1
Xhold1241 _06240_/A _09467_/Q VPWR VGND sg13cmos5l_dlygate4sd3_1
Xhold1274 _05907_/B _05878_/B VPWR VGND sg13cmos5l_dlygate4sd3_1
Xhold1263 hold1263/X _07118_/Y VPWR VGND sg13cmos5l_dlygate4sd3_1
Xhold1285 hold1285/X _09607_/Q VPWR VGND sg13cmos5l_dlygate4sd3_1
X_08839_ _09278_/D _08839_/A _08930_/A VPWR VGND sg13cmos5l_nor2_1
XFILLER_45_459 VPWR VGND sg13cmos5l_decap_4
Xhold1296 hold1296/X _09606_/Q VPWR VGND sg13cmos5l_dlygate4sd3_1
XFILLER_13_334 VPWR VGND sg13cmos5l_fill_1
XFILLER_31_94 VPWR VGND sg13cmos5l_fill_1
X_09458__649 _09458_/RESET_B VPWR VGND sg13cmos5l_tiehi
XFILLER_36_415 VPWR VGND sg13cmos5l_fill_2
XFILLER_17_651 VPWR VGND sg13cmos5l_fill_1
XFILLER_17_673 VPWR VGND sg13cmos5l_fill_1
XFILLER_17_684 VPWR VGND sg13cmos5l_fill_1
X_07170_ _09010_/D _07197_/A _07216_/C VPWR VGND sg13cmos5l_nor2b_1
X_06121_ _06144_/A _06133_/A _06121_/B _06133_/B VPWR VGND sg13cmos5l_nand3_1
X_06052_ _06053_/B _09446_/Q _06062_/B VPWR VGND sg13cmos5l_nor2b_1
X_05003_ _05003_/Y _05003_/A VPWR VGND sg13cmos5l_inv_1
X_09207__260 _09207_/RESET_B VPWR VGND sg13cmos5l_tiehi
XFILLER_39_231 VPWR VGND sg13cmos5l_fill_1
X_06954_ _06954_/Y _09533_/Q _06957_/B VPWR VGND sg13cmos5l_nand2_1
X_05905_ _05905_/Y _06025_/A VPWR VGND sg13cmos5l_inv_1
XFILLER_39_275 VPWR VGND sg13cmos5l_fill_1
X_06885_ _06885_/Y _06881_/S _06883_/Y _06884_/Y VPWR VGND sg13cmos5l_a21oi_1
X_05836_ _09403_/D _05898_/A _05836_/B VPWR VGND sg13cmos5l_nor2_1
X_08624_ _08625_/B _08626_/B hold1334/X VPWR VGND sg13cmos5l_nor2b_1
X_08555_ _08555_/Y _08555_/A _08568_/B VPWR VGND sg13cmos5l_nor2_1
X_09097__379 _09097_/RESET_B VPWR VGND sg13cmos5l_tiehi
X_05767_ _05767_/Y _05780_/A _05762_/B _05766_/Y VPWR VGND sg13cmos5l_a21oi_1
X_07506_ _07506_/X _09076_/Q _07506_/B VPWR VGND sg13cmos5l_xor2_1
XFILLER_35_492 VPWR VGND sg13cmos5l_fill_1
X_08486_ _08486_/Y _09245_/Q _09222_/Q _08485_/X VPWR VGND sg13cmos5l_a21oi_1
X_05698_ _09393_/D _05698_/A _05784_/A VPWR VGND sg13cmos5l_nor2_1
X_07437_ _07438_/C _07437_/A _07437_/B _07437_/C VPWR VGND sg13cmos5l_and3_1
X_09214__253 _09214_/RESET_B VPWR VGND sg13cmos5l_tiehi
X_07368_ _07368_/Y _07349_/A _07367_/B _07367_/Y VPWR VGND sg13cmos5l_o21ai_1
XFILLER_6_319 VPWR VGND sg13cmos5l_fill_2
X_09107_ _09107_/Q clkload15/A _09107_/D _09107_/RESET_B VPWR VGND sg13cmos5l_dfrbpq_1
X_06319_ _06652_/B _06742_/A _06319_/B VPWR VGND sg13cmos5l_nand2_1
X_07299_ _07299_/Y _06880_/A _07324_/B _07298_/Y VPWR VGND sg13cmos5l_o21ai_1
X_09038_ _09038_/Q _09565_/CLK _09038_/D _09038_/RESET_B VPWR VGND sg13cmos5l_dfrbpq_1
XFILLER_2_547 VPWR VGND sg13cmos5l_fill_2
X_09221__246 _09221_/RESET_B VPWR VGND sg13cmos5l_tiehi
Xhold1060 _09305_/D _08982_/Y VPWR VGND sg13cmos5l_dlygate4sd3_1
Xhold1082 _09535_/D _06726_/Y VPWR VGND sg13cmos5l_dlygate4sd3_1
Xhold1093 _06716_/A _09531_/Q VPWR VGND sg13cmos5l_dlygate4sd3_1
Xhold1071 _05909_/A _09440_/Q VPWR VGND sg13cmos5l_dlygate4sd3_1
XFILLER_46_779 VPWR VGND sg13cmos5l_fill_2
XFILLER_27_993 VPWR VGND sg13cmos5l_fill_1
XFILLER_14_665 VPWR VGND sg13cmos5l_fill_2
X_09052__430 _09052_/RESET_B VPWR VGND sg13cmos5l_tiehi
XFILLER_9_179 VPWR VGND sg13cmos5l_fill_2
XFILLER_47_6 VPWR VGND sg13cmos5l_fill_1
XFILLER_49_595 VPWR VGND sg13cmos5l_fill_1
X_06670_ _06771_/C _06670_/A _06670_/B _06670_/C VPWR VGND sg13cmos5l_nand3_1
X_05621_ _05636_/S _05630_/A _05630_/C VPWR VGND sg13cmos5l_nand2_1
X_05552_ _05871_/A _09398_/Q _09399_/Q VPWR VGND sg13cmos5l_xnor2_1
X_08340_ _08340_/Y _08456_/A VPWR VGND sg13cmos5l_inv_1
X_05483_ _05508_/B _05481_/Y _05482_/Y _05473_/Y VPWR VGND sg13cmos5l_a21oi_1
X_08271_ _08293_/C _09190_/Q _08271_/B VPWR VGND sg13cmos5l_xor2_1
XFILLER_32_473 VPWR VGND sg13cmos5l_fill_1
X_07222_ _07222_/Y _07624_/B _07383_/A VPWR VGND sg13cmos5l_nand2b_1
X_07153_ _09006_/D _07197_/A _07153_/B VPWR VGND sg13cmos5l_nor2_1
X_09168__303 _09168_/RESET_B VPWR VGND sg13cmos5l_tiehi
X_06104_ _06104_/Y _06104_/A VPWR VGND sg13cmos5l_inv_1
X_07084_ _07086_/A _09602_/Q _07083_/Y _07079_/Y VPWR VGND sg13cmos5l_a21oi_1
X_06035_ _06035_/Y _06014_/A _06041_/S _05963_/B VPWR VGND sg13cmos5l_o21ai_1
Xfanout103 _05719_/B _05705_/Y VPWR VGND sg13cmos5l_buf_1
Xfanout114 _08599_/B _08478_/Y VPWR VGND sg13cmos5l_buf_1
Xfanout136 _07463_/A _07369_/A VPWR VGND sg13cmos5l_buf_1
Xfanout125 _08081_/A _08017_/Y VPWR VGND sg13cmos5l_buf_1
Xfanout147 _06818_/A _06627_/A VPWR VGND sg13cmos5l_buf_1
X_07986_ _07999_/C _09146_/Q _09147_/Q _09148_/Q _09149_/Q VPWR VGND sg13cmos5l_nor4_1
Xfanout169 _05423_/A _05263_/Y VPWR VGND sg13cmos5l_buf_1
Xfanout158 _06218_/B _06047_/Y VPWR VGND sg13cmos5l_buf_1
X_06937_ _06937_/Y _07386_/A _09531_/Q VPWR VGND sg13cmos5l_nand2b_1
X_06868_ _09555_/D _07070_/A _06868_/B VPWR VGND sg13cmos5l_nor2_1
X_08607_ _08607_/Y hold956/A _09207_/Q VPWR VGND sg13cmos5l_xnor2_1
XFILLER_42_204 VPWR VGND sg13cmos5l_fill_1
X_05819_ _06139_/A _06223_/A _05820_/B VPWR VGND sg13cmos5l_and2_1
X_09587_ _09587_/Q _09591_/CLK _09587_/D _09587_/RESET_B VPWR VGND sg13cmos5l_dfrbpq_1
X_06799_ _06799_/Y _06799_/A _06799_/B VPWR VGND sg13cmos5l_nor2_1
X_08538_ _08538_/Y _08538_/A _08538_/B VPWR VGND sg13cmos5l_nor2_1
XFILLER_24_974 VPWR VGND sg13cmos5l_fill_2
X_08469_ _09217_/D _08442_/B fanout21/X _08468_/Y VPWR VGND sg13cmos5l_a21oi_1
XFILLER_7_606 VPWR VGND sg13cmos5l_fill_1
X_09448__659 _09448_/RESET_B VPWR VGND sg13cmos5l_tiehi
XFILLER_12_96 VPWR VGND sg13cmos5l_fill_2
XFILLER_2_311 VPWR VGND sg13cmos5l_fill_1
X_09303__343 _09303_/RESET_B VPWR VGND sg13cmos5l_tiehi
XFILLER_46_510 VPWR VGND sg13cmos5l_decap_4
XFILLER_18_1013 VPWR VGND sg13cmos5l_fill_2
XFILLER_6_683 VPWR VGND sg13cmos5l_fill_1
X_07840_ _07840_/Y _08147_/A _09086_/Q _09085_/Q _08146_/A _07839_/Y VPWR VGND sg13cmos5l_a221oi_1
XFILLER_25_1028 VPWR VGND sg13cmos5l_fill_1
X_07771_ _07924_/A _07772_/B _07772_/C _07770_/Y VPWR VGND sg13cmos5l_a21o_1
X_09510_ _09510_/Q clkload22/A _09510_/D _09510_/RESET_B VPWR VGND sg13cmos5l_dfrbpq_1
X_04983_ _04983_/Y _05909_/B VPWR VGND sg13cmos5l_inv_1
X_06722_ _06722_/Y _06707_/B _06716_/B _06721_/Y VPWR VGND sg13cmos5l_a21oi_1
X_09441_ _09441_/Q clkload21/A _09441_/D _09441_/RESET_B VPWR VGND sg13cmos5l_dfrbpq_1
X_06653_ _06654_/B _09490_/Q _06648_/B hold1271/X VPWR VGND sg13cmos5l_o21ai_1
X_05604_ _05604_/X _09360_/Q _05604_/B VPWR VGND sg13cmos5l_or2_1
X_09372_ _09372_/Q clkload12/A _09372_/D _09372_/RESET_B VPWR VGND sg13cmos5l_dfrbpq_1
X_06584_ _06912_/A _06993_/A _06588_/B VPWR VGND sg13cmos5l_and2_1
X_05535_ _05537_/B _09370_/Q _05548_/B VPWR VGND sg13cmos5l_nor2b_1
X_08323_ _08334_/C _08316_/X _08319_/Y _08321_/Y VPWR VGND sg13cmos5l_a21o_1
X_08254_ _08254_/X _09185_/Q _08254_/B VPWR VGND sg13cmos5l_or2_1
XFILLER_20_454 VPWR VGND sg13cmos5l_fill_2
X_05466_ _05467_/C _05466_/A _05466_/B VPWR VGND sg13cmos5l_nor2_1
X_08185_ _08208_/B _08211_/A _08183_/B _08181_/Y _08184_/Y VPWR VGND sg13cmos5l_a22oi_1
X_09211__256 _09211_/RESET_B VPWR VGND sg13cmos5l_tiehi
X_07205_ _09022_/D _04938_/Y fanout54/X _07204_/Y VPWR VGND sg13cmos5l_a21oi_1
X_05397_ _05397_/Y _09345_/Q _05397_/B VPWR VGND sg13cmos5l_nand2_1
X_07136_ _07136_/Y _07163_/B _07136_/B VPWR VGND sg13cmos5l_nand2b_1
X_07067_ _07067_/Y _07049_/A _07069_/S _07071_/B1 VPWR VGND sg13cmos5l_o21ai_1
X_06018_ _06018_/Y _06012_/A _06012_/B _06020_/A _06020_/B VPWR VGND sg13cmos5l_a22oi_1
X_09042__440 _09042_/RESET_B VPWR VGND sg13cmos5l_tiehi
X_07969_ _09143_/D _07969_/A _07968_/Y VPWR VGND sg13cmos5l_nor2b_1
XFILLER_30_229 VPWR VGND sg13cmos5l_fill_2
XFILLER_19_554 VPWR VGND sg13cmos5l_fill_1
X_05320_ _09328_/D _05378_/A _05320_/B VPWR VGND sg13cmos5l_nor2_1
XFILLER_9_75 VPWR VGND sg13cmos5l_fill_2
XFILLER_30_752 VPWR VGND sg13cmos5l_fill_1
X_05251_ _09321_/D _05227_/X _05256_/S _05250_/Y VPWR VGND sg13cmos5l_a21oi_1
X_05182_ _08931_/A _05183_/C _05183_/D VPWR VGND sg13cmos5l_and2_1
Xhold904 hold904/X hold904/A VPWR VGND sg13cmos5l_dlygate4sd3_1
XFILLER_7_992 VPWR VGND sg13cmos5l_fill_2
XFILLER_7_981 VPWR VGND sg13cmos5l_fill_1
Xhold937 hold937/X hold937/A VPWR VGND sg13cmos5l_dlygate4sd3_1
Xhold926 hold926/X hold926/A VPWR VGND sg13cmos5l_dlygate4sd3_1
Xhold915 hold915/X hold915/A VPWR VGND sg13cmos5l_dlygate4sd3_1
XFILLER_43_0 VPWR VGND sg13cmos5l_fill_2
Xhold959 hold959/X hold959/A VPWR VGND sg13cmos5l_dlygate4sd3_1
Xhold948 hold948/X hold948/A VPWR VGND sg13cmos5l_dlygate4sd3_1
X_08941_ _09300_/D _08941_/A _08942_/B VPWR VGND sg13cmos5l_nor2_1
X_08872_ _08872_/X _08867_/Y _08869_/Y _08871_/Y VPWR VGND sg13cmos5l_a21o_1
X_07823_ _07924_/D _07812_/A _07812_/B _07519_/Y VPWR VGND sg13cmos5l_o21ai_1
X_09438__669 _09438_/RESET_B VPWR VGND sg13cmos5l_tiehi
X_07754_ _07754_/Y _07732_/Y _07733_/Y _07753_/Y VPWR VGND sg13cmos5l_a21oi_1
X_04966_ _04966_/Y _09533_/Q VPWR VGND sg13cmos5l_inv_1
X_07685_ _07685_/X _07518_/B _07699_/B _07684_/Y VPWR VGND sg13cmos5l_a21o_1
X_06705_ _06705_/Y _09553_/Q _06705_/B VPWR VGND sg13cmos5l_nor2_1
X_04897_ _08146_/A _04897_/A VPWR VGND sg13cmos5l_inv_1
X_09424_ hold947/A _09575_/CLK hold919/X _09424_/RESET_B VPWR VGND sg13cmos5l_dfrbpq_1
X_06636_ _06636_/Y _09491_/Q _09490_/Q _06648_/B VPWR VGND sg13cmos5l_nor3_1
X_06567_ _06612_/A _09517_/Q _09518_/Q VPWR VGND sg13cmos5l_xnor2_1
X_09355_ _09355_/Q clkload7/A _09355_/D _09355_/RESET_B VPWR VGND sg13cmos5l_dfrbpq_1
X_08306_ _08306_/Y _07991_/C _09154_/Q VPWR VGND sg13cmos5l_nand2b_1
X_05518_ _05519_/B _05493_/B _05515_/Y _05443_/B VPWR VGND sg13cmos5l_o21ai_1
X_09286_ _09286_/Q clkload8/A _09286_/D _09286_/RESET_B VPWR VGND sg13cmos5l_dfrbpq_1
X_06498_ _06499_/B _06498_/A _06498_/B VPWR VGND sg13cmos5l_xnor2_1
X_08237_ _08240_/B _09219_/Q _09220_/Q _09218_/Q _08278_/A VPWR VGND sg13cmos5l_nor4_1
X_05449_ _05487_/A hold982/A hold905/A VPWR VGND sg13cmos5l_nand2_1
Xclkbuf_3_0__f_clk clkbuf_leaf_2_clk/A clkbuf_0_clk/X VPWR VGND sg13cmos5l_buf_8
X_08168_ _08219_/A _08189_/B _08207_/B _08168_/C VPWR VGND sg13cmos5l_nor3_1
X_08099_ _08100_/A _08397_/A _09122_/Q _08111_/B VPWR VGND sg13cmos5l_mux2_1
X_07119_ _07138_/B _08841_/A _09028_/Q _07154_/A VPWR VGND sg13cmos5l_nor3_1
XFILLER_44_822 VPWR VGND sg13cmos5l_fill_2
XFILLER_28_384 VPWR VGND sg13cmos5l_fill_2
X_09409__237 _09409_/D VPWR VGND sg13cmos5l_tielo
XFILLER_4_951 VPWR VGND sg13cmos5l_fill_2
X_04820_ _04820_/Y hold900/X VPWR VGND sg13cmos5l_inv_1
XFILLER_46_192 VPWR VGND sg13cmos5l_fill_2
XFILLER_46_170 VPWR VGND sg13cmos5l_fill_1
X_07470_ _07496_/B _09105_/Q _09103_/Q _09104_/Q VPWR VGND sg13cmos5l_nor3_1
X_06421_ _06421_/Y _09515_/Q _06194_/A _04974_/Y _09514_/Q _06420_/Y VPWR VGND sg13cmos5l_a221oi_1
X_06352_ _09480_/D _06473_/B _06352_/B VPWR VGND sg13cmos5l_and2_1
X_09140_ _09140_/Q clkload6/A _09140_/D _09140_/RESET_B VPWR VGND sg13cmos5l_dfrbpq_1
X_05303_ _05303_/Y _05298_/X _05301_/X _05293_/Y VPWR VGND sg13cmos5l_o21ai_1
X_09071_ _09071_/Q _09573_/CLK _09071_/D _09071_/RESET_B VPWR VGND sg13cmos5l_dfrbpq_1
X_06283_ _06283_/X _06283_/A _06283_/B VPWR VGND sg13cmos5l_or2_1
X_08022_ _08175_/B _08009_/Y _08013_/Y _08021_/X VPWR VGND sg13cmos5l_o21ai_1
X_09032__450 _09032_/RESET_B VPWR VGND sg13cmos5l_tiehi
X_05234_ _05234_/Y _05234_/A _05234_/B VPWR VGND sg13cmos5l_nor2_1
X_05165_ _05166_/B _09262_/Q _05156_/B _05137_/A VPWR VGND sg13cmos5l_o21ai_1
X_05096_ _05096_/Y _09290_/Q _09289_/Q _09321_/Q VPWR VGND sg13cmos5l_nand3b_1
X_08924_ _08925_/B _08885_/B _08865_/Y _08924_/S VPWR VGND sg13cmos5l_mux2_1
Xhold1401 _06069_/A _09444_/Q VPWR VGND sg13cmos5l_dlygate4sd3_1
Xhold1412 _08077_/B _08076_/Y VPWR VGND sg13cmos5l_dlygate4sd3_1
Xhold1423 hold1423/X _09034_/Q VPWR VGND sg13cmos5l_dlygate4sd3_1
X_08855_ _08907_/A _08906_/B _08906_/C _08906_/A VPWR VGND sg13cmos5l_a21oi_1
X_07806_ _07806_/X _07818_/A _07806_/B VPWR VGND sg13cmos5l_and2_1
X_08786_ _09263_/D _08786_/A _09282_/D VPWR VGND sg13cmos5l_nor2b_1
X_05998_ _05998_/Y _05845_/Y _05898_/B _05997_/Y VPWR VGND sg13cmos5l_o21ai_1
X_07737_ _07772_/A _07746_/B _07743_/C VPWR VGND sg13cmos5l_nand2_1
XFILLER_26_833 VPWR VGND sg13cmos5l_fill_2
X_04949_ _07617_/A _07855_/A VPWR VGND sg13cmos5l_inv_1
X_07668_ _07668_/Y _07668_/A _07668_/B _07668_/C _07668_/D VPWR VGND sg13cmos5l_nand4_1
XFILLER_13_516 VPWR VGND sg13cmos5l_fill_2
X_09407_ _09407_/Q clkload20/A _09407_/D _09407_/RESET_B VPWR VGND sg13cmos5l_dfrbpq_1
X_07599_ _07599_/Y _07599_/A _07602_/B VPWR VGND sg13cmos5l_nand2_1
X_06619_ _06771_/B _06623_/A _06603_/B hold1344/X VPWR VGND sg13cmos5l_o21ai_1
X_09338_ _09338_/Q clkload11/A _09338_/D _09338_/RESET_B VPWR VGND sg13cmos5l_dfrbpq_1
X_09269_ _09269_/Q clkload7/A _09269_/D _09269_/RESET_B VPWR VGND sg13cmos5l_dfrbpq_1
XFILLER_5_737 VPWR VGND sg13cmos5l_fill_1
XFILLER_1_998 VPWR VGND sg13cmos5l_decap_8
XFILLER_31_335 VPWR VGND sg13cmos5l_fill_2
X_09317__684 _09317_/RESET_B VPWR VGND sg13cmos5l_tiehi
XFILLER_8_553 VPWR VGND sg13cmos5l_fill_1
X_09428__679 _09428_/RESET_B VPWR VGND sg13cmos5l_tiehi
X_09398__712 _09398_/RESET_B VPWR VGND sg13cmos5l_tiehi
XFILLER_4_792 VPWR VGND sg13cmos5l_fill_1
XFILLER_3_291 VPWR VGND sg13cmos5l_fill_2
X_06970_ _06970_/Y _06950_/Y _06974_/B _06969_/Y VPWR VGND sg13cmos5l_o21ai_1
X_05921_ _05940_/A _06218_/A hold1160/X _05933_/B VPWR VGND sg13cmos5l_mux2_1
X_05852_ _05852_/Y _05852_/A _05852_/B _05852_/C VPWR VGND sg13cmos5l_nor3_1
XFILLER_39_457 VPWR VGND sg13cmos5l_fill_2
X_08640_ _08640_/Y _08640_/A _08663_/A _08663_/B VPWR VGND sg13cmos5l_nand3_1
X_08571_ _08571_/Y _09232_/Q _08570_/Y _08566_/Y VPWR VGND sg13cmos5l_o21ai_1
X_05783_ _05784_/B _05783_/A _05783_/B VPWR VGND sg13cmos5l_nor2_1
X_07522_ _07522_/Y _07668_/A _07668_/B VPWR VGND sg13cmos5l_nand2_1
X_07453_ _07466_/C _07444_/Y _07449_/Y _07452_/Y VPWR VGND sg13cmos5l_o21ai_1
X_06404_ _06405_/B _06404_/A _06404_/B VPWR VGND sg13cmos5l_and2_1
X_09123_ _09123_/Q _09388_/CLK _09123_/D _09123_/RESET_B VPWR VGND sg13cmos5l_dfrbpq_1
X_07384_ _09057_/D _07384_/A hold876/X VPWR VGND sg13cmos5l_and2_1
X_06335_ _06361_/B _06335_/A _06334_/Y VPWR VGND sg13cmos5l_nor2b_1
X_06266_ _06266_/Y _06266_/A _06266_/B _06266_/C VPWR VGND sg13cmos5l_nor3_1
X_09054_ _09054_/Q clkload13/A _09054_/D _09054_/RESET_B VPWR VGND sg13cmos5l_dfrbpq_1
X_08005_ _08021_/B _09152_/Q _08007_/B VPWR VGND sg13cmos5l_xor2_1
X_05217_ _05218_/B _05217_/A VPWR VGND sg13cmos5l_inv_1
X_06197_ _06197_/Y _06175_/X fanout43/X _06218_/B VPWR VGND sg13cmos5l_o21ai_1
X_05148_ _05149_/B _09283_/Q _09258_/Q VPWR VGND sg13cmos5l_nor2_1
X_05079_ _05079_/Y _05237_/B _05078_/X VPWR VGND sg13cmos5l_nor2b_1
X_08907_ _08908_/B _08907_/A _08907_/B VPWR VGND sg13cmos5l_nor2_1
Xhold1220 hold1220/X _09179_/Q VPWR VGND sg13cmos5l_dlygate4sd3_1
X_08838_ _09276_/D _08838_/A hold892/X VPWR VGND sg13cmos5l_and2_1
Xhold1231 _06261_/A _09468_/Q VPWR VGND sg13cmos5l_dlygate4sd3_1
Xhold1242 hold1242/X _09277_/Q VPWR VGND sg13cmos5l_dlygate4sd3_1
Xhold1264 _09005_/B _07213_/B VPWR VGND sg13cmos5l_dlygate4sd3_1
Xhold1253 _06497_/A _09508_/Q VPWR VGND sg13cmos5l_dlygate4sd3_1
Xhold1275 hold1275/X _09529_/Q VPWR VGND sg13cmos5l_dlygate4sd3_1
X_08769_ _09253_/D _08783_/B _08769_/B VPWR VGND sg13cmos5l_nor2_1
Xhold1297 _04909_/A _09065_/Q VPWR VGND sg13cmos5l_dlygate4sd3_1
Xclkbuf_leaf_37_clk clkload5/A clkbuf_leaf_2_clk/A VPWR VGND sg13cmos5l_buf_8
Xhold1286 hold1286/X _05049_/Y VPWR VGND sg13cmos5l_dlygate4sd3_1
XFILLER_25_162 VPWR VGND sg13cmos5l_fill_1
XFILLER_41_644 VPWR VGND sg13cmos5l_fill_2
XFILLER_15_85 VPWR VGND sg13cmos5l_fill_1
XFILLER_48_232 VPWR VGND sg13cmos5l_fill_1
XFILLER_49_799 VPWR VGND sg13cmos5l_fill_1
XFILLER_49_788 VPWR VGND sg13cmos5l_fill_2
Xclkbuf_leaf_28_clk _09565_/CLK clkbuf_3_5__f_clk/X VPWR VGND sg13cmos5l_buf_8
X_06120_ _06148_/A _09414_/Q _09415_/Q _09413_/Q _06153_/A VPWR VGND sg13cmos5l_nor4_1
X_06051_ _06062_/B _09445_/Q _06064_/B VPWR VGND sg13cmos5l_nor2b_1
X_05002_ _08800_/A _09264_/Q VPWR VGND sg13cmos5l_inv_1
XFILLER_28_1026 VPWR VGND sg13cmos5l_fill_2
X_06953_ _06953_/X _06953_/A _06953_/B VPWR VGND sg13cmos5l_or2_1
X_05904_ _06025_/A _05591_/Y _05888_/X _05903_/X VPWR VGND sg13cmos5l_a21oi_1
X_06884_ _06884_/Y _06884_/A _06884_/B _06884_/C VPWR VGND sg13cmos5l_nor3_1
X_05835_ _05836_/B _05993_/A _05993_/B VPWR VGND sg13cmos5l_and2_1
X_08623_ _08623_/Y _08682_/B _08698_/B _08623_/C VPWR VGND sg13cmos5l_nor3_1
Xclkbuf_leaf_19_clk clkload22/A clkload1/A VPWR VGND sg13cmos5l_buf_8
X_08554_ _08572_/B _09250_/Q _04926_/Y _08552_/Y _08553_/Y VPWR VGND sg13cmos5l_a22oi_1
X_05766_ _05766_/Y _05783_/A _05768_/B VPWR VGND sg13cmos5l_nor2_1
X_07505_ _07521_/C _09076_/Q _07506_/B VPWR VGND sg13cmos5l_xnor2_1
X_09233__833 _09233_/RESET_B VPWR VGND sg13cmos5l_tiehi
X_08485_ _08485_/X _09222_/Q _09223_/Q VPWR VGND sg13cmos5l_xor2_1
X_05697_ _09392_/D _05697_/A _05784_/A VPWR VGND sg13cmos5l_nor2_1
X_07436_ _07436_/Y _07436_/A _07436_/B VPWR VGND sg13cmos5l_nor2_1
X_07367_ _07367_/Y _07367_/A _07367_/B VPWR VGND sg13cmos5l_nand2_1
X_09106_ _09106_/Q clkload15/A _09106_/D _09106_/RESET_B VPWR VGND sg13cmos5l_dfrbpq_1
X_06318_ _06656_/A _06742_/A _06319_/B VPWR VGND sg13cmos5l_and2_1
X_07298_ _07298_/Y _07298_/A _07320_/A _07320_/B VPWR VGND sg13cmos5l_nand3_1
X_09037_ _09037_/Q _09573_/CLK _09037_/D _09037_/RESET_B VPWR VGND sg13cmos5l_dfrbpq_1
X_06249_ _06249_/X _06096_/X _06151_/B _06248_/Y VPWR VGND sg13cmos5l_a21o_1
X_09457__650 _09457_/RESET_B VPWR VGND sg13cmos5l_tiehi
Xhold1050 _05656_/A _09399_/Q VPWR VGND sg13cmos5l_dlygate4sd3_1
Xhold1072 hold1072/X _09301_/Q VPWR VGND sg13cmos5l_dlygate4sd3_1
XFILLER_46_747 VPWR VGND sg13cmos5l_fill_2
Xhold1061 _07193_/A _09016_/Q VPWR VGND sg13cmos5l_dlygate4sd3_1
Xhold1083 _04999_/A _09268_/Q VPWR VGND sg13cmos5l_dlygate4sd3_1
Xhold1094 _08801_/A _09285_/Q VPWR VGND sg13cmos5l_dlygate4sd3_1
XFILLER_42_920 VPWR VGND sg13cmos5l_fill_1
X_09388__722 _09388_/RESET_B VPWR VGND sg13cmos5l_tiehi
X_09395__715 _09395_/RESET_B VPWR VGND sg13cmos5l_tiehi
XFILLER_49_574 VPWR VGND sg13cmos5l_decap_8
XFILLER_49_552 VPWR VGND sg13cmos5l_decap_4
XFILLER_3_1028 VPWR VGND sg13cmos5l_fill_1
X_05620_ _05630_/C _05614_/Y _05618_/Y _05619_/Y VPWR VGND sg13cmos5l_o21ai_1
X_09096__380 _09096_/RESET_B VPWR VGND sg13cmos5l_tiehi
X_05551_ _05557_/A _09397_/Q _09365_/Q _05575_/B _05964_/A VPWR VGND sg13cmos5l_a22oi_1
X_08270_ _08285_/C _09190_/Q _08271_/B VPWR VGND sg13cmos5l_xnor2_1
X_05482_ _05482_/Y _05504_/A _05383_/Y _05508_/A _05509_/A VPWR VGND sg13cmos5l_a22oi_1
X_07221_ _07221_/Y _08757_/A _07624_/B VPWR VGND sg13cmos5l_nor2_1
X_07152_ _07153_/B _04925_/Y _07149_/Y _07150_/Y _07164_/B VPWR VGND sg13cmos5l_a22oi_1
X_06103_ _06104_/A _06103_/A _06103_/B VPWR VGND sg13cmos5l_nor2_1
X_07083_ _07083_/Y _07083_/A _09593_/Q VPWR VGND sg13cmos5l_xnor2_1
Xclkbuf_leaf_8_clk _09288_/CLK clkbuf_leaf_9_clk/A VPWR VGND sg13cmos5l_buf_8
X_06034_ _06034_/Y _06030_/A _06045_/C _06034_/C VPWR VGND sg13cmos5l_nand3b_1
Xfanout104 _05722_/B _05705_/Y VPWR VGND sg13cmos5l_buf_1
Xfanout137 _07369_/A _07222_/Y VPWR VGND sg13cmos5l_buf_1
Xfanout126 _07875_/A _07879_/B1 VPWR VGND sg13cmos5l_buf_1
Xfanout115 _08723_/A _08478_/Y VPWR VGND sg13cmos5l_buf_1
Xfanout159 _05898_/A _06042_/A VPWR VGND sg13cmos5l_buf_1
X_07985_ _08315_/A _07992_/B _07985_/B VPWR VGND sg13cmos5l_nand2b_1
Xfanout148 _06742_/B _06608_/Y VPWR VGND sg13cmos5l_buf_1
X_06936_ _06936_/Y _06936_/A _06936_/B VPWR VGND sg13cmos5l_nand2_1
X_06867_ _06868_/B _07018_/A _07018_/B VPWR VGND sg13cmos5l_and2_1
X_05818_ _05818_/X _09408_/Q _05818_/B VPWR VGND sg13cmos5l_xor2_1
X_09591__495 _09591_/RESET_B VPWR VGND sg13cmos5l_tiehi
X_08606_ _08606_/Y _09237_/Q _09208_/Q VPWR VGND sg13cmos5l_xnor2_1
X_09586_ _09586_/Q _09586_/CLK _09586_/D _09586_/RESET_B VPWR VGND sg13cmos5l_dfrbpq_1
X_06798_ _06798_/Y _06798_/A _06798_/B _06798_/C VPWR VGND sg13cmos5l_nor3_1
X_05749_ _05749_/Y _05742_/A _05720_/Y _05760_/B _05574_/B _05746_/Y VPWR VGND sg13cmos5l_a221oi_1
X_08537_ _09225_/D _08599_/B _08537_/B VPWR VGND sg13cmos5l_and2_1
X_08468_ _08468_/Y _08442_/A fanout21/X _08474_/B1 VPWR VGND sg13cmos5l_o21ai_1
X_07419_ _07419_/Y _07419_/A _07419_/B _07419_/C _07419_/D VPWR VGND sg13cmos5l_nand4_1
XFILLER_10_157 VPWR VGND sg13cmos5l_fill_1
XFILLER_10_168 VPWR VGND sg13cmos5l_fill_1
X_08399_ _09213_/D _08399_/A _08400_/B VPWR VGND sg13cmos5l_nor2_1
XFILLER_46_599 VPWR VGND sg13cmos5l_fill_2
XFILLER_49_360 VPWR VGND sg13cmos5l_fill_1
X_07770_ _07770_/Y _07780_/A _08056_/A VPWR VGND sg13cmos5l_nand2_1
X_04982_ _04982_/Y _09418_/Q VPWR VGND sg13cmos5l_inv_1
X_06721_ _06721_/Y hold1186/X _06716_/B _06737_/B VPWR VGND sg13cmos5l_o21ai_1
X_09440_ _09440_/Q clkload19/A _09440_/D _09440_/RESET_B VPWR VGND sg13cmos5l_dfrbpq_1
XFILLER_18_780 VPWR VGND sg13cmos5l_fill_1
X_06652_ _06652_/Y _06680_/A _06652_/B VPWR VGND sg13cmos5l_nand2_1
X_09371_ _09371_/Q clkload11/A _09371_/D _09371_/RESET_B VPWR VGND sg13cmos5l_dfrbpq_1
X_05603_ _05604_/B _09359_/Q _09335_/Q _09334_/Q VPWR VGND sg13cmos5l_nor3_1
X_06583_ _06583_/Y _06569_/Y _06576_/Y _06582_/Y VPWR VGND sg13cmos5l_o21ai_1
X_05534_ _05548_/B _09369_/Q _05564_/B VPWR VGND sg13cmos5l_nor2b_1
X_08322_ _08322_/Y _08316_/X _08319_/Y _08321_/Y VPWR VGND sg13cmos5l_a21oi_1
X_08253_ _08280_/A _09184_/Q _08253_/B VPWR VGND sg13cmos5l_xnor2_1
X_07204_ _07204_/Y _07213_/A fanout54/X _08834_/B1 VPWR VGND sg13cmos5l_o21ai_1
X_05465_ _05503_/B _05510_/A _05510_/B VPWR VGND sg13cmos5l_and2_1
X_05396_ _05397_/B _05396_/A _09307_/Q VPWR VGND sg13cmos5l_nor2_1
X_08184_ _08184_/Y _08184_/A _08184_/B VPWR VGND sg13cmos5l_nor2_1
X_09447__660 _09447_/RESET_B VPWR VGND sg13cmos5l_tiehi
X_07135_ _07135_/Y _07123_/Y _07163_/B _07134_/Y VPWR VGND sg13cmos5l_a21oi_1
X_07066_ _09588_/D _07039_/X _07062_/Y _07065_/Y VPWR VGND sg13cmos5l_a21oi_1
X_06017_ _06020_/B _05846_/B _05898_/B _06025_/B VPWR VGND sg13cmos5l_mux2_1
X_07968_ _07968_/Y _07944_/B _07967_/B _07895_/B VPWR VGND sg13cmos5l_a21oi_1
X_06919_ _09562_/D _06988_/B _07018_/C _07018_/D VPWR VGND sg13cmos5l_and3_1
X_07899_ _07899_/Y _07897_/Y _07898_/Y _07932_/A VPWR VGND sg13cmos5l_a21oi_1
XFILLER_16_717 VPWR VGND sg13cmos5l_fill_1
X_09454__653 _09454_/RESET_B VPWR VGND sg13cmos5l_tiehi
X_09569_ _09569_/Q clkload13/A _09569_/D _09569_/RESET_B VPWR VGND sg13cmos5l_dfrbpq_1
XFILLER_48_1018 VPWR VGND sg13cmos5l_decap_8
X_09461__646 _09461_/RESET_B VPWR VGND sg13cmos5l_tiehi
XFILLER_3_0 VPWR VGND sg13cmos5l_fill_1
X_09392__718 _09392_/RESET_B VPWR VGND sg13cmos5l_tiehi
XFILLER_46_352 VPWR VGND sg13cmos5l_fill_1
X_09093__383 _09093_/RESET_B VPWR VGND sg13cmos5l_tiehi
X_05250_ _05250_/Y _05079_/Y _05256_/S _08997_/B VPWR VGND sg13cmos5l_o21ai_1
X_05181_ _05183_/D _05199_/B _05125_/B _05179_/Y VPWR VGND sg13cmos5l_a21o_1
Xhold916 hold916/X hold916/A VPWR VGND sg13cmos5l_dlygate4sd3_1
Xhold927 hold927/X hold927/A VPWR VGND sg13cmos5l_dlygate4sd3_1
Xhold905 hold905/X hold905/A VPWR VGND sg13cmos5l_dlygate4sd3_1
Xhold949 hold949/X hold949/A VPWR VGND sg13cmos5l_dlygate4sd3_1
Xhold938 hold938/X hold938/A VPWR VGND sg13cmos5l_dlygate4sd3_1
X_08940_ _09299_/D _08940_/A _08942_/B VPWR VGND sg13cmos5l_nor2_1
X_08871_ _08871_/Y _08882_/A _08772_/A _08870_/Y VPWR VGND sg13cmos5l_o21ai_1
XFILLER_36_0 VPWR VGND sg13cmos5l_fill_1
X_07822_ _07924_/C _07822_/A _07822_/B _07829_/C VPWR VGND sg13cmos5l_nand3_1
X_04965_ _04965_/Y hold961/X VPWR VGND sg13cmos5l_inv_1
X_07753_ _07753_/Y _07781_/A _07753_/B VPWR VGND sg13cmos5l_nor2_1
X_04896_ _08148_/A _04896_/A VPWR VGND sg13cmos5l_inv_1
X_07684_ _07684_/Y _07665_/C _07665_/D _07671_/Y _07673_/Y _07674_/X VPWR VGND sg13cmos5l_a221oi_1
X_06704_ _06704_/Y _04967_/Y _06698_/A _06703_/A _04966_/Y VPWR VGND sg13cmos5l_a22oi_1
X_09423_ _09423_/Q _09575_/CLK hold929/X _09423_/RESET_B VPWR VGND sg13cmos5l_dfrbpq_1
X_06635_ _06648_/B _09488_/Q _09489_/Q _09486_/Q _09487_/Q VPWR VGND sg13cmos5l_or4_1
X_09354_ _09354_/Q _09387_/CLK _09354_/D _09354_/RESET_B VPWR VGND sg13cmos5l_dfrbpq_1
X_08305_ _08305_/X _08334_/A _08334_/B _08311_/A VPWR VGND sg13cmos5l_a21o_1
X_06566_ _06569_/B _09550_/Q _06566_/B VPWR VGND sg13cmos5l_nor2_1
X_05517_ _05519_/A _05517_/A _05517_/B VPWR VGND sg13cmos5l_nor2_1
X_09285_ _09285_/Q clkload8/A _09285_/D _09285_/RESET_B VPWR VGND sg13cmos5l_dfrbpq_1
X_06497_ _06498_/B _06497_/A _06541_/A VPWR VGND sg13cmos5l_xnor2_1
X_05448_ _09358_/D _05448_/A _05448_/B VPWR VGND sg13cmos5l_nor2_1
X_08236_ _08263_/B _09219_/Q _09218_/Q _08278_/A VPWR VGND sg13cmos5l_nor3_1
X_08167_ _08168_/C _08167_/A _08171_/B VPWR VGND sg13cmos5l_nor2_1
X_05379_ _05379_/Y _05379_/A _05379_/B _05379_/C VPWR VGND sg13cmos5l_nor3_1
X_07118_ _07118_/Y _07118_/A _07118_/B VPWR VGND sg13cmos5l_xnor2_1
X_08098_ _08116_/B _09183_/Q _08098_/B VPWR VGND sg13cmos5l_nor2_1
X_07049_ _07049_/Y _07049_/A _07049_/B VPWR VGND sg13cmos5l_nor2_1
XFILLER_43_333 VPWR VGND sg13cmos5l_decap_8
XFILLER_43_322 VPWR VGND sg13cmos5l_fill_1
XFILLER_7_212 VPWR VGND sg13cmos5l_fill_2
XFILLER_4_996 VPWR VGND sg13cmos5l_fill_1
XFILLER_47_672 VPWR VGND sg13cmos5l_fill_1
X_09437__670 _09437_/RESET_B VPWR VGND sg13cmos5l_tiehi
X_06420_ _06420_/Y _06740_/A _09457_/Q _09456_/Q _06739_/A _06419_/Y VPWR VGND sg13cmos5l_a221oi_1
XFILLER_34_344 VPWR VGND sg13cmos5l_fill_1
X_06351_ _06352_/B _06367_/S _06350_/Y _06349_/Y VPWR VGND sg13cmos5l_a21o_1
X_06282_ _06283_/B _06162_/X _06281_/B _06281_/Y VPWR VGND sg13cmos5l_a21oi_1
X_05302_ _05302_/Y _05330_/B _05617_/A _05304_/A _05304_/B VPWR VGND sg13cmos5l_a22oi_1
X_09070_ _09070_/Q _09573_/CLK _09070_/D _09070_/RESET_B VPWR VGND sg13cmos5l_dfrbpq_1
X_08021_ _08021_/X _08021_/A _08021_/B VPWR VGND sg13cmos5l_and2_1
X_05233_ _05233_/Y _05221_/Y _05225_/Y _05234_/A _05234_/B VPWR VGND sg13cmos5l_a22oi_1
X_09444__663 _09444_/RESET_B VPWR VGND sg13cmos5l_tiehi
X_05164_ _05164_/Y _08746_/A VPWR VGND sg13cmos5l_inv_1
X_05095_ _05132_/B _09289_/Q _09290_/Q VPWR VGND sg13cmos5l_xnor2_1
X_08923_ _09285_/D _08930_/A _08923_/B VPWR VGND sg13cmos5l_nor2_1
Xhold1424 hold1424/X _09291_/Q VPWR VGND sg13cmos5l_dlygate4sd3_1
Xhold1402 _05792_/A _09409_/Q VPWR VGND sg13cmos5l_dlygate4sd3_1
Xhold1413 _05455_/A _09355_/Q VPWR VGND sg13cmos5l_dlygate4sd3_1
X_08854_ _08906_/C _09280_/Q _08863_/B _08864_/A VPWR VGND sg13cmos5l_o21ai_1
X_05997_ _05997_/Y _05997_/A _05997_/B _05997_/C _05997_/D VPWR VGND sg13cmos5l_nand4_1
X_07805_ _07806_/B _09081_/Q _07802_/B _07790_/A VPWR VGND sg13cmos5l_o21ai_1
X_08785_ _09282_/D _08785_/A _08930_/A VPWR VGND sg13cmos5l_nor2_1
X_07736_ _07743_/C _09109_/Q _09108_/Q _09110_/Q VPWR VGND sg13cmos5l_o21ai_1
X_04948_ _07607_/A _04948_/A VPWR VGND sg13cmos5l_inv_1
XFILLER_26_823 VPWR VGND sg13cmos5l_fill_1
X_09451__656 _09451_/RESET_B VPWR VGND sg13cmos5l_tiehi
X_07667_ _07667_/Y _07522_/Y _07570_/B _07664_/Y _07665_/Y _07666_/Y VPWR VGND sg13cmos5l_a221oi_1
X_04879_ _07209_/B input6/X VPWR VGND sg13cmos5l_inv_1
XFILLER_38_1028 VPWR VGND sg13cmos5l_fill_1
X_09406_ _09406_/Q clkload20/A _09406_/D _09406_/RESET_B VPWR VGND sg13cmos5l_dfrbpq_1
X_07598_ _07598_/Y _07587_/Y _07593_/Y _07597_/Y VPWR VGND sg13cmos5l_o21ai_1
XFILLER_25_399 VPWR VGND sg13cmos5l_fill_1
X_06618_ _06618_/Y _06574_/B _06564_/C _06629_/B VPWR VGND sg13cmos5l_a21oi_1
X_09337_ _09337_/Q clkload11/A _09337_/D _09337_/RESET_B VPWR VGND sg13cmos5l_dfrbpq_1
XFILLER_40_358 VPWR VGND sg13cmos5l_fill_2
X_06549_ _06549_/Y _06524_/Y _06557_/S _06558_/A VPWR VGND sg13cmos5l_o21ai_1
X_09268_ _09268_/Q clkload7/A _09268_/D _09268_/RESET_B VPWR VGND sg13cmos5l_dfrbpq_1
X_08219_ _08221_/A _08219_/A _08229_/B VPWR VGND sg13cmos5l_nor2_1
X_09199_ _09199_/Q clkload4/A _09199_/D _09199_/RESET_B VPWR VGND sg13cmos5l_dfrbpq_1
XFILLER_20_53 VPWR VGND sg13cmos5l_fill_1
XFILLER_20_86 VPWR VGND sg13cmos5l_fill_1
XFILLER_49_915 VPWR VGND sg13cmos5l_fill_1
XFILLER_1_977 VPWR VGND sg13cmos5l_decap_8
XFILLER_49_959 VPWR VGND sg13cmos5l_decap_8
XFILLER_0_498 VPWR VGND sg13cmos5l_fill_2
XFILLER_43_196 VPWR VGND sg13cmos5l_decap_4
X_05920_ _05920_/Y _05920_/A VPWR VGND sg13cmos5l_inv_1
X_05851_ _09406_/D _05997_/A _05997_/B _05898_/A VPWR VGND sg13cmos5l_a21oi_1
X_08570_ _08570_/Y _08570_/A VPWR VGND sg13cmos5l_inv_1
X_07521_ _07668_/B _07521_/A _07521_/B _07521_/C VPWR VGND sg13cmos5l_nand3_1
X_05782_ _05783_/B _05759_/A _05721_/Y _05763_/Y _05767_/Y _05768_/B VPWR VGND sg13cmos5l_a221oi_1
X_07452_ _07452_/Y _07449_/A _07449_/B _07454_/A _07466_/B VPWR VGND sg13cmos5l_a22oi_1
X_06403_ _06404_/B _06409_/A _06403_/B _06409_/C VPWR VGND sg13cmos5l_or3_1
X_07383_ _09056_/D _07383_/A hold902/X VPWR VGND sg13cmos5l_and2_1
X_09122_ _09122_/Q _09214_/CLK _09122_/D _09122_/RESET_B VPWR VGND sg13cmos5l_dfrbpq_1
X_06334_ _06334_/Y _09513_/Q _09512_/Q _09514_/Q VPWR VGND sg13cmos5l_o21ai_1
X_06265_ _06265_/X _06097_/B _06151_/B _06281_/B VPWR VGND sg13cmos5l_mux2_1
X_09053_ _09053_/Q clkload13/A _09053_/D _09053_/RESET_B VPWR VGND sg13cmos5l_dfrbpq_1
X_05216_ _05217_/A _08934_/A _08940_/A _05232_/S VPWR VGND sg13cmos5l_mux2_1
X_08004_ _08004_/Y _08004_/A _08004_/B VPWR VGND sg13cmos5l_nor2_1
X_06196_ _06196_/Y _06193_/Y _06195_/Y _06177_/Y VPWR VGND sg13cmos5l_o21ai_1
X_05147_ _05152_/A _05146_/A _05146_/B _05188_/A VPWR VGND sg13cmos5l_a21o_1
X_05078_ _05078_/X _05078_/A _05078_/B VPWR VGND sg13cmos5l_xor2_1
X_08906_ _08906_/Y _08906_/A _08906_/B _08906_/C VPWR VGND sg13cmos5l_nand3_1
Xhold1210 _07997_/B _09183_/Q VPWR VGND sg13cmos5l_dlygate4sd3_1
Xhold1243 _04959_/A _09572_/Q VPWR VGND sg13cmos5l_dlygate4sd3_1
Xhold1221 _04913_/A _09589_/Q VPWR VGND sg13cmos5l_dlygate4sd3_1
X_08837_ _09275_/D _08838_/A hold891/X VPWR VGND sg13cmos5l_and2_1
Xhold1232 _06262_/B _06261_/X VPWR VGND sg13cmos5l_dlygate4sd3_1
Xhold1276 _06933_/B _06910_/B VPWR VGND sg13cmos5l_dlygate4sd3_1
Xhold1265 hold1265/X _09604_/Q VPWR VGND sg13cmos5l_dlygate4sd3_1
Xhold1254 hold1254/X _09507_/Q VPWR VGND sg13cmos5l_dlygate4sd3_1
X_08768_ _08768_/Y _08870_/B _08870_/C VPWR VGND sg13cmos5l_nand2_1
Xhold1287 hold1287/X _09158_/Q VPWR VGND sg13cmos5l_dlygate4sd3_1
Xhold1298 _05986_/A _09429_/Q VPWR VGND sg13cmos5l_dlygate4sd3_1
X_07719_ _07719_/Y _07719_/A _07719_/B VPWR VGND sg13cmos5l_nand2_1
X_08699_ _08699_/Y _08699_/A _08699_/B VPWR VGND sg13cmos5l_nor2_1
XFILLER_15_20 VPWR VGND sg13cmos5l_fill_2
X_09314__825 _09314_/RESET_B VPWR VGND sg13cmos5l_tiehi
XFILLER_31_85 VPWR VGND sg13cmos5l_fill_2
X_09427__680 _09427_/RESET_B VPWR VGND sg13cmos5l_tiehi
XFILLER_36_439 VPWR VGND sg13cmos5l_fill_2
X_09022__461 _09022_/RESET_B VPWR VGND sg13cmos5l_tiehi
X_09434__673 _09434_/RESET_B VPWR VGND sg13cmos5l_tiehi
XFILLER_9_863 VPWR VGND sg13cmos5l_fill_2
XFILLER_9_896 VPWR VGND sg13cmos5l_fill_2
X_06050_ _06064_/B _09442_/Q _09441_/Q _09443_/Q _09444_/Q VPWR VGND sg13cmos5l_nor4_1
X_05001_ _05001_/Y _05001_/A VPWR VGND sg13cmos5l_inv_1
X_09441__666 _09441_/RESET_B VPWR VGND sg13cmos5l_tiehi
X_06952_ _06953_/B _04962_/Y _06945_/X _06951_/Y VPWR VGND sg13cmos5l_o21ai_1
.ends
