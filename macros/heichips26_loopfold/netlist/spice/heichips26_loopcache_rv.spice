* NGSPICE file created from heichips26_loopcache_rv.ext - technology: ihp-sg13cmos5l

* Black-box entry subcircuit for sg13cmos5l_fill_2 abstract view
.subckt sg13cmos5l_fill_2 VDD VSS
.ends

* Black-box entry subcircuit for sg13cmos5l_nor2_1 abstract view
.subckt sg13cmos5l_nor2_1 Y A B VDD VSS
.ends

* Black-box entry subcircuit for sg13cmos5l_tiehi abstract view
.subckt sg13cmos5l_tiehi L_HI VDD VSS
.ends

* Black-box entry subcircuit for sg13cmos5l_a21oi_1 abstract view
.subckt sg13cmos5l_a21oi_1 Y A1 A2 B1 VDD VSS
.ends

* Black-box entry subcircuit for sg13cmos5l_a21o_1 abstract view
.subckt sg13cmos5l_a21o_1 X A1 A2 B1 VDD VSS
.ends

* Black-box entry subcircuit for sg13cmos5l_inv_1 abstract view
.subckt sg13cmos5l_inv_1 Y A VDD VSS
.ends

* Black-box entry subcircuit for sg13cmos5l_nand3_1 abstract view
.subckt sg13cmos5l_nand3_1 Y A B C VDD VSS
.ends

* Black-box entry subcircuit for sg13cmos5l_nor3_1 abstract view
.subckt sg13cmos5l_nor3_1 Y A B C VDD VSS
.ends

* Black-box entry subcircuit for sg13cmos5l_or2_1 abstract view
.subckt sg13cmos5l_or2_1 X A B VDD VSS
.ends

* Black-box entry subcircuit for sg13cmos5l_fill_1 abstract view
.subckt sg13cmos5l_fill_1 VDD VSS
.ends

* Black-box entry subcircuit for sg13cmos5l_decap_8 abstract view
.subckt sg13cmos5l_decap_8 VDD VSS
.ends

* Black-box entry subcircuit for sg13cmos5l_buf_1 abstract view
.subckt sg13cmos5l_buf_1 X A VDD VSS
.ends

* Black-box entry subcircuit for sg13cmos5l_a22oi_1 abstract view
.subckt sg13cmos5l_a22oi_1 Y A1 A2 B1 B2 VDD VSS
.ends

* Black-box entry subcircuit for sg13cmos5l_dfrbpq_1 abstract view
.subckt sg13cmos5l_dfrbpq_1 Q CLK D RESET_B VDD VSS
.ends

* Black-box entry subcircuit for sg13cmos5l_o21ai_1 abstract view
.subckt sg13cmos5l_o21ai_1 Y A1 A2 B1 VDD VSS
.ends

* Black-box entry subcircuit for sg13cmos5l_nand2_1 abstract view
.subckt sg13cmos5l_nand2_1 Y A B VDD VSS
.ends

* Black-box entry subcircuit for sg13cmos5l_a221oi_1 abstract view
.subckt sg13cmos5l_a221oi_1 Y A1 A2 B1 B2 C1 VDD VSS
.ends

* Black-box entry subcircuit for sg13cmos5l_and2_1 abstract view
.subckt sg13cmos5l_and2_1 X A B VDD VSS
.ends

* Black-box entry subcircuit for sg13cmos5l_decap_4 abstract view
.subckt sg13cmos5l_decap_4 VDD VSS
.ends

* Black-box entry subcircuit for sg13cmos5l_mux2_1 abstract view
.subckt sg13cmos5l_mux2_1 X A0 A1 S VDD VSS
.ends

* Black-box entry subcircuit for sg13cmos5l_xnor2_1 abstract view
.subckt sg13cmos5l_xnor2_1 Y A B VDD VSS
.ends

* Black-box entry subcircuit for sg13cmos5l_nand2b_1 abstract view
.subckt sg13cmos5l_nand2b_1 Y A_N B VDD VSS
.ends

* Black-box entry subcircuit for sg13cmos5l_buf_8 abstract view
.subckt sg13cmos5l_buf_8 X A VDD VSS
.ends

* Black-box entry subcircuit for sg13cmos5l_mux4_1 abstract view
.subckt sg13cmos5l_mux4_1 X A0 A1 A2 A3 S0 S1 VDD VSS
.ends

* Black-box entry subcircuit for sg13cmos5l_nor2b_1 abstract view
.subckt sg13cmos5l_nor2b_1 Y A B_N VDD VSS
.ends

* Black-box entry subcircuit for sg13cmos5l_nor4_1 abstract view
.subckt sg13cmos5l_nor4_1 Y A B C D VDD VSS
.ends

* Black-box entry subcircuit for sg13cmos5l_dlygate4sd3_1 abstract view
.subckt sg13cmos5l_dlygate4sd3_1 X A VDD VSS
.ends

* Black-box entry subcircuit for sg13cmos5l_or3_1 abstract view
.subckt sg13cmos5l_or3_1 X A B C VDD VSS
.ends

* Black-box entry subcircuit for sg13cmos5l_and3_1 abstract view
.subckt sg13cmos5l_and3_1 X A B C VDD VSS
.ends

* Black-box entry subcircuit for sg13cmos5l_nand4_1 abstract view
.subckt sg13cmos5l_nand4_1 Y A B C D VDD VSS
.ends

* Black-box entry subcircuit for sg13cmos5l_antennanp abstract view
.subckt sg13cmos5l_antennanp A VDD VSS
.ends

* Black-box entry subcircuit for sg13cmos5l_xor2_1 abstract view
.subckt sg13cmos5l_xor2_1 X A B VDD VSS
.ends

* Black-box entry subcircuit for sg13cmos5l_nand3b_1 abstract view
.subckt sg13cmos5l_nand3b_1 Y A_N B C VDD VSS
.ends

* Black-box entry subcircuit for sg13cmos5l_or4_1 abstract view
.subckt sg13cmos5l_or4_1 X A B C D VDD VSS
.ends

* Black-box entry subcircuit for sg13cmos5l_inv_2 abstract view
.subckt sg13cmos5l_inv_2 Y A VDD VSS
.ends

* Black-box entry subcircuit for sg13cmos5l_inv_4 abstract view
.subckt sg13cmos5l_inv_4 Y A VDD VSS
.ends

* Black-box entry subcircuit for sg13cmos5l_and4_1 abstract view
.subckt sg13cmos5l_and4_1 X A B C D VDD VSS
.ends

* Black-box entry subcircuit for sg13cmos5l_inv_8 abstract view
.subckt sg13cmos5l_inv_8 Y A VDD VSS
.ends

* Black-box entry subcircuit for sg13cmos5l_inv_16 abstract view
.subckt sg13cmos5l_inv_16 Y A VDD VSS
.ends

.subckt heichips26_loopcache_rv VGND VPWR clk ena rst_n ui_in[0] ui_in[10] ui_in[11]
+ ui_in[12] ui_in[13] ui_in[14] ui_in[15] ui_in[1] ui_in[2] ui_in[3] ui_in[4] ui_in[5]
+ ui_in[6] ui_in[7] ui_in[8] ui_in[9] uio_in[0] uio_in[10] uio_in[11] uio_in[12] uio_in[13]
+ uio_in[14] uio_in[15] uio_in[1] uio_in[2] uio_in[3] uio_in[4] uio_in[5] uio_in[6]
+ uio_in[7] uio_in[8] uio_in[9] uio_oe[0] uio_oe[10] uio_oe[11] uio_oe[12] uio_oe[13]
+ uio_oe[14] uio_oe[15] uio_oe[1] uio_oe[2] uio_oe[3] uio_oe[4] uio_oe[5] uio_oe[6]
+ uio_oe[7] uio_oe[8] uio_oe[9] uio_out[0] uio_out[10] uio_out[11] uio_out[12] uio_out[13]
+ uio_out[14] uio_out[15] uio_out[1] uio_out[2] uio_out[3] uio_out[4] uio_out[5] uio_out[6]
+ uio_out[7] uio_out[8] uio_out[9] uo_out[0] uo_out[10] uo_out[11] uo_out[12] uo_out[13]
+ uo_out[14] uo_out[15] uo_out[1] uo_out[2] uo_out[3] uo_out[4] uo_out[5] uo_out[6]
+ uo_out[7] uo_out[8] uo_out[9]
XFILLER_100_149 VPWR VGND sg13cmos5l_fill_2
X_09671_ _09671_/Y _09671_/A _09671_/B VPWR VGND sg13cmos5l_nor2_1
X_13407__2015 _13407_/RESET_B VPWR VGND sg13cmos5l_tiehi
X_08622_ _08623_/B _08625_/A _07812_/Y _08621_/Y VPWR VGND sg13cmos5l_a21oi_1
X_08553_ _08558_/B _08542_/Y _08576_/B _08577_/A VPWR VGND sg13cmos5l_a21o_1
XFILLER_35_483 VPWR VGND sg13cmos5l_fill_2
XFILLER_36_995 VPWR VGND sg13cmos5l_fill_2
X_07504_ _14249_/D _10971_/A VPWR VGND sg13cmos5l_inv_1
X_08484_ _08484_/Y _08819_/A _08491_/C _08491_/D VPWR VGND sg13cmos5l_nand3_1
X_07435_ _07435_/Y _08964_/A _12963_/A _08964_/B VPWR VGND sg13cmos5l_nor3_1
XFILLER_22_166 VPWR VGND sg13cmos5l_fill_2
X_07366_ _07467_/C _07366_/A _07369_/B VPWR VGND sg13cmos5l_or2_1
X_07297_ _07297_/Y _07297_/A VPWR VGND sg13cmos5l_inv_1
X_09105_ _09105_/Y _11375_/A _09104_/Y _09106_/A2 VPWR VGND sg13cmos5l_a21oi_1
X_09036_ _09036_/Y _09034_/Y _09035_/Y _09075_/B1 VPWR VGND sg13cmos5l_a21oi_1
XFILLER_2_516 VPWR VGND sg13cmos5l_fill_2
XFILLER_104_433 VPWR VGND sg13cmos5l_fill_1
XFILLER_105_967 VPWR VGND sg13cmos5l_decap_8
X_09938_ _09938_/Y _09938_/A _09948_/B VPWR VGND sg13cmos5l_nor2_1
Xfanout842 _11821_/A _14352_/Q VPWR VGND sg13cmos5l_buf_1
Xfanout831 _11083_/B _11091_/B VPWR VGND sg13cmos5l_buf_1
Xfanout820 _11025_/A _14569_/Q VPWR VGND sg13cmos5l_buf_1
XFILLER_58_520 VPWR VGND sg13cmos5l_fill_2
XFILLER_86_840 VPWR VGND sg13cmos5l_decap_8
XFILLER_86_851 VPWR VGND sg13cmos5l_fill_1
Xfanout875 _11275_/A _11202_/A VPWR VGND sg13cmos5l_buf_1
Xfanout864 _08471_/A _08476_/A VPWR VGND sg13cmos5l_buf_1
Xfanout853 _10653_/A _14240_/Q VPWR VGND sg13cmos5l_buf_1
XFILLER_46_715 VPWR VGND sg13cmos5l_fill_2
X_09869_ _13701_/D _10326_/A1 _09882_/B _09868_/Y VPWR VGND sg13cmos5l_a21oi_1
Xfanout897 _09219_/A _14117_/Q VPWR VGND sg13cmos5l_buf_1
Xfanout886 _09304_/A _14128_/Q VPWR VGND sg13cmos5l_buf_1
XFILLER_100_694 VPWR VGND sg13cmos5l_decap_8
X_11900_ _11900_/Y _14354_/Q _13239_/Q _11876_/Y VPWR VGND sg13cmos5l_a21oi_1
X_12880_ _12880_/Y _14371_/Q _12405_/B fanout60/X _12879_/X VPWR VGND sg13cmos5l_a22oi_1
X_11831_ _11831_/Y _11827_/Y _11828_/Y _11829_/Y _11830_/Y VPWR VGND sg13cmos5l_a22oi_1
X_14550_ _14550_/Q clkload12/A _14550_/D fanout957/X VPWR VGND sg13cmos5l_dfrbpq_1
X_11762_ _11762_/Y _11793_/A1 _11758_/Y _11761_/Y VPWR VGND sg13cmos5l_o21ai_1
X_13501_ _13501_/Q clkload30/A _13501_/D _13501_/RESET_B VPWR VGND sg13cmos5l_dfrbpq_1
XFILLER_13_155 VPWR VGND sg13cmos5l_fill_1
X_10713_ _10713_/Y _10808_/S _10711_/Y _10712_/Y VPWR VGND sg13cmos5l_o21ai_1
X_11693_ _11693_/Y _13815_/Q _11697_/B VPWR VGND sg13cmos5l_nand2_1
X_14481_ _14481_/Q clkload10/A _14481_/D fanout977/X VPWR VGND sg13cmos5l_dfrbpq_1
X_10644_ _10648_/B _14078_/Q _14079_/Q _10647_/D VPWR VGND sg13cmos5l_nand3_1
X_14212__1265 _14212_/RESET_B VPWR VGND sg13cmos5l_tiehi
X_13432_ _13432_/Q _14105_/CLK _13432_/D _13432_/RESET_B VPWR VGND sg13cmos5l_dfrbpq_1
X_10575_ _14047_/D _10575_/A1 _10594_/B _10574_/Y VPWR VGND sg13cmos5l_o21ai_1
X_13363_ _13363_/Q _14292_/CLK _13363_/D _13363_/RESET_B VPWR VGND sg13cmos5l_dfrbpq_1
XFILLER_6_833 VPWR VGND sg13cmos5l_fill_1
X_12314_ _12314_/Y _12310_/Y _12311_/Y _12312_/Y _12313_/Y VPWR VGND sg13cmos5l_a22oi_1
X_13294_ _13294_/Q clkload11/A _13294_/D fanout963/X VPWR VGND sg13cmos5l_dfrbpq_1
X_12245_ _12245_/Y _12232_/Y _12233_/Y _12234_/Y _12245_/B2 _12378_/B1 VPWR VGND sg13cmos5l_a221oi_1
X_12176_ _12176_/Y _12176_/A _12176_/B _12176_/C VPWR VGND sg13cmos5l_nand3_1
XFILLER_96_615 VPWR VGND sg13cmos5l_fill_1
X_11127_ _14299_/D _11135_/B _11125_/Y _11126_/Y VPWR VGND sg13cmos5l_a21oi_1
XFILLER_1_582 VPWR VGND sg13cmos5l_fill_2
X_13471__1951 _13471_/RESET_B VPWR VGND sg13cmos5l_tiehi
X_11058_ _11058_/X _14374_/Q _11083_/B VPWR VGND sg13cmos5l_and2_1
XFILLER_37_726 VPWR VGND sg13cmos5l_fill_2
XFILLER_49_586 VPWR VGND sg13cmos5l_decap_8
XFILLER_92_821 VPWR VGND sg13cmos5l_fill_1
XFILLER_92_832 VPWR VGND sg13cmos5l_decap_4
X_10009_ _10009_/Y _10009_/A _10009_/B VPWR VGND sg13cmos5l_nand2_1
XFILLER_92_887 VPWR VGND sg13cmos5l_decap_8
XFILLER_64_589 VPWR VGND sg13cmos5l_fill_1
XFILLER_33_954 VPWR VGND sg13cmos5l_fill_1
X_07220_ _07656_/B _12187_/A VPWR VGND sg13cmos5l_inv_1
XFILLER_66_0 VPWR VGND sg13cmos5l_fill_1
X_13246__1018 _13246_/RESET_B VPWR VGND sg13cmos5l_tiehi
XFILLER_101_414 VPWR VGND sg13cmos5l_fill_2
Xfanout138 _10595_/A1 _09640_/Y VPWR VGND sg13cmos5l_buf_1
Xfanout127 _09366_/S _09368_/S VPWR VGND sg13cmos5l_buf_1
Xfanout116 _09474_/S _09443_/Y VPWR VGND sg13cmos5l_buf_1
Xfanout105 _07640_/B1 _07638_/Y VPWR VGND sg13cmos5l_buf_1
XFILLER_68_840 VPWR VGND sg13cmos5l_fill_2
X_07984_ _14255_/D _14255_/Q _12609_/B _08368_/S VPWR VGND sg13cmos5l_mux2_1
Xfanout149 _09030_/B _09032_/S VPWR VGND sg13cmos5l_buf_1
XFILLER_68_873 VPWR VGND sg13cmos5l_fill_1
XFILLER_86_158 VPWR VGND sg13cmos5l_fill_2
X_09723_ _13630_/D _10377_/A1 _09760_/B _09722_/Y VPWR VGND sg13cmos5l_a21oi_1
XFILLER_55_534 VPWR VGND sg13cmos5l_decap_4
XFILLER_67_372 VPWR VGND sg13cmos5l_decap_8
X_09654_ _13611_/D _09655_/B _10599_/A1 _09653_/Y VPWR VGND sg13cmos5l_a21oi_1
X_08605_ _14609_/D _08893_/A _08605_/B VPWR VGND sg13cmos5l_xnor2_1
XFILLER_70_537 VPWR VGND sg13cmos5l_decap_8
X_09585_ _09585_/Y _09585_/A _09587_/B VPWR VGND sg13cmos5l_nor2_1
X_13646__1745 _13646_/RESET_B VPWR VGND sg13cmos5l_tiehi
XFILLER_70_548 VPWR VGND sg13cmos5l_fill_1
X_08536_ _08536_/Y _08536_/A _08852_/A _08536_/C VPWR VGND sg13cmos5l_nor3_1
X_08467_ _08467_/Y _07716_/A _08466_/Y _08471_/A VPWR VGND sg13cmos5l_a21oi_1
X_07418_ _07418_/Y _07344_/Y _12997_/B hold2231/X VPWR VGND sg13cmos5l_a21oi_1
X_08398_ _08398_/X _13520_/Q _13488_/Q _08398_/S VPWR VGND sg13cmos5l_mux2_1
XFILLER_7_619 VPWR VGND sg13cmos5l_fill_2
X_07349_ _07389_/B _13329_/Q _13328_/Q _13327_/Q VPWR VGND sg13cmos5l_nor3_1
X_14026__1365 _14026_/RESET_B VPWR VGND sg13cmos5l_tiehi
X_13861__1530 _13861_/RESET_B VPWR VGND sg13cmos5l_tiehi
XFILLER_12_54 VPWR VGND sg13cmos5l_fill_1
X_10360_ _10360_/Y _10360_/A _10374_/B VPWR VGND sg13cmos5l_nor2_1
X_09019_ _13291_/D _09033_/S _08961_/Y _09018_/Y VPWR VGND sg13cmos5l_o21ai_1
X_10291_ _10291_/Y _10291_/A _10295_/B VPWR VGND sg13cmos5l_nor2_1
XFILLER_105_753 VPWR VGND sg13cmos5l_fill_1
XFILLER_5_4 VPWR VGND sg13cmos5l_fill_1
X_12030_ _12033_/A _13859_/Q _12030_/B VPWR VGND sg13cmos5l_nand2_1
X_13894__1497 _13894_/RESET_B VPWR VGND sg13cmos5l_tiehi
XFILLER_59_840 VPWR VGND sg13cmos5l_fill_1
Xfanout650 _11093_/B _11146_/B1 VPWR VGND sg13cmos5l_buf_1
XFILLER_59_851 VPWR VGND sg13cmos5l_decap_8
Xfanout694 _09135_/B1 _11029_/B VPWR VGND sg13cmos5l_buf_1
Xfanout683 _11408_/A _11482_/A VPWR VGND sg13cmos5l_buf_1
Xfanout672 _08943_/A2 _08914_/Y VPWR VGND sg13cmos5l_buf_1
Xfanout661 _08938_/B1 _08923_/X VPWR VGND sg13cmos5l_buf_1
X_13981_ _13981_/Q _14045_/CLK _13981_/D _13981_/RESET_B VPWR VGND sg13cmos5l_dfrbpq_1
XFILLER_101_992 VPWR VGND sg13cmos5l_decap_8
X_12932_ _14453_/D _12932_/A VPWR VGND sg13cmos5l_inv_1
XFILLER_37_84 VPWR VGND sg13cmos5l_fill_2
XFILLER_46_545 VPWR VGND sg13cmos5l_decap_8
XFILLER_85_191 VPWR VGND sg13cmos5l_fill_1
X_14602_ _14602_/Q clkload76/A _14602_/D _14602_/RESET_B VPWR VGND sg13cmos5l_dfrbpq_1
X_12863_ _12864_/C _12863_/A _12863_/B VPWR VGND sg13cmos5l_nor2_1
XFILLER_15_943 VPWR VGND sg13cmos5l_fill_1
X_11814_ _11814_/Y _11837_/C1 _11806_/Y _11810_/Y _11813_/Y VPWR VGND sg13cmos5l_a22oi_1
X_12794_ _12794_/Y _12806_/A _12792_/Y _12793_/X fanout59/X VPWR VGND sg13cmos5l_a22oi_1
X_11745_ _11747_/B _13913_/Q _11939_/B VPWR VGND sg13cmos5l_nand2_1
X_14533_ _14533_/Q clkload14/A _14533_/D fanout973/X VPWR VGND sg13cmos5l_dfrbpq_1
XFILLER_41_283 VPWR VGND sg13cmos5l_fill_2
X_14464_ _14464_/Q clkload79/A _14464_/D _14464_/RESET_B VPWR VGND sg13cmos5l_dfrbpq_1
X_11676_ _11676_/Y _08750_/Y _11793_/A1 _11675_/Y VPWR VGND sg13cmos5l_o21ai_1
X_13415_ _13415_/Q clkload28/A _13415_/D _13415_/RESET_B VPWR VGND sg13cmos5l_dfrbpq_1
XFILLER_10_681 VPWR VGND sg13cmos5l_fill_2
X_10627_ _10628_/B _14069_/Q _10626_/C _14070_/Q VPWR VGND sg13cmos5l_a21o_1
X_14395_ _14395_/Q clkload75/A _14395_/D _14395_/RESET_B VPWR VGND sg13cmos5l_dfrbpq_1
X_13489__1933 _13489_/RESET_B VPWR VGND sg13cmos5l_tiehi
X_10558_ _10558_/Y _10558_/A _10564_/B VPWR VGND sg13cmos5l_nand2_1
X_13346_ _13346_/Q clkload41/A _13346_/D _13346_/RESET_B VPWR VGND sg13cmos5l_dfrbpq_1
X_13277_ _13277_/Q clkload19/A _13277_/D fanout981/X VPWR VGND sg13cmos5l_dfrbpq_1
X_10489_ _10489_/Y _10489_/A _10501_/B VPWR VGND sg13cmos5l_nand2_1
X_12228_ _12228_/Y _13834_/Q _12237_/B _12238_/B1 VPWR VGND sg13cmos5l_a21oi_1
X_13724__1667 _13724_/RESET_B VPWR VGND sg13cmos5l_tiehi
X_12159_ _12161_/B _12160_/B _12216_/A VPWR VGND sg13cmos5l_nand2b_1
XFILLER_65_821 VPWR VGND sg13cmos5l_decap_8
XFILLER_77_681 VPWR VGND sg13cmos5l_decap_8
XFILLER_65_876 VPWR VGND sg13cmos5l_decap_4
XFILLER_80_802 VPWR VGND sg13cmos5l_fill_1
X_09370_ _13483_/D _08332_/A hold3121/X _09376_/S VPWR VGND sg13cmos5l_mux2_1
XFILLER_21_913 VPWR VGND sg13cmos5l_fill_1
X_08321_ _08321_/X _13514_/Q _13482_/Q _08390_/S VPWR VGND sg13cmos5l_mux2_1
X_08252_ _08252_/Y _08252_/A _08252_/B VPWR VGND sg13cmos5l_nand2_1
X_07203_ _13071_/B _14522_/Q VPWR VGND sg13cmos5l_inv_1
X_13357__2065 _13357_/RESET_B VPWR VGND sg13cmos5l_tiehi
X_08183_ _08186_/A _14075_/Q _08207_/A2 _11039_/B1 _14496_/Q VPWR VGND sg13cmos5l_a22oi_1
Xclkbuf_4_12_0_clk clkbuf_4_12_0_clk/X clkbuf_0_clk/X VPWR VGND sg13cmos5l_buf_8
XFILLER_106_539 VPWR VGND sg13cmos5l_fill_2
X_14626__2169 _14626_/RESET_B VPWR VGND sg13cmos5l_tiehi
X_14288__1220 _14288_/RESET_B VPWR VGND sg13cmos5l_tiehi
XFILLER_88_946 VPWR VGND sg13cmos5l_fill_2
XFILLER_88_968 VPWR VGND sg13cmos5l_decap_8
XFILLER_75_629 VPWR VGND sg13cmos5l_fill_2
X_07967_ _07967_/X _13566_/Q _13534_/Q _13502_/Q _13470_/Q _08378_/A1 _07194_/A VPWR
+ VGND sg13cmos5l_mux4_1
XFILLER_56_821 VPWR VGND sg13cmos5l_fill_2
X_09706_ _09706_/Y _09706_/A _09706_/B VPWR VGND sg13cmos5l_nor2_1
X_07898_ _11016_/B _07944_/A _07898_/B VPWR VGND sg13cmos5l_nand2b_1
X_13879__1512 _13879_/RESET_B VPWR VGND sg13cmos5l_tiehi
XFILLER_55_364 VPWR VGND sg13cmos5l_decap_8
XFILLER_55_386 VPWR VGND sg13cmos5l_fill_1
X_09637_ _09639_/B _14459_/Q _09638_/C _14460_/Q VPWR VGND sg13cmos5l_a21oi_1
X_13567__1855 _13567_/RESET_B VPWR VGND sg13cmos5l_tiehi
X_09568_ _11321_/B _14419_/Q _14638_/Q _09615_/S VPWR VGND sg13cmos5l_mux2_1
X_08519_ _08520_/B _07674_/A _07678_/Y _07675_/B VPWR VGND sg13cmos5l_o21ai_1
X_14390__1118 _14390_/RESET_B VPWR VGND sg13cmos5l_tiehi
X_09499_ _13588_/D _09511_/B _10357_/A1 _09498_/Y VPWR VGND sg13cmos5l_a21oi_1
X_11530_ _11531_/B _11530_/A _11530_/B VPWR VGND sg13cmos5l_nand2_1
XFILLER_8_928 VPWR VGND sg13cmos5l_decap_8
X_13802__1589 _13802_/RESET_B VPWR VGND sg13cmos5l_tiehi
XFILLER_7_427 VPWR VGND sg13cmos5l_fill_2
XFILLER_7_438 VPWR VGND sg13cmos5l_fill_1
X_11461_ _11461_/X _11460_/A _11460_/B _11614_/A VPWR VGND sg13cmos5l_a21o_1
X_10412_ _10412_/Y _10412_/A _10412_/B VPWR VGND sg13cmos5l_nor2_1
X_11392_ _11392_/X _11393_/B _11392_/B VPWR VGND sg13cmos5l_and2_1
X_14180_ _14180_/Q clkload40/A _14180_/D _14180_/RESET_B VPWR VGND sg13cmos5l_dfrbpq_1
X_13200_ _13200_/Q clkload13/A _13200_/D fanout957/X VPWR VGND sg13cmos5l_dfrbpq_1
X_10343_ _10343_/Y _10343_/A _10343_/B VPWR VGND sg13cmos5l_nor2_1
X_13131_ _14553_/D hold3513/X _08040_/B _13136_/S VPWR VGND sg13cmos5l_mux2_1
X_13402__2020 _13402_/RESET_B VPWR VGND sg13cmos5l_tiehi
XFILLER_105_561 VPWR VGND sg13cmos5l_fill_1
XFILLER_97_209 VPWR VGND sg13cmos5l_fill_1
X_10274_ _10274_/Y _10274_/A _10274_/B VPWR VGND sg13cmos5l_nor2_1
X_14448__1058 _14448_/RESET_B VPWR VGND sg13cmos5l_tiehi
X_13062_ _14516_/D _13062_/A _13063_/B VPWR VGND sg13cmos5l_nor2b_1
XFILLER_79_957 VPWR VGND sg13cmos5l_decap_4
X_12013_ _12013_/Y _11950_/A _12124_/A2 _12162_/B VPWR VGND sg13cmos5l_a21oi_1
XFILLER_94_916 VPWR VGND sg13cmos5l_decap_8
XFILLER_59_670 VPWR VGND sg13cmos5l_fill_2
XFILLER_59_681 VPWR VGND sg13cmos5l_decap_8
XFILLER_65_128 VPWR VGND sg13cmos5l_fill_2
XFILLER_93_426 VPWR VGND sg13cmos5l_fill_1
Xfanout491 _11944_/A1 _11730_/B1 VPWR VGND sg13cmos5l_buf_1
Xfanout480 _12174_/B _12297_/B1 VPWR VGND sg13cmos5l_buf_1
XFILLER_0_24 VPWR VGND sg13cmos5l_decap_8
X_13964_ _13964_/Q clkload61/A _13964_/D _13964_/RESET_B VPWR VGND sg13cmos5l_dfrbpq_1
X_13895_ _13895_/Q _14064_/CLK _13895_/D _13895_/RESET_B VPWR VGND sg13cmos5l_dfrbpq_1
X_12915_ _12916_/A _14445_/Q _11262_/B _11256_/D _12923_/B2 VPWR VGND sg13cmos5l_a22oi_1
XFILLER_46_386 VPWR VGND sg13cmos5l_fill_2
XFILLER_73_172 VPWR VGND sg13cmos5l_fill_1
X_12846_ _12866_/B _14461_/Q _13251_/Q _13252_/Q _14462_/Q VPWR VGND sg13cmos5l_a22oi_1
XFILLER_15_740 VPWR VGND sg13cmos5l_fill_2
XFILLER_62_879 VPWR VGND sg13cmos5l_decap_4
X_14366__1142 _14366_/RESET_B VPWR VGND sg13cmos5l_tiehi
X_14516_ _15895_/A _14520_/CLK _14516_/D fanout972/X VPWR VGND sg13cmos5l_dfrbpq_1
X_12777_ _12778_/B _12777_/A _12777_/B VPWR VGND sg13cmos5l_xnor2_1
XFILLER_30_754 VPWR VGND sg13cmos5l_fill_1
X_11728_ _11728_/Y _11728_/A _11728_/B _11728_/C _11728_/D VPWR VGND sg13cmos5l_nor4_1
X_11659_ _11659_/Y _11671_/A _11660_/B VPWR VGND sg13cmos5l_nor2_1
X_14447_ _14447_/Q clkload65/A _14447_/D _14447_/RESET_B VPWR VGND sg13cmos5l_dfrbpq_1
X_14087__1320 _14087_/RESET_B VPWR VGND sg13cmos5l_tiehi
X_14378_ _14378_/Q clkload24/A _14378_/D _14378_/RESET_B VPWR VGND sg13cmos5l_dfrbpq_1
X_13329_ _13329_/Q clkload73/A _13329_/D _13329_/RESET_B VPWR VGND sg13cmos5l_dfrbpq_1
XFILLER_6_493 VPWR VGND sg13cmos5l_decap_4
X_13957__1434 _13957_/RESET_B VPWR VGND sg13cmos5l_tiehi
Xhold3008 hold3008/X _13478_/Q VPWR VGND sg13cmos5l_dlygate4sd3_1
Xhold3019 hold3019/X _13381_/Q VPWR VGND sg13cmos5l_dlygate4sd3_1
XFILLER_9_1024 VPWR VGND sg13cmos5l_decap_4
X_08870_ _14645_/D _08870_/A _08870_/B _08870_/C VPWR VGND sg13cmos5l_nand3_1
Xhold2307 _13078_/A _14523_/Q VPWR VGND sg13cmos5l_dlygate4sd3_1
Xhold2318 _10757_/A _14146_/Q VPWR VGND sg13cmos5l_dlygate4sd3_1
XFILLER_29_0 VPWR VGND sg13cmos5l_fill_1
XFILLER_57_607 VPWR VGND sg13cmos5l_decap_4
XFILLER_69_456 VPWR VGND sg13cmos5l_fill_1
XFILLER_96_253 VPWR VGND sg13cmos5l_fill_2
XFILLER_96_264 VPWR VGND sg13cmos5l_fill_2
X_07821_ _07821_/Y _14404_/Q _12417_/A VPWR VGND sg13cmos5l_nor2_1
Xhold2329 _09975_/A _13753_/Q VPWR VGND sg13cmos5l_dlygate4sd3_1
X_07752_ _07752_/Y _14386_/Q _11901_/A VPWR VGND sg13cmos5l_nor2_1
X_14171__1306 _14171_/RESET_B VPWR VGND sg13cmos5l_tiehi
XFILLER_38_898 VPWR VGND sg13cmos5l_fill_1
XFILLER_93_993 VPWR VGND sg13cmos5l_fill_2
X_07683_ _08847_/A _07683_/A _07682_/Y VPWR VGND sg13cmos5l_nor2b_1
XFILLER_80_621 VPWR VGND sg13cmos5l_decap_8
X_09422_ _13533_/D _10690_/A1 hold3154/X _09438_/S VPWR VGND sg13cmos5l_mux2_1
X_09353_ _13466_/D _08170_/A hold3276/X _09366_/S VPWR VGND sg13cmos5l_mux2_1
X_08304_ _08304_/Y _11034_/A _11035_/A1 _08297_/Y _08299_/Y _08303_/Y VPWR VGND sg13cmos5l_a221oi_1
XFILLER_21_765 VPWR VGND sg13cmos5l_fill_2
X_09284_ _13408_/D _07985_/A hold3354/X _09295_/B VPWR VGND sg13cmos5l_mux2_1
X_08235_ _08235_/Y _08238_/S _07302_/Y _08165_/A VPWR VGND sg13cmos5l_a21oi_1
X_08166_ _08166_/Y _08165_/A _08163_/X _08165_/Y VPWR VGND sg13cmos5l_a21oi_1
X_08097_ _08097_/Y _08113_/A _09443_/A _13119_/B VPWR VGND sg13cmos5l_nand3_1
XFILLER_106_369 VPWR VGND sg13cmos5l_fill_2
XFILLER_88_743 VPWR VGND sg13cmos5l_decap_4
Xhold3531 hold3531/X _14344_/Q VPWR VGND sg13cmos5l_dlygate4sd3_1
Xhold3542 _13253_/D _08937_/Y VPWR VGND sg13cmos5l_dlygate4sd3_1
Xhold3520 hold3520/X _14543_/Q VPWR VGND sg13cmos5l_dlygate4sd3_1
XFILLER_102_542 VPWR VGND sg13cmos5l_fill_2
XFILLER_102_553 VPWR VGND sg13cmos5l_fill_2
XFILLER_87_231 VPWR VGND sg13cmos5l_fill_1
Xhold2830 _11103_/A _14293_/Q VPWR VGND sg13cmos5l_dlygate4sd3_1
Xhold2841 _09787_/A _13661_/Q VPWR VGND sg13cmos5l_dlygate4sd3_1
Xhold3553 hold3553/X _14460_/Q VPWR VGND sg13cmos5l_dlygate4sd3_1
Xhold3564 _13061_/A _15894_/A VPWR VGND sg13cmos5l_dlygate4sd3_1
X_14444__1064 _14444_/RESET_B VPWR VGND sg13cmos5l_tiehi
X_08999_ _09001_/C _08999_/A _08999_/B VPWR VGND sg13cmos5l_xnor2_1
Xhold2852 _10426_/A _13974_/Q VPWR VGND sg13cmos5l_dlygate4sd3_1
Xhold2863 _09493_/A _13587_/Q VPWR VGND sg13cmos5l_dlygate4sd3_1
Xhold2874 _13321_/D _09150_/Y VPWR VGND sg13cmos5l_dlygate4sd3_1
XFILLER_18_42 VPWR VGND sg13cmos5l_fill_2
Xhold2885 _09819_/A _13677_/Q VPWR VGND sg13cmos5l_dlygate4sd3_1
Xhold2896 _10311_/A _13918_/Q VPWR VGND sg13cmos5l_dlygate4sd3_1
X_10961_ _10961_/Y _10961_/A _10961_/B _10961_/C VPWR VGND sg13cmos5l_nand3_1
X_13680_ _13680_/Q clkload61/A _13680_/D _13680_/RESET_B VPWR VGND sg13cmos5l_dfrbpq_1
X_12700_ _12700_/Y _12676_/B _12700_/B VPWR VGND sg13cmos5l_nand2b_1
XFILLER_34_30 VPWR VGND sg13cmos5l_fill_2
X_10892_ _14194_/D _11536_/A _10961_/A _10891_/Y VPWR VGND sg13cmos5l_o21ai_1
X_12631_ _12646_/B _12631_/A _12631_/B _12631_/C VPWR VGND sg13cmos5l_or3_1
XFILLER_31_529 VPWR VGND sg13cmos5l_fill_2
X_12562_ _12562_/Y _12562_/A _12640_/A VPWR VGND sg13cmos5l_nor2b_1
X_11513_ _11513_/Y _11513_/A _11555_/C VPWR VGND sg13cmos5l_xnor2_1
X_14301_ _14301_/Q clkload25/A _14301_/D _14301_/RESET_B VPWR VGND sg13cmos5l_dfrbpq_1
X_12493_ _12493_/Y _12504_/A _13244_/Q _12492_/Y VPWR VGND sg13cmos5l_o21ai_1
X_11444_ _11444_/Y _11444_/A _11444_/B VPWR VGND sg13cmos5l_nor2_1
X_14232_ _14232_/Q clkload38/A _14232_/D _14232_/RESET_B VPWR VGND sg13cmos5l_dfrbpq_1
X_11375_ _11401_/C _11375_/A _11375_/B VPWR VGND sg13cmos5l_nand2_1
X_14163_ _14163_/Q _14576_/CLK _14163_/D fanout991/X VPWR VGND sg13cmos5l_dfrbpq_1
XFILLER_4_964 VPWR VGND sg13cmos5l_fill_1
X_10326_ _13925_/D _10326_/A1 _10347_/B _10325_/Y VPWR VGND sg13cmos5l_a21oi_1
X_14094_ _14094_/Q clkload66/A _14094_/D _14094_/RESET_B VPWR VGND sg13cmos5l_dfrbpq_1
X_13114_ _14542_/D hold3540/X _08036_/B _13118_/S VPWR VGND sg13cmos5l_mux2_1
X_10257_ _13891_/D _10583_/A1 _10278_/B _10256_/Y VPWR VGND sg13cmos5l_a21oi_1
X_13045_ _13049_/C _15886_/A _15887_/A _13045_/C VPWR VGND sg13cmos5l_and3_1
XFILLER_67_927 VPWR VGND sg13cmos5l_fill_1
XFILLER_94_702 VPWR VGND sg13cmos5l_fill_2
X_13641__1750 _13641_/RESET_B VPWR VGND sg13cmos5l_tiehi
XFILLER_38_106 VPWR VGND sg13cmos5l_fill_1
X_10188_ _13857_/D _10514_/A1 _10213_/B _10187_/Y VPWR VGND sg13cmos5l_a21oi_1
X_13947_ _13947_/Q _14042_/CLK _13947_/D _13947_/RESET_B VPWR VGND sg13cmos5l_dfrbpq_1
XFILLER_62_621 VPWR VGND sg13cmos5l_fill_1
X_14625__2168 _14625_/RESET_B VPWR VGND sg13cmos5l_tiehi
X_14021__1370 _14021_/RESET_B VPWR VGND sg13cmos5l_tiehi
X_13878_ _13878_/Q clkload16/A _13878_/D _13878_/RESET_B VPWR VGND sg13cmos5l_dfrbpq_1
XFILLER_34_389 VPWR VGND sg13cmos5l_fill_1
XFILLER_50_849 VPWR VGND sg13cmos5l_fill_2
X_12829_ _12832_/A _12789_/A _12828_/X _12827_/Y VPWR VGND sg13cmos5l_o21ai_1
X_08020_ _08031_/B _14552_/Q _08041_/B VPWR VGND sg13cmos5l_xnor2_1
X_09971_ _09971_/Y _09971_/A _09977_/B VPWR VGND sg13cmos5l_nand2_1
X_14225__1252 _14225_/RESET_B VPWR VGND sg13cmos5l_tiehi
X_08922_ _13246_/D _07284_/Y _13196_/A2 _13190_/B1 _08921_/Y VPWR VGND sg13cmos5l_a22oi_1
XFILLER_58_916 VPWR VGND sg13cmos5l_decap_4
XFILLER_97_540 VPWR VGND sg13cmos5l_fill_1
XFILLER_69_275 VPWR VGND sg13cmos5l_fill_2
X_08853_ _08853_/Y _08535_/A _08875_/B _08852_/Y VPWR VGND sg13cmos5l_o21ai_1
XFILLER_73_919 VPWR VGND sg13cmos5l_decap_8
X_07804_ _07804_/Y _08593_/B _07803_/Y _07802_/Y VPWR VGND sg13cmos5l_a21oi_1
X_08784_ _08784_/Y _13149_/A1 _07341_/Y _08783_/Y VPWR VGND sg13cmos5l_o21ai_1
X_07735_ _07736_/B _14379_/Q _07712_/B _07734_/A _07734_/B VPWR VGND sg13cmos5l_a22oi_1
XFILLER_53_610 VPWR VGND sg13cmos5l_decap_4
XFILLER_65_492 VPWR VGND sg13cmos5l_fill_2
XFILLER_81_930 VPWR VGND sg13cmos5l_fill_2
X_07666_ _07666_/X _14393_/Q _14361_/Q VPWR VGND sg13cmos5l_and2_1
X_09405_ _13517_/D _09230_/A hold3136/X _09405_/S VPWR VGND sg13cmos5l_mux2_1
XFILLER_13_518 VPWR VGND sg13cmos5l_fill_2
XFILLER_71_28 VPWR VGND sg13cmos5l_fill_2
XFILLER_80_484 VPWR VGND sg13cmos5l_fill_2
XFILLER_81_996 VPWR VGND sg13cmos5l_decap_4
X_07597_ _08152_/C _07629_/A _07597_/B _07597_/C _07597_/D VPWR VGND sg13cmos5l_nand4_1
X_09336_ _13452_/D _08344_/A hold3221/X _09338_/S VPWR VGND sg13cmos5l_mux2_1
X_09267_ _13392_/D _08397_/A hold3066/X _09267_/S VPWR VGND sg13cmos5l_mux2_1
X_13683__1708 _13683_/RESET_B VPWR VGND sg13cmos5l_tiehi
X_08218_ _08218_/X _09286_/A _08409_/B VPWR VGND sg13cmos5l_and2_1
X_09198_ _09198_/Y _09197_/B _09196_/Y _09197_/Y VPWR VGND sg13cmos5l_a21oi_1
X_08149_ _08151_/B _13223_/Q _13224_/Q _08149_/C VPWR VGND sg13cmos5l_nand3_1
X_11160_ _11160_/Y _11164_/B _11628_/A VPWR VGND sg13cmos5l_nor2b_1
X_14063__1328 _14063_/RESET_B VPWR VGND sg13cmos5l_tiehi
X_10111_ _10111_/Y _10111_/A _10137_/B VPWR VGND sg13cmos5l_nand2_1
X_11091_ _11091_/Y _11151_/B _11091_/B VPWR VGND sg13cmos5l_nor2_1
XFILLER_0_433 VPWR VGND sg13cmos5l_fill_1
XFILLER_103_862 VPWR VGND sg13cmos5l_decap_8
XFILLER_88_540 VPWR VGND sg13cmos5l_fill_1
XFILLER_96_58 VPWR VGND sg13cmos5l_fill_1
X_10042_ _10042_/Y _10042_/A _10042_/B VPWR VGND sg13cmos5l_nand2_1
Xhold3361 hold3361/X _13386_/Q VPWR VGND sg13cmos5l_dlygate4sd3_1
Xhold3350 hold3350/X _13372_/Q VPWR VGND sg13cmos5l_dlygate4sd3_1
XFILLER_76_724 VPWR VGND sg13cmos5l_fill_2
Xhold3394 _13468_/D _09355_/X VPWR VGND sg13cmos5l_dlygate4sd3_1
Xhold3383 hold3383/X _13531_/Q VPWR VGND sg13cmos5l_dlygate4sd3_1
Xhold3372 hold3372/X _13260_/Q VPWR VGND sg13cmos5l_dlygate4sd3_1
XFILLER_0_499 VPWR VGND sg13cmos5l_fill_1
XFILLER_21_1000 VPWR VGND sg13cmos5l_fill_2
XFILLER_64_908 VPWR VGND sg13cmos5l_fill_2
Xhold2660 _09821_/A _13678_/Q VPWR VGND sg13cmos5l_dlygate4sd3_1
Xhold2671 _10242_/A _13884_/Q VPWR VGND sg13cmos5l_dlygate4sd3_1
Xhold2682 _09958_/A _13745_/Q VPWR VGND sg13cmos5l_dlygate4sd3_1
XFILLER_63_418 VPWR VGND sg13cmos5l_fill_1
Xhold2693 hold2693/X _14605_/Q VPWR VGND sg13cmos5l_dlygate4sd3_1
X_13801_ _13801_/Q clkload59/A _13801_/D _13801_/RESET_B VPWR VGND sg13cmos5l_dfrbpq_1
XFILLER_29_684 VPWR VGND sg13cmos5l_fill_2
X_11993_ _12021_/B _11993_/A _12107_/A VPWR VGND sg13cmos5l_nand2_1
X_13732_ _13732_/Q clkload69/A _13732_/D _13732_/RESET_B VPWR VGND sg13cmos5l_dfrbpq_1
X_13352__2070 _13352_/RESET_B VPWR VGND sg13cmos5l_tiehi
XFILLER_72_952 VPWR VGND sg13cmos5l_fill_1
X_10944_ _10945_/A hold3488/X _10939_/B _10844_/D _10943_/Y VPWR VGND sg13cmos5l_a22oi_1
XFILLER_43_175 VPWR VGND sg13cmos5l_fill_2
XFILLER_71_473 VPWR VGND sg13cmos5l_fill_2
X_10875_ _14190_/D _10865_/Y _10873_/Y _10874_/Y VPWR VGND sg13cmos5l_o21ai_1
X_13663_ _13663_/Q clkload60/A _13663_/D _13663_/RESET_B VPWR VGND sg13cmos5l_dfrbpq_1
X_13594_ _13594_/Q clkload52/A _13594_/D _13594_/RESET_B VPWR VGND sg13cmos5l_dfrbpq_1
X_12614_ _12620_/B _12643_/A _12614_/B VPWR VGND sg13cmos5l_nand2_1
X_12545_ _12545_/Y _12545_/A _12545_/B VPWR VGND sg13cmos5l_nand2_1
X_13659__1732 _13659_/RESET_B VPWR VGND sg13cmos5l_tiehi
XFILLER_8_566 VPWR VGND sg13cmos5l_fill_1
X_12476_ _12476_/Y _12480_/A _12476_/B VPWR VGND sg13cmos5l_nand2_1
XANTENNA_5 uio_in[0] VPWR VGND sg13cmos5l_antennanp
X_11427_ _11443_/B _07266_/Y _11410_/Y _11453_/C _11413_/B _11456_/C VPWR VGND sg13cmos5l_a221oi_1
X_14215_ _14215_/Q _14217_/CLK _14215_/D _14215_/RESET_B VPWR VGND sg13cmos5l_dfrbpq_1
X_11358_ _11358_/Y _11358_/A _11358_/B VPWR VGND sg13cmos5l_nand2_1
X_14146_ _14146_/Q clkload23/A _14146_/D fanout992/X VPWR VGND sg13cmos5l_dfrbpq_1
XFILLER_4_783 VPWR VGND sg13cmos5l_fill_1
XFILLER_99_849 VPWR VGND sg13cmos5l_fill_2
X_10309_ _10309_/Y _10309_/A _10315_/B VPWR VGND sg13cmos5l_nor2_1
X_14039__1352 _14039_/RESET_B VPWR VGND sg13cmos5l_tiehi
XFILLER_79_540 VPWR VGND sg13cmos5l_decap_4
X_11289_ _11289_/Y _11285_/Y _11286_/Y _11288_/Y _11536_/A _08913_/A VPWR VGND sg13cmos5l_a221oi_1
X_14077_ _14077_/Q clkload14/A _14077_/D _09199_/A VPWR VGND sg13cmos5l_dfrbpq_1
X_13562__1860 _13562_/RESET_B VPWR VGND sg13cmos5l_tiehi
X_13028_ _13028_/Y _13028_/A _13028_/B VPWR VGND sg13cmos5l_xnor2_1
XFILLER_39_459 VPWR VGND sg13cmos5l_fill_2
XFILLER_82_716 VPWR VGND sg13cmos5l_fill_2
X_07520_ _14245_/D _08383_/B _13033_/A _07519_/Y VPWR VGND sg13cmos5l_o21ai_1
XFILLER_62_440 VPWR VGND sg13cmos5l_decap_4
XFILLER_63_952 VPWR VGND sg13cmos5l_decap_8
XFILLER_81_259 VPWR VGND sg13cmos5l_fill_1
XFILLER_50_602 VPWR VGND sg13cmos5l_decap_4
XFILLER_62_484 VPWR VGND sg13cmos5l_fill_1
X_07451_ _07454_/B _14475_/Q _07530_/B1 _07528_/B1 _14491_/Q VPWR VGND sg13cmos5l_a22oi_1
X_14252__1799 _14252_/RESET_B VPWR VGND sg13cmos5l_tiehi
X_07382_ _07592_/A _13307_/Q _14544_/Q VPWR VGND sg13cmos5l_xor2_1
X_09121_ _11422_/A _14329_/Q _09163_/B VPWR VGND sg13cmos5l_nand2_1
XFILLER_30_370 VPWR VGND sg13cmos5l_fill_2
X_09052_ _09052_/Y _11235_/A _09051_/Y _09076_/A2 VPWR VGND sg13cmos5l_a21oi_1
X_08003_ _08005_/B _12964_/A _13040_/C hold3562/X VPWR VGND sg13cmos5l_a21oi_1
X_14458__1041 _14458_/RESET_B VPWR VGND sg13cmos5l_tiehi
X_13394__2028 _13394_/RESET_B VPWR VGND sg13cmos5l_tiehi
XFILLER_89_348 VPWR VGND sg13cmos5l_fill_2
X_09954_ _09954_/Y _09954_/A _09958_/B VPWR VGND sg13cmos5l_nor2_1
X_08905_ _08907_/B _08625_/B _08905_/A2 _08905_/B1 _07816_/X VPWR VGND sg13cmos5l_a22oi_1
X_09885_ _13709_/D fanout76/X _09862_/B _09884_/Y VPWR VGND sg13cmos5l_a21oi_1
XFILLER_57_223 VPWR VGND sg13cmos5l_fill_1
X_08836_ _08837_/A _08517_/B _08819_/B _08841_/B hold3420/X _08835_/Y VPWR VGND sg13cmos5l_a221oi_1
X_08767_ _08767_/Y _08781_/A1 _14153_/Q _13262_/Q _08781_/B2 VPWR VGND sg13cmos5l_a22oi_1
X_13737__1654 _13737_/RESET_B VPWR VGND sg13cmos5l_tiehi
XFILLER_82_16 VPWR VGND sg13cmos5l_fill_2
X_07718_ _08461_/B _11105_/A _14345_/Q VPWR VGND sg13cmos5l_nor2_1
X_08698_ _14620_/D _08698_/A _08698_/B VPWR VGND sg13cmos5l_nand2_1
X_13425__1997 _13425_/RESET_B VPWR VGND sg13cmos5l_tiehi
X_07649_ _07649_/Y _08619_/A _08619_/B VPWR VGND sg13cmos5l_nand2_1
X_10660_ _14085_/D _14266_/D _14085_/Q _10832_/S VPWR VGND sg13cmos5l_mux2_1
XFILLER_15_76 VPWR VGND sg13cmos5l_fill_1
XFILLER_51_1004 VPWR VGND sg13cmos5l_fill_1
X_09319_ _13435_/D _08182_/A hold3399/X _09320_/S VPWR VGND sg13cmos5l_mux2_1
X_10591_ _14055_/D _10591_/A1 _10608_/B _10590_/Y VPWR VGND sg13cmos5l_o21ai_1
X_12330_ _12330_/Y _12256_/B _12330_/B _12330_/C VPWR VGND sg13cmos5l_nand3b_1
X_12261_ _12263_/B _13963_/Q _12296_/A2 _12293_/B1 VPWR VGND sg13cmos5l_a21oi_1
X_11212_ _11239_/A _11211_/A _11211_/B _11211_/C VPWR VGND sg13cmos5l_a21o_1
X_14000_ _14000_/Q clkload78/A _14000_/D _14000_/RESET_B VPWR VGND sg13cmos5l_dfrbpq_1
X_12192_ _12192_/Y _12192_/A _12417_/B VPWR VGND sg13cmos5l_nor2_1
Xoutput31 uio_out[2] _15882_/X VPWR VGND sg13cmos5l_buf_1
Xoutput42 uo_out[12] _08780_/Y VPWR VGND sg13cmos5l_buf_1
X_14624__2167 _14624_/RESET_B VPWR VGND sg13cmos5l_tiehi
XFILLER_1_753 VPWR VGND sg13cmos5l_fill_2
X_11143_ _11143_/Y _14388_/Q _11143_/A2 _11146_/B1 _14404_/Q _11083_/X VPWR VGND sg13cmos5l_a221oi_1
Xoutput53 uo_out[8] _08772_/Y VPWR VGND sg13cmos5l_buf_1
XFILLER_0_263 VPWR VGND sg13cmos5l_fill_2
X_11074_ _14286_/D _11135_/B _11072_/Y _11073_/Y VPWR VGND sg13cmos5l_a21oi_1
X_10025_ _10025_/Y _10547_/A _10090_/B VPWR VGND sg13cmos5l_nand2_1
Xhold3180 hold3180/X _13514_/Q VPWR VGND sg13cmos5l_dlygate4sd3_1
Xhold3191 _13529_/D _09418_/X VPWR VGND sg13cmos5l_dlygate4sd3_1
X_15882_ _15882_/X _15882_/A VPWR VGND sg13cmos5l_buf_1
XFILLER_64_727 VPWR VGND sg13cmos5l_decap_4
Xhold2490 _10558_/A _14039_/Q VPWR VGND sg13cmos5l_dlygate4sd3_1
XFILLER_91_524 VPWR VGND sg13cmos5l_fill_2
X_11976_ _11976_/Y _07228_/Y _12164_/C _12382_/A _11975_/Y VPWR VGND sg13cmos5l_a22oi_1
X_10927_ _10927_/Y _10927_/A _10934_/B VPWR VGND sg13cmos5l_nand2_1
X_13715_ _13715_/Q clkload50/A _13715_/D _13715_/RESET_B VPWR VGND sg13cmos5l_dfrbpq_1
XFILLER_32_635 VPWR VGND sg13cmos5l_fill_2
X_13646_ _13646_/Q clkload56/A _13646_/D _13646_/RESET_B VPWR VGND sg13cmos5l_dfrbpq_1
X_10858_ _10954_/C _14244_/D _14243_/D VPWR VGND sg13cmos5l_nand2_1
X_10789_ _10789_/Y _10792_/A _11132_/A VPWR VGND sg13cmos5l_nand2_1
X_13577_ _13577_/Q clkload37/A _13577_/D _13577_/RESET_B VPWR VGND sg13cmos5l_dfrbpq_1
X_12528_ _12529_/B _14400_/Q _12530_/B VPWR VGND sg13cmos5l_nand2_1
X_12459_ _14382_/D _12459_/A _12459_/B VPWR VGND sg13cmos5l_nand2_1
XFILLER_99_624 VPWR VGND sg13cmos5l_fill_2
X_13815__1576 _13815_/RESET_B VPWR VGND sg13cmos5l_tiehi
Xfanout309 _09892_/B _09890_/B VPWR VGND sg13cmos5l_buf_1
X_14129_ _14129_/Q clkload34/A _14129_/D fanout998/X VPWR VGND sg13cmos5l_dfrbpq_1
XFILLER_79_370 VPWR VGND sg13cmos5l_fill_2
X_09670_ _09676_/B _14465_/Q _12856_/A _09670_/C VPWR VGND sg13cmos5l_nand3_1
X_08621_ _08621_/Y _08625_/A _08621_/B _08621_/C VPWR VGND sg13cmos5l_nor3_1
XFILLER_67_587 VPWR VGND sg13cmos5l_decap_8
X_08552_ _08577_/A _07666_/X _08552_/B VPWR VGND sg13cmos5l_nand2b_1
XFILLER_23_613 VPWR VGND sg13cmos5l_fill_1
XFILLER_35_473 VPWR VGND sg13cmos5l_fill_1
X_07503_ _10971_/A _07533_/S _13032_/D _07502_/X VPWR VGND sg13cmos5l_a21oi_1
X_08483_ _08483_/Y _08819_/A _08488_/C _07745_/B VPWR VGND sg13cmos5l_o21ai_1
X_07434_ _07434_/Y _08964_/A _12963_/A _07434_/C VPWR VGND sg13cmos5l_nor3_1
XFILLER_11_808 VPWR VGND sg13cmos5l_fill_1
XFILLER_10_329 VPWR VGND sg13cmos5l_fill_1
X_07365_ _08068_/A _07369_/A _07369_/B VPWR VGND sg13cmos5l_nor2_1
X_07296_ _07296_/Y _13257_/Q VPWR VGND sg13cmos5l_inv_1
X_09104_ _09104_/Y _14422_/Q _11374_/A VPWR VGND sg13cmos5l_nand2_1
X_09035_ _09035_/Y _14410_/Q _11197_/S VPWR VGND sg13cmos5l_nand2_1
XFILLER_105_946 VPWR VGND sg13cmos5l_decap_8
XFILLER_2_539 VPWR VGND sg13cmos5l_fill_1
XFILLER_89_123 VPWR VGND sg13cmos5l_fill_2
X_09937_ _13734_/D fanout79/X _09952_/B _09936_/Y VPWR VGND sg13cmos5l_a21oi_1
Xfanout843 _11765_/A _14350_/Q VPWR VGND sg13cmos5l_buf_1
Xfanout832 _11091_/B _14564_/Q VPWR VGND sg13cmos5l_buf_1
Xfanout821 _12480_/A _12489_/A1 VPWR VGND sg13cmos5l_buf_1
Xfanout810 _11007_/A _14573_/Q VPWR VGND sg13cmos5l_buf_1
Xfanout876 _11202_/A _11433_/A1 VPWR VGND sg13cmos5l_buf_1
Xfanout865 _08476_/A _08498_/A VPWR VGND sg13cmos5l_buf_1
Xfanout854 _10987_/A _14238_/Q VPWR VGND sg13cmos5l_buf_1
XFILLER_58_576 VPWR VGND sg13cmos5l_decap_8
X_09868_ _09868_/Y _09868_/A _09882_/B VPWR VGND sg13cmos5l_nor2_1
Xfanout898 _09288_/A _14116_/Q VPWR VGND sg13cmos5l_buf_1
Xfanout887 _09302_/A _14127_/Q VPWR VGND sg13cmos5l_buf_1
X_08819_ _08823_/A _08819_/A _08819_/B VPWR VGND sg13cmos5l_nand2_1
X_09799_ _09799_/Y _09799_/A _09821_/B VPWR VGND sg13cmos5l_nor2_1
X_11830_ _11830_/Y _13756_/Q _11998_/B1 _11966_/B _13820_/Q VPWR VGND sg13cmos5l_a22oi_1
X_11761_ _11761_/Y _14444_/Q _11686_/B _11760_/Y VPWR VGND sg13cmos5l_a21oi_1
X_10712_ _10712_/Y _10712_/A _10808_/S VPWR VGND sg13cmos5l_nand2_1
X_13500_ _13500_/Q _14109_/CLK _13500_/D _13500_/RESET_B VPWR VGND sg13cmos5l_dfrbpq_1
X_11692_ _11692_/Y _13751_/Q _11697_/B _11726_/B VPWR VGND sg13cmos5l_a21oi_1
X_14480_ _14480_/Q _14576_/CLK _14480_/D fanout976/X VPWR VGND sg13cmos5l_dfrbpq_1
X_10643_ _14078_/D _10643_/A _10647_/D VPWR VGND sg13cmos5l_xor2_1
X_13431_ _13431_/Q _14520_/CLK _13431_/D _13431_/RESET_B VPWR VGND sg13cmos5l_dfrbpq_1
X_10574_ _10574_/Y _10574_/A _10594_/B VPWR VGND sg13cmos5l_nand2_1
X_13362_ _13362_/Q _14102_/CLK _13362_/D _13362_/RESET_B VPWR VGND sg13cmos5l_dfrbpq_1
XFILLER_6_823 VPWR VGND sg13cmos5l_fill_2
X_12313_ _12313_/Y _14029_/Q _12195_/B _12087_/B _13837_/Q VPWR VGND sg13cmos5l_a22oi_1
X_13293_ _13293_/Q clkload12/A _13293_/D fanout963/X VPWR VGND sg13cmos5l_dfrbpq_1
X_12244_ _12244_/Y _12419_/A2 _12241_/Y _12242_/Y _12243_/Y _12430_/A1 VPWR VGND sg13cmos5l_a221oi_1
X_12175_ _12176_/C _14056_/Q _12397_/B _12399_/A2 _13736_/Q VPWR VGND sg13cmos5l_a22oi_1
X_14251__1798 _14251_/RESET_B VPWR VGND sg13cmos5l_tiehi
XFILLER_68_329 VPWR VGND sg13cmos5l_fill_1
X_11126_ _11126_/Y _11126_/A _11132_/B VPWR VGND sg13cmos5l_nor2_1
XFILLER_49_532 VPWR VGND sg13cmos5l_decap_8
XFILLER_92_800 VPWR VGND sg13cmos5l_decap_8
X_11057_ _14282_/D _11121_/A _11123_/B _11056_/Y VPWR VGND sg13cmos5l_a21oi_1
XFILLER_92_844 VPWR VGND sg13cmos5l_fill_2
XFILLER_97_1026 VPWR VGND sg13cmos5l_fill_2
X_10008_ _13769_/D _10595_/A1 _10007_/B _10007_/Y VPWR VGND sg13cmos5l_o21ai_1
XFILLER_33_933 VPWR VGND sg13cmos5l_fill_2
XFILLER_33_944 VPWR VGND sg13cmos5l_fill_1
XFILLER_60_741 VPWR VGND sg13cmos5l_fill_2
X_11959_ _11960_/C _11988_/A _11958_/B _11981_/B VPWR VGND sg13cmos5l_o21ai_1
X_13629_ _13629_/Q clkload48/A _13629_/D _13629_/RESET_B VPWR VGND sg13cmos5l_dfrbpq_1
XFILLER_73_2 VPWR VGND sg13cmos5l_fill_1
XFILLER_9_683 VPWR VGND sg13cmos5l_fill_2
X_13254__1010 _13254_/RESET_B VPWR VGND sg13cmos5l_tiehi
XFILLER_105_209 VPWR VGND sg13cmos5l_fill_2
XFILLER_59_0 VPWR VGND sg13cmos5l_fill_2
XFILLER_102_916 VPWR VGND sg13cmos5l_decap_8
XFILLER_102_927 VPWR VGND sg13cmos5l_fill_1
Xfanout128 _09368_/S _09375_/S VPWR VGND sg13cmos5l_buf_1
Xfanout117 _09421_/S _09434_/S VPWR VGND sg13cmos5l_buf_1
Xfanout106 _10534_/A1 _10599_/A1 VPWR VGND sg13cmos5l_buf_1
X_07983_ _12609_/B _08379_/C1 _07982_/Y _07978_/Y VPWR VGND sg13cmos5l_o21ai_1
X_09722_ _09722_/Y _09722_/A _09760_/B VPWR VGND sg13cmos5l_nor2_1
Xfanout139 _10399_/A1 _09640_/Y VPWR VGND sg13cmos5l_buf_1
XFILLER_41_1014 VPWR VGND sg13cmos5l_fill_1
XFILLER_83_822 VPWR VGND sg13cmos5l_fill_2
X_09653_ _09653_/Y _09653_/A _09655_/B VPWR VGND sg13cmos5l_nor2_1
XFILLER_27_237 VPWR VGND sg13cmos5l_fill_1
XFILLER_43_708 VPWR VGND sg13cmos5l_decap_4
XFILLER_55_557 VPWR VGND sg13cmos5l_fill_2
XFILLER_67_395 VPWR VGND sg13cmos5l_fill_1
X_08604_ _08605_/B _08604_/A _08604_/B _08604_/C VPWR VGND sg13cmos5l_nand3_1
X_09584_ _09584_/Y _09571_/A _11359_/B _09583_/Y VPWR VGND sg13cmos5l_a21oi_1
X_08535_ _08536_/C _08535_/A _08535_/B VPWR VGND sg13cmos5l_nor2_1
X_14623__2166 _14623_/RESET_B VPWR VGND sg13cmos5l_tiehi
XFILLER_51_752 VPWR VGND sg13cmos5l_fill_2
X_08466_ _08466_/Y _08801_/A _08463_/C _07716_/B VPWR VGND sg13cmos5l_o21ai_1
XFILLER_11_627 VPWR VGND sg13cmos5l_fill_1
X_07417_ _12997_/B _10780_/A _07417_/B VPWR VGND sg13cmos5l_and2_1
X_08397_ _08397_/Y _08397_/A _08397_/B _08409_/C VPWR VGND sg13cmos5l_nand3_1
X_07348_ _07350_/B _13318_/Q _13319_/Q _13320_/Q _13321_/Q VPWR VGND sg13cmos5l_nor4_1
X_07279_ _07279_/Y _13242_/Q VPWR VGND sg13cmos5l_inv_1
XFILLER_105_710 VPWR VGND sg13cmos5l_decap_8
XFILLER_3_826 VPWR VGND sg13cmos5l_decap_8
X_09018_ _09018_/Y _09018_/A _09033_/S VPWR VGND sg13cmos5l_nand2_1
X_10290_ _13907_/D _10355_/A1 _10295_/B _10289_/Y VPWR VGND sg13cmos5l_a21oi_1
XFILLER_105_776 VPWR VGND sg13cmos5l_decap_4
Xfanout651 _11092_/A _11146_/B1 VPWR VGND sg13cmos5l_buf_1
Xfanout640 _12301_/B _11635_/B VPWR VGND sg13cmos5l_buf_1
Xfanout684 _11450_/A _11482_/A VPWR VGND sg13cmos5l_buf_1
Xfanout673 _08653_/B _08655_/A VPWR VGND sg13cmos5l_buf_1
Xfanout662 _13151_/B1 _08923_/X VPWR VGND sg13cmos5l_buf_1
X_13980_ _13980_/Q clkload46/A _13980_/D _13980_/RESET_B VPWR VGND sg13cmos5l_dfrbpq_1
Xfanout695 _09160_/A2 _09196_/A2 VPWR VGND sg13cmos5l_buf_1
X_12931_ _12932_/A _14453_/Q _11358_/B _11401_/C _12933_/B2 VPWR VGND sg13cmos5l_a22oi_1
X_12862_ _14433_/D _12859_/Y _12861_/Y _12893_/B1 VPWR VGND sg13cmos5l_a21oi_1
XFILLER_15_911 VPWR VGND sg13cmos5l_fill_2
XFILLER_34_719 VPWR VGND sg13cmos5l_fill_2
XFILLER_37_96 VPWR VGND sg13cmos5l_fill_1
X_11813_ _11813_/Y _11811_/Y _11812_/Y _11837_/C1 VPWR VGND sg13cmos5l_a21oi_1
X_14601_ _14601_/Q clkload76/A _14601_/D _14601_/RESET_B VPWR VGND sg13cmos5l_dfrbpq_1
X_12793_ _12793_/X _11092_/A _12598_/X _12739_/A VPWR VGND sg13cmos5l_a21o_1
XFILLER_14_465 VPWR VGND sg13cmos5l_fill_1
XFILLER_18_1027 VPWR VGND sg13cmos5l_fill_2
X_11744_ _11747_/A _13593_/Q _11805_/A2 _08687_/A VPWR VGND sg13cmos5l_a21oi_1
X_14532_ _14532_/Q _14532_/CLK _14532_/D fanout970/X VPWR VGND sg13cmos5l_dfrbpq_1
X_11675_ _11675_/Y _14441_/Q _11686_/B _11670_/X _11851_/A _11674_/Y VPWR VGND sg13cmos5l_a221oi_1
X_14463_ _14463_/Q _14654_/CLK _14463_/D _14463_/RESET_B VPWR VGND sg13cmos5l_dfrbpq_1
X_10626_ _10630_/B _14070_/Q _14069_/Q _10626_/C VPWR VGND sg13cmos5l_nand3_1
X_13414_ _13414_/Q clkload38/A _13414_/D _13414_/RESET_B VPWR VGND sg13cmos5l_dfrbpq_1
X_14394_ _14394_/Q clkload76/A _14394_/D _14394_/RESET_B VPWR VGND sg13cmos5l_dfrbpq_1
XFILLER_10_693 VPWR VGND sg13cmos5l_fill_1
X_10557_ _14038_/D _10557_/A1 _10576_/B _10556_/Y VPWR VGND sg13cmos5l_o21ai_1
X_13345_ _13345_/Q clkload31/A _13345_/D _13345_/RESET_B VPWR VGND sg13cmos5l_dfrbpq_1
XFILLER_6_675 VPWR VGND sg13cmos5l_fill_1
X_10488_ _14004_/D _10553_/A1 _10497_/B _10487_/Y VPWR VGND sg13cmos5l_o21ai_1
X_13276_ _13276_/Q clkload19/A _13276_/D fanout981/X VPWR VGND sg13cmos5l_dfrbpq_1
X_12227_ _12227_/Y _13802_/Q _12234_/B VPWR VGND sg13cmos5l_nand2_1
XFILLER_69_605 VPWR VGND sg13cmos5l_decap_4
XFILLER_69_616 VPWR VGND sg13cmos5l_fill_1
XFILLER_96_413 VPWR VGND sg13cmos5l_fill_2
X_13242__1036 _13242_/RESET_B VPWR VGND sg13cmos5l_tiehi
X_12158_ _12160_/B _12132_/A _12220_/A _12157_/Y VPWR VGND sg13cmos5l_o21ai_1
X_11109_ _11109_/Y _11109_/A _11109_/B VPWR VGND sg13cmos5l_nor2_1
X_12089_ _12090_/C _13925_/Q _12319_/A2 _12195_/B _13861_/Q VPWR VGND sg13cmos5l_a22oi_1
XFILLER_37_546 VPWR VGND sg13cmos5l_fill_2
XFILLER_49_395 VPWR VGND sg13cmos5l_fill_1
XFILLER_64_332 VPWR VGND sg13cmos5l_fill_2
XFILLER_76_192 VPWR VGND sg13cmos5l_fill_1
XFILLER_65_888 VPWR VGND sg13cmos5l_fill_1
XFILLER_65_899 VPWR VGND sg13cmos5l_fill_2
XFILLER_45_590 VPWR VGND sg13cmos5l_decap_8
X_08320_ _08320_/Y _08320_/A _08397_/B _08344_/C VPWR VGND sg13cmos5l_nand3_1
X_13245__1788 _13245_/RESET_B VPWR VGND sg13cmos5l_tiehi
XFILLER_60_560 VPWR VGND sg13cmos5l_fill_2
XFILLER_60_582 VPWR VGND sg13cmos5l_fill_1
X_08251_ _08252_/B _13572_/Q _13540_/Q _08309_/A VPWR VGND sg13cmos5l_mux2_1
X_07202_ _07599_/A _13283_/Q VPWR VGND sg13cmos5l_inv_1
XFILLER_20_468 VPWR VGND sg13cmos5l_fill_2
X_08182_ _08182_/X _08182_/A _08307_/B VPWR VGND sg13cmos5l_and2_1
XFILLER_58_18 VPWR VGND sg13cmos5l_fill_1
XFILLER_58_29 VPWR VGND sg13cmos5l_fill_2
XFILLER_87_457 VPWR VGND sg13cmos5l_fill_1
X_07966_ _07966_/Y _08356_/C _07961_/X _07965_/Y _08187_/B2 VPWR VGND sg13cmos5l_a22oi_1
X_09705_ _13621_/D _10425_/A1 _09706_/B _09704_/Y VPWR VGND sg13cmos5l_a21oi_1
XFILLER_56_855 VPWR VGND sg13cmos5l_decap_8
X_07897_ _07944_/A _07897_/A _07897_/B _07897_/C VPWR VGND sg13cmos5l_nor3_1
X_09636_ _11482_/B _14429_/Q _14648_/Q _09662_/S VPWR VGND sg13cmos5l_mux2_1
Xclkbuf_leaf_94_clk clkload49/A clkbuf_4_8_0_clk/X VPWR VGND sg13cmos5l_buf_8
XFILLER_43_516 VPWR VGND sg13cmos5l_decap_8
X_09567_ _09567_/Y _09567_/A _09578_/B VPWR VGND sg13cmos5l_nor2_1
XFILLER_70_346 VPWR VGND sg13cmos5l_fill_2
X_08518_ _08520_/A _08518_/A _08530_/A VPWR VGND sg13cmos5l_nor2_1
X_09498_ _09498_/Y _09498_/A _09511_/B VPWR VGND sg13cmos5l_nor2_1
X_14250__1797 _14250_/RESET_B VPWR VGND sg13cmos5l_tiehi
X_08449_ _08451_/A _08502_/A _14374_/Q VPWR VGND sg13cmos5l_nand2_1
X_13774__1617 _13774_/RESET_B VPWR VGND sg13cmos5l_tiehi
XFILLER_8_907 VPWR VGND sg13cmos5l_decap_4
X_13810__1581 _13810_/RESET_B VPWR VGND sg13cmos5l_tiehi
XFILLER_23_65 VPWR VGND sg13cmos5l_fill_1
X_11460_ _11460_/Y _11460_/A _11460_/B VPWR VGND sg13cmos5l_nor2_1
X_10411_ _13967_/D fanout61/X _10410_/B _10410_/Y VPWR VGND sg13cmos5l_a21oi_1
X_11391_ _11392_/B _11391_/A _11391_/B _11391_/C VPWR VGND sg13cmos5l_nand3_1
X_10342_ _13933_/D fanout76/X _10319_/B _10341_/Y VPWR VGND sg13cmos5l_a21oi_1
X_13130_ _14552_/D hold3527/X _08041_/B _13136_/S VPWR VGND sg13cmos5l_mux2_1
X_13061_ _13063_/B _13061_/A _15895_/A _13061_/C VPWR VGND sg13cmos5l_nand3_1
XFILLER_79_914 VPWR VGND sg13cmos5l_decap_8
X_10273_ _13899_/D _10534_/A1 _10280_/B _10272_/Y VPWR VGND sg13cmos5l_a21oi_1
X_12012_ _12012_/Y _12012_/A1 _12004_/Y _12008_/Y _12011_/Y VPWR VGND sg13cmos5l_a22oi_1
XFILLER_79_936 VPWR VGND sg13cmos5l_decap_8
XFILLER_78_446 VPWR VGND sg13cmos5l_decap_8
XFILLER_78_479 VPWR VGND sg13cmos5l_decap_8
Xfanout492 _11914_/A2 _11730_/B1 VPWR VGND sg13cmos5l_buf_1
Xfanout481 _12144_/B _12297_/B1 VPWR VGND sg13cmos5l_buf_1
Xfanout470 _08744_/B1 fanout484/X VPWR VGND sg13cmos5l_buf_1
XFILLER_86_490 VPWR VGND sg13cmos5l_decap_8
XFILLER_93_449 VPWR VGND sg13cmos5l_fill_1
Xclkbuf_leaf_85_clk clkload51/A clkload4/A VPWR VGND sg13cmos5l_buf_8
X_13963_ _13963_/Q clkload62/A _13963_/D _13963_/RESET_B VPWR VGND sg13cmos5l_dfrbpq_1
XFILLER_46_376 VPWR VGND sg13cmos5l_decap_4
XFILLER_47_899 VPWR VGND sg13cmos5l_fill_1
XFILLER_74_674 VPWR VGND sg13cmos5l_fill_2
X_13894_ _13894_/Q clkload64/A _13894_/D _13894_/RESET_B VPWR VGND sg13cmos5l_dfrbpq_1
X_12914_ _14444_/D _12914_/A VPWR VGND sg13cmos5l_inv_1
X_12845_ _12863_/A _14463_/Q _13253_/Q VPWR VGND sg13cmos5l_xnor2_1
X_12776_ _12777_/B _12785_/A _12776_/B VPWR VGND sg13cmos5l_nand2_1
X_11727_ _11728_/D _13656_/Q _11727_/B VPWR VGND sg13cmos5l_nor2_1
X_14515_ _15894_/A _14520_/CLK _14515_/D fanout972/X VPWR VGND sg13cmos5l_dfrbpq_1
X_11658_ _11658_/Y _11672_/A _12607_/B _11656_/Y VPWR VGND sg13cmos5l_o21ai_1
X_14446_ _14446_/Q _14630_/CLK _14446_/D _14446_/RESET_B VPWR VGND sg13cmos5l_dfrbpq_1
X_10609_ _14064_/D fanout58/X _10608_/B _10608_/Y VPWR VGND sg13cmos5l_o21ai_1
X_11589_ _14339_/D _11587_/Y _11588_/Y _11571_/Y VPWR VGND sg13cmos5l_o21ai_1
X_14377_ _14377_/Q clkload24/A _14377_/D _14377_/RESET_B VPWR VGND sg13cmos5l_dfrbpq_1
X_13438__1984 _13438_/RESET_B VPWR VGND sg13cmos5l_tiehi
X_13328_ _13328_/Q clkload73/A _13328_/D _13328_/RESET_B VPWR VGND sg13cmos5l_dfrbpq_1
Xhold3009 _09908_/A _13720_/Q VPWR VGND sg13cmos5l_dlygate4sd3_1
X_14622__2165 _14622_/RESET_B VPWR VGND sg13cmos5l_tiehi
X_13259_ _13259_/Q _14520_/CLK _13259_/D fanout972/X VPWR VGND sg13cmos5l_dfrbpq_1
Xhold2308 _11307_/A _14322_/Q VPWR VGND sg13cmos5l_dlygate4sd3_1
Xhold2319 _14146_/D _10758_/Y VPWR VGND sg13cmos5l_dlygate4sd3_1
XFILLER_85_906 VPWR VGND sg13cmos5l_decap_8
X_07820_ _07822_/B _07823_/A _12415_/A _07812_/Y _07843_/A VPWR VGND sg13cmos5l_a22oi_1
X_07751_ _07751_/Y _14387_/Q _07751_/B VPWR VGND sg13cmos5l_nor2_1
X_13852__1539 _13852_/RESET_B VPWR VGND sg13cmos5l_tiehi
XFILLER_65_630 VPWR VGND sg13cmos5l_decap_4
Xclkbuf_leaf_76_clk clkload58/A clkbuf_4_10_0_clk/X VPWR VGND sg13cmos5l_buf_8
X_13998__1393 _13998_/RESET_B VPWR VGND sg13cmos5l_tiehi
XFILLER_80_600 VPWR VGND sg13cmos5l_decap_8
X_07682_ _07682_/Y _14389_/Q _14357_/Q VPWR VGND sg13cmos5l_nand2_1
XFILLER_80_633 VPWR VGND sg13cmos5l_fill_2
XFILLER_80_644 VPWR VGND sg13cmos5l_fill_1
X_09421_ _13532_/D _08194_/A hold3252/X _09421_/S VPWR VGND sg13cmos5l_mux2_1
X_09352_ _09352_/X _14106_/Q hold3358/X _09366_/S VPWR VGND sg13cmos5l_mux2_1
X_08303_ _08303_/Y _11034_/A _08301_/X _08302_/Y _08300_/X _11033_/S1 VPWR VGND sg13cmos5l_a221oi_1
XFILLER_100_48 VPWR VGND sg13cmos5l_fill_2
XFILLER_21_755 VPWR VGND sg13cmos5l_fill_1
X_09283_ _13407_/D _07973_/A hold3295/X _09295_/B VPWR VGND sg13cmos5l_mux2_1
X_08234_ _08234_/Y _08315_/A _08233_/X _08311_/C1 VPWR VGND sg13cmos5l_a21oi_1
X_08165_ _08165_/Y _08165_/A _08164_/X VPWR VGND sg13cmos5l_nor2b_1
X_08096_ _08102_/C _13128_/B _09343_/D VPWR VGND sg13cmos5l_nor2_1
Xclkload80 clkload80/Y clkload80/A VPWR VGND sg13cmos5l_inv_1
Xhold3510 hold3510/X _14572_/Q VPWR VGND sg13cmos5l_dlygate4sd3_1
XFILLER_0_615 VPWR VGND sg13cmos5l_fill_2
XFILLER_102_510 VPWR VGND sg13cmos5l_fill_1
Xhold3532 hold3532/X _14268_/Q VPWR VGND sg13cmos5l_dlygate4sd3_1
Xhold3543 hold3543/X _14449_/Q VPWR VGND sg13cmos5l_dlygate4sd3_1
Xhold3521 _12353_/A _14465_/Q VPWR VGND sg13cmos5l_dlygate4sd3_1
XFILLER_0_648 VPWR VGND sg13cmos5l_fill_2
XFILLER_48_608 VPWR VGND sg13cmos5l_fill_2
XFILLER_85_16 VPWR VGND sg13cmos5l_fill_2
Xhold2820 _09716_/A _13627_/Q VPWR VGND sg13cmos5l_dlygate4sd3_1
Xhold2831 hold2831/X _13204_/Q VPWR VGND sg13cmos5l_dlygate4sd3_1
Xhold3554 hold3554/X _14551_/Q VPWR VGND sg13cmos5l_dlygate4sd3_1
Xhold3565 _13064_/B _13063_/B VPWR VGND sg13cmos5l_dlygate4sd3_1
XFILLER_102_565 VPWR VGND sg13cmos5l_fill_1
X_08998_ _13278_/D _08994_/B _08997_/Y _08994_/Y VPWR VGND sg13cmos5l_o21ai_1
Xhold2842 _09817_/A _13676_/Q VPWR VGND sg13cmos5l_dlygate4sd3_1
Xhold2853 _10625_/A _14069_/Q VPWR VGND sg13cmos5l_dlygate4sd3_1
Xhold2864 _10209_/A _13868_/Q VPWR VGND sg13cmos5l_dlygate4sd3_1
Xhold2875 _09799_/A _13667_/Q VPWR VGND sg13cmos5l_dlygate4sd3_1
X_07949_ _07949_/X _14574_/Q _12997_/B VPWR VGND sg13cmos5l_or2_1
Xhold2886 _10213_/A _13870_/Q VPWR VGND sg13cmos5l_dlygate4sd3_1
Xhold2897 _10260_/A _13893_/Q VPWR VGND sg13cmos5l_dlygate4sd3_1
Xclkbuf_leaf_67_clk clkload61/A clkload5/A VPWR VGND sg13cmos5l_buf_8
X_13828__1563 _13828_/RESET_B VPWR VGND sg13cmos5l_tiehi
XFILLER_18_65 VPWR VGND sg13cmos5l_fill_1
XFILLER_44_803 VPWR VGND sg13cmos5l_fill_2
X_10960_ _10960_/Y _10978_/B _10960_/B VPWR VGND sg13cmos5l_nand2_1
XFILLER_56_685 VPWR VGND sg13cmos5l_fill_2
XFILLER_71_633 VPWR VGND sg13cmos5l_decap_4
XFILLER_84_994 VPWR VGND sg13cmos5l_decap_8
X_09619_ _09619_/Y _09617_/A _11437_/B _09617_/Y VPWR VGND sg13cmos5l_o21ai_1
X_10891_ _10891_/Y _14246_/D _10961_/A _10891_/C _10961_/B VPWR VGND sg13cmos5l_nand4_1
XFILLER_43_368 VPWR VGND sg13cmos5l_decap_4
X_12630_ _12631_/C _14442_/Q _13232_/Q _12603_/X _12604_/Y _12602_/X VPWR VGND sg13cmos5l_a221oi_1
XFILLER_54_1002 VPWR VGND sg13cmos5l_fill_1
XFILLER_51_390 VPWR VGND sg13cmos5l_fill_2
X_12561_ _12561_/Y _12636_/C _12559_/X _12560_/X _12637_/C VPWR VGND sg13cmos5l_a22oi_1
XFILLER_12_777 VPWR VGND sg13cmos5l_fill_1
X_11512_ _11575_/A _11513_/A _11555_/C VPWR VGND sg13cmos5l_nor2b_1
X_14300_ _14300_/Q clkload16/A _14300_/D _14300_/RESET_B VPWR VGND sg13cmos5l_dfrbpq_1
X_12492_ _12492_/Y _12504_/A _12492_/B VPWR VGND sg13cmos5l_nand2_1
X_11443_ _11444_/B _11443_/A _11443_/B _11443_/C VPWR VGND sg13cmos5l_nor3_1
X_14231_ _14231_/Q clkload45/A _14231_/D _14231_/RESET_B VPWR VGND sg13cmos5l_dfrbpq_1
X_14162_ _14162_/Q clkload23/A _14162_/D fanout992/X VPWR VGND sg13cmos5l_dfrbpq_1
X_13315__2107 _13315_/RESET_B VPWR VGND sg13cmos5l_tiehi
X_11374_ _11375_/B _11374_/A _11374_/B VPWR VGND sg13cmos5l_nand2_1
X_13113_ _14541_/D _14541_/Q _08040_/B _13118_/S VPWR VGND sg13cmos5l_mux2_1
X_10325_ _10325_/Y _10325_/A _10347_/B VPWR VGND sg13cmos5l_nor2_1
X_14093_ _14093_/Q clkload71/A _14093_/D _14093_/RESET_B VPWR VGND sg13cmos5l_dfrbpq_1
X_10256_ _10256_/Y _10256_/A _10278_/B VPWR VGND sg13cmos5l_nor2_1
X_13044_ _13046_/A _13043_/A _13045_/C hold3432/X VPWR VGND sg13cmos5l_a21oi_1
XFILLER_61_1028 VPWR VGND sg13cmos5l_fill_1
XFILLER_79_788 VPWR VGND sg13cmos5l_fill_2
X_10187_ _10187_/Y _10187_/A _10213_/B VPWR VGND sg13cmos5l_nor2_1
Xclkbuf_leaf_58_clk clkload67/A clkbuf_4_12_0_clk/X VPWR VGND sg13cmos5l_buf_8
Xclkbuf_4_11_0_clk clkload5/A clkbuf_0_clk/X VPWR VGND sg13cmos5l_buf_8
X_13946_ _13946_/Q _14045_/CLK _13946_/D _13946_/RESET_B VPWR VGND sg13cmos5l_dfrbpq_1
XFILLER_75_994 VPWR VGND sg13cmos5l_fill_1
XFILLER_90_975 VPWR VGND sg13cmos5l_fill_1
XFILLER_90_986 VPWR VGND sg13cmos5l_fill_1
X_14279__1229 _14279_/RESET_B VPWR VGND sg13cmos5l_tiehi
X_13877_ _13877_/Q clkload16/A _13877_/D _13877_/RESET_B VPWR VGND sg13cmos5l_dfrbpq_1
XFILLER_34_379 VPWR VGND sg13cmos5l_fill_1
X_14315__1193 _14315_/RESET_B VPWR VGND sg13cmos5l_tiehi
X_12828_ _12828_/X _12828_/A _12828_/B _12828_/C _12828_/D VPWR VGND sg13cmos5l_or4_1
XFILLER_91_70 VPWR VGND sg13cmos5l_fill_2
X_12759_ _12759_/Y _12788_/B _12759_/B VPWR VGND sg13cmos5l_xnor2_1
X_14429_ _14429_/Q clkload81/A _14429_/D _14429_/RESET_B VPWR VGND sg13cmos5l_dfrbpq_1
X_13906__1485 _13906_/RESET_B VPWR VGND sg13cmos5l_tiehi
X_09970_ _13750_/D _10557_/A1 _09969_/B _09969_/Y VPWR VGND sg13cmos5l_o21ai_1
X_08921_ _08921_/Y _11316_/A _14096_/Q _13191_/B1 _14261_/Q VPWR VGND sg13cmos5l_a22oi_1
X_08852_ _08852_/Y _08852_/A _08861_/C VPWR VGND sg13cmos5l_nand2_1
XFILLER_85_714 VPWR VGND sg13cmos5l_fill_2
X_07803_ _07803_/Y _14398_/Q _12193_/A VPWR VGND sg13cmos5l_nor2_1
XFILLER_38_630 VPWR VGND sg13cmos5l_fill_2
XFILLER_66_950 VPWR VGND sg13cmos5l_decap_8
XFILLER_84_224 VPWR VGND sg13cmos5l_fill_2
XFILLER_84_235 VPWR VGND sg13cmos5l_fill_1
X_08783_ _08783_/Y _13148_/A _14161_/Q _14098_/Q _07959_/B VPWR VGND sg13cmos5l_a22oi_1
Xclkbuf_leaf_49_clk _14654_/CLK clkload7/A VPWR VGND sg13cmos5l_buf_8
X_07734_ _07734_/X _07734_/A _07734_/B VPWR VGND sg13cmos5l_and2_1
XFILLER_53_622 VPWR VGND sg13cmos5l_fill_1
XFILLER_53_633 VPWR VGND sg13cmos5l_decap_4
XFILLER_81_920 VPWR VGND sg13cmos5l_fill_2
X_07665_ _07842_/A _08575_/A _08575_/B _07665_/C VPWR VGND sg13cmos5l_nand3_1
X_09404_ _13516_/D _08344_/A hold3030/X _09409_/S VPWR VGND sg13cmos5l_mux2_1
X_07596_ _07597_/D _07596_/A _07596_/B _07596_/C VPWR VGND sg13cmos5l_nand3_1
X_09335_ _13451_/D _08332_/A hold3230/X _09338_/S VPWR VGND sg13cmos5l_mux2_1
X_09266_ _13391_/D _09304_/A hold3353/X _09266_/S VPWR VGND sg13cmos5l_mux2_1
X_08217_ _14257_/D hold3391/X _12735_/B _08368_/S VPWR VGND sg13cmos5l_mux2_1
X_13691__1700 _13691_/RESET_B VPWR VGND sg13cmos5l_tiehi
X_09197_ _09197_/Y _09197_/A _09197_/B VPWR VGND sg13cmos5l_nor2_1
X_08148_ _08148_/Y _13223_/Q _08149_/C hold2792/X VPWR VGND sg13cmos5l_a21oi_1
X_08079_ _09377_/A _08087_/A _08087_/B VPWR VGND sg13cmos5l_nor2b_1
X_13244__1028 _13244_/RESET_B VPWR VGND sg13cmos5l_tiehi
XFILLER_106_167 VPWR VGND sg13cmos5l_fill_2
XFILLER_20_99 VPWR VGND sg13cmos5l_fill_1
X_10110_ _13819_/D _10567_/A1 _10109_/B _10109_/Y VPWR VGND sg13cmos5l_o21ai_1
X_11090_ _14290_/D _11147_/B _11088_/Y _11089_/Y VPWR VGND sg13cmos5l_a21oi_1
XFILLER_1_957 VPWR VGND sg13cmos5l_fill_1
X_10041_ _13785_/D _10563_/A1 _10044_/B _10040_/Y VPWR VGND sg13cmos5l_o21ai_1
Xhold3351 hold3351/X _13439_/Q VPWR VGND sg13cmos5l_dlygate4sd3_1
Xhold3340 hold3340/X _13534_/Q VPWR VGND sg13cmos5l_dlygate4sd3_1
XFILLER_48_405 VPWR VGND sg13cmos5l_fill_1
Xhold3384 _13531_/D _09420_/X VPWR VGND sg13cmos5l_dlygate4sd3_1
Xhold3373 hold3373/X _14184_/Q VPWR VGND sg13cmos5l_dlygate4sd3_1
Xhold3362 hold3362/X _14171_/Q VPWR VGND sg13cmos5l_dlygate4sd3_1
Xhold2650 _09666_/A _13613_/Q VPWR VGND sg13cmos5l_dlygate4sd3_1
Xhold2661 _10287_/A _13906_/Q VPWR VGND sg13cmos5l_dlygate4sd3_1
Xhold2672 _08133_/A _13217_/Q VPWR VGND sg13cmos5l_dlygate4sd3_1
Xhold2683 _10187_/A _13857_/Q VPWR VGND sg13cmos5l_dlygate4sd3_1
Xhold3395 _13043_/A _15886_/A VPWR VGND sg13cmos5l_dlygate4sd3_1
X_13603__1819 _13603_/RESET_B VPWR VGND sg13cmos5l_tiehi
X_11992_ _12107_/A _14358_/Q _13243_/Q VPWR VGND sg13cmos5l_xor2_1
Xhold2694 _10360_/A _13942_/Q VPWR VGND sg13cmos5l_dlygate4sd3_1
X_13800_ _13800_/Q _14640_/CLK _13800_/D _13800_/RESET_B VPWR VGND sg13cmos5l_dfrbpq_1
X_10943_ _10943_/Y _10943_/A _10943_/B VPWR VGND sg13cmos5l_nor2_1
X_13731_ _13731_/Q clkload57/A _13731_/D _13731_/RESET_B VPWR VGND sg13cmos5l_dfrbpq_1
XFILLER_44_655 VPWR VGND sg13cmos5l_decap_4
XFILLER_45_63 VPWR VGND sg13cmos5l_fill_1
XFILLER_31_316 VPWR VGND sg13cmos5l_fill_2
X_10874_ _10874_/Y _10874_/A _10932_/B VPWR VGND sg13cmos5l_nand2_1
X_13662_ _13662_/Q clkload60/A _13662_/D _13662_/RESET_B VPWR VGND sg13cmos5l_dfrbpq_1
X_14621__2164 _14621_/RESET_B VPWR VGND sg13cmos5l_tiehi
X_13593_ _13593_/Q clkload48/A _13593_/D _13593_/RESET_B VPWR VGND sg13cmos5l_dfrbpq_1
X_12613_ _12614_/B _12548_/Y _12610_/Y _12612_/Y VPWR VGND sg13cmos5l_o21ai_1
X_12544_ _14404_/D _12541_/B _12543_/Y _12541_/Y VPWR VGND sg13cmos5l_o21ai_1
X_12475_ _12475_/Y _12475_/A _12485_/B VPWR VGND sg13cmos5l_nand2_1
XANTENNA_6 uio_in[1] VPWR VGND sg13cmos5l_antennanp
X_11426_ _11428_/B _11413_/B _11453_/C _11453_/A VPWR VGND sg13cmos5l_a21oi_1
X_14214_ _14214_/Q _14217_/CLK _14214_/D _14214_/RESET_B VPWR VGND sg13cmos5l_dfrbpq_1
X_11357_ _14324_/D _11355_/Y _11356_/Y _11342_/Y VPWR VGND sg13cmos5l_o21ai_1
X_14145_ _14145_/Q clkload23/A _14145_/D fanout992/X VPWR VGND sg13cmos5l_dfrbpq_1
XFILLER_3_261 VPWR VGND sg13cmos5l_fill_2
X_10308_ _13916_/D _10308_/A1 _10319_/B _10307_/Y VPWR VGND sg13cmos5l_a21oi_1
X_14076_ _14076_/Q clkload14/A _14076_/D fanout969/X VPWR VGND sg13cmos5l_dfrbpq_1
X_11288_ _11288_/Y _11288_/A _11302_/C VPWR VGND sg13cmos5l_xnor2_1
X_13027_ _13027_/Y _13027_/A _13027_/B VPWR VGND sg13cmos5l_xnor2_1
XFILLER_67_703 VPWR VGND sg13cmos5l_decap_8
XFILLER_67_714 VPWR VGND sg13cmos5l_fill_1
X_10239_ _13882_/D _10565_/A1 _10238_/B _10238_/Y VPWR VGND sg13cmos5l_a21oi_1
XFILLER_0_990 VPWR VGND sg13cmos5l_decap_8
XFILLER_94_577 VPWR VGND sg13cmos5l_fill_1
XFILLER_47_471 VPWR VGND sg13cmos5l_decap_8
XFILLER_63_942 VPWR VGND sg13cmos5l_decap_4
X_14402__1106 _14402_/RESET_B VPWR VGND sg13cmos5l_tiehi
XFILLER_35_666 VPWR VGND sg13cmos5l_fill_2
X_13929_ _13929_/Q clkload63/A _13929_/D _13929_/RESET_B VPWR VGND sg13cmos5l_dfrbpq_1
XFILLER_63_986 VPWR VGND sg13cmos5l_decap_4
XFILLER_90_761 VPWR VGND sg13cmos5l_decap_8
X_07450_ _07455_/B _07450_/A _07450_/B VPWR VGND sg13cmos5l_nand2_1
XFILLER_22_327 VPWR VGND sg13cmos5l_fill_2
XFILLER_62_496 VPWR VGND sg13cmos5l_fill_2
X_07381_ _07595_/A _08999_/A _14546_/Q VPWR VGND sg13cmos5l_xor2_1
XFILLER_89_0 VPWR VGND sg13cmos5l_fill_2
X_09120_ _13316_/D _09095_/B _09118_/Y _09119_/Y VPWR VGND sg13cmos5l_a21oi_1
X_09051_ _09051_/Y _14413_/Q _11234_/A VPWR VGND sg13cmos5l_nand2_1
X_08002_ _14624_/D _07940_/B _07997_/X _10829_/S _08001_/A VPWR VGND sg13cmos5l_a22oi_1
XFILLER_44_1012 VPWR VGND sg13cmos5l_fill_2
XFILLER_98_850 VPWR VGND sg13cmos5l_fill_1
X_09953_ _13742_/D fanout74/X _09952_/B _09952_/Y VPWR VGND sg13cmos5l_a21oi_1
XFILLER_44_1023 VPWR VGND sg13cmos5l_decap_4
X_08904_ _08907_/A _08904_/A _08904_/B VPWR VGND sg13cmos5l_nand2_1
X_09884_ _09884_/Y _09884_/A _09890_/B VPWR VGND sg13cmos5l_nor2_1
X_08835_ _08835_/Y _07679_/A _08875_/B _08834_/Y VPWR VGND sg13cmos5l_o21ai_1
X_08766_ _08766_/Y _13149_/A1 _07332_/Y _08765_/Y VPWR VGND sg13cmos5l_o21ai_1
XFILLER_72_227 VPWR VGND sg13cmos5l_fill_2
X_07717_ _07732_/A _08465_/A VPWR VGND sg13cmos5l_inv_1
X_08697_ _08698_/B _14178_/Q _08753_/B _08696_/Y _11657_/B VPWR VGND sg13cmos5l_a22oi_1
XFILLER_26_677 VPWR VGND sg13cmos5l_fill_1
XFILLER_54_997 VPWR VGND sg13cmos5l_fill_1
X_07648_ _08619_/B _08615_/A _08616_/B VPWR VGND sg13cmos5l_nand2_1
X_07579_ _07579_/Y _07579_/A _07579_/B _07579_/C VPWR VGND sg13cmos5l_nor3_1
XFILLER_22_872 VPWR VGND sg13cmos5l_fill_2
X_09318_ _13434_/D _08170_/A hold3213/X _09320_/S VPWR VGND sg13cmos5l_mux2_1
X_10590_ _10590_/Y _10590_/A _10608_/B VPWR VGND sg13cmos5l_nand2_1
X_13632__1759 _13632_/RESET_B VPWR VGND sg13cmos5l_tiehi
X_09249_ _13374_/D _07961_/A hold3122/X _09268_/S VPWR VGND sg13cmos5l_mux2_1
X_12260_ _12263_/A _13707_/Q _12260_/B VPWR VGND sg13cmos5l_nand2_1
XFILLER_5_548 VPWR VGND sg13cmos5l_fill_1
X_11211_ _11213_/B _11211_/A _11211_/B _11211_/C VPWR VGND sg13cmos5l_nand3_1
X_12191_ _12191_/Y _12383_/A2 _12275_/B _12165_/A VPWR VGND sg13cmos5l_o21ai_1
X_11142_ _14304_/D _11141_/B _11140_/Y _11141_/Y VPWR VGND sg13cmos5l_a21oi_1
Xoutput32 uio_out[3] _15883_/X VPWR VGND sg13cmos5l_buf_1
Xoutput43 uo_out[13] _08782_/Y VPWR VGND sg13cmos5l_buf_1
X_14012__1379 _14012_/RESET_B VPWR VGND sg13cmos5l_tiehi
XFILLER_89_850 VPWR VGND sg13cmos5l_decap_4
Xoutput54 uo_out[9] _08774_/Y VPWR VGND sg13cmos5l_buf_1
X_11073_ _11073_/Y _11073_/A _11135_/B VPWR VGND sg13cmos5l_nor2_1
X_10024_ _13777_/D fanout56/X _10023_/B _10023_/Y VPWR VGND sg13cmos5l_o21ai_1
Xhold3170 hold3170/X _13403_/Q VPWR VGND sg13cmos5l_dlygate4sd3_1
Xhold3181 hold3181/X _13460_/Q VPWR VGND sg13cmos5l_dlygate4sd3_1
Xhold3192 hold3192/X _13576_/Q VPWR VGND sg13cmos5l_dlygate4sd3_1
X_15881_ _15881_/X _15881_/A VPWR VGND sg13cmos5l_buf_1
Xhold2480 _09963_/A _13747_/Q VPWR VGND sg13cmos5l_dlygate4sd3_1
Xhold2491 _10023_/A _13777_/Q VPWR VGND sg13cmos5l_dlygate4sd3_1
XFILLER_17_611 VPWR VGND sg13cmos5l_decap_4
XFILLER_29_482 VPWR VGND sg13cmos5l_fill_2
X_11975_ _11975_/Y _14356_/Q _12164_/B VPWR VGND sg13cmos5l_nand2_1
X_10926_ _14208_/D _10844_/Y _10909_/Y _10925_/Y VPWR VGND sg13cmos5l_o21ai_1
X_13714_ _13714_/Q clkload54/A _13714_/D _13714_/RESET_B VPWR VGND sg13cmos5l_dfrbpq_1
XFILLER_60_967 VPWR VGND sg13cmos5l_decap_8
X_10857_ _10857_/Y _14248_/D _10906_/A VPWR VGND sg13cmos5l_nor2_1
X_13645_ _13645_/Q _14053_/CLK _13645_/D _13645_/RESET_B VPWR VGND sg13cmos5l_dfrbpq_1
X_10788_ _10788_/Y _10790_/B _10786_/Y _10787_/Y VPWR VGND sg13cmos5l_o21ai_1
X_13608__1783 _13608_/RESET_B VPWR VGND sg13cmos5l_tiehi
X_13576_ _13576_/Q clkload28/A _13576_/D _13576_/RESET_B VPWR VGND sg13cmos5l_dfrbpq_1
XFILLER_8_364 VPWR VGND sg13cmos5l_fill_2
X_12527_ _12529_/A _12538_/B _13253_/Q _12526_/Y VPWR VGND sg13cmos5l_o21ai_1
X_12458_ _12459_/B _08638_/A _13235_/Q _12457_/Y VPWR VGND sg13cmos5l_o21ai_1
X_11409_ _11430_/A _11409_/A _11409_/B VPWR VGND sg13cmos5l_nand2_1
X_13787__1604 _13787_/RESET_B VPWR VGND sg13cmos5l_tiehi
X_12389_ _12389_/Y _14372_/Q _13257_/Q VPWR VGND sg13cmos5l_xnor2_1
X_14128_ _14128_/Q clkload34/A _14128_/D fanout998/X VPWR VGND sg13cmos5l_dfrbpq_1
X_13475__1947 _13475_/RESET_B VPWR VGND sg13cmos5l_tiehi
XFILLER_67_500 VPWR VGND sg13cmos5l_decap_8
X_14059_ _14059_/Q clkload62/A _14059_/D _14059_/RESET_B VPWR VGND sg13cmos5l_dfrbpq_1
X_08620_ _08621_/C _07644_/B _07645_/X _07642_/Y VPWR VGND sg13cmos5l_a21o_1
XFILLER_36_920 VPWR VGND sg13cmos5l_fill_2
X_08551_ _08552_/B _08861_/A _14360_/Q _08551_/C VPWR VGND sg13cmos5l_nand3_1
X_07502_ _07502_/X _14249_/Q _08168_/A VPWR VGND sg13cmos5l_and2_1
X_08482_ _14590_/D _08819_/A _08482_/B VPWR VGND sg13cmos5l_xnor2_1
XFILLER_22_113 VPWR VGND sg13cmos5l_fill_2
XFILLER_51_934 VPWR VGND sg13cmos5l_decap_8
X_07433_ _07433_/Y _07467_/C _07433_/B VPWR VGND sg13cmos5l_nor2_1
XFILLER_31_680 VPWR VGND sg13cmos5l_fill_1
X_07364_ _07569_/A _08999_/A _14558_/Q VPWR VGND sg13cmos5l_xnor2_1
X_09103_ _11375_/A _14326_/Q _09193_/B VPWR VGND sg13cmos5l_nand2_1
X_07295_ _07295_/Y _13256_/Q VPWR VGND sg13cmos5l_inv_1
X_09034_ _09034_/Y _14314_/Q _09073_/B VPWR VGND sg13cmos5l_nand2_1
X_13343__2079 _13343_/RESET_B VPWR VGND sg13cmos5l_tiehi
XFILLER_105_925 VPWR VGND sg13cmos5l_fill_2
Xfanout800 _08398_/S _08393_/A1 VPWR VGND sg13cmos5l_buf_1
X_09936_ _09936_/Y _09936_/A _09952_/B VPWR VGND sg13cmos5l_nor2_1
Xfanout833 _12856_/A _14464_/Q VPWR VGND sg13cmos5l_buf_1
Xfanout822 _12489_/A1 fanout828/X VPWR VGND sg13cmos5l_buf_1
Xfanout811 _11657_/B _11867_/B VPWR VGND sg13cmos5l_buf_1
X_14620__2163 _14620_/RESET_B VPWR VGND sg13cmos5l_tiehi
XFILLER_58_522 VPWR VGND sg13cmos5l_fill_1
Xfanout866 _08498_/A _14216_/Q VPWR VGND sg13cmos5l_buf_1
Xfanout855 _09532_/S _11005_/B1 VPWR VGND sg13cmos5l_buf_1
Xfanout844 _11740_/A _14349_/Q VPWR VGND sg13cmos5l_buf_1
X_14274__1234 _14274_/RESET_B VPWR VGND sg13cmos5l_tiehi
XFILLER_100_630 VPWR VGND sg13cmos5l_fill_2
XFILLER_86_886 VPWR VGND sg13cmos5l_decap_4
X_09867_ _13700_/D _10128_/A1 _09878_/B _09866_/Y VPWR VGND sg13cmos5l_a21oi_1
Xfanout899 _09286_/A _14115_/Q VPWR VGND sg13cmos5l_buf_1
Xfanout888 _09230_/A _14126_/Q VPWR VGND sg13cmos5l_buf_1
Xfanout877 _11316_/A _10982_/B VPWR VGND sg13cmos5l_buf_1
XFILLER_73_536 VPWR VGND sg13cmos5l_decap_4
X_08818_ _14632_/D _08818_/A _08818_/B _08818_/C VPWR VGND sg13cmos5l_nand3_1
X_09798_ _13666_/D _10385_/A1 _09797_/B _09797_/Y VPWR VGND sg13cmos5l_a21oi_1
X_13520__1902 _13520_/RESET_B VPWR VGND sg13cmos5l_tiehi
XFILLER_61_709 VPWR VGND sg13cmos5l_decap_8
X_08749_ _08749_/Y _08746_/Y _08748_/Y _11837_/C1 VPWR VGND sg13cmos5l_a21oi_1
XFILLER_54_772 VPWR VGND sg13cmos5l_fill_1
X_11760_ _11760_/Y _07238_/Y _11868_/A2 _11816_/B1 _12634_/B _11624_/B VPWR VGND sg13cmos5l_a221oi_1
XFILLER_41_433 VPWR VGND sg13cmos5l_fill_2
XFILLER_53_271 VPWR VGND sg13cmos5l_decap_4
XFILLER_53_282 VPWR VGND sg13cmos5l_fill_2
XFILLER_53_293 VPWR VGND sg13cmos5l_decap_8
X_10711_ _10711_/Y _10780_/A _14275_/Q VPWR VGND sg13cmos5l_nand2_1
X_11691_ _11691_/Y _13719_/Q _11702_/B VPWR VGND sg13cmos5l_nand2_1
X_13865__1526 _13865_/RESET_B VPWR VGND sg13cmos5l_tiehi
X_10642_ _10642_/Y _10642_/A _10642_/B VPWR VGND sg13cmos5l_xnor2_1
X_13901__1490 _13901_/RESET_B VPWR VGND sg13cmos5l_tiehi
X_13553__1869 _13553_/RESET_B VPWR VGND sg13cmos5l_tiehi
X_13430_ _13430_/Q clkload27/A _13430_/D _13430_/RESET_B VPWR VGND sg13cmos5l_dfrbpq_1
X_10573_ _14046_/D _10573_/A1 _10582_/B _10572_/Y VPWR VGND sg13cmos5l_o21ai_1
X_13361_ _13361_/Q clkload32/A _13361_/D _13361_/RESET_B VPWR VGND sg13cmos5l_dfrbpq_1
XFILLER_10_875 VPWR VGND sg13cmos5l_fill_2
XFILLER_10_886 VPWR VGND sg13cmos5l_fill_2
XFILLER_42_97 VPWR VGND sg13cmos5l_fill_2
X_13292_ _13292_/Q clkload12/A _13292_/D fanout958/X VPWR VGND sg13cmos5l_dfrbpq_1
X_12312_ _12312_/Y _13773_/Q _12317_/B _12346_/B1 VPWR VGND sg13cmos5l_a21oi_1
X_12243_ _12243_/Y _13898_/Q _12427_/B1 _12243_/B1 VPWR VGND sg13cmos5l_a21oi_1
XFILLER_5_378 VPWR VGND sg13cmos5l_fill_2
XFILLER_5_389 VPWR VGND sg13cmos5l_fill_1
X_12174_ _12176_/B _13992_/Q _12174_/B VPWR VGND sg13cmos5l_nand2_1
XFILLER_49_500 VPWR VGND sg13cmos5l_decap_8
X_11125_ _11125_/Y _14382_/Q _11143_/A2 _11093_/B _14398_/Q _11058_/X VPWR VGND sg13cmos5l_a221oi_1
XFILLER_1_584 VPWR VGND sg13cmos5l_fill_1
X_11056_ _11056_/Y _11056_/A _11123_/B VPWR VGND sg13cmos5l_nor2_1
XFILLER_49_544 VPWR VGND sg13cmos5l_decap_8
X_10007_ _10007_/Y _10007_/A _10007_/B VPWR VGND sg13cmos5l_nand2_1
XFILLER_64_514 VPWR VGND sg13cmos5l_decap_8
XFILLER_76_396 VPWR VGND sg13cmos5l_fill_1
XFILLER_44_260 VPWR VGND sg13cmos5l_fill_2
XFILLER_60_720 VPWR VGND sg13cmos5l_decap_8
XFILLER_60_731 VPWR VGND sg13cmos5l_fill_1
X_11958_ _11960_/B _11988_/A _11958_/B _11981_/B VPWR VGND sg13cmos5l_or3_1
XFILLER_32_466 VPWR VGND sg13cmos5l_fill_1
X_10909_ _10909_/Y _14256_/Q _10909_/B VPWR VGND sg13cmos5l_nand2b_1
X_11889_ _11889_/Y _13950_/Q _12419_/A2 _12377_/B1 _13694_/Q _11888_/X VPWR VGND sg13cmos5l_a221oi_1
XFILLER_60_786 VPWR VGND sg13cmos5l_fill_2
Xeco_diode_0 ui_in[6] VPWR VGND sg13cmos5l_antennanp
X_13628_ _13628_/Q clkload46/A _13628_/D _13628_/RESET_B VPWR VGND sg13cmos5l_dfrbpq_1
X_13559_ _13559_/Q _14105_/CLK _13559_/D _13559_/RESET_B VPWR VGND sg13cmos5l_dfrbpq_1
X_13529__1893 _13529_/RESET_B VPWR VGND sg13cmos5l_tiehi
X_14352__1156 _14352_/RESET_B VPWR VGND sg13cmos5l_tiehi
X_07982_ _07982_/Y _08214_/A _07979_/X _07981_/Y VPWR VGND sg13cmos5l_a21oi_1
Xfanout129 _09373_/S _09376_/S VPWR VGND sg13cmos5l_buf_1
Xfanout118 _09434_/S _09441_/S VPWR VGND sg13cmos5l_buf_1
Xfanout107 _10599_/A1 _09652_/Y VPWR VGND sg13cmos5l_buf_1
XFILLER_101_416 VPWR VGND sg13cmos5l_fill_1
X_09721_ _13629_/D _10375_/A1 _09724_/B _09720_/Y VPWR VGND sg13cmos5l_a21oi_1
X_13943__1448 _13943_/RESET_B VPWR VGND sg13cmos5l_tiehi
XFILLER_28_717 VPWR VGND sg13cmos5l_fill_1
XFILLER_55_514 VPWR VGND sg13cmos5l_fill_2
XFILLER_68_886 VPWR VGND sg13cmos5l_decap_8
X_09652_ _09652_/Y _09671_/A _11510_/B _09657_/B _09651_/Y VPWR VGND sg13cmos5l_a22oi_1
X_08603_ _08604_/C _08609_/B _08603_/B _08603_/C VPWR VGND sg13cmos5l_nand3b_1
X_09583_ _09583_/Y _09583_/A _09582_/Y VPWR VGND sg13cmos5l_nor2b_1
XFILLER_83_878 VPWR VGND sg13cmos5l_decap_8
X_08534_ _14598_/D _08540_/A _08534_/B VPWR VGND sg13cmos5l_xor2_1
X_08465_ _14586_/D _08465_/A _08465_/B VPWR VGND sg13cmos5l_xnor2_1
XFILLER_11_639 VPWR VGND sg13cmos5l_fill_2
XFILLER_50_285 VPWR VGND sg13cmos5l_fill_1
X_07416_ _07416_/Y _07416_/A _08098_/A VPWR VGND sg13cmos5l_nand2_1
X_08396_ _14271_/D _08383_/B _12608_/A _08383_/Y VPWR VGND sg13cmos5l_o21ai_1
X_07347_ _07352_/B _13314_/Q _13315_/Q _13316_/Q _13317_/Q VPWR VGND sg13cmos5l_nor4_1
X_07278_ _11926_/B _13241_/Q VPWR VGND sg13cmos5l_inv_1
X_09017_ _13290_/D _08956_/A _09033_/S _09016_/Y VPWR VGND sg13cmos5l_o21ai_1
X_14328__1180 _14328_/RESET_B VPWR VGND sg13cmos5l_tiehi
XFILLER_104_232 VPWR VGND sg13cmos5l_fill_1
XFILLER_78_628 VPWR VGND sg13cmos5l_fill_2
Xfanout641 _11635_/B _11630_/X VPWR VGND sg13cmos5l_buf_1
Xfanout630 _12485_/B _12487_/B VPWR VGND sg13cmos5l_buf_1
XFILLER_101_961 VPWR VGND sg13cmos5l_fill_2
X_09919_ _13725_/D _10571_/A1 _09924_/B _09918_/Y VPWR VGND sg13cmos5l_a21oi_1
Xfanout685 _11482_/A _11542_/A VPWR VGND sg13cmos5l_buf_1
Xfanout674 _09073_/B _09175_/B VPWR VGND sg13cmos5l_buf_1
Xfanout663 _13164_/A2 _13184_/A2 VPWR VGND sg13cmos5l_buf_1
Xfanout652 _12891_/A1 _11146_/B1 VPWR VGND sg13cmos5l_buf_1
X_13919__1472 _13919_/RESET_B VPWR VGND sg13cmos5l_tiehi
XFILLER_101_972 VPWR VGND sg13cmos5l_fill_2
XFILLER_92_119 VPWR VGND sg13cmos5l_fill_1
Xfanout696 _09178_/A2 _09196_/A2 VPWR VGND sg13cmos5l_buf_1
X_12930_ _14452_/D _12930_/A VPWR VGND sg13cmos5l_inv_1
XFILLER_74_845 VPWR VGND sg13cmos5l_decap_8
XFILLER_74_867 VPWR VGND sg13cmos5l_fill_2
X_12861_ _12861_/Y _14369_/Q _12861_/A2 fanout60/X _12860_/X VPWR VGND sg13cmos5l_a22oi_1
XFILLER_27_761 VPWR VGND sg13cmos5l_fill_1
XFILLER_61_517 VPWR VGND sg13cmos5l_fill_2
X_11812_ _11812_/Y _13851_/Q _11916_/A2 _11858_/B _13659_/Q _11695_/B VPWR VGND sg13cmos5l_a221oi_1
X_14600_ _14600_/Q clkload76/A _14600_/D _14600_/RESET_B VPWR VGND sg13cmos5l_dfrbpq_1
X_14430__1078 _14430_/RESET_B VPWR VGND sg13cmos5l_tiehi
XFILLER_54_591 VPWR VGND sg13cmos5l_decap_8
X_12792_ _12792_/Y _12792_/A _12792_/B VPWR VGND sg13cmos5l_nor2_1
X_11743_ _11763_/B _11851_/A _11743_/B _11768_/B VPWR VGND sg13cmos5l_nand3_1
X_14531_ _14531_/Q clkload10/A _14531_/D fanout977/X VPWR VGND sg13cmos5l_dfrbpq_1
XFILLER_105_1009 VPWR VGND sg13cmos5l_decap_8
X_11674_ _11674_/Y _07712_/B _11816_/B1 _11672_/Y VPWR VGND sg13cmos5l_o21ai_1
X_14462_ _14462_/Q _14650_/CLK _14462_/D _14462_/RESET_B VPWR VGND sg13cmos5l_dfrbpq_1
X_10625_ _14069_/D _10625_/A _10626_/C VPWR VGND sg13cmos5l_xor2_1
X_13413_ _13413_/Q clkload38/A _13413_/D _13413_/RESET_B VPWR VGND sg13cmos5l_dfrbpq_1
X_14393_ _14393_/Q clkload76/A _14393_/D _14393_/RESET_B VPWR VGND sg13cmos5l_dfrbpq_1
X_10556_ _10556_/Y _10556_/A _10576_/B VPWR VGND sg13cmos5l_nand2_1
X_13406__2016 _13406_/RESET_B VPWR VGND sg13cmos5l_tiehi
X_13344_ _13344_/Q _13568_/CLK _13344_/D _13344_/RESET_B VPWR VGND sg13cmos5l_dfrbpq_1
X_10487_ _10487_/Y _10487_/A _10497_/B VPWR VGND sg13cmos5l_nand2_1
X_13275_ _13275_/Q clkload18/A _13275_/D fanout981/X VPWR VGND sg13cmos5l_dfrbpq_1
X_12226_ _12226_/Y _12224_/Y _12226_/B VPWR VGND sg13cmos5l_nand2b_1
X_12157_ _12157_/Y _14363_/Q _13248_/Q _12136_/D VPWR VGND sg13cmos5l_a21oi_1
X_11108_ _14294_/D _11107_/B _11106_/Y _11107_/Y VPWR VGND sg13cmos5l_a21oi_1
X_12088_ _12090_/B _13605_/Q _12200_/B1 _12349_/C1 VPWR VGND sg13cmos5l_a21oi_1
X_11039_ _11040_/D _14534_/Q _11039_/A2 _11039_/B1 _14498_/Q VPWR VGND sg13cmos5l_a22oi_1
XFILLER_65_856 VPWR VGND sg13cmos5l_decap_8
XFILLER_92_631 VPWR VGND sg13cmos5l_fill_1
XFILLER_80_815 VPWR VGND sg13cmos5l_fill_1
X_08250_ _08250_/Y _08309_/A _13444_/Q _08249_/Y VPWR VGND sg13cmos5l_o21ai_1
X_07201_ _07602_/A _13287_/Q VPWR VGND sg13cmos5l_inv_1
X_08181_ _14251_/D hold3419/X _12550_/B _11042_/S VPWR VGND sg13cmos5l_mux2_1
X_14271__1818 _14271_/RESET_B VPWR VGND sg13cmos5l_tiehi
XFILLER_87_403 VPWR VGND sg13cmos5l_fill_2
XFILLER_88_915 VPWR VGND sg13cmos5l_decap_4
X_07965_ _07965_/Y _07965_/A _07965_/B _07965_/C VPWR VGND sg13cmos5l_nand3_1
X_09704_ _09704_/Y _09704_/A _09706_/B VPWR VGND sg13cmos5l_nor2_1
X_14211__1266 _14211_/RESET_B VPWR VGND sg13cmos5l_tiehi
X_07896_ _07897_/C _07896_/A _07896_/B _07896_/C _07896_/D VPWR VGND sg13cmos5l_nand4_1
X_09635_ _09635_/Y _09635_/A _09666_/B VPWR VGND sg13cmos5l_nor2_1
XFILLER_55_377 VPWR VGND sg13cmos5l_decap_8
XFILLER_43_528 VPWR VGND sg13cmos5l_fill_2
X_09566_ _13598_/D _09587_/B _10377_/A1 _09565_/Y VPWR VGND sg13cmos5l_a21oi_1
XFILLER_36_591 VPWR VGND sg13cmos5l_fill_1
X_08517_ _08530_/A _08838_/A _08517_/B VPWR VGND sg13cmos5l_nand2_1
X_09497_ _09497_/Y _09509_/A _09495_/X _09496_/Y VPWR VGND sg13cmos5l_a21oi_1
X_08448_ _14618_/D _09060_/B _08446_/Y _08447_/Y VPWR VGND sg13cmos5l_a21oi_1
XFILLER_11_447 VPWR VGND sg13cmos5l_fill_2
XFILLER_104_1020 VPWR VGND sg13cmos5l_decap_8
X_08379_ _08379_/Y _11033_/S1 _08374_/Y _08376_/Y _08378_/Y _08379_/C1 VPWR VGND sg13cmos5l_a221oi_1
X_10410_ _10410_/Y _10410_/A _10410_/B VPWR VGND sg13cmos5l_nor2_1
X_13470__1952 _13470_/RESET_B VPWR VGND sg13cmos5l_tiehi
X_11390_ _11393_/B _14175_/Q _11401_/C _11391_/C _11388_/Y _11389_/Y VPWR VGND sg13cmos5l_a221oi_1
X_10341_ _10341_/Y _10341_/A _10341_/B VPWR VGND sg13cmos5l_nor2_1
X_10272_ _10272_/Y _10272_/A _10274_/B VPWR VGND sg13cmos5l_nor2_1
X_13060_ _13062_/A _13059_/A _13061_/C hold3413/X VPWR VGND sg13cmos5l_a21oi_1
X_12011_ _12011_/Y _12009_/Y _12010_/Y _12012_/A1 VPWR VGND sg13cmos5l_a21oi_1
XFILLER_59_672 VPWR VGND sg13cmos5l_fill_1
Xfanout493 _11730_/B1 _08650_/X VPWR VGND sg13cmos5l_buf_1
Xfanout482 _12297_/B1 _12427_/A2 VPWR VGND sg13cmos5l_buf_1
Xfanout471 _11944_/B2 fanout484/X VPWR VGND sg13cmos5l_buf_1
Xfanout460 _12428_/B1 fanout465/X VPWR VGND sg13cmos5l_buf_1
X_13962_ _13962_/Q _14020_/CLK _13962_/D _13962_/RESET_B VPWR VGND sg13cmos5l_dfrbpq_1
XFILLER_58_182 VPWR VGND sg13cmos5l_fill_1
X_12913_ _12914_/A _14444_/Q _11220_/B _11256_/C _12913_/B2 VPWR VGND sg13cmos5l_a22oi_1
XFILLER_46_355 VPWR VGND sg13cmos5l_decap_8
X_13893_ _13893_/Q _14028_/CLK _13893_/D _13893_/RESET_B VPWR VGND sg13cmos5l_dfrbpq_1
XFILLER_46_388 VPWR VGND sg13cmos5l_fill_1
XFILLER_46_399 VPWR VGND sg13cmos5l_decap_8
XFILLER_64_62 VPWR VGND sg13cmos5l_fill_2
X_12844_ _12857_/A _14463_/Q _13253_/Q VPWR VGND sg13cmos5l_nand2_1
X_12775_ _12777_/A _12783_/B _12785_/B VPWR VGND sg13cmos5l_nand2_1
XFILLER_14_274 VPWR VGND sg13cmos5l_fill_1
X_11726_ _11728_/C _13592_/Q _11726_/B VPWR VGND sg13cmos5l_nor2_1
X_14514_ _15893_/A clkload14/A _14514_/D fanout970/X VPWR VGND sg13cmos5l_dfrbpq_1
XFILLER_30_778 VPWR VGND sg13cmos5l_fill_1
X_11657_ _12607_/B _11668_/A _11657_/B VPWR VGND sg13cmos5l_nand2_1
X_14445_ _14445_/Q _14630_/CLK _14445_/D _14445_/RESET_B VPWR VGND sg13cmos5l_dfrbpq_1
XFILLER_7_930 VPWR VGND sg13cmos5l_fill_1
X_10608_ _10608_/Y _10608_/A _10608_/B VPWR VGND sg13cmos5l_nand2_1
X_11588_ _11588_/Y _11576_/Y _11586_/Y _12955_/B2 VPWR VGND sg13cmos5l_o21ai_1
X_14376_ _14376_/Q clkload24/A _14376_/D _14376_/RESET_B VPWR VGND sg13cmos5l_dfrbpq_1
X_13309__2203 _13309_/RESET_B VPWR VGND sg13cmos5l_tiehi
X_10539_ _10539_/Y _10539_/A _10539_/B VPWR VGND sg13cmos5l_nand2_1
X_13327_ _13327_/Q clkload73/A _13327_/D _13327_/RESET_B VPWR VGND sg13cmos5l_dfrbpq_1
X_13645__1746 _13645_/RESET_B VPWR VGND sg13cmos5l_tiehi
X_13258_ _13258_/Q clkload22/A _13258_/D fanout989/X VPWR VGND sg13cmos5l_dfrbpq_1
X_12209_ _12209_/Y _14057_/Q _08687_/Y _12206_/Y _12208_/Y _12205_/Y VPWR VGND sg13cmos5l_a221oi_1
Xhold2309 _10052_/A _13791_/Q VPWR VGND sg13cmos5l_dlygate4sd3_1
X_13189_ _13189_/Y _08923_/A _14094_/Q _13189_/B1 _10877_/A VPWR VGND sg13cmos5l_a22oi_1
XFILLER_78_992 VPWR VGND sg13cmos5l_decap_4
X_07750_ _07758_/B _14389_/Q _11950_/A VPWR VGND sg13cmos5l_nor2_1
XFILLER_93_951 VPWR VGND sg13cmos5l_decap_8
X_14025__1366 _14025_/RESET_B VPWR VGND sg13cmos5l_tiehi
X_13860__1531 _13860_/RESET_B VPWR VGND sg13cmos5l_tiehi
X_07681_ _07683_/A _14389_/Q _14357_/Q VPWR VGND sg13cmos5l_nor2_1
XFILLER_92_494 VPWR VGND sg13cmos5l_fill_2
XFILLER_93_995 VPWR VGND sg13cmos5l_fill_1
X_09420_ _09420_/X _14108_/Q hold3383/X _09421_/S VPWR VGND sg13cmos5l_mux2_1
XFILLER_40_509 VPWR VGND sg13cmos5l_fill_2
X_09351_ _09351_/X _14105_/Q hold3346/X _09368_/S VPWR VGND sg13cmos5l_mux2_1
XFILLER_61_881 VPWR VGND sg13cmos5l_fill_2
X_08302_ _08302_/Y _08301_/S _07310_/Y _08165_/A VPWR VGND sg13cmos5l_a21oi_1
X_09282_ _13406_/D _07961_/A hold3070/X _09295_/B VPWR VGND sg13cmos5l_mux2_1
X_13893__1498 _13893_/RESET_B VPWR VGND sg13cmos5l_tiehi
X_08233_ _08233_/X _13507_/Q _13475_/Q _08238_/S VPWR VGND sg13cmos5l_mux2_1
XFILLER_21_789 VPWR VGND sg13cmos5l_fill_2
XFILLER_20_277 VPWR VGND sg13cmos5l_fill_2
X_08164_ _08164_/X _13433_/Q _13401_/Q _13369_/Q _13337_/Q _08164_/S0 _08254_/A1 VPWR
+ VGND sg13cmos5l_mux4_1
X_08095_ _08095_/Y _13128_/B _08095_/B VPWR VGND sg13cmos5l_nor2_1
X_14229__1248 _14229_/RESET_B VPWR VGND sg13cmos5l_tiehi
Xclkload70 clkload70/Y clkload70/A VPWR VGND sg13cmos5l_inv_1
Xhold3500 hold3500/X _14246_/Q VPWR VGND sg13cmos5l_dlygate4sd3_1
Xclkload81 clkload81/Y clkload81/A VPWR VGND sg13cmos5l_inv_1
XFILLER_0_627 VPWR VGND sg13cmos5l_fill_2
Xhold3533 hold3533/X _14485_/Q VPWR VGND sg13cmos5l_dlygate4sd3_1
Xhold3522 _09071_/A _13308_/Q VPWR VGND sg13cmos5l_dlygate4sd3_1
Xhold3511 hold3511/X _14451_/Q VPWR VGND sg13cmos5l_dlygate4sd3_1
XFILLER_102_544 VPWR VGND sg13cmos5l_fill_1
Xhold2810 _13105_/A _14536_/Q VPWR VGND sg13cmos5l_dlygate4sd3_1
Xhold2821 hold2821/X _14584_/Q VPWR VGND sg13cmos5l_dlygate4sd3_1
Xhold2832 _10268_/A _13897_/Q VPWR VGND sg13cmos5l_dlygate4sd3_1
Xhold3544 hold3544/X _14558_/Q VPWR VGND sg13cmos5l_dlygate4sd3_1
Xhold3555 hold3555/X _14546_/Q VPWR VGND sg13cmos5l_dlygate4sd3_1
Xhold3566 hold3566/X _14270_/Q VPWR VGND sg13cmos5l_dlygate4sd3_1
X_08997_ _08997_/Y _08996_/B _08995_/X _08996_/Y VPWR VGND sg13cmos5l_o21ai_1
Xhold2843 _10201_/A _13864_/Q VPWR VGND sg13cmos5l_dlygate4sd3_1
Xhold2854 hold2854/X _14522_/Q VPWR VGND sg13cmos5l_dlygate4sd3_1
Xhold2865 _09738_/A _13638_/Q VPWR VGND sg13cmos5l_dlygate4sd3_1
X_07948_ _14566_/D _07917_/Y _07948_/B _07948_/C VPWR VGND sg13cmos5l_nand3b_1
Xhold2876 _10163_/A _13845_/Q VPWR VGND sg13cmos5l_dlygate4sd3_1
Xhold2887 _10244_/A _13885_/Q VPWR VGND sg13cmos5l_dlygate4sd3_1
Xhold2898 _09698_/A _13618_/Q VPWR VGND sg13cmos5l_dlygate4sd3_1
XFILLER_84_962 VPWR VGND sg13cmos5l_fill_2
XFILLER_84_973 VPWR VGND sg13cmos5l_fill_2
XFILLER_90_409 VPWR VGND sg13cmos5l_fill_2
X_07879_ _07879_/X _14185_/Q _14184_/Q VPWR VGND sg13cmos5l_or2_1
X_13488__1934 _13488_/RESET_B VPWR VGND sg13cmos5l_tiehi
XFILLER_55_185 VPWR VGND sg13cmos5l_fill_1
XFILLER_71_623 VPWR VGND sg13cmos5l_decap_4
X_09618_ _09625_/D _14457_/Q _14456_/Q _14455_/Q VPWR VGND sg13cmos5l_and3_1
X_10890_ _10961_/B _10971_/A _10971_/B VPWR VGND sg13cmos5l_nor2b_1
XFILLER_43_347 VPWR VGND sg13cmos5l_fill_2
XFILLER_71_645 VPWR VGND sg13cmos5l_decap_8
X_09549_ _09549_/X _14447_/Q _09549_/B VPWR VGND sg13cmos5l_xor2_1
XFILLER_12_701 VPWR VGND sg13cmos5l_fill_2
XFILLER_70_177 VPWR VGND sg13cmos5l_fill_2
XFILLER_52_892 VPWR VGND sg13cmos5l_decap_8
X_13723__1668 _13723_/RESET_B VPWR VGND sg13cmos5l_tiehi
X_12560_ _12560_/X _12583_/A _12560_/B VPWR VGND sg13cmos5l_and2_1
XFILLER_8_705 VPWR VGND sg13cmos5l_fill_2
X_11511_ _11555_/C _11511_/A _11511_/B VPWR VGND sg13cmos5l_nand2_1
X_12491_ _12491_/Y _14391_/Q _12503_/B VPWR VGND sg13cmos5l_nand2_1
X_11442_ _11442_/Y _11443_/A _11443_/B _11443_/C VPWR VGND sg13cmos5l_o21ai_1
X_14230_ _14230_/Q clkload45/A _14230_/D _14230_/RESET_B VPWR VGND sg13cmos5l_dfrbpq_1
X_11373_ _11373_/Y _11373_/A _11436_/B VPWR VGND sg13cmos5l_nand2_1
X_14161_ _14161_/Q clkload25/A _14161_/D fanout992/X VPWR VGND sg13cmos5l_dfrbpq_1
X_10324_ _13924_/D _10585_/A1 _10345_/B _10323_/Y VPWR VGND sg13cmos5l_a21oi_1
X_13112_ _14540_/D hold3528/X _08041_/B _13118_/S VPWR VGND sg13cmos5l_mux2_1
XFILLER_106_861 VPWR VGND sg13cmos5l_decap_4
X_14092_ _14092_/Q clkload71/A _14092_/D _14092_/RESET_B VPWR VGND sg13cmos5l_dfrbpq_1
XFILLER_106_894 VPWR VGND sg13cmos5l_decap_8
XFILLER_78_211 VPWR VGND sg13cmos5l_fill_1
X_10255_ _13890_/D _10385_/A1 _10276_/B _10254_/Y VPWR VGND sg13cmos5l_a21oi_1
X_13043_ _14507_/D _13043_/A _13043_/B VPWR VGND sg13cmos5l_xnor2_1
XFILLER_67_907 VPWR VGND sg13cmos5l_fill_2
XFILLER_79_745 VPWR VGND sg13cmos5l_decap_4
X_10186_ _13856_/D _10381_/A1 _10169_/B _10185_/Y VPWR VGND sg13cmos5l_a21oi_1
XFILLER_94_704 VPWR VGND sg13cmos5l_fill_1
XFILLER_94_726 VPWR VGND sg13cmos5l_fill_1
X_13356__2066 _13356_/RESET_B VPWR VGND sg13cmos5l_tiehi
Xfanout290 _09910_/B _09922_/B VPWR VGND sg13cmos5l_buf_1
X_14270__1817 _14270_/RESET_B VPWR VGND sg13cmos5l_tiehi
XFILLER_47_675 VPWR VGND sg13cmos5l_fill_1
X_13945_ _13945_/Q clkload50/A _13945_/D _13945_/RESET_B VPWR VGND sg13cmos5l_dfrbpq_1
XFILLER_74_461 VPWR VGND sg13cmos5l_decap_4
X_13876_ _13876_/Q clkload18/A _13876_/D _13876_/RESET_B VPWR VGND sg13cmos5l_dfrbpq_1
X_14287__1221 _14287_/RESET_B VPWR VGND sg13cmos5l_tiehi
X_12827_ _12827_/Y _12822_/Y _12825_/Y _12826_/Y VPWR VGND sg13cmos5l_a21oi_1
XFILLER_30_520 VPWR VGND sg13cmos5l_decap_4
X_12758_ _12759_/B _14453_/Q _13243_/Q _12750_/Y VPWR VGND sg13cmos5l_a21oi_1
X_11709_ _14347_/D _07712_/B _11738_/S _11708_/Y VPWR VGND sg13cmos5l_a21oi_1
X_12689_ _12689_/Y _12698_/A _12700_/B VPWR VGND sg13cmos5l_nand2_1
X_14428_ _14428_/Q clkload81/A _14428_/D _14428_/RESET_B VPWR VGND sg13cmos5l_dfrbpq_1
X_14359_ _14359_/Q clkload77/A _14359_/D _14359_/RESET_B VPWR VGND sg13cmos5l_dfrbpq_1
X_13878__1513 _13878_/RESET_B VPWR VGND sg13cmos5l_tiehi
X_13566__1856 _13566_/RESET_B VPWR VGND sg13cmos5l_tiehi
X_08920_ _13245_/D _07283_/Y _13196_/A2 _13190_/B1 _08919_/Y VPWR VGND sg13cmos5l_a22oi_1
XFILLER_34_0 VPWR VGND sg13cmos5l_fill_2
X_08851_ _14640_/D _08851_/A _08851_/B _08851_/C _08851_/D VPWR VGND sg13cmos5l_nand4_1
XFILLER_69_277 VPWR VGND sg13cmos5l_fill_1
X_07802_ _07802_/Y _14399_/Q _12248_/A VPWR VGND sg13cmos5l_nor2_1
XFILLER_66_940 VPWR VGND sg13cmos5l_decap_4
X_08782_ _08782_/Y _08782_/A1 _07340_/Y _08781_/Y VPWR VGND sg13cmos5l_o21ai_1
X_07733_ _07734_/B _11109_/A _11668_/A VPWR VGND sg13cmos5l_nand2_1
XFILLER_1_91 VPWR VGND sg13cmos5l_fill_1
XFILLER_26_848 VPWR VGND sg13cmos5l_fill_1
XFILLER_93_781 VPWR VGND sg13cmos5l_fill_2
X_07664_ _07665_/C _08867_/A _08562_/B VPWR VGND sg13cmos5l_nor2_1
XFILLER_81_954 VPWR VGND sg13cmos5l_decap_8
X_09403_ _13515_/D _08332_/A hold3054/X _09409_/S VPWR VGND sg13cmos5l_mux2_1
XFILLER_80_464 VPWR VGND sg13cmos5l_decap_8
XFILLER_80_486 VPWR VGND sg13cmos5l_fill_1
X_07595_ _07596_/C _07595_/A _08999_/B VPWR VGND sg13cmos5l_xor2_1
X_13401__2021 _13401_/RESET_B VPWR VGND sg13cmos5l_tiehi
X_09334_ _13450_/D _08320_/A hold3267/X _09338_/S VPWR VGND sg13cmos5l_mux2_1
X_09265_ _13390_/D _09302_/A hold3257/X _09268_/S VPWR VGND sg13cmos5l_mux2_1
X_08216_ _12735_/B _08379_/C1 _08215_/Y _08211_/Y VPWR VGND sg13cmos5l_o21ai_1
X_09196_ _09196_/Y _14373_/Q _09196_/A2 _09195_/Y VPWR VGND sg13cmos5l_a21oi_1
X_08147_ _13223_/D _08147_/A _08149_/C VPWR VGND sg13cmos5l_xor2_1
X_08078_ _13204_/D _13146_/A _08078_/B _08078_/C VPWR VGND sg13cmos5l_nor3_1
XFILLER_1_936 VPWR VGND sg13cmos5l_decap_8
XFILLER_96_27 VPWR VGND sg13cmos5l_fill_2
X_10040_ _10040_/Y _10040_/A _10044_/B VPWR VGND sg13cmos5l_nand2_1
Xhold3352 hold3352/X _13547_/Q VPWR VGND sg13cmos5l_dlygate4sd3_1
Xhold3341 hold3341/X _13499_/Q VPWR VGND sg13cmos5l_dlygate4sd3_1
Xhold3330 _08911_/A _14613_/Q VPWR VGND sg13cmos5l_dlygate4sd3_1
X_14365__1143 _14365_/RESET_B VPWR VGND sg13cmos5l_tiehi
XFILLER_76_726 VPWR VGND sg13cmos5l_fill_1
Xhold2640 _11196_/A _14314_/Q VPWR VGND sg13cmos5l_dlygate4sd3_1
Xhold3385 hold3385/X _13279_/Q VPWR VGND sg13cmos5l_dlygate4sd3_1
Xhold3374 hold3374/X _13431_/Q VPWR VGND sg13cmos5l_dlygate4sd3_1
Xhold3363 hold3363/X _13498_/Q VPWR VGND sg13cmos5l_dlygate4sd3_1
Xhold2651 _10199_/A _13863_/Q VPWR VGND sg13cmos5l_dlygate4sd3_1
Xhold2662 _07319_/A _13357_/Q VPWR VGND sg13cmos5l_dlygate4sd3_1
Xhold2673 _10337_/A _13931_/Q VPWR VGND sg13cmos5l_dlygate4sd3_1
Xhold3396 _11043_/A _14275_/Q VPWR VGND sg13cmos5l_dlygate4sd3_1
X_14086__1321 _14086_/RESET_B VPWR VGND sg13cmos5l_tiehi
XFILLER_63_409 VPWR VGND sg13cmos5l_decap_8
X_11991_ _12022_/A _14358_/Q _13243_/Q VPWR VGND sg13cmos5l_nand2_1
Xhold2684 _10472_/A _13997_/Q VPWR VGND sg13cmos5l_dlygate4sd3_1
Xhold2695 _10366_/A _13945_/Q VPWR VGND sg13cmos5l_dlygate4sd3_1
XFILLER_56_461 VPWR VGND sg13cmos5l_fill_1
XFILLER_72_921 VPWR VGND sg13cmos5l_decap_8
XFILLER_72_932 VPWR VGND sg13cmos5l_fill_1
X_10942_ _14214_/D _10844_/Y _10943_/B _10941_/Y VPWR VGND sg13cmos5l_o21ai_1
X_13730_ _13730_/Q clkload58/A _13730_/D _13730_/RESET_B VPWR VGND sg13cmos5l_dfrbpq_1
XFILLER_43_111 VPWR VGND sg13cmos5l_fill_1
XFILLER_44_667 VPWR VGND sg13cmos5l_fill_1
XFILLER_72_943 VPWR VGND sg13cmos5l_decap_8
XFILLER_71_475 VPWR VGND sg13cmos5l_fill_1
X_10873_ _10873_/Y _10877_/A _10873_/B VPWR VGND sg13cmos5l_nand2_1
X_13956__1435 _13956_/RESET_B VPWR VGND sg13cmos5l_tiehi
X_13661_ _13661_/Q _14045_/CLK _13661_/D _13661_/RESET_B VPWR VGND sg13cmos5l_dfrbpq_1
X_13592_ _13592_/Q _14299_/CLK _13592_/D _13592_/RESET_B VPWR VGND sg13cmos5l_dfrbpq_1
X_12612_ _12612_/Y _13034_/A _12639_/C _12641_/A _12611_/Y VPWR VGND sg13cmos5l_a22oi_1
X_12543_ _12543_/Y _12545_/A _13257_/Q _12542_/Y VPWR VGND sg13cmos5l_o21ai_1
X_14213_ _14213_/Q _14217_/CLK _14213_/D _14213_/RESET_B VPWR VGND sg13cmos5l_dfrbpq_1
X_12474_ _14386_/D _12474_/A _12474_/B VPWR VGND sg13cmos5l_nand2_1
XANTENNA_7 _08861_/A VPWR VGND sg13cmos5l_antennanp
X_11425_ _11453_/C _14176_/Q _11403_/B _11416_/B _14095_/Q VPWR VGND sg13cmos5l_a22oi_1
X_14170__1307 _14170_/RESET_B VPWR VGND sg13cmos5l_tiehi
XFILLER_99_818 VPWR VGND sg13cmos5l_fill_1
X_11356_ _11356_/Y _11338_/A _11347_/B _12933_/B2 VPWR VGND sg13cmos5l_o21ai_1
X_14144_ _14144_/Q clkload26/A _14144_/D fanout985/X VPWR VGND sg13cmos5l_dfrbpq_1
XFILLER_3_251 VPWR VGND sg13cmos5l_fill_1
X_10307_ _10307_/Y _10307_/A _10319_/B VPWR VGND sg13cmos5l_nor2_1
X_14075_ _14075_/Q clkload14/A _14075_/D fanout970/X VPWR VGND sg13cmos5l_dfrbpq_1
X_11287_ _11303_/A _11302_/A _11302_/B _11302_/C VPWR VGND sg13cmos5l_nand3_1
X_13026_ _13028_/B _14499_/Q _14500_/Q _14501_/Q _13026_/D VPWR VGND sg13cmos5l_nand4_1
X_10238_ _10238_/Y _10238_/A _10238_/B VPWR VGND sg13cmos5l_nor2_1
X_10169_ _10169_/Y _10169_/A _10169_/B VPWR VGND sg13cmos5l_nor2_1
XFILLER_82_718 VPWR VGND sg13cmos5l_fill_1
XFILLER_63_910 VPWR VGND sg13cmos5l_fill_2
X_13928_ _13928_/Q clkload61/A _13928_/D _13928_/RESET_B VPWR VGND sg13cmos5l_dfrbpq_1
XFILLER_34_111 VPWR VGND sg13cmos5l_fill_2
XFILLER_34_122 VPWR VGND sg13cmos5l_fill_1
XFILLER_50_615 VPWR VGND sg13cmos5l_fill_2
XFILLER_62_464 VPWR VGND sg13cmos5l_fill_2
X_13859_ _13859_/Q clkload59/A _13859_/D _13859_/RESET_B VPWR VGND sg13cmos5l_dfrbpq_1
X_07380_ _07400_/B _07587_/A VPWR VGND sg13cmos5l_inv_1
XFILLER_30_372 VPWR VGND sg13cmos5l_fill_1
X_09050_ _11235_/A _14317_/Q _09073_/B VPWR VGND sg13cmos5l_nand2_1
X_14443__1065 _14443_/RESET_B VPWR VGND sg13cmos5l_tiehi
X_08001_ _14181_/D _08001_/A VPWR VGND sg13cmos5l_inv_1
X_09952_ _09952_/Y _09952_/A _09952_/B VPWR VGND sg13cmos5l_nor2_1
X_08903_ _14654_/D hold2560/X _08911_/B _08902_/Y VPWR VGND sg13cmos5l_a21o_1
XFILLER_106_48 VPWR VGND sg13cmos5l_fill_2
X_09883_ _13708_/D fanout78/X _09882_/B _09882_/Y VPWR VGND sg13cmos5l_a21oi_1
X_13419__2003 _13419_/RESET_B VPWR VGND sg13cmos5l_tiehi
X_13240__1024 _13240_/RESET_B VPWR VGND sg13cmos5l_tiehi
XFILLER_100_845 VPWR VGND sg13cmos5l_fill_1
X_08834_ _08834_/Y _08834_/A _08839_/B VPWR VGND sg13cmos5l_nand2_1
X_14179__1298 _14179_/RESET_B VPWR VGND sg13cmos5l_tiehi
XFILLER_100_856 VPWR VGND sg13cmos5l_fill_1
XFILLER_100_878 VPWR VGND sg13cmos5l_decap_8
X_08765_ _08765_/Y _08781_/A1 _14152_/Q _13261_/Q _07959_/B VPWR VGND sg13cmos5l_a22oi_1
XFILLER_100_889 VPWR VGND sg13cmos5l_fill_2
XFILLER_54_921 VPWR VGND sg13cmos5l_fill_1
X_07716_ _08465_/A _07716_/A _07716_/B VPWR VGND sg13cmos5l_nand2_1
X_08696_ _08696_/Y _14619_/Q _14620_/Q VPWR VGND sg13cmos5l_xnor2_1
X_13314__2118 _13314_/RESET_B VPWR VGND sg13cmos5l_tiehi
XFILLER_81_762 VPWR VGND sg13cmos5l_decap_8
X_07647_ _08616_/B _14402_/Q _14370_/Q VPWR VGND sg13cmos5l_or2_1
X_07578_ _07579_/C _07578_/A _08979_/B VPWR VGND sg13cmos5l_xor2_1
XFILLER_40_136 VPWR VGND sg13cmos5l_fill_1
X_09317_ _13433_/D _08157_/A hold3001/X _09333_/S VPWR VGND sg13cmos5l_mux2_1
XFILLER_51_1028 VPWR VGND sg13cmos5l_fill_1
X_13640__1751 _13640_/RESET_B VPWR VGND sg13cmos5l_tiehi
XFILLER_31_33 VPWR VGND sg13cmos5l_fill_1
X_09248_ _13373_/D _10690_/A1 hold3089/X _09268_/S VPWR VGND sg13cmos5l_mux2_1
XFILLER_31_66 VPWR VGND sg13cmos5l_fill_2
XFILLER_5_527 VPWR VGND sg13cmos5l_decap_4
X_09179_ _09179_/Y _09179_/A _09197_/B VPWR VGND sg13cmos5l_nor2_1
Xclkbuf_4_10_0_clk clkbuf_4_10_0_clk/X clkbuf_0_clk/X VPWR VGND sg13cmos5l_buf_8
X_11210_ _11211_/C _14086_/Q _11214_/D VPWR VGND sg13cmos5l_xnor2_1
X_12190_ _12275_/B _14366_/Q _12405_/B VPWR VGND sg13cmos5l_nand2_1
X_11141_ _11141_/Y _11141_/A _11141_/B VPWR VGND sg13cmos5l_nor2_1
Xoutput33 uio_out[4] _15884_/X VPWR VGND sg13cmos5l_buf_1
X_14020__1371 _14020_/RESET_B VPWR VGND sg13cmos5l_tiehi
Xoutput44 uo_out[14] _08784_/Y VPWR VGND sg13cmos5l_buf_1
XFILLER_1_755 VPWR VGND sg13cmos5l_fill_1
XFILLER_49_704 VPWR VGND sg13cmos5l_decap_4
X_11072_ _11072_/Y _14385_/Q _11088_/A2 _11071_/X VPWR VGND sg13cmos5l_a21oi_1
Xhold3160 hold3160/X _13402_/Q VPWR VGND sg13cmos5l_dlygate4sd3_1
XFILLER_76_534 VPWR VGND sg13cmos5l_decap_8
X_10023_ _10023_/Y _10023_/A _10023_/B VPWR VGND sg13cmos5l_nand2_1
Xhold3171 hold3171/X _13365_/Q VPWR VGND sg13cmos5l_dlygate4sd3_1
Xhold3182 _08119_/A _13211_/Q VPWR VGND sg13cmos5l_dlygate4sd3_1
Xhold3193 hold3193/X _13463_/Q VPWR VGND sg13cmos5l_dlygate4sd3_1
X_15880_ _15880_/X _15880_/A VPWR VGND sg13cmos5l_buf_1
XFILLER_56_30 VPWR VGND sg13cmos5l_fill_2
XFILLER_64_707 VPWR VGND sg13cmos5l_fill_1
XFILLER_76_545 VPWR VGND sg13cmos5l_decap_8
XFILLER_76_578 VPWR VGND sg13cmos5l_fill_2
Xhold2470 _14074_/D _10636_/Y VPWR VGND sg13cmos5l_dlygate4sd3_1
Xhold2481 _07324_/A _13425_/Q VPWR VGND sg13cmos5l_dlygate4sd3_1
XFILLER_29_472 VPWR VGND sg13cmos5l_fill_1
XFILLER_91_526 VPWR VGND sg13cmos5l_fill_1
Xhold2492 _10093_/A _13811_/Q VPWR VGND sg13cmos5l_dlygate4sd3_1
XFILLER_16_122 VPWR VGND sg13cmos5l_fill_1
XFILLER_29_494 VPWR VGND sg13cmos5l_decap_8
XFILLER_45_943 VPWR VGND sg13cmos5l_fill_2
XFILLER_56_291 VPWR VGND sg13cmos5l_decap_8
X_11974_ _11974_/Y _11964_/Y _11968_/Y _11973_/Y _12012_/A1 VPWR VGND sg13cmos5l_a22oi_1
XFILLER_72_762 VPWR VGND sg13cmos5l_decap_8
XFILLER_72_773 VPWR VGND sg13cmos5l_fill_1
X_10925_ _10925_/Y _10925_/A _10932_/B VPWR VGND sg13cmos5l_nand2_1
X_13713_ _13713_/Q clkload70/A _13713_/D _13713_/RESET_B VPWR VGND sg13cmos5l_dfrbpq_1
XFILLER_32_637 VPWR VGND sg13cmos5l_fill_1
X_10856_ _10906_/A _14247_/D _10971_/A VPWR VGND sg13cmos5l_nand2_1
X_14224__1253 _14224_/RESET_B VPWR VGND sg13cmos5l_tiehi
X_13644_ _13644_/Q clkload61/A _13644_/D _13644_/RESET_B VPWR VGND sg13cmos5l_dfrbpq_1
XFILLER_13_884 VPWR VGND sg13cmos5l_fill_2
X_10787_ _10787_/Y _10787_/A _10790_/B VPWR VGND sg13cmos5l_nand2_1
X_13575_ _13575_/Q clkload28/A _13575_/D _13575_/RESET_B VPWR VGND sg13cmos5l_dfrbpq_1
X_12526_ _12526_/Y _12523_/A _12299_/Y _12530_/B VPWR VGND sg13cmos5l_a21oi_1
XFILLER_9_899 VPWR VGND sg13cmos5l_fill_2
X_12457_ _12457_/Y _08638_/A _11789_/Y _12460_/B VPWR VGND sg13cmos5l_a21oi_1
X_11408_ _11409_/B _11408_/A _11408_/B VPWR VGND sg13cmos5l_nand2_1
X_14127_ _14127_/Q clkload33/A _14127_/D fanout998/X VPWR VGND sg13cmos5l_dfrbpq_1
X_12388_ _12388_/Y _14372_/Q _13257_/Q VPWR VGND sg13cmos5l_nand2_1
X_11339_ _11339_/Y _11316_/A _11336_/Y _11338_/Y _10982_/Y VPWR VGND sg13cmos5l_a22oi_1
XFILLER_79_361 VPWR VGND sg13cmos5l_fill_2
X_14058_ _14058_/Q clkload51/A _14058_/D _14058_/RESET_B VPWR VGND sg13cmos5l_dfrbpq_1
XFILLER_79_394 VPWR VGND sg13cmos5l_fill_2
XFILLER_95_821 VPWR VGND sg13cmos5l_decap_4
X_13009_ _13009_/Y _13009_/A _13009_/B VPWR VGND sg13cmos5l_xnor2_1
XFILLER_67_567 VPWR VGND sg13cmos5l_decap_4
X_13682__1709 _13682_/RESET_B VPWR VGND sg13cmos5l_tiehi
XFILLER_48_781 VPWR VGND sg13cmos5l_fill_2
XFILLER_55_718 VPWR VGND sg13cmos5l_decap_8
XFILLER_48_792 VPWR VGND sg13cmos5l_fill_1
XFILLER_63_740 VPWR VGND sg13cmos5l_decap_8
X_08550_ _08576_/B _08582_/A _08582_/B VPWR VGND sg13cmos5l_nor2_1
X_07501_ _13032_/D _07532_/A _07501_/B VPWR VGND sg13cmos5l_and2_1
X_08481_ _08482_/B _08476_/A _08488_/C _08480_/X VPWR VGND sg13cmos5l_a21oi_1
X_07432_ _07432_/Y _07434_/C _07433_/B VPWR VGND sg13cmos5l_nor2_1
X_14062__1329 _14062_/RESET_B VPWR VGND sg13cmos5l_tiehi
X_07363_ _07578_/A _08979_/A _14554_/Q VPWR VGND sg13cmos5l_xnor2_1
X_09102_ _13313_/D _09125_/B _09100_/Y _09101_/Y VPWR VGND sg13cmos5l_a21oi_1
X_07294_ _12334_/B _13255_/Q VPWR VGND sg13cmos5l_inv_1
X_09033_ _13299_/D _09001_/C hold3509/X _09033_/S VPWR VGND sg13cmos5l_mux2_1
X_13351__2071 _13351_/RESET_B VPWR VGND sg13cmos5l_tiehi
X_09935_ _13733_/D _10326_/A1 _09948_/B _09934_/Y VPWR VGND sg13cmos5l_a21oi_1
Xfanout834 _12589_/A _14440_/Q VPWR VGND sg13cmos5l_buf_1
Xfanout823 _12504_/A fanout828/X VPWR VGND sg13cmos5l_buf_1
Xfanout812 _11867_/B _11635_/A VPWR VGND sg13cmos5l_buf_1
Xfanout801 _08403_/S _08393_/A1 VPWR VGND sg13cmos5l_buf_1
X_09866_ _09866_/Y _09866_/A _09878_/B VPWR VGND sg13cmos5l_nor2_1
Xfanout867 _08559_/A fanout872/X VPWR VGND sg13cmos5l_buf_1
Xfanout856 _09560_/S _11005_/B1 VPWR VGND sg13cmos5l_buf_1
Xfanout845 _11711_/A _14348_/Q VPWR VGND sg13cmos5l_buf_1
X_08817_ _08818_/C _08817_/A _08822_/B VPWR VGND sg13cmos5l_nand2_1
Xfanout889 _08344_/A _14125_/Q VPWR VGND sg13cmos5l_buf_1
Xfanout878 _08923_/A _10982_/B VPWR VGND sg13cmos5l_buf_1
XFILLER_73_504 VPWR VGND sg13cmos5l_decap_8
X_09797_ _09797_/Y _09797_/A _09797_/B VPWR VGND sg13cmos5l_nor2_1
X_13658__1733 _13658_/RESET_B VPWR VGND sg13cmos5l_tiehi
X_08748_ _08748_/Y _13910_/Q _08729_/B _08748_/B1 _13846_/Q _08747_/X VPWR VGND sg13cmos5l_a221oi_1
XFILLER_26_453 VPWR VGND sg13cmos5l_fill_2
X_08679_ _14619_/D _14177_/Q _08753_/B _08678_/Y VPWR VGND sg13cmos5l_a21o_1
XFILLER_42_946 VPWR VGND sg13cmos5l_fill_1
X_10710_ _14130_/D input8/X hold3483/X _10710_/S VPWR VGND sg13cmos5l_mux2_1
XFILLER_41_456 VPWR VGND sg13cmos5l_decap_4
X_11690_ _11690_/Y _11687_/Y _11688_/Y _11689_/Y _12245_/B2 VPWR VGND sg13cmos5l_a22oi_1
X_14038__1353 _14038_/RESET_B VPWR VGND sg13cmos5l_tiehi
X_10641_ _10647_/D _10641_/A _10642_/B VPWR VGND sg13cmos5l_nor2_1
X_13561__1861 _13561_/RESET_B VPWR VGND sg13cmos5l_tiehi
X_10572_ _10572_/Y _10572_/A _10582_/B VPWR VGND sg13cmos5l_nand2_1
X_13360_ _13360_/Q clkload34/A _13360_/D _13360_/RESET_B VPWR VGND sg13cmos5l_dfrbpq_1
X_13291_ _13291_/Q clkload8/A _13291_/D fanout959/X VPWR VGND sg13cmos5l_dfrbpq_1
X_12311_ _12311_/Y _13741_/Q _12317_/B _12195_/B _13997_/Q _12349_/C1 VPWR VGND sg13cmos5l_a221oi_1
X_12242_ _12242_/Y _13866_/Q _12242_/B VPWR VGND sg13cmos5l_nand2_1
X_12173_ _12176_/A _13800_/Q _12401_/B1 _12398_/B1 VPWR VGND sg13cmos5l_a21oi_1
XFILLER_96_629 VPWR VGND sg13cmos5l_decap_4
X_11124_ _14298_/D _11123_/B _11122_/Y _11123_/Y VPWR VGND sg13cmos5l_a21oi_1
XFILLER_104_992 VPWR VGND sg13cmos5l_decap_8
XFILLER_77_832 VPWR VGND sg13cmos5l_decap_4
X_11055_ _14281_/D _11117_/A _11141_/B _11054_/Y VPWR VGND sg13cmos5l_a21oi_1
XFILLER_103_491 VPWR VGND sg13cmos5l_fill_1
X_10006_ _13768_/D _10593_/A1 _10013_/B _10005_/Y VPWR VGND sg13cmos5l_o21ai_1
XFILLER_97_1028 VPWR VGND sg13cmos5l_fill_1
XFILLER_64_559 VPWR VGND sg13cmos5l_fill_1
XFILLER_92_846 VPWR VGND sg13cmos5l_fill_1
XFILLER_92_879 VPWR VGND sg13cmos5l_decap_4
X_11957_ _11981_/B _11957_/A _11956_/Y VPWR VGND sg13cmos5l_nor2b_1
X_10908_ _14200_/D _10908_/A VPWR VGND sg13cmos5l_inv_1
X_13393__2029 _13393_/RESET_B VPWR VGND sg13cmos5l_tiehi
XFILLER_32_434 VPWR VGND sg13cmos5l_fill_1
XFILLER_60_743 VPWR VGND sg13cmos5l_fill_1
X_11888_ _11888_/X _13630_/Q _12373_/B VPWR VGND sg13cmos5l_and2_1
X_10839_ _10841_/D _10935_/B VPWR VGND sg13cmos5l_inv_1
X_13627_ _13627_/Q _14042_/CLK _13627_/D _13627_/RESET_B VPWR VGND sg13cmos5l_dfrbpq_1
X_13558_ _13558_/Q clkload27/A _13558_/D _13558_/RESET_B VPWR VGND sg13cmos5l_dfrbpq_1
XFILLER_9_685 VPWR VGND sg13cmos5l_fill_1
X_12509_ _12510_/B _12515_/B _13248_/Q _12508_/Y VPWR VGND sg13cmos5l_o21ai_1
X_13489_ _13489_/Q clkload32/A _13489_/D _13489_/RESET_B VPWR VGND sg13cmos5l_dfrbpq_1
X_13736__1655 _13736_/RESET_B VPWR VGND sg13cmos5l_tiehi
X_13424__1998 _13424_/RESET_B VPWR VGND sg13cmos5l_tiehi
X_07981_ _07981_/Y _08214_/A _07980_/X VPWR VGND sg13cmos5l_nor2b_1
Xfanout119 _09438_/S _09442_/S VPWR VGND sg13cmos5l_buf_1
Xfanout108 _10532_/A1 _10597_/A1 VPWR VGND sg13cmos5l_buf_1
X_09720_ _09720_/Y _09720_/A _09724_/B VPWR VGND sg13cmos5l_nor2_1
XFILLER_68_854 VPWR VGND sg13cmos5l_fill_2
X_13951__1440 _13951_/RESET_B VPWR VGND sg13cmos5l_tiehi
XFILLER_83_802 VPWR VGND sg13cmos5l_decap_8
XFILLER_83_824 VPWR VGND sg13cmos5l_fill_1
X_09651_ _09651_/Y _07166_/Y _09645_/Y _09671_/A VPWR VGND sg13cmos5l_a21oi_1
XFILLER_67_386 VPWR VGND sg13cmos5l_decap_4
X_08602_ _08604_/B _08616_/A _08602_/B VPWR VGND sg13cmos5l_or2_1
X_09582_ _09582_/Y _09589_/B _09589_/C _09571_/A VPWR VGND sg13cmos5l_a21oi_1
XFILLER_24_913 VPWR VGND sg13cmos5l_fill_1
XFILLER_82_367 VPWR VGND sg13cmos5l_fill_2
X_08533_ _08534_/B _08536_/A _08535_/B _08532_/Y VPWR VGND sg13cmos5l_o21ai_1
XFILLER_91_890 VPWR VGND sg13cmos5l_decap_8
XFILLER_51_765 VPWR VGND sg13cmos5l_decap_4
X_08464_ _08465_/B _08464_/A _08464_/B VPWR VGND sg13cmos5l_nor2_1
X_13369__2053 _13369_/RESET_B VPWR VGND sg13cmos5l_tiehi
XFILLER_50_275 VPWR VGND sg13cmos5l_fill_2
XFILLER_51_787 VPWR VGND sg13cmos5l_fill_2
X_07415_ _08098_/A _07629_/A _07415_/B _07415_/C _07415_/D VPWR VGND sg13cmos5l_nand4_1
X_08395_ _12608_/A _08344_/C _08384_/X _08394_/Y VPWR VGND sg13cmos5l_a21oi_1
X_07346_ _07350_/A _13323_/Q _13322_/Q _13325_/Q _13324_/Q VPWR VGND sg13cmos5l_nor4_1
X_07277_ _07277_/Y _13240_/Q VPWR VGND sg13cmos5l_inv_1
X_09016_ _09016_/Y _09016_/A _09024_/B VPWR VGND sg13cmos5l_nand2_1
X_09918_ _09918_/Y _09918_/A _09924_/B VPWR VGND sg13cmos5l_nor2_1
Xfanout642 _12124_/A2 _12383_/A2 VPWR VGND sg13cmos5l_buf_1
Xfanout631 _12503_/B _12487_/B VPWR VGND sg13cmos5l_buf_1
Xfanout620 _08208_/A2 _07527_/B1 VPWR VGND sg13cmos5l_buf_1
Xfanout675 _09163_/B _09175_/B VPWR VGND sg13cmos5l_buf_1
Xfanout664 _13184_/A2 _10885_/C VPWR VGND sg13cmos5l_buf_1
Xfanout653 _11146_/B1 _11091_/Y VPWR VGND sg13cmos5l_buf_1
X_09849_ _13691_/D _10371_/A1 _09858_/B _09848_/Y VPWR VGND sg13cmos5l_a21oi_1
Xfanout697 _09196_/A2 _11029_/B VPWR VGND sg13cmos5l_buf_1
Xfanout686 _11530_/A _11605_/A VPWR VGND sg13cmos5l_buf_1
X_13579__1843 _13579_/RESET_B VPWR VGND sg13cmos5l_tiehi
XFILLER_2_1010 VPWR VGND sg13cmos5l_decap_8
X_12860_ _12860_/X _11092_/A _12582_/X _12879_/B1 VPWR VGND sg13cmos5l_a21o_1
XFILLER_15_913 VPWR VGND sg13cmos5l_fill_1
X_11811_ _11811_/Y _13915_/Q _11915_/B _11811_/B1 _13595_/Q VPWR VGND sg13cmos5l_a22oi_1
XFILLER_14_423 VPWR VGND sg13cmos5l_fill_2
XFILLER_54_570 VPWR VGND sg13cmos5l_fill_1
XFILLER_61_529 VPWR VGND sg13cmos5l_decap_8
X_14530_ _14530_/Q _14532_/CLK _14530_/D fanout970/X VPWR VGND sg13cmos5l_dfrbpq_1
X_12791_ _12806_/A _12790_/B _12790_/C _12824_/A VPWR VGND sg13cmos5l_o21ai_1
X_11742_ _11768_/B _11741_/A _11741_/B _11741_/C VPWR VGND sg13cmos5l_a21o_1
X_13814__1577 _13814_/RESET_B VPWR VGND sg13cmos5l_tiehi
X_11673_ _12620_/A _14347_/Q _11867_/B VPWR VGND sg13cmos5l_nand2_1
X_14461_ _14461_/Q _14650_/CLK _14461_/D _14461_/RESET_B VPWR VGND sg13cmos5l_dfrbpq_1
XFILLER_23_990 VPWR VGND sg13cmos5l_fill_1
X_10624_ _10624_/Y _10624_/A _10624_/B VPWR VGND sg13cmos5l_xnor2_1
X_14392_ _14392_/Q clkload76/A _14392_/D _14392_/RESET_B VPWR VGND sg13cmos5l_dfrbpq_1
X_13412_ _13412_/Q _14622_/CLK _13412_/D _13412_/RESET_B VPWR VGND sg13cmos5l_dfrbpq_1
X_13343_ _13343_/Q _13568_/CLK _13343_/D _13343_/RESET_B VPWR VGND sg13cmos5l_dfrbpq_1
X_10555_ _14037_/D _10555_/A1 _10564_/B _10554_/Y VPWR VGND sg13cmos5l_o21ai_1
X_10486_ _14003_/D _10551_/A1 _10497_/B _10485_/Y VPWR VGND sg13cmos5l_o21ai_1
X_13274_ _13274_/Q clkload11/A _13274_/D fanout963/X VPWR VGND sg13cmos5l_dfrbpq_1
XFILLER_5_187 VPWR VGND sg13cmos5l_decap_8
X_12225_ _12226_/B _12256_/A _12256_/B _12136_/A VPWR VGND sg13cmos5l_a21oi_1
X_12156_ _12216_/A _14364_/Q _13249_/Q VPWR VGND sg13cmos5l_xnor2_1
XFILLER_78_83 VPWR VGND sg13cmos5l_fill_1
XFILLER_96_426 VPWR VGND sg13cmos5l_fill_2
X_11107_ _11107_/Y _11107_/A _11107_/B VPWR VGND sg13cmos5l_nor2_1
XFILLER_49_331 VPWR VGND sg13cmos5l_fill_1
X_12087_ _12090_/A _13669_/Q _12087_/B VPWR VGND sg13cmos5l_nand2_1
X_11038_ _11040_/C _14482_/Q _07434_/Y _07435_/Y _15895_/A VPWR VGND sg13cmos5l_a22oi_1
XFILLER_64_334 VPWR VGND sg13cmos5l_fill_1
XFILLER_52_518 VPWR VGND sg13cmos5l_fill_2
XFILLER_91_131 VPWR VGND sg13cmos5l_fill_1
XFILLER_92_654 VPWR VGND sg13cmos5l_fill_2
X_14378__1130 _14378_/RESET_B VPWR VGND sg13cmos5l_tiehi
XFILLER_64_378 VPWR VGND sg13cmos5l_fill_2
X_12989_ _12989_/Y _12989_/A _12989_/B VPWR VGND sg13cmos5l_xnor2_1
XFILLER_91_197 VPWR VGND sg13cmos5l_fill_2
XFILLER_60_562 VPWR VGND sg13cmos5l_fill_1
X_07200_ _07618_/B _14504_/Q VPWR VGND sg13cmos5l_inv_1
X_08180_ _12550_/B _08204_/A1 _08179_/Y _08175_/Y VPWR VGND sg13cmos5l_o21ai_1
X_13969__1422 _13969_/RESET_B VPWR VGND sg13cmos5l_tiehi
XFILLER_106_509 VPWR VGND sg13cmos5l_fill_1
XFILLER_99_275 VPWR VGND sg13cmos5l_fill_1
XFILLER_99_286 VPWR VGND sg13cmos5l_fill_1
X_07964_ _07965_/C _14078_/Q _08207_/A2 _08208_/A2 _14517_/Q VPWR VGND sg13cmos5l_a22oi_1
X_07895_ _07896_/D _14212_/Q _14206_/Q _14193_/Q _14190_/Q VPWR VGND sg13cmos5l_nor4_1
X_09703_ _13620_/D _10357_/A1 _09706_/B _09702_/Y VPWR VGND sg13cmos5l_a21oi_1
XFILLER_67_183 VPWR VGND sg13cmos5l_fill_2
XFILLER_83_621 VPWR VGND sg13cmos5l_fill_2
X_09634_ _13608_/D _09682_/B _10397_/A1 _09629_/Y VPWR VGND sg13cmos5l_a21oi_1
X_09565_ _09565_/Y _09565_/A _09587_/B VPWR VGND sg13cmos5l_nor2_1
XFILLER_70_348 VPWR VGND sg13cmos5l_fill_1
X_08516_ _08516_/Y _08536_/A _08516_/B VPWR VGND sg13cmos5l_nand2_1
X_09496_ _09496_/Y _12577_/A _09509_/A VPWR VGND sg13cmos5l_nor2_1
X_08447_ _08447_/Y _08447_/A _09060_/B VPWR VGND sg13cmos5l_nor2_1
X_08378_ _08378_/Y _08378_/A1 _13454_/Q _08377_/Y VPWR VGND sg13cmos5l_o21ai_1
X_07329_ _07329_/Y _07329_/A VPWR VGND sg13cmos5l_inv_1
X_10340_ _13932_/D fanout77/X _10339_/B _10339_/Y VPWR VGND sg13cmos5l_a21oi_1
X_10271_ _13898_/D _10597_/A1 _10280_/B _10270_/Y VPWR VGND sg13cmos5l_a21oi_1
X_12010_ _12010_/Y _13922_/Q _12010_/A2 _12203_/B1 _13858_/Q _12010_/C1 VPWR VGND
+ sg13cmos5l_a221oi_1
XFILLER_78_404 VPWR VGND sg13cmos5l_decap_8
XFILLER_78_415 VPWR VGND sg13cmos5l_fill_1
Xfanout450 _08725_/B _08743_/B VPWR VGND sg13cmos5l_buf_1
Xfanout483 _12427_/A2 fanout484/X VPWR VGND sg13cmos5l_buf_1
Xfanout472 _11916_/A2 fanout484/X VPWR VGND sg13cmos5l_buf_1
Xfanout461 _12260_/B _12296_/B1 VPWR VGND sg13cmos5l_buf_1
X_13961_ _13961_/Q clkload64/A _13961_/D _13961_/RESET_B VPWR VGND sg13cmos5l_dfrbpq_1
XFILLER_46_312 VPWR VGND sg13cmos5l_fill_1
XFILLER_74_632 VPWR VGND sg13cmos5l_decap_8
Xfanout494 _11998_/B1 fanout505/X VPWR VGND sg13cmos5l_buf_1
X_12912_ _14443_/D _12912_/A VPWR VGND sg13cmos5l_inv_1
XFILLER_0_38 VPWR VGND sg13cmos5l_decap_8
XFILLER_74_676 VPWR VGND sg13cmos5l_fill_1
X_13892_ _13892_/Q clkload70/A _13892_/D _13892_/RESET_B VPWR VGND sg13cmos5l_dfrbpq_1
XFILLER_55_890 VPWR VGND sg13cmos5l_decap_4
XFILLER_61_315 VPWR VGND sg13cmos5l_fill_1
XFILLER_74_698 VPWR VGND sg13cmos5l_fill_2
X_13253__1011 _13253_/RESET_B VPWR VGND sg13cmos5l_tiehi
X_12843_ _14431_/D _12843_/A _12843_/B VPWR VGND sg13cmos5l_and2_1
X_12774_ _12785_/B _14456_/Q _13246_/Q VPWR VGND sg13cmos5l_nand2_1
XFILLER_70_860 VPWR VGND sg13cmos5l_fill_1
XFILLER_70_882 VPWR VGND sg13cmos5l_decap_8
X_11725_ _11728_/B _13848_/Q _11725_/B VPWR VGND sg13cmos5l_nor2_1
X_14513_ _15892_/A clkload14/A _14513_/D fanout969/X VPWR VGND sg13cmos5l_dfrbpq_1
X_14444_ _14444_/Q _14630_/CLK _14444_/D _14444_/RESET_B VPWR VGND sg13cmos5l_dfrbpq_1
X_11656_ _11656_/Y _11656_/A _11657_/B _11672_/A VPWR VGND sg13cmos5l_nand3_1
Xfanout90 _09295_/B _09297_/S VPWR VGND sg13cmos5l_buf_1
X_10607_ _14063_/D fanout62/X _10610_/B _10606_/Y VPWR VGND sg13cmos5l_o21ai_1
X_11587_ _11587_/Y _11587_/A _11587_/B VPWR VGND sg13cmos5l_nor2_1
X_14375_ _14375_/Q _14621_/CLK _14375_/D _14375_/RESET_B VPWR VGND sg13cmos5l_dfrbpq_1
X_10538_ _14029_/D fanout76/X _10539_/B _10537_/Y VPWR VGND sg13cmos5l_o21ai_1
X_13326_ _13326_/Q clkload74/A _13326_/D _13326_/RESET_B VPWR VGND sg13cmos5l_dfrbpq_1
X_13257_ _13257_/Q clkload66/A _13257_/D _13257_/RESET_B VPWR VGND sg13cmos5l_dfrbpq_1
X_10469_ _13995_/D _10534_/A1 _10470_/B _10468_/Y VPWR VGND sg13cmos5l_a21oi_1
X_12208_ _12208_/Y _12208_/A VPWR VGND sg13cmos5l_inv_1
X_13188_ _13240_/D _07277_/Y _13188_/A2 _13192_/B1 _13187_/Y VPWR VGND sg13cmos5l_a22oi_1
X_12139_ _12139_/Y _13767_/Q _12399_/A2 _12401_/B1 _13831_/Q VPWR VGND sg13cmos5l_a22oi_1
XFILLER_78_960 VPWR VGND sg13cmos5l_fill_1
XFILLER_65_621 VPWR VGND sg13cmos5l_fill_2
XFILLER_93_974 VPWR VGND sg13cmos5l_fill_2
X_07680_ _07680_/Y _08838_/A _08517_/B VPWR VGND sg13cmos5l_nor2_1
X_14319__1189 _14319_/RESET_B VPWR VGND sg13cmos5l_tiehi
XFILLER_52_326 VPWR VGND sg13cmos5l_fill_2
XFILLER_65_687 VPWR VGND sg13cmos5l_decap_8
X_09350_ _13463_/D _09416_/A0 hold3193/X _09368_/S VPWR VGND sg13cmos5l_mux2_1
X_08301_ _08301_/X _13576_/Q _13544_/Q _08301_/S VPWR VGND sg13cmos5l_mux2_1
X_09281_ _13405_/D _10690_/A1 hold3386/X _09295_/B VPWR VGND sg13cmos5l_mux2_1
XFILLER_60_381 VPWR VGND sg13cmos5l_fill_1
X_08232_ _08232_/X _09288_/A _08307_/B VPWR VGND sg13cmos5l_and2_1
X_08163_ _08163_/X _13561_/Q _13529_/Q _13497_/Q _13465_/Q _08164_/S0 _08254_/A1 VPWR
+ VGND sg13cmos5l_mux4_1
X_08094_ _13206_/D _13146_/A _08094_/B _08094_/C VPWR VGND sg13cmos5l_nor3_1
X_14237__1240 _14237_/RESET_B VPWR VGND sg13cmos5l_tiehi
Xclkload71 clkload71/Y clkload71/A VPWR VGND sg13cmos5l_inv_2
Xclkload60 clkload60/Y clkload60/A VPWR VGND sg13cmos5l_inv_1
Xhold3501 _07184_/A _14307_/Q VPWR VGND sg13cmos5l_dlygate4sd3_1
Xhold3534 _11790_/A _14349_/Q VPWR VGND sg13cmos5l_dlygate4sd3_1
Xhold3523 hold3523/X _14269_/Q VPWR VGND sg13cmos5l_dlygate4sd3_1
Xhold3512 hold3512/X _13298_/Q VPWR VGND sg13cmos5l_dlygate4sd3_1
X_08996_ _08996_/Y _13298_/Q _08996_/B VPWR VGND sg13cmos5l_nand2b_1
Xhold2800 _13079_/A _14524_/Q VPWR VGND sg13cmos5l_dlygate4sd3_1
Xhold2811 _10246_/A _13886_/Q VPWR VGND sg13cmos5l_dlygate4sd3_1
Xhold2822 _09585_/A _13601_/Q VPWR VGND sg13cmos5l_dlygate4sd3_1
Xhold3545 hold3545/X _14124_/Q VPWR VGND sg13cmos5l_dlygate4sd3_1
Xhold3556 _09077_/A _13309_/Q VPWR VGND sg13cmos5l_dlygate4sd3_1
Xhold3567 _12976_/A _14476_/Q VPWR VGND sg13cmos5l_dlygate4sd3_1
XFILLER_85_18 VPWR VGND sg13cmos5l_fill_1
X_07947_ _07948_/C _07947_/A _07947_/B _14469_/D VPWR VGND sg13cmos5l_nand3_1
Xhold2833 _12452_/A _14381_/Q VPWR VGND sg13cmos5l_dlygate4sd3_1
Xhold2844 _09858_/A _13696_/Q VPWR VGND sg13cmos5l_dlygate4sd3_1
Xhold2855 _13075_/B _13074_/Y VPWR VGND sg13cmos5l_dlygate4sd3_1
Xhold2866 hold2866/X _14473_/Q VPWR VGND sg13cmos5l_dlygate4sd3_1
XFILLER_75_429 VPWR VGND sg13cmos5l_decap_8
Xhold2877 _09083_/A _13310_/Q VPWR VGND sg13cmos5l_dlygate4sd3_1
Xhold2888 _09870_/A _13702_/Q VPWR VGND sg13cmos5l_dlygate4sd3_1
Xhold2899 _10378_/A _13951_/Q VPWR VGND sg13cmos5l_dlygate4sd3_1
X_07878_ _07878_/X _14219_/Q _14218_/Q VPWR VGND sg13cmos5l_or2_1
XFILLER_16_529 VPWR VGND sg13cmos5l_fill_2
XFILLER_83_473 VPWR VGND sg13cmos5l_decap_8
X_09617_ _09617_/Y _09617_/A _09617_/B VPWR VGND sg13cmos5l_nand2_1
XFILLER_70_134 VPWR VGND sg13cmos5l_fill_2
X_09548_ _09548_/Y _09556_/A _09548_/B VPWR VGND sg13cmos5l_nand2_1
X_09479_ _10155_/C _10416_/A _10416_/D VPWR VGND sg13cmos5l_nor2_1
X_11510_ _11511_/B _11530_/A _11510_/B VPWR VGND sg13cmos5l_nand2_1
X_13731__1660 _13731_/RESET_B VPWR VGND sg13cmos5l_tiehi
X_12490_ _14390_/D _12490_/A _12490_/B VPWR VGND sg13cmos5l_nand2_1
XFILLER_8_739 VPWR VGND sg13cmos5l_fill_1
X_11441_ _11443_/C _11456_/D VPWR VGND sg13cmos5l_inv_1
X_11372_ _14325_/D _11370_/Y _11371_/Y _11358_/Y VPWR VGND sg13cmos5l_o21ai_1
X_14160_ _14160_/Q clkload20/A _14160_/D fanout984/X VPWR VGND sg13cmos5l_dfrbpq_1
X_10323_ _10323_/Y _10323_/A _10345_/B VPWR VGND sg13cmos5l_nor2_1
X_13111_ _14539_/D hold3561/X _08039_/B _13118_/S VPWR VGND sg13cmos5l_mux2_1
X_14091_ _14091_/Q clkload71/A _14091_/D _14091_/RESET_B VPWR VGND sg13cmos5l_dfrbpq_1
XFILLER_106_873 VPWR VGND sg13cmos5l_decap_8
XFILLER_79_724 VPWR VGND sg13cmos5l_decap_8
XFILLER_79_735 VPWR VGND sg13cmos5l_fill_2
X_10254_ _10254_/Y _10254_/A _10276_/B VPWR VGND sg13cmos5l_nor2_1
X_13042_ _14506_/D _13042_/A _13045_/C VPWR VGND sg13cmos5l_nor2_1
X_10185_ _10185_/Y _10185_/A _10185_/B VPWR VGND sg13cmos5l_nor2_1
XFILLER_19_301 VPWR VGND sg13cmos5l_fill_1
XFILLER_47_632 VPWR VGND sg13cmos5l_decap_8
Xfanout291 _09924_/B _09922_/B VPWR VGND sg13cmos5l_buf_1
Xfanout280 _10171_/B _10185_/B VPWR VGND sg13cmos5l_buf_1
XFILLER_47_643 VPWR VGND sg13cmos5l_fill_1
X_13944_ _13944_/Q _14299_/CLK _13944_/D _13944_/RESET_B VPWR VGND sg13cmos5l_dfrbpq_1
XFILLER_19_378 VPWR VGND sg13cmos5l_fill_2
X_13875_ _13875_/Q clkload18/A _13875_/D _13875_/RESET_B VPWR VGND sg13cmos5l_dfrbpq_1
XFILLER_50_808 VPWR VGND sg13cmos5l_fill_1
XFILLER_62_668 VPWR VGND sg13cmos5l_decap_8
XFILLER_90_944 VPWR VGND sg13cmos5l_fill_1
X_12826_ _12826_/Y _12817_/A _12815_/B _12813_/Y VPWR VGND sg13cmos5l_a21oi_1
XFILLER_42_381 VPWR VGND sg13cmos5l_fill_2
X_12757_ _12788_/B _14454_/Q _13244_/Q VPWR VGND sg13cmos5l_xnor2_1
X_11708_ _11708_/Y _11708_/A _11708_/B _11708_/C _11708_/D VPWR VGND sg13cmos5l_nor4_1
X_12688_ _12700_/B _14448_/Q _13238_/Q VPWR VGND sg13cmos5l_or2_1
X_11639_ _11639_/Y _12165_/A _11638_/Y VPWR VGND sg13cmos5l_nor2b_1
X_14427_ _14427_/Q clkload81/A _14427_/D _14427_/RESET_B VPWR VGND sg13cmos5l_dfrbpq_1
XFILLER_11_790 VPWR VGND sg13cmos5l_fill_2
X_14358_ _14358_/Q clkload77/A _14358_/D _14358_/RESET_B VPWR VGND sg13cmos5l_dfrbpq_1
XFILLER_7_783 VPWR VGND sg13cmos5l_fill_1
X_13309_ _13309_/Q _14621_/CLK _13309_/D _13309_/RESET_B VPWR VGND sg13cmos5l_dfrbpq_1
X_14289_ _14289_/Q clkload25/A _14289_/D _14289_/RESET_B VPWR VGND sg13cmos5l_dfrbpq_1
X_08850_ _08851_/D _08850_/A _08869_/B VPWR VGND sg13cmos5l_nand2_1
XFILLER_27_0 VPWR VGND sg13cmos5l_fill_2
XFILLER_97_587 VPWR VGND sg13cmos5l_decap_8
X_07801_ _07801_/Y _14401_/Q _12301_/A VPWR VGND sg13cmos5l_nor2_1
X_13773__1618 _13773_/RESET_B VPWR VGND sg13cmos5l_tiehi
XFILLER_38_632 VPWR VGND sg13cmos5l_fill_1
X_08781_ _08781_/Y _08781_/A1 _14160_/Q _13269_/Q _08781_/B2 VPWR VGND sg13cmos5l_a22oi_1
X_07732_ _07734_/A _07732_/A _08461_/B _08461_/C VPWR VGND sg13cmos5l_or3_1
X_07663_ _08562_/B _14395_/Q _12130_/A VPWR VGND sg13cmos5l_xor2_1
XFILLER_80_443 VPWR VGND sg13cmos5l_decap_4
X_09402_ _13514_/D _08320_/A hold3180/X _09409_/S VPWR VGND sg13cmos5l_mux2_1
XFILLER_34_860 VPWR VGND sg13cmos5l_fill_2
XFILLER_52_145 VPWR VGND sg13cmos5l_fill_1
X_07594_ _07596_/B _07594_/A _08995_/B VPWR VGND sg13cmos5l_xor2_1
X_09333_ _13449_/D _09225_/A hold3076/X _09333_/S VPWR VGND sg13cmos5l_mux2_1
X_09264_ _13389_/D _09230_/A hold3223/X _09266_/S VPWR VGND sg13cmos5l_mux2_1
X_08215_ _08215_/Y _08214_/A _08212_/X _08214_/Y VPWR VGND sg13cmos5l_a21oi_1
X_09195_ _09195_/Y _11606_/A _09194_/Y _09196_/A2 VPWR VGND sg13cmos5l_a21oi_1
XFILLER_101_1013 VPWR VGND sg13cmos5l_decap_8
X_08146_ _08146_/X _08146_/A _08146_/B VPWR VGND sg13cmos5l_xor2_1
X_08077_ _08078_/C hold2831/X _08076_/Y _08074_/A VPWR VGND sg13cmos5l_a21oi_1
XFILLER_103_821 VPWR VGND sg13cmos5l_fill_2
Xhold3342 hold3342/X _13399_/Q VPWR VGND sg13cmos5l_dlygate4sd3_1
Xhold3331 hold3331/X _13580_/Q VPWR VGND sg13cmos5l_dlygate4sd3_1
Xhold3320 hold3320/X _13420_/Q VPWR VGND sg13cmos5l_dlygate4sd3_1
XFILLER_0_458 VPWR VGND sg13cmos5l_fill_2
XFILLER_48_418 VPWR VGND sg13cmos5l_decap_4
Xhold2630 _14167_/D _10816_/Y VPWR VGND sg13cmos5l_dlygate4sd3_1
Xhold3375 hold3375/X _13560_/Q VPWR VGND sg13cmos5l_dlygate4sd3_1
Xhold3364 _12998_/A _14487_/Q VPWR VGND sg13cmos5l_dlygate4sd3_1
Xhold3353 hold3353/X _13391_/Q VPWR VGND sg13cmos5l_dlygate4sd3_1
XFILLER_48_429 VPWR VGND sg13cmos5l_decap_4
X_08979_ _08980_/B _08979_/A _08979_/B VPWR VGND sg13cmos5l_xor2_1
Xhold2641 _09944_/A _13738_/Q VPWR VGND sg13cmos5l_dlygate4sd3_1
Xhold2652 _10436_/A _13979_/Q VPWR VGND sg13cmos5l_dlygate4sd3_1
Xhold2663 _10390_/A _13957_/Q VPWR VGND sg13cmos5l_dlygate4sd3_1
Xhold2674 _07320_/A _13422_/Q VPWR VGND sg13cmos5l_dlygate4sd3_1
Xhold3397 _09016_/A _13290_/Q VPWR VGND sg13cmos5l_dlygate4sd3_1
Xhold3386 hold3386/X _13405_/Q VPWR VGND sg13cmos5l_dlygate4sd3_1
X_13749__1642 _13749_/RESET_B VPWR VGND sg13cmos5l_tiehi
XFILLER_57_974 VPWR VGND sg13cmos5l_decap_8
X_11990_ _11993_/A _11799_/A _11984_/Y _11989_/Y VPWR VGND sg13cmos5l_a21o_1
Xhold2685 hold2685/X _14479_/Q VPWR VGND sg13cmos5l_dlygate4sd3_1
Xhold2696 _09801_/A _13668_/Q VPWR VGND sg13cmos5l_dlygate4sd3_1
X_13437__1985 _13437_/RESET_B VPWR VGND sg13cmos5l_tiehi
XFILLER_72_911 VPWR VGND sg13cmos5l_fill_1
XFILLER_84_782 VPWR VGND sg13cmos5l_fill_2
X_10941_ _10941_/Y _10941_/A _10941_/B VPWR VGND sg13cmos5l_nand2_1
X_13660_ _13660_/Q clkload47/A _13660_/D _13660_/RESET_B VPWR VGND sg13cmos5l_dfrbpq_1
XFILLER_71_454 VPWR VGND sg13cmos5l_fill_2
X_10872_ _14189_/D hold3405/X _10932_/B _10871_/Y VPWR VGND sg13cmos5l_a21o_1
X_12611_ _12611_/Y _12611_/A _12640_/A VPWR VGND sg13cmos5l_nor2b_1
X_13591_ _13591_/Q clkload49/A _13591_/D _13591_/RESET_B VPWR VGND sg13cmos5l_dfrbpq_1
XFILLER_40_841 VPWR VGND sg13cmos5l_fill_1
X_12542_ _12542_/Y _12545_/A _12542_/B VPWR VGND sg13cmos5l_nand2_1
X_12473_ _12474_/B _12480_/A _13239_/Q _12472_/Y VPWR VGND sg13cmos5l_o21ai_1
X_11424_ _11456_/C _14096_/Q _11430_/B VPWR VGND sg13cmos5l_xnor2_1
X_14212_ _14212_/Q _14217_/CLK _14212_/D _14212_/RESET_B VPWR VGND sg13cmos5l_dfrbpq_1
X_13997__1394 _13997_/RESET_B VPWR VGND sg13cmos5l_tiehi
X_11355_ _11355_/Y _10982_/B _11351_/Y _11354_/Y _10982_/Y VPWR VGND sg13cmos5l_a22oi_1
X_14143_ _14143_/Q clkload25/A _14143_/D fanout992/X VPWR VGND sg13cmos5l_dfrbpq_1
XFILLER_3_263 VPWR VGND sg13cmos5l_fill_1
X_10306_ _13915_/D _10371_/A1 _10315_/B _10305_/Y VPWR VGND sg13cmos5l_a21oi_1
X_11286_ _11286_/Y _11536_/A _11286_/B VPWR VGND sg13cmos5l_nor2_1
X_14074_ _14074_/Q clkload14/A _14074_/D fanout969/X VPWR VGND sg13cmos5l_dfrbpq_1
X_10237_ _13881_/D _10367_/A1 _10250_/B _10236_/Y VPWR VGND sg13cmos5l_a21oi_1
X_13025_ _14500_/D _13027_/B _13025_/B VPWR VGND sg13cmos5l_and2_1
XFILLER_0_970 VPWR VGND sg13cmos5l_decap_8
X_10168_ _13847_/D _10298_/A1 _10169_/B _10167_/Y VPWR VGND sg13cmos5l_a21oi_1
X_10099_ _10099_/Y _10099_/A _10099_/B VPWR VGND sg13cmos5l_nand2_1
XFILLER_63_922 VPWR VGND sg13cmos5l_decap_8
X_13927_ _13927_/Q clkload61/A _13927_/D _13927_/RESET_B VPWR VGND sg13cmos5l_dfrbpq_1
XFILLER_35_646 VPWR VGND sg13cmos5l_fill_2
XFILLER_63_933 VPWR VGND sg13cmos5l_decap_4
XFILLER_62_476 VPWR VGND sg13cmos5l_fill_1
XFILLER_90_785 VPWR VGND sg13cmos5l_fill_1
X_13858_ _13858_/Q clkload60/A _13858_/D _13858_/RESET_B VPWR VGND sg13cmos5l_dfrbpq_1
XFILLER_50_649 VPWR VGND sg13cmos5l_decap_8
XFILLER_62_498 VPWR VGND sg13cmos5l_fill_1
X_13789_ _13789_/Q _14045_/CLK _13789_/D _13789_/RESET_B VPWR VGND sg13cmos5l_dfrbpq_1
X_12809_ _12809_/Y _12859_/A _12809_/B _12817_/B VPWR VGND sg13cmos5l_nand3_1
X_08000_ _08001_/A _08000_/A _11014_/B _08000_/C VPWR VGND sg13cmos5l_nand3_1
X_13827__1564 _13827_/RESET_B VPWR VGND sg13cmos5l_tiehi
X_09951_ _13741_/D fanout75/X _09952_/B _09950_/Y VPWR VGND sg13cmos5l_a21oi_1
X_08902_ _08902_/Y _08619_/A _08902_/A2 _08901_/Y VPWR VGND sg13cmos5l_o21ai_1
XFILLER_98_863 VPWR VGND sg13cmos5l_decap_8
XFILLER_98_874 VPWR VGND sg13cmos5l_fill_1
X_09882_ _09882_/Y _09882_/A _09882_/B VPWR VGND sg13cmos5l_nor2_1
XFILLER_100_824 VPWR VGND sg13cmos5l_fill_2
X_08833_ _14636_/D hold2534/X _08841_/B _08832_/Y VPWR VGND sg13cmos5l_a21o_1
X_08764_ _08764_/Y _08782_/A1 _07331_/Y _08763_/Y VPWR VGND sg13cmos5l_o21ai_1
X_14187__1290 _14187_/RESET_B VPWR VGND sg13cmos5l_tiehi
XFILLER_38_451 VPWR VGND sg13cmos5l_fill_2
XFILLER_54_900 VPWR VGND sg13cmos5l_fill_2
X_07715_ _07716_/B _14378_/Q _11668_/A VPWR VGND sg13cmos5l_or2_1
XFILLER_38_484 VPWR VGND sg13cmos5l_fill_1
XFILLER_93_590 VPWR VGND sg13cmos5l_fill_1
X_08695_ _08698_/A _08694_/Y _12449_/A VPWR VGND sg13cmos5l_nand2b_1
XFILLER_25_134 VPWR VGND sg13cmos5l_fill_2
XFILLER_80_240 VPWR VGND sg13cmos5l_fill_2
X_07646_ _08615_/A _14402_/Q _14370_/Q VPWR VGND sg13cmos5l_nand2_1
XFILLER_90_1001 VPWR VGND sg13cmos5l_fill_1
X_07577_ _07579_/B _07577_/A _08974_/B VPWR VGND sg13cmos5l_xor2_1
X_09316_ _13432_/D _10685_/A1 hold3411/X _09320_/S VPWR VGND sg13cmos5l_mux2_1
X_09247_ _13372_/D _08194_/A hold3350/X _09258_/S VPWR VGND sg13cmos5l_mux2_1
X_09178_ _09178_/Y _14370_/Q _09178_/A2 _09177_/Y VPWR VGND sg13cmos5l_a21oi_1
X_08129_ _08136_/A _13215_/Q _13214_/Q _13216_/Q VPWR VGND sg13cmos5l_nand3_1
X_11140_ _11140_/Y _14387_/Q _11143_/A2 _11093_/B _14403_/Q _11079_/X VPWR VGND sg13cmos5l_a221oi_1
Xoutput23 uio_out[0] _15880_/X VPWR VGND sg13cmos5l_buf_1
Xoutput34 uio_out[5] _15885_/X VPWR VGND sg13cmos5l_buf_1
Xoutput45 uo_out[15] _08786_/Y VPWR VGND sg13cmos5l_buf_1
X_14314__1194 _14314_/RESET_B VPWR VGND sg13cmos5l_tiehi
XFILLER_49_716 VPWR VGND sg13cmos5l_fill_1
XFILLER_89_874 VPWR VGND sg13cmos5l_decap_8
X_11071_ _11071_/X _14377_/Q _11083_/B VPWR VGND sg13cmos5l_and2_1
Xhold3150 hold3150/X _13443_/Q VPWR VGND sg13cmos5l_dlygate4sd3_1
XFILLER_102_161 VPWR VGND sg13cmos5l_fill_2
XFILLER_76_502 VPWR VGND sg13cmos5l_decap_8
XFILLER_76_524 VPWR VGND sg13cmos5l_decap_4
X_10022_ _13776_/D fanout58/X _10023_/B _10021_/Y VPWR VGND sg13cmos5l_o21ai_1
Xhold3161 hold3161/X _13475_/Q VPWR VGND sg13cmos5l_dlygate4sd3_1
Xhold3172 hold3172/X _13339_/Q VPWR VGND sg13cmos5l_dlygate4sd3_1
Xhold3194 hold3194/X _13500_/Q VPWR VGND sg13cmos5l_dlygate4sd3_1
Xhold2460 _14482_/D _12989_/Y VPWR VGND sg13cmos5l_dlygate4sd3_1
Xhold2471 _09979_/A _13755_/Q VPWR VGND sg13cmos5l_dlygate4sd3_1
Xhold2482 _10543_/A _14032_/Q VPWR VGND sg13cmos5l_dlygate4sd3_1
XFILLER_57_771 VPWR VGND sg13cmos5l_fill_1
Xhold2493 _10566_/A _14043_/Q VPWR VGND sg13cmos5l_dlygate4sd3_1
XFILLER_44_432 VPWR VGND sg13cmos5l_fill_2
XFILLER_45_955 VPWR VGND sg13cmos5l_fill_2
X_11973_ _11973_/Y _11969_/Y _11970_/Y _11971_/Y _11972_/Y VPWR VGND sg13cmos5l_a22oi_1
XFILLER_44_465 VPWR VGND sg13cmos5l_fill_2
XFILLER_60_903 VPWR VGND sg13cmos5l_decap_4
X_10924_ _14207_/D _10924_/A VPWR VGND sg13cmos5l_inv_1
X_13905__1486 _13905_/RESET_B VPWR VGND sg13cmos5l_tiehi
X_13712_ _13712_/Q clkload78/A _13712_/D _13712_/RESET_B VPWR VGND sg13cmos5l_dfrbpq_1
XFILLER_44_476 VPWR VGND sg13cmos5l_decap_8
XFILLER_71_273 VPWR VGND sg13cmos5l_fill_2
X_10855_ _14185_/D _10943_/A _10871_/C _10854_/Y VPWR VGND sg13cmos5l_o21ai_1
X_13643_ _13643_/Q clkload62/A _13643_/D _13643_/RESET_B VPWR VGND sg13cmos5l_dfrbpq_1
X_13574_ _13574_/Q clkload39/A _13574_/D _13574_/RESET_B VPWR VGND sg13cmos5l_dfrbpq_1
XFILLER_12_340 VPWR VGND sg13cmos5l_fill_2
XFILLER_13_874 VPWR VGND sg13cmos5l_fill_2
X_10786_ _10786_/Y _10792_/A _14300_/Q VPWR VGND sg13cmos5l_nand2_1
X_12525_ _14399_/D _12530_/B _12524_/Y _12522_/Y VPWR VGND sg13cmos5l_o21ai_1
XFILLER_12_373 VPWR VGND sg13cmos5l_fill_2
XFILLER_12_384 VPWR VGND sg13cmos5l_fill_1
XFILLER_8_366 VPWR VGND sg13cmos5l_fill_1
X_12456_ _12459_/A _14382_/Q _12460_/B VPWR VGND sg13cmos5l_nand2_1
X_11407_ _11407_/Y _11407_/A _11436_/B VPWR VGND sg13cmos5l_nand2_1
X_12387_ _12387_/Y _14371_/Q _13256_/Q _12360_/A _12360_/B _12364_/D VPWR VGND sg13cmos5l_a221oi_1
X_11338_ _11338_/Y _11338_/A _11338_/B VPWR VGND sg13cmos5l_nand2_1
X_14126_ _14126_/Q clkload30/A _14126_/D fanout998/X VPWR VGND sg13cmos5l_dfrbpq_1
XFILLER_98_115 VPWR VGND sg13cmos5l_fill_2
X_11269_ _11270_/B _07263_/Y _11223_/Y _11239_/B _11239_/A _11268_/X VPWR VGND sg13cmos5l_a221oi_1
X_14057_ _14057_/Q clkload59/A _14057_/D _14057_/RESET_B VPWR VGND sg13cmos5l_dfrbpq_1
XFILLER_67_524 VPWR VGND sg13cmos5l_fill_2
X_13008_ _13011_/C _13008_/A _13009_/B VPWR VGND sg13cmos5l_nor2_1
X_13690__1701 _13690_/RESET_B VPWR VGND sg13cmos5l_tiehi
XFILLER_36_900 VPWR VGND sg13cmos5l_fill_2
XFILLER_36_922 VPWR VGND sg13cmos5l_fill_1
XFILLER_95_888 VPWR VGND sg13cmos5l_fill_2
X_07500_ _07501_/B _07490_/Y _07495_/Y _07499_/Y _08187_/B2 VPWR VGND sg13cmos5l_a22oi_1
X_08480_ _08480_/X _08502_/A _08491_/C _08491_/D VPWR VGND sg13cmos5l_and3_1
X_07431_ _07431_/Y _07436_/C _07433_/B VPWR VGND sg13cmos5l_nor2_1
XFILLER_51_969 VPWR VGND sg13cmos5l_fill_2
XFILLER_94_0 VPWR VGND sg13cmos5l_fill_2
X_07362_ _07577_/A _08974_/A _14553_/Q VPWR VGND sg13cmos5l_xor2_1
X_09101_ _09101_/Y _09101_/A _09125_/B VPWR VGND sg13cmos5l_nor2_1
X_07293_ _07293_/Y _13254_/Q VPWR VGND sg13cmos5l_inv_1
X_09032_ _13298_/D _08995_/X hold3512/X _09032_/S VPWR VGND sg13cmos5l_mux2_1
XFILLER_105_927 VPWR VGND sg13cmos5l_fill_1
X_09934_ _09934_/Y _09934_/A _09948_/B VPWR VGND sg13cmos5l_nor2_1
Xfanout824 _12515_/B fanout828/X VPWR VGND sg13cmos5l_buf_1
Xfanout813 _11635_/A _14571_/Q VPWR VGND sg13cmos5l_buf_1
Xfanout802 _08338_/S _08393_/A1 VPWR VGND sg13cmos5l_buf_1
XFILLER_58_513 VPWR VGND sg13cmos5l_decap_8
X_09865_ _13699_/D _10453_/A1 _09886_/B _09864_/Y VPWR VGND sg13cmos5l_a21oi_1
Xfanout857 _11005_/B1 _14236_/Q VPWR VGND sg13cmos5l_buf_1
Xfanout846 _11668_/A _14346_/Q VPWR VGND sg13cmos5l_buf_1
Xfanout835 _12577_/A _14439_/Q VPWR VGND sg13cmos5l_buf_1
XFILLER_97_181 VPWR VGND sg13cmos5l_fill_1
X_08816_ _08818_/B _07827_/Y _08808_/B _08831_/B1 _08491_/C VPWR VGND sg13cmos5l_a22oi_1
Xfanout879 _10982_/B _11433_/A1 VPWR VGND sg13cmos5l_buf_1
Xfanout868 _08572_/A fanout872/X VPWR VGND sg13cmos5l_buf_1
XFILLER_100_687 VPWR VGND sg13cmos5l_decap_8
X_09796_ _13665_/D _10514_/A1 _09797_/B _09795_/Y VPWR VGND sg13cmos5l_a21oi_1
XFILLER_73_549 VPWR VGND sg13cmos5l_fill_2
X_08747_ _08747_/X _13654_/Q _08747_/B VPWR VGND sg13cmos5l_and2_1
X_08678_ _08678_/Y _11671_/B _14619_/Q _08676_/Y VPWR VGND sg13cmos5l_o21ai_1
XFILLER_14_627 VPWR VGND sg13cmos5l_decap_4
XFILLER_27_999 VPWR VGND sg13cmos5l_fill_2
X_07629_ _07634_/B _07629_/A _07629_/B _07629_/C _07629_/D VPWR VGND sg13cmos5l_nand4_1
XFILLER_41_435 VPWR VGND sg13cmos5l_fill_1
X_10640_ _14076_/D _10642_/B _10640_/B VPWR VGND sg13cmos5l_and2_1
X_13699__1692 _13699_/RESET_B VPWR VGND sg13cmos5l_tiehi
X_10571_ _14045_/D _10571_/A1 _10576_/B _10570_/Y VPWR VGND sg13cmos5l_o21ai_1
XFILLER_10_877 VPWR VGND sg13cmos5l_fill_1
XFILLER_42_99 VPWR VGND sg13cmos5l_fill_1
X_13290_ _13290_/Q clkload8/A _13290_/D fanout962/X VPWR VGND sg13cmos5l_dfrbpq_1
X_12310_ _12310_/Y _14061_/Q _12348_/A2 _12345_/B1 _13805_/Q VPWR VGND sg13cmos5l_a22oi_1
X_12241_ _12241_/Y _13962_/Q _12242_/B _12240_/Y VPWR VGND sg13cmos5l_o21ai_1
X_14401__1107 _14401_/RESET_B VPWR VGND sg13cmos5l_tiehi
X_12172_ _12172_/Y _12170_/Y _12171_/Y _12403_/B1 VPWR VGND sg13cmos5l_a21oi_1
XFILLER_96_608 VPWR VGND sg13cmos5l_fill_1
X_11123_ _11123_/Y _11123_/A _11123_/B VPWR VGND sg13cmos5l_nor2_1
XFILLER_104_971 VPWR VGND sg13cmos5l_decap_8
XFILLER_95_107 VPWR VGND sg13cmos5l_fill_2
X_11054_ _11054_/Y _11054_/A _11141_/B VPWR VGND sg13cmos5l_nor2_1
XFILLER_76_343 VPWR VGND sg13cmos5l_fill_2
X_10005_ _10005_/Y _10005_/A _10013_/B VPWR VGND sg13cmos5l_nand2_1
XFILLER_92_825 VPWR VGND sg13cmos5l_decap_8
Xhold2290 _10101_/A _13815_/Q VPWR VGND sg13cmos5l_dlygate4sd3_1
XFILLER_29_281 VPWR VGND sg13cmos5l_fill_1
XFILLER_57_590 VPWR VGND sg13cmos5l_decap_8
XFILLER_17_432 VPWR VGND sg13cmos5l_fill_1
XFILLER_18_977 VPWR VGND sg13cmos5l_fill_2
X_11956_ _11956_/Y _14357_/Q _13242_/Q VPWR VGND sg13cmos5l_nand2_1
X_10907_ _10908_/A hold3495/X _10960_/B _10861_/Y _10906_/Y VPWR VGND sg13cmos5l_a22oi_1
X_14457__1043 _14457_/RESET_B VPWR VGND sg13cmos5l_tiehi
XFILLER_33_969 VPWR VGND sg13cmos5l_fill_1
X_11887_ _11887_/Y _13886_/Q _12366_/B _12242_/B VPWR VGND sg13cmos5l_a21oi_1
XFILLER_60_788 VPWR VGND sg13cmos5l_fill_1
XFILLER_60_799 VPWR VGND sg13cmos5l_decap_4
X_10838_ _10935_/B _14267_/Q _14268_/Q _14269_/Q _14270_/Q VPWR VGND sg13cmos5l_nor4_1
X_13626_ _13626_/Q clkload53/A _13626_/D _13626_/RESET_B VPWR VGND sg13cmos5l_dfrbpq_1
X_10769_ _10769_/Y _10769_/A _10805_/B VPWR VGND sg13cmos5l_nand2_1
X_13557_ _13557_/Q _14102_/CLK _13557_/D _13557_/RESET_B VPWR VGND sg13cmos5l_dfrbpq_1
X_13488_ _13488_/Q clkload34/A _13488_/D _13488_/RESET_B VPWR VGND sg13cmos5l_dfrbpq_1
X_12508_ _12508_/Y _12515_/B _12149_/Y _12511_/B VPWR VGND sg13cmos5l_a21oi_1
X_12439_ _12439_/Y _12445_/A _13229_/Q _12447_/S VPWR VGND sg13cmos5l_a21oi_1
X_07980_ _07980_/X _13439_/Q _13407_/Q _13375_/Q _13343_/Q _08378_/A1 _07194_/A VPWR
+ VGND sg13cmos5l_mux4_1
Xfanout109 _10597_/A1 _09647_/Y VPWR VGND sg13cmos5l_buf_1
X_14109_ _14109_/Q _14109_/CLK _14109_/D fanout995/X VPWR VGND sg13cmos5l_dfrbpq_1
X_13432__1990 _13432_/RESET_B VPWR VGND sg13cmos5l_tiehi
XFILLER_41_1028 VPWR VGND sg13cmos5l_fill_1
X_09650_ _09657_/B _14462_/Q _14461_/Q _09650_/C VPWR VGND sg13cmos5l_nand3_1
X_08601_ _08604_/A _07791_/A _08596_/Y _08600_/Y VPWR VGND sg13cmos5l_o21ai_1
X_09581_ _09583_/A _09589_/B _09589_/C VPWR VGND sg13cmos5l_nor2_1
XFILLER_24_903 VPWR VGND sg13cmos5l_fill_1
X_08532_ _08532_/Y _08536_/A _08532_/B VPWR VGND sg13cmos5l_nand2_1
XFILLER_36_774 VPWR VGND sg13cmos5l_fill_2
X_08463_ _08464_/B _08471_/A _08801_/A _08463_/C VPWR VGND sg13cmos5l_nor3_1
X_07414_ _07415_/D _07414_/A _07414_/B _07588_/B VPWR VGND sg13cmos5l_nor3_1
X_08394_ _08394_/Y _08405_/C1 _08389_/Y _08391_/Y _08393_/Y _08406_/B1 VPWR VGND sg13cmos5l_a221oi_1
X_07345_ _07352_/A _13310_/Q _13311_/Q _13312_/Q _13313_/Q VPWR VGND sg13cmos5l_nor4_1
X_07276_ _11901_/B _13239_/Q VPWR VGND sg13cmos5l_inv_1
Xclkbuf_leaf_30_clk clkload34/A clkload2/A VPWR VGND sg13cmos5l_buf_8
XFILLER_12_69 VPWR VGND sg13cmos5l_fill_2
X_09015_ _13289_/D hold3402/X _08999_/A _13034_/B VPWR VGND sg13cmos5l_mux2_1
XFILLER_105_735 VPWR VGND sg13cmos5l_fill_2
X_09917_ _13724_/D _10569_/A1 _09924_/B _09916_/Y VPWR VGND sg13cmos5l_a21oi_1
Xfanout632 _12511_/B _12487_/B VPWR VGND sg13cmos5l_buf_1
Xfanout621 _07527_/B1 _07435_/Y VPWR VGND sg13cmos5l_buf_1
Xfanout610 _12933_/B2 _12937_/B2 VPWR VGND sg13cmos5l_buf_1
XFILLER_101_941 VPWR VGND sg13cmos5l_fill_2
Xfanout676 _09193_/B _09175_/B VPWR VGND sg13cmos5l_buf_1
Xfanout665 _10976_/B _10904_/B VPWR VGND sg13cmos5l_buf_1
Xfanout654 _11088_/A2 _11152_/A VPWR VGND sg13cmos5l_buf_1
Xfanout643 _12383_/A2 _11672_/A VPWR VGND sg13cmos5l_buf_1
Xclkbuf_leaf_97_clk clkload18/A clkbuf_4_2_0_clk/X VPWR VGND sg13cmos5l_buf_8
XFILLER_101_963 VPWR VGND sg13cmos5l_fill_1
XFILLER_101_985 VPWR VGND sg13cmos5l_decap_8
XFILLER_58_354 VPWR VGND sg13cmos5l_decap_4
XFILLER_74_814 VPWR VGND sg13cmos5l_decap_4
X_09848_ _09848_/Y _09848_/A _09858_/B VPWR VGND sg13cmos5l_nor2_1
Xfanout698 _11029_/B _08422_/Y VPWR VGND sg13cmos5l_buf_1
Xfanout687 _11605_/A _11542_/A VPWR VGND sg13cmos5l_buf_1
X_13607__1784 _13607_/RESET_B VPWR VGND sg13cmos5l_tiehi
XFILLER_46_527 VPWR VGND sg13cmos5l_decap_4
XFILLER_58_387 VPWR VGND sg13cmos5l_decap_4
XFILLER_86_696 VPWR VGND sg13cmos5l_fill_1
X_09779_ _09779_/Y _09779_/A _09793_/B VPWR VGND sg13cmos5l_nor2_1
X_11810_ _11810_/Y _11810_/A _11810_/B _11810_/C VPWR VGND sg13cmos5l_nand3_1
X_12790_ _12792_/B _12824_/A _12790_/B _12790_/C VPWR VGND sg13cmos5l_nor3_1
XFILLER_14_402 VPWR VGND sg13cmos5l_fill_2
XFILLER_27_785 VPWR VGND sg13cmos5l_fill_1
XFILLER_54_560 VPWR VGND sg13cmos5l_fill_2
XFILLER_82_880 VPWR VGND sg13cmos5l_fill_1
X_11741_ _11743_/B _11741_/A _11741_/B _11741_/C VPWR VGND sg13cmos5l_nand3_1
X_14589__2132 _14589_/RESET_B VPWR VGND sg13cmos5l_tiehi
X_13786__1605 _13786_/RESET_B VPWR VGND sg13cmos5l_tiehi
XFILLER_30_906 VPWR VGND sg13cmos5l_fill_2
XFILLER_30_939 VPWR VGND sg13cmos5l_fill_1
XFILLER_42_777 VPWR VGND sg13cmos5l_fill_1
X_11672_ _11672_/Y _11672_/A _11672_/B VPWR VGND sg13cmos5l_nand2_1
X_14460_ _14460_/Q clkload80/A _14460_/D _14460_/RESET_B VPWR VGND sg13cmos5l_dfrbpq_1
X_13474__1948 _13474_/RESET_B VPWR VGND sg13cmos5l_tiehi
X_10623_ _10626_/C _10623_/A _10624_/B VPWR VGND sg13cmos5l_nor2_1
X_14391_ _14391_/Q _14640_/CLK _14391_/D _14391_/RESET_B VPWR VGND sg13cmos5l_dfrbpq_1
X_13411_ _13411_/Q clkload37/A _13411_/D _13411_/RESET_B VPWR VGND sg13cmos5l_dfrbpq_1
XFILLER_10_652 VPWR VGND sg13cmos5l_fill_2
X_10554_ _10554_/Y _10554_/A _10564_/B VPWR VGND sg13cmos5l_nand2_1
Xclkbuf_leaf_21_clk _14109_/CLK clkbuf_4_4_0_clk/X VPWR VGND sg13cmos5l_buf_8
X_13342_ _13342_/Q clkload32/A _13342_/D _13342_/RESET_B VPWR VGND sg13cmos5l_dfrbpq_1
X_10485_ _10485_/Y _10485_/A _10497_/B VPWR VGND sg13cmos5l_nand2_1
X_13273_ _13273_/Q clkload12/A _13273_/D fanout958/X VPWR VGND sg13cmos5l_dfrbpq_1
X_12224_ _12224_/Y _12256_/A _12256_/B VPWR VGND sg13cmos5l_nor2_1
XFILLER_97_917 VPWR VGND sg13cmos5l_decap_4
X_12155_ _14363_/D _12162_/A _12154_/A _12154_/Y VPWR VGND sg13cmos5l_a21oi_1
X_11106_ _11106_/Y _14393_/Q _11105_/B _11105_/Y VPWR VGND sg13cmos5l_a21oi_1
X_12086_ _12086_/Y _13957_/Q _12296_/A2 _12290_/A2 _13893_/Q _12293_/B1 VPWR VGND
+ sg13cmos5l_a221oi_1
Xclkbuf_leaf_88_clk clkload54/A clkload4/A VPWR VGND sg13cmos5l_buf_8
XFILLER_37_505 VPWR VGND sg13cmos5l_fill_1
X_11037_ _11040_/B _14077_/Q _07431_/Y _07432_/Y _13221_/Q VPWR VGND sg13cmos5l_a22oi_1
XFILLER_17_262 VPWR VGND sg13cmos5l_fill_2
XFILLER_17_273 VPWR VGND sg13cmos5l_fill_2
X_12988_ _12991_/B _12988_/A _12989_/B VPWR VGND sg13cmos5l_nor2_1
XFILLER_17_284 VPWR VGND sg13cmos5l_fill_2
X_11939_ _11939_/X _13952_/Q _11939_/B VPWR VGND sg13cmos5l_and2_1
XFILLER_20_416 VPWR VGND sg13cmos5l_fill_1
XFILLER_20_427 VPWR VGND sg13cmos5l_fill_2
X_13609_ _13609_/Q clkload64/A _13609_/D _13609_/RESET_B VPWR VGND sg13cmos5l_dfrbpq_1
Xclkbuf_leaf_12_clk clkload24/A clkload1/A VPWR VGND sg13cmos5l_buf_8
X_14589_ _14589_/Q _14631_/CLK _14589_/D _14589_/RESET_B VPWR VGND sg13cmos5l_dfrbpq_1
X_14273__1235 _14273_/RESET_B VPWR VGND sg13cmos5l_tiehi
XFILLER_57_0 VPWR VGND sg13cmos5l_fill_1
XFILLER_88_939 VPWR VGND sg13cmos5l_decap_4
X_13864__1527 _13864_/RESET_B VPWR VGND sg13cmos5l_tiehi
X_07963_ _07965_/B _13222_/Q _08207_/B1 _08209_/B1 _14483_/Q VPWR VGND sg13cmos5l_a22oi_1
Xclkbuf_leaf_79_clk clkload46/A clkbuf_4_8_0_clk/X VPWR VGND sg13cmos5l_buf_8
X_13900__1491 _13900_/RESET_B VPWR VGND sg13cmos5l_tiehi
XFILLER_56_814 VPWR VGND sg13cmos5l_decap_8
XFILLER_96_972 VPWR VGND sg13cmos5l_fill_1
X_07894_ _07896_/C _14196_/Q _14197_/Q _08840_/B VPWR VGND sg13cmos5l_nor3_1
X_09702_ _09702_/Y _09702_/A _09706_/B VPWR VGND sg13cmos5l_nor2_1
XFILLER_95_471 VPWR VGND sg13cmos5l_fill_2
X_09633_ _09633_/Y _09639_/A _11470_/B _09632_/Y VPWR VGND sg13cmos5l_a21oi_1
X_09564_ _09564_/Y _09571_/A _11308_/B _09561_/Y _09563_/Y VPWR VGND sg13cmos5l_a22oi_1
XFILLER_36_571 VPWR VGND sg13cmos5l_decap_4
X_08515_ _08516_/B _07675_/Y _07752_/Y _08502_/B _07680_/Y _07751_/Y VPWR VGND sg13cmos5l_a221oi_1
X_09495_ _09495_/X _14408_/Q _14627_/Q _09532_/S VPWR VGND sg13cmos5l_mux2_1
XFILLER_51_574 VPWR VGND sg13cmos5l_decap_4
X_08446_ _08446_/Y _14345_/Q _09065_/A2 _08445_/Y VPWR VGND sg13cmos5l_a21oi_1
X_08377_ _08377_/Y _08375_/S _07320_/Y _07993_/A VPWR VGND sg13cmos5l_a21oi_1
XFILLER_11_449 VPWR VGND sg13cmos5l_fill_1
X_07328_ _07328_/Y _07328_/A VPWR VGND sg13cmos5l_inv_1
XFILLER_87_1028 VPWR VGND sg13cmos5l_fill_1
X_07259_ _07259_/Y _11091_/B VPWR VGND sg13cmos5l_inv_1
X_10270_ _10270_/Y _10270_/A _10280_/B VPWR VGND sg13cmos5l_nor2_1
Xfanout440 _10464_/B fanout445/X VPWR VGND sg13cmos5l_buf_1
Xfanout484 fanout484/X _08652_/Y VPWR VGND sg13cmos5l_buf_1
Xfanout473 _11971_/A2 _12203_/B1 VPWR VGND sg13cmos5l_buf_1
Xfanout462 _12401_/B1 _12296_/B1 VPWR VGND sg13cmos5l_buf_1
Xfanout451 _11862_/B _08743_/B VPWR VGND sg13cmos5l_buf_1
X_13960_ _13960_/Q _14065_/CLK _13960_/D _13960_/RESET_B VPWR VGND sg13cmos5l_dfrbpq_1
X_13528__1894 _13528_/RESET_B VPWR VGND sg13cmos5l_tiehi
Xfanout495 _11884_/B fanout505/X VPWR VGND sg13cmos5l_buf_1
X_12911_ _12912_/A _14443_/Q _11220_/B _11228_/B _12913_/B2 VPWR VGND sg13cmos5l_a22oi_1
XFILLER_74_644 VPWR VGND sg13cmos5l_fill_2
XFILLER_74_655 VPWR VGND sg13cmos5l_fill_2
XFILLER_74_666 VPWR VGND sg13cmos5l_decap_4
X_14351__1157 _14351_/RESET_B VPWR VGND sg13cmos5l_tiehi
X_13891_ _13891_/Q clkload56/A _13891_/D _13891_/RESET_B VPWR VGND sg13cmos5l_dfrbpq_1
X_12842_ _12843_/B _11008_/Y _12839_/Y _12841_/Y VPWR VGND sg13cmos5l_o21ai_1
X_12773_ _12783_/B _14456_/Q _13246_/Q VPWR VGND sg13cmos5l_or2_1
XFILLER_14_265 VPWR VGND sg13cmos5l_fill_1
XFILLER_42_563 VPWR VGND sg13cmos5l_decap_8
XFILLER_42_574 VPWR VGND sg13cmos5l_fill_2
X_11724_ _11728_/A _13912_/Q _08687_/B _08658_/S VPWR VGND sg13cmos5l_o21ai_1
X_14512_ _15891_/A clkload14/A _14512_/D fanout969/X VPWR VGND sg13cmos5l_dfrbpq_1
X_11655_ _14344_/D _07720_/B _11708_/A _11654_/Y VPWR VGND sg13cmos5l_a21oi_1
X_14443_ _14443_/Q _14630_/CLK _14443_/D _14443_/RESET_B VPWR VGND sg13cmos5l_dfrbpq_1
XFILLER_30_769 VPWR VGND sg13cmos5l_decap_4
Xfanout91 _09297_/S _09269_/Y VPWR VGND sg13cmos5l_buf_1
Xfanout80 fanout80/X _09619_/Y VPWR VGND sg13cmos5l_buf_1
X_13942__1449 _13942_/RESET_B VPWR VGND sg13cmos5l_tiehi
X_10606_ _10606_/Y _10606_/A _10610_/B VPWR VGND sg13cmos5l_nand2_1
X_11586_ _11586_/Y _11586_/A _11586_/B VPWR VGND sg13cmos5l_nand2_1
X_14374_ _14374_/Q _14621_/CLK _14374_/D _14374_/RESET_B VPWR VGND sg13cmos5l_dfrbpq_1
X_10537_ _10537_/Y _10537_/A _10537_/B VPWR VGND sg13cmos5l_nand2_1
X_13325_ _13325_/Q _14650_/CLK _13325_/D _13325_/RESET_B VPWR VGND sg13cmos5l_dfrbpq_1
X_10468_ _10468_/Y _10468_/A _10470_/B VPWR VGND sg13cmos5l_nor2_1
X_13256_ _13256_/Q clkload74/A _13256_/D _13256_/RESET_B VPWR VGND sg13cmos5l_dfrbpq_1
XFILLER_6_497 VPWR VGND sg13cmos5l_fill_2
X_12207_ _12208_/A _13833_/Q _12206_/B _12005_/B VPWR VGND sg13cmos5l_o21ai_1
XFILLER_9_1017 VPWR VGND sg13cmos5l_decap_8
XFILLER_9_1028 VPWR VGND sg13cmos5l_fill_1
X_10399_ _13961_/D _10399_/A1 _10408_/B _10398_/Y VPWR VGND sg13cmos5l_a21oi_1
X_13187_ _13187_/Y _08923_/A _14093_/Q _13189_/B1 hold3558/X VPWR VGND sg13cmos5l_a22oi_1
XFILLER_2_681 VPWR VGND sg13cmos5l_fill_2
X_12138_ _12138_/Y _13991_/Q _12174_/B _12401_/B1 _13799_/Q _12297_/C1 VPWR VGND sg13cmos5l_a221oi_1
X_12069_ _12069_/Y _12062_/Y _12067_/Y _12068_/Y _12054_/Y VPWR VGND sg13cmos5l_a22oi_1
Xclkbuf_leaf_1_clk clkload9/A clkbuf_4_0_0_clk/X VPWR VGND sg13cmos5l_buf_8
XFILLER_93_920 VPWR VGND sg13cmos5l_fill_2
XFILLER_92_430 VPWR VGND sg13cmos5l_decap_4
X_14327__1181 _14327_/RESET_B VPWR VGND sg13cmos5l_tiehi
XFILLER_80_614 VPWR VGND sg13cmos5l_decap_8
XFILLER_52_338 VPWR VGND sg13cmos5l_fill_2
XFILLER_92_496 VPWR VGND sg13cmos5l_fill_1
X_08300_ _08300_/X _08301_/S _13448_/Q VPWR VGND sg13cmos5l_or2_1
X_09280_ _13404_/D _08194_/A hold3097/X _09280_/S VPWR VGND sg13cmos5l_mux2_1
XFILLER_61_894 VPWR VGND sg13cmos5l_fill_2
X_08231_ _08231_/Y _08231_/A _08281_/B VPWR VGND sg13cmos5l_nand2_1
XFILLER_20_279 VPWR VGND sg13cmos5l_fill_1
X_08162_ _08162_/Y _08244_/C _08157_/X _08161_/Y _08187_/B2 VPWR VGND sg13cmos5l_a22oi_1
X_13918__1473 _13918_/RESET_B VPWR VGND sg13cmos5l_tiehi
X_08093_ _08094_/C hold3212/X _08092_/Y _08090_/A VPWR VGND sg13cmos5l_a21oi_1
Xclkload61 clkload61/Y clkload61/A VPWR VGND sg13cmos5l_inv_1
Xclkload50 clkload50/Y clkload50/A VPWR VGND sg13cmos5l_inv_1
Xclkload72 clkload72/X clkload72/A VPWR VGND sg13cmos5l_buf_8
X_14588__2131 _14588_/RESET_B VPWR VGND sg13cmos5l_tiehi
XFILLER_0_629 VPWR VGND sg13cmos5l_fill_1
Xhold3524 hold3524/X _14272_/Q VPWR VGND sg13cmos5l_dlygate4sd3_1
Xhold3513 hold3513/X _14553_/Q VPWR VGND sg13cmos5l_dlygate4sd3_1
Xhold3502 hold3502/X _14267_/Q VPWR VGND sg13cmos5l_dlygate4sd3_1
XFILLER_102_524 VPWR VGND sg13cmos5l_fill_2
XFILLER_88_758 VPWR VGND sg13cmos5l_fill_1
X_08995_ _08995_/X _08995_/A _08995_/B VPWR VGND sg13cmos5l_xor2_1
Xhold2801 _09840_/A _13687_/Q VPWR VGND sg13cmos5l_dlygate4sd3_1
Xhold2812 _09852_/A _13693_/Q VPWR VGND sg13cmos5l_dlygate4sd3_1
Xhold2823 _10648_/A _14080_/Q VPWR VGND sg13cmos5l_dlygate4sd3_1
Xhold3535 hold3535/X _14545_/Q VPWR VGND sg13cmos5l_dlygate4sd3_1
Xhold3546 hold3546/X _14466_/Q VPWR VGND sg13cmos5l_dlygate4sd3_1
Xhold3557 hold3557/X _14468_/Q VPWR VGND sg13cmos5l_dlygate4sd3_1
Xhold3568 _08117_/A _13210_/Q VPWR VGND sg13cmos5l_dlygate4sd3_1
XFILLER_87_246 VPWR VGND sg13cmos5l_fill_1
X_07946_ _14469_/D _08000_/A _07946_/B VPWR VGND sg13cmos5l_and2_1
Xhold2834 _08147_/A _13223_/Q VPWR VGND sg13cmos5l_dlygate4sd3_1
Xhold2845 hold2845/X _14533_/Q VPWR VGND sg13cmos5l_dlygate4sd3_1
Xhold2856 _09830_/A _13682_/Q VPWR VGND sg13cmos5l_dlygate4sd3_1
Xhold2867 _10434_/A _13978_/Q VPWR VGND sg13cmos5l_dlygate4sd3_1
Xhold2878 _09173_/A _13325_/Q VPWR VGND sg13cmos5l_dlygate4sd3_1
Xhold2889 hold2889/X _14528_/Q VPWR VGND sg13cmos5l_dlygate4sd3_1
XFILLER_84_964 VPWR VGND sg13cmos5l_fill_1
X_07877_ _07877_/Y _14219_/Q _14218_/Q VPWR VGND sg13cmos5l_nor2_1
X_13405__2017 _13405_/RESET_B VPWR VGND sg13cmos5l_tiehi
XFILLER_16_519 VPWR VGND sg13cmos5l_fill_1
X_09616_ _09617_/B _09616_/A _09616_/B VPWR VGND sg13cmos5l_xnor2_1
XFILLER_24_530 VPWR VGND sg13cmos5l_fill_2
XFILLER_43_349 VPWR VGND sg13cmos5l_fill_1
X_09547_ _09548_/B _09560_/S _14635_/Q _09546_/Y VPWR VGND sg13cmos5l_a21oi_1
XFILLER_12_703 VPWR VGND sg13cmos5l_fill_1
XFILLER_70_146 VPWR VGND sg13cmos5l_fill_2
XFILLER_24_585 VPWR VGND sg13cmos5l_fill_2
X_09478_ _10416_/D _14237_/Q _14229_/Q VPWR VGND sg13cmos5l_nor2_1
X_08429_ _10652_/A _11011_/A _15882_/A VPWR VGND sg13cmos5l_nand2_1
XFILLER_7_217 VPWR VGND sg13cmos5l_fill_2
X_11440_ _11456_/D _11440_/A _11463_/B VPWR VGND sg13cmos5l_xnor2_1
Xclkload0 clkload0/X clkload0/A VPWR VGND sg13cmos5l_buf_8
XFILLER_20_791 VPWR VGND sg13cmos5l_fill_2
X_11371_ _11371_/Y _11338_/A _11401_/B _12933_/B2 VPWR VGND sg13cmos5l_o21ai_1
XFILLER_3_412 VPWR VGND sg13cmos5l_fill_1
X_10322_ _13923_/D _10453_/A1 _10343_/B _10321_/Y VPWR VGND sg13cmos5l_a21oi_1
X_14090_ _14090_/Q clkload72/A _14090_/D _14090_/RESET_B VPWR VGND sg13cmos5l_dfrbpq_1
X_13110_ _13118_/S _13140_/A _13110_/B VPWR VGND sg13cmos5l_nor2_1
XFILLER_106_852 VPWR VGND sg13cmos5l_decap_4
XFILLER_4_946 VPWR VGND sg13cmos5l_fill_1
X_14369__1139 _14369_/RESET_B VPWR VGND sg13cmos5l_tiehi
X_13041_ _13045_/C _13043_/B VPWR VGND sg13cmos5l_inv_1
X_10253_ _13889_/D _10579_/A1 _10276_/B _10252_/Y VPWR VGND sg13cmos5l_a21oi_1
X_10184_ _13855_/D _10379_/A1 _10189_/B _10183_/Y VPWR VGND sg13cmos5l_a21oi_1
XFILLER_59_482 VPWR VGND sg13cmos5l_fill_1
XFILLER_87_780 VPWR VGND sg13cmos5l_fill_1
Xfanout292 _09922_/B fanout300/X VPWR VGND sg13cmos5l_buf_1
Xfanout281 _10185_/B _10169_/B VPWR VGND sg13cmos5l_buf_1
Xfanout270 _10230_/B _10245_/A2 VPWR VGND sg13cmos5l_buf_1
XFILLER_75_953 VPWR VGND sg13cmos5l_fill_2
X_13943_ _13943_/Q _14299_/CLK _13943_/D _13943_/RESET_B VPWR VGND sg13cmos5l_dfrbpq_1
XFILLER_19_368 VPWR VGND sg13cmos5l_fill_1
X_13874_ _13874_/Q _14631_/CLK _13874_/D _13874_/RESET_B VPWR VGND sg13cmos5l_dfrbpq_1
XFILLER_15_530 VPWR VGND sg13cmos5l_fill_2
XFILLER_61_135 VPWR VGND sg13cmos5l_fill_1
X_12825_ _12825_/Y _12787_/A _12828_/D _12823_/X VPWR VGND sg13cmos5l_o21ai_1
XFILLER_27_390 VPWR VGND sg13cmos5l_fill_2
X_12756_ _12784_/A _14454_/Q _13244_/Q VPWR VGND sg13cmos5l_nor2_1
XFILLER_30_544 VPWR VGND sg13cmos5l_fill_2
X_11707_ _11708_/D _11793_/A1 _11706_/Y _11684_/Y VPWR VGND sg13cmos5l_o21ai_1
X_12687_ _12698_/A _14448_/Q _13238_/Q VPWR VGND sg13cmos5l_nand2_1
X_11638_ _11638_/Y _14200_/Q _11638_/B VPWR VGND sg13cmos5l_nor2_1
X_14426_ _14426_/Q clkload75/A _14426_/D _14426_/RESET_B VPWR VGND sg13cmos5l_dfrbpq_1
X_14210__1267 _14210_/RESET_B VPWR VGND sg13cmos5l_tiehi
X_14357_ _14357_/Q clkload68/A _14357_/D _14357_/RESET_B VPWR VGND sg13cmos5l_dfrbpq_1
X_11569_ _11569_/Y _11586_/A _11575_/C _12955_/B2 VPWR VGND sg13cmos5l_o21ai_1
X_13308_ _13308_/Q _14621_/CLK _13308_/D _13308_/RESET_B VPWR VGND sg13cmos5l_dfrbpq_1
X_14288_ _14288_/Q clkload26/A _14288_/D _14288_/RESET_B VPWR VGND sg13cmos5l_dfrbpq_1
X_13239_ _13239_/Q clkload67/A _13239_/D _13239_/RESET_B VPWR VGND sg13cmos5l_dfrbpq_1
XFILLER_34_2 VPWR VGND sg13cmos5l_fill_1
XFILLER_58_909 VPWR VGND sg13cmos5l_decap_8
X_07800_ _07844_/B _07800_/A VPWR VGND sg13cmos5l_inv_1
X_08780_ _08780_/Y _13149_/A1 _07339_/Y _08779_/Y VPWR VGND sg13cmos5l_o21ai_1
X_07731_ _08461_/C _11105_/A _14345_/Q _08455_/A _07729_/Y _07719_/Y VPWR VGND sg13cmos5l_a221oi_1
X_13781__1610 _13781_/RESET_B VPWR VGND sg13cmos5l_tiehi
XFILLER_38_655 VPWR VGND sg13cmos5l_fill_1
XFILLER_93_750 VPWR VGND sg13cmos5l_decap_8
XFILLER_25_316 VPWR VGND sg13cmos5l_fill_2
XFILLER_53_614 VPWR VGND sg13cmos5l_fill_1
XFILLER_93_772 VPWR VGND sg13cmos5l_fill_2
XFILLER_93_783 VPWR VGND sg13cmos5l_fill_1
X_07662_ _07662_/X _14395_/Q _12130_/A VPWR VGND sg13cmos5l_and2_1
XFILLER_65_485 VPWR VGND sg13cmos5l_decap_8
X_07593_ _07596_/A _07593_/A _07593_/B _07593_/C VPWR VGND sg13cmos5l_nor3_1
X_09401_ _13513_/D _09225_/A hold3146/X _09401_/S VPWR VGND sg13cmos5l_mux2_1
XFILLER_18_390 VPWR VGND sg13cmos5l_fill_2
X_09332_ _13448_/D _09295_/A hold3360/X _09341_/S VPWR VGND sg13cmos5l_mux2_1
X_09263_ _13388_/D _08344_/A hold3348/X _09266_/S VPWR VGND sg13cmos5l_mux2_1
X_08214_ _08214_/Y _08214_/A _08213_/X VPWR VGND sg13cmos5l_nor2b_1
X_09194_ _09194_/Y _14437_/Q _11605_/A VPWR VGND sg13cmos5l_nand2_1
X_08145_ _08149_/C _08146_/A _08146_/B VPWR VGND sg13cmos5l_and2_1
X_08076_ _08076_/Y _08961_/A _08092_/B VPWR VGND sg13cmos5l_nand2_1
Xhold3343 hold3343/X _13383_/Q VPWR VGND sg13cmos5l_dlygate4sd3_1
Xhold3332 _13580_/D _09470_/X VPWR VGND sg13cmos5l_dlygate4sd3_1
Xhold3321 hold3321/X _13364_/Q VPWR VGND sg13cmos5l_dlygate4sd3_1
Xhold3310 hold3310/X _14170_/Q VPWR VGND sg13cmos5l_dlygate4sd3_1
Xhold2620 _08822_/A _14590_/Q VPWR VGND sg13cmos5l_dlygate4sd3_1
Xhold2631 _10914_/A _14203_/Q VPWR VGND sg13cmos5l_dlygate4sd3_1
Xhold3376 _07954_/C _14163_/Q VPWR VGND sg13cmos5l_dlygate4sd3_1
Xhold3365 _08862_/A _14600_/Q VPWR VGND sg13cmos5l_dlygate4sd3_1
Xhold3354 hold3354/X _13408_/Q VPWR VGND sg13cmos5l_dlygate4sd3_1
X_08978_ _13274_/D _08977_/B _08976_/Y _08977_/Y VPWR VGND sg13cmos5l_o21ai_1
Xhold2642 _09511_/A _13590_/Q VPWR VGND sg13cmos5l_dlygate4sd3_1
Xhold2653 _10805_/A _14162_/Q VPWR VGND sg13cmos5l_dlygate4sd3_1
Xhold2664 _12980_/A _14478_/Q VPWR VGND sg13cmos5l_dlygate4sd3_1
Xhold3398 _10631_/A _14072_/Q VPWR VGND sg13cmos5l_dlygate4sd3_1
Xhold3387 hold3387/X _13368_/Q VPWR VGND sg13cmos5l_dlygate4sd3_1
X_07929_ _07930_/C _07929_/A _10976_/A _07929_/C _14579_/Q VPWR VGND sg13cmos5l_or4_1
Xhold2675 _10642_/A _14077_/Q VPWR VGND sg13cmos5l_dlygate4sd3_1
Xhold2686 _10252_/A _13889_/Q VPWR VGND sg13cmos5l_dlygate4sd3_1
Xhold2697 _10215_/A _13871_/Q VPWR VGND sg13cmos5l_dlygate4sd3_1
XFILLER_29_677 VPWR VGND sg13cmos5l_fill_2
XFILLER_44_614 VPWR VGND sg13cmos5l_fill_1
X_10940_ _14213_/D _10943_/A _10937_/A _10939_/Y VPWR VGND sg13cmos5l_o21ai_1
X_13308__2204 _13308_/RESET_B VPWR VGND sg13cmos5l_tiehi
X_10871_ _10871_/Y _10871_/A _10976_/B _10871_/C VPWR VGND sg13cmos5l_nor3_1
X_13644__1747 _13644_/RESET_B VPWR VGND sg13cmos5l_tiehi
X_12610_ _12610_/Y _12636_/C _12608_/Y _12609_/X _12637_/C VPWR VGND sg13cmos5l_a22oi_1
X_13590_ _13590_/Q clkload16/A _13590_/D _13590_/RESET_B VPWR VGND sg13cmos5l_dfrbpq_1
X_12541_ _12541_/Y _14404_/Q _12541_/B VPWR VGND sg13cmos5l_nand2_1
XFILLER_61_76 VPWR VGND sg13cmos5l_fill_1
X_12472_ _12472_/Y _12480_/A _11891_/Y _12485_/B VPWR VGND sg13cmos5l_a21oi_1
X_11423_ _11443_/A _14096_/Q _11430_/B VPWR VGND sg13cmos5l_and2_1
X_14211_ _14211_/Q _14614_/CLK _14211_/D _14211_/RESET_B VPWR VGND sg13cmos5l_dfrbpq_1
X_14024__1367 _14024_/RESET_B VPWR VGND sg13cmos5l_tiehi
X_11354_ _11354_/Y _11401_/A _11353_/Y _11338_/A VPWR VGND sg13cmos5l_o21ai_1
X_14142_ _14142_/Q clkload25/A _14142_/D fanout992/X VPWR VGND sg13cmos5l_dfrbpq_1
X_10305_ _10305_/Y _10305_/A _10315_/B VPWR VGND sg13cmos5l_nor2_1
X_11285_ _11285_/Y _11284_/A _11298_/A _11328_/A VPWR VGND sg13cmos5l_o21ai_1
X_14073_ _14073_/Q clkload14/A _14073_/D fanout969/X VPWR VGND sg13cmos5l_dfrbpq_1
XFILLER_106_682 VPWR VGND sg13cmos5l_decap_8
X_10236_ _10236_/Y _10236_/A _10250_/B VPWR VGND sg13cmos5l_nor2_1
X_13024_ _13025_/B _14499_/Q _13026_/D _14500_/Q VPWR VGND sg13cmos5l_a21o_1
XFILLER_79_544 VPWR VGND sg13cmos5l_fill_2
X_13892__1499 _13892_/RESET_B VPWR VGND sg13cmos5l_tiehi
XFILLER_79_599 VPWR VGND sg13cmos5l_decap_8
X_10167_ _10167_/Y _10167_/A _10169_/B VPWR VGND sg13cmos5l_nor2_1
XFILLER_82_709 VPWR VGND sg13cmos5l_fill_2
X_10098_ _13813_/D _10555_/A1 _10099_/B _10097_/Y VPWR VGND sg13cmos5l_o21ai_1
X_14228__1249 _14228_/RESET_B VPWR VGND sg13cmos5l_tiehi
X_13926_ _13926_/Q clkload64/A _13926_/D _13926_/RESET_B VPWR VGND sg13cmos5l_dfrbpq_1
XFILLER_90_720 VPWR VGND sg13cmos5l_fill_2
XFILLER_90_731 VPWR VGND sg13cmos5l_fill_1
XFILLER_50_606 VPWR VGND sg13cmos5l_fill_1
XFILLER_62_466 VPWR VGND sg13cmos5l_fill_1
X_13857_ _13857_/Q clkload58/A _13857_/D _13857_/RESET_B VPWR VGND sg13cmos5l_dfrbpq_1
XFILLER_22_308 VPWR VGND sg13cmos5l_fill_2
XFILLER_50_617 VPWR VGND sg13cmos5l_fill_1
X_14587__2130 _14587_/RESET_B VPWR VGND sg13cmos5l_tiehi
X_13788_ _13788_/Q clkload47/A _13788_/D _13788_/RESET_B VPWR VGND sg13cmos5l_dfrbpq_1
X_12808_ _12817_/B _12823_/A _12828_/B _12808_/C VPWR VGND sg13cmos5l_or3_1
XFILLER_15_393 VPWR VGND sg13cmos5l_fill_1
X_12739_ _12739_/X _12739_/A _12739_/B VPWR VGND sg13cmos5l_or2_1
X_14409_ _14409_/Q clkload40/A _14409_/D _14409_/RESET_B VPWR VGND sg13cmos5l_dfrbpq_1
XFILLER_7_581 VPWR VGND sg13cmos5l_fill_2
X_13487__1935 _13487_/RESET_B VPWR VGND sg13cmos5l_tiehi
X_09950_ _09950_/Y _09950_/A _09952_/B VPWR VGND sg13cmos5l_nor2_1
X_08901_ _08901_/Y _07642_/Y _08905_/A2 _08905_/B1 _07644_/B VPWR VGND sg13cmos5l_a22oi_1
XFILLER_58_706 VPWR VGND sg13cmos5l_decap_4
X_09881_ _13707_/D _10599_/A1 _09882_/B _09880_/Y VPWR VGND sg13cmos5l_a21oi_1
X_13722__1669 _13722_/RESET_B VPWR VGND sg13cmos5l_tiehi
XFILLER_97_374 VPWR VGND sg13cmos5l_fill_1
X_08832_ _08832_/Y _08500_/A _08879_/A2 _08831_/Y VPWR VGND sg13cmos5l_o21ai_1
XFILLER_73_709 VPWR VGND sg13cmos5l_fill_1
X_08763_ _08763_/Y _08781_/A1 _14151_/Q _13260_/Q _08781_/B2 VPWR VGND sg13cmos5l_a22oi_1
X_07714_ _07716_/A _14378_/Q _11668_/A VPWR VGND sg13cmos5l_nand2_1
XFILLER_26_625 VPWR VGND sg13cmos5l_fill_2
XFILLER_66_794 VPWR VGND sg13cmos5l_fill_1
X_08694_ _08694_/Y _08683_/Y _08686_/Y _08693_/Y _11788_/C1 VPWR VGND sg13cmos5l_a22oi_1
XFILLER_80_252 VPWR VGND sg13cmos5l_fill_1
X_07645_ _07645_/X _14402_/Q _14370_/Q VPWR VGND sg13cmos5l_and2_1
X_13322__2100 _13322_/RESET_B VPWR VGND sg13cmos5l_tiehi
X_07576_ _07579_/A _07576_/A _07576_/B _07576_/C VPWR VGND sg13cmos5l_nand3_1
X_09315_ _13431_/D _09416_/A0 hold3374/X _09320_/S VPWR VGND sg13cmos5l_mux2_1
X_09246_ _13371_/D _08182_/A hold3324/X _09258_/S VPWR VGND sg13cmos5l_mux2_1
X_13355__2067 _13355_/RESET_B VPWR VGND sg13cmos5l_tiehi
XFILLER_31_68 VPWR VGND sg13cmos5l_fill_1
X_09177_ _09177_/Y _11562_/A _09176_/Y _09178_/A2 VPWR VGND sg13cmos5l_a21oi_1
X_08128_ _13215_/D _08128_/A _08127_/Y VPWR VGND sg13cmos5l_nor2b_1
X_08059_ _13207_/D _08057_/Y _08058_/Y _08051_/Y VPWR VGND sg13cmos5l_a21oi_1
Xoutput24 uio_out[10] _15890_/X VPWR VGND sg13cmos5l_buf_1
XFILLER_89_831 VPWR VGND sg13cmos5l_fill_2
X_11070_ _14285_/D _11132_/B _11068_/Y _11069_/Y VPWR VGND sg13cmos5l_a21oi_1
Xoutput35 uio_out[6] _15886_/X VPWR VGND sg13cmos5l_buf_1
Xoutput46 uo_out[1] _08758_/Y VPWR VGND sg13cmos5l_buf_1
X_14286__1222 _14286_/RESET_B VPWR VGND sg13cmos5l_tiehi
X_10021_ _10021_/Y _10021_/A _10021_/B VPWR VGND sg13cmos5l_nand2_1
Xhold3140 hold3140/X _13506_/Q VPWR VGND sg13cmos5l_dlygate4sd3_1
Xhold3151 hold3151/X _13340_/Q VPWR VGND sg13cmos5l_dlygate4sd3_1
Xhold3162 _13475_/D _09362_/X VPWR VGND sg13cmos5l_dlygate4sd3_1
Xhold3173 _10224_/A _13875_/Q VPWR VGND sg13cmos5l_dlygate4sd3_1
Xhold3184 hold3184/X _13337_/Q VPWR VGND sg13cmos5l_dlygate4sd3_1
Xhold2450 _10511_/A _14016_/Q VPWR VGND sg13cmos5l_dlygate4sd3_1
Xhold2461 _10572_/A _14046_/Q VPWR VGND sg13cmos5l_dlygate4sd3_1
Xhold2472 _10149_/A _13839_/Q VPWR VGND sg13cmos5l_dlygate4sd3_1
Xhold3195 hold3195/X _13486_/Q VPWR VGND sg13cmos5l_dlygate4sd3_1
XFILLER_56_65 VPWR VGND sg13cmos5l_fill_1
XFILLER_91_517 VPWR VGND sg13cmos5l_fill_1
Xhold2483 _10143_/A _13836_/Q VPWR VGND sg13cmos5l_dlygate4sd3_1
Xhold2494 _10590_/A _14055_/Q VPWR VGND sg13cmos5l_dlygate4sd3_1
XFILLER_17_647 VPWR VGND sg13cmos5l_decap_4
XFILLER_45_934 VPWR VGND sg13cmos5l_fill_1
XFILLER_45_945 VPWR VGND sg13cmos5l_fill_1
XFILLER_84_591 VPWR VGND sg13cmos5l_fill_1
X_11972_ _11972_/Y _13761_/Q _11998_/B1 _11966_/B _13825_/Q VPWR VGND sg13cmos5l_a22oi_1
X_13877__1514 _13877_/RESET_B VPWR VGND sg13cmos5l_tiehi
X_13711_ _13711_/Q _14020_/CLK _13711_/D _13711_/RESET_B VPWR VGND sg13cmos5l_dfrbpq_1
XFILLER_71_230 VPWR VGND sg13cmos5l_fill_1
X_10923_ _10924_/A hold3018/X _10939_/B _10844_/D _10922_/Y VPWR VGND sg13cmos5l_a22oi_1
XFILLER_31_105 VPWR VGND sg13cmos5l_fill_1
XFILLER_32_628 VPWR VGND sg13cmos5l_fill_2
XFILLER_60_926 VPWR VGND sg13cmos5l_decap_4
XFILLER_71_285 VPWR VGND sg13cmos5l_fill_2
X_10854_ _10854_/Y _10854_/A _10941_/B VPWR VGND sg13cmos5l_nand2_1
X_13642_ _13642_/Q clkload51/A _13642_/D _13642_/RESET_B VPWR VGND sg13cmos5l_dfrbpq_1
X_13565__1857 _13565_/RESET_B VPWR VGND sg13cmos5l_tiehi
X_13573_ _13573_/Q clkload42/A _13573_/D _13573_/RESET_B VPWR VGND sg13cmos5l_dfrbpq_1
XFILLER_13_886 VPWR VGND sg13cmos5l_fill_1
XFILLER_9_813 VPWR VGND sg13cmos5l_fill_1
X_10785_ _10785_/Y _10793_/B _10783_/Y _10784_/Y VPWR VGND sg13cmos5l_o21ai_1
X_12524_ _12524_/Y _12523_/A _13252_/Q _12523_/Y VPWR VGND sg13cmos5l_o21ai_1
XFILLER_13_897 VPWR VGND sg13cmos5l_fill_2
X_12455_ _14381_/D _12455_/A _12455_/B VPWR VGND sg13cmos5l_nand2_1
X_11406_ _14327_/D _11404_/Y _11405_/Y _11386_/Y VPWR VGND sg13cmos5l_o21ai_1
X_12386_ _14371_/D _07810_/B _12409_/A _12383_/Y _12385_/Y VPWR VGND sg13cmos5l_a22oi_1
X_11337_ _11338_/B _11337_/A _11337_/B VPWR VGND sg13cmos5l_xnor2_1
X_14125_ _14125_/Q clkload32/A _14125_/D _07198_/A VPWR VGND sg13cmos5l_dfrbpq_1
XFILLER_97_72 VPWR VGND sg13cmos5l_fill_1
X_11268_ _11268_/X _11268_/A _11268_/B VPWR VGND sg13cmos5l_or2_1
X_14056_ _14056_/Q _14640_/CLK _14056_/D _14056_/RESET_B VPWR VGND sg13cmos5l_dfrbpq_1
X_13400__2022 _13400_/RESET_B VPWR VGND sg13cmos5l_tiehi
XFILLER_67_514 VPWR VGND sg13cmos5l_fill_1
X_10219_ _10219_/Y _10219_/A _10219_/B VPWR VGND sg13cmos5l_nor2_1
X_11199_ _11200_/C _14085_/Q _11214_/C VPWR VGND sg13cmos5l_xnor2_1
X_13007_ _14491_/D _13009_/B _13007_/B VPWR VGND sg13cmos5l_and2_1
XFILLER_39_227 VPWR VGND sg13cmos5l_fill_1
XFILLER_67_536 VPWR VGND sg13cmos5l_fill_2
XFILLER_48_783 VPWR VGND sg13cmos5l_fill_1
XFILLER_74_1008 VPWR VGND sg13cmos5l_fill_2
X_13909_ _13909_/Q clkload49/A _13909_/D _13909_/RESET_B VPWR VGND sg13cmos5l_dfrbpq_1
X_07430_ _07433_/B _08964_/A _08970_/A VPWR VGND sg13cmos5l_nand2_1
XFILLER_22_138 VPWR VGND sg13cmos5l_fill_1
X_07361_ _07436_/C _07369_/B _07366_/A VPWR VGND sg13cmos5l_nand2b_1
X_09100_ _09100_/Y _14357_/Q _09106_/A2 _09099_/Y VPWR VGND sg13cmos5l_a21oi_1
X_14364__1144 _14364_/RESET_B VPWR VGND sg13cmos5l_tiehi
XFILLER_31_694 VPWR VGND sg13cmos5l_fill_1
X_07292_ _07292_/Y _13253_/Q VPWR VGND sg13cmos5l_inv_1
X_09031_ _13297_/D _09030_/B _08990_/B _09030_/Y VPWR VGND sg13cmos5l_o21ai_1
X_14085__1322 _14085_/RESET_B VPWR VGND sg13cmos5l_tiehi
XFILLER_105_939 VPWR VGND sg13cmos5l_decap_8
X_13955__1436 _13955_/RESET_B VPWR VGND sg13cmos5l_tiehi
X_09933_ _13732_/D _10128_/A1 _09944_/B _09932_/Y VPWR VGND sg13cmos5l_a21oi_1
Xfanout825 _12523_/A _12545_/A VPWR VGND sg13cmos5l_buf_1
Xfanout814 _12164_/B _12861_/A2 VPWR VGND sg13cmos5l_buf_1
Xfanout803 _08393_/A1 fanout804/X VPWR VGND sg13cmos5l_buf_1
XFILLER_86_812 VPWR VGND sg13cmos5l_fill_1
X_09864_ _09864_/Y _09864_/A _09886_/B VPWR VGND sg13cmos5l_nor2_1
Xfanout858 _09615_/S _09662_/S VPWR VGND sg13cmos5l_buf_1
Xfanout847 _11656_/A _14344_/Q VPWR VGND sg13cmos5l_buf_1
Xfanout836 _08861_/A _14392_/Q VPWR VGND sg13cmos5l_buf_1
XFILLER_58_536 VPWR VGND sg13cmos5l_decap_4
X_08815_ _08818_/A _08815_/A _08819_/B VPWR VGND sg13cmos5l_nand2_1
Xfanout869 _08536_/A fanout872/X VPWR VGND sg13cmos5l_buf_1
X_09795_ _09795_/Y _09795_/A _09797_/B VPWR VGND sg13cmos5l_nor2_1
X_08746_ _08746_/Y _13590_/Q _11809_/A2 _08687_/A VPWR VGND sg13cmos5l_a21oi_1
XFILLER_42_904 VPWR VGND sg13cmos5l_fill_2
X_08677_ _08753_/B _11025_/A _11867_/B VPWR VGND sg13cmos5l_nor2_1
XFILLER_41_403 VPWR VGND sg13cmos5l_fill_1
X_07628_ _07629_/D _13307_/Q _07628_/B VPWR VGND sg13cmos5l_xnor2_1
X_07559_ _07560_/C _07559_/A _07559_/B _07559_/C VPWR VGND sg13cmos5l_nand3_1
X_10570_ _10570_/Y _10570_/A _10576_/B VPWR VGND sg13cmos5l_nand2_1
X_09229_ _13356_/D _08344_/A hold3329/X _09235_/S VPWR VGND sg13cmos5l_mux2_1
X_12240_ _12240_/Y _13930_/Q _12242_/B VPWR VGND sg13cmos5l_nand2b_1
X_12171_ _12171_/Y _13928_/Q _12397_/B _12399_/A2 _13608_/Q _12297_/C1 VPWR VGND sg13cmos5l_a221oi_1
XFILLER_104_950 VPWR VGND sg13cmos5l_decap_8
X_11122_ _11122_/Y _14397_/Q _11109_/B _11121_/Y VPWR VGND sg13cmos5l_a21oi_1
XFILLER_76_300 VPWR VGND sg13cmos5l_fill_1
XFILLER_77_812 VPWR VGND sg13cmos5l_decap_8
XFILLER_88_160 VPWR VGND sg13cmos5l_fill_1
X_11053_ _14280_/D hold3369/X _14379_/Q _11099_/B VPWR VGND sg13cmos5l_mux2_1
XFILLER_88_171 VPWR VGND sg13cmos5l_fill_2
X_10004_ _13767_/D _10591_/A1 _10013_/B _10003_/Y VPWR VGND sg13cmos5l_o21ai_1
XFILLER_18_912 VPWR VGND sg13cmos5l_fill_1
XFILLER_97_1019 VPWR VGND sg13cmos5l_decap_8
Xhold2280 _12967_/B _14471_/Q VPWR VGND sg13cmos5l_dlygate4sd3_1
Xhold2291 _10499_/A _14010_/Q VPWR VGND sg13cmos5l_dlygate4sd3_1
X_14442__1066 _14442_/RESET_B VPWR VGND sg13cmos5l_tiehi
XFILLER_92_859 VPWR VGND sg13cmos5l_fill_1
X_11955_ _11957_/A _14357_/Q _13242_/Q VPWR VGND sg13cmos5l_nor2_1
XFILLER_18_989 VPWR VGND sg13cmos5l_fill_2
XFILLER_72_572 VPWR VGND sg13cmos5l_fill_2
X_10906_ _10906_/Y _10906_/A _14248_/D VPWR VGND sg13cmos5l_nor2b_1
X_11886_ _11886_/Y _11886_/A _11886_/B _11886_/C VPWR VGND sg13cmos5l_nand3_1
X_13625_ _13625_/Q _14048_/CLK _13625_/D _13625_/RESET_B VPWR VGND sg13cmos5l_dfrbpq_1
X_10837_ _10946_/A _10877_/A _10873_/B VPWR VGND sg13cmos5l_nand2b_1
X_13418__2004 _13418_/RESET_B VPWR VGND sg13cmos5l_tiehi
X_10768_ _10768_/Y _10801_/A _14294_/Q VPWR VGND sg13cmos5l_nand2_1
X_13556_ _13556_/Q _14520_/CLK _13556_/D _13556_/RESET_B VPWR VGND sg13cmos5l_dfrbpq_1
XFILLER_9_654 VPWR VGND sg13cmos5l_fill_2
X_14178__1299 _14178_/RESET_B VPWR VGND sg13cmos5l_tiehi
X_13487_ _13487_/Q clkload33/A _13487_/D _13487_/RESET_B VPWR VGND sg13cmos5l_dfrbpq_1
X_12507_ _12510_/A _14395_/Q _12511_/B VPWR VGND sg13cmos5l_nand2_1
X_10699_ _14119_/D input12/X _08269_/A _10709_/S VPWR VGND sg13cmos5l_mux2_1
X_12438_ _14375_/D _11097_/A _12447_/S _12437_/Y _08698_/A VPWR VGND sg13cmos5l_a22oi_1
X_12369_ _12369_/Y _13615_/Q _12373_/B _12366_/B _13871_/Q VPWR VGND sg13cmos5l_a22oi_1
X_14108_ _14108_/Q _14109_/CLK _14108_/D fanout995/X VPWR VGND sg13cmos5l_dfrbpq_1
X_14039_ _14039_/Q clkload16/A _14039_/D _14039_/RESET_B VPWR VGND sg13cmos5l_dfrbpq_1
XFILLER_67_322 VPWR VGND sg13cmos5l_fill_1
XFILLER_68_856 VPWR VGND sg13cmos5l_fill_1
X_08600_ _08600_/Y _08603_/C _08889_/A VPWR VGND sg13cmos5l_nor2_1
XFILLER_103_29 VPWR VGND sg13cmos5l_fill_2
X_09580_ _11359_/B _14421_/Q _14640_/Q _09615_/S VPWR VGND sg13cmos5l_mux2_1
X_14418__1090 _14418_/RESET_B VPWR VGND sg13cmos5l_tiehi
X_08531_ _08535_/B _08520_/B _08529_/X _08530_/Y _08506_/Y _08528_/Y VPWR VGND sg13cmos5l_a221oi_1
XFILLER_36_797 VPWR VGND sg13cmos5l_fill_2
X_08462_ _08463_/C _08457_/A _08457_/B _07833_/A VPWR VGND sg13cmos5l_a21oi_1
X_07413_ _07415_/C _07413_/A _07413_/B _07413_/C _07413_/D VPWR VGND sg13cmos5l_nor4_1
XFILLER_11_609 VPWR VGND sg13cmos5l_fill_1
XFILLER_23_469 VPWR VGND sg13cmos5l_fill_2
X_08393_ _08393_/Y _08393_/A1 _13455_/Q _08392_/Y VPWR VGND sg13cmos5l_o21ai_1
X_07344_ _07344_/Y _14574_/Q VPWR VGND sg13cmos5l_inv_1
X_07275_ _11846_/B _13238_/Q VPWR VGND sg13cmos5l_inv_1
X_09014_ _13288_/D hold3457/X _08995_/A _13034_/B VPWR VGND sg13cmos5l_mux2_1
XFILLER_105_703 VPWR VGND sg13cmos5l_decap_8
X_09916_ _09916_/Y _09916_/A _09924_/B VPWR VGND sg13cmos5l_nor2_1
Xfanout633 _12487_/B fanout637/X VPWR VGND sg13cmos5l_buf_1
Xfanout622 _08209_/B1 _07530_/B1 VPWR VGND sg13cmos5l_buf_1
Xfanout611 _12937_/B2 _07933_/A VPWR VGND sg13cmos5l_buf_1
Xfanout600 _12351_/A1 _12012_/A1 VPWR VGND sg13cmos5l_buf_1
X_14223__1254 _14223_/RESET_B VPWR VGND sg13cmos5l_tiehi
XFILLER_101_931 VPWR VGND sg13cmos5l_fill_1
Xfanout666 _10939_/B _10904_/B VPWR VGND sg13cmos5l_buf_1
Xfanout655 _12648_/B _12727_/A1 VPWR VGND sg13cmos5l_buf_1
Xfanout644 _11672_/A _11629_/Y VPWR VGND sg13cmos5l_buf_1
X_09847_ _13690_/D _10369_/A1 _09846_/B _09846_/Y VPWR VGND sg13cmos5l_a21oi_1
Xfanout699 _10710_/S _10709_/S VPWR VGND sg13cmos5l_buf_1
Xfanout688 _11542_/A _08437_/X VPWR VGND sg13cmos5l_buf_1
Xfanout677 _09175_/B _08438_/Y VPWR VGND sg13cmos5l_buf_1
X_09778_ _13656_/D _10496_/A1 _09801_/B _09777_/Y VPWR VGND sg13cmos5l_a21oi_1
X_08729_ _08729_/X _13909_/Q _08729_/B VPWR VGND sg13cmos5l_and2_1
X_11740_ _11741_/C _11740_/A _13234_/Q VPWR VGND sg13cmos5l_xnor2_1
XFILLER_26_296 VPWR VGND sg13cmos5l_fill_1
X_11671_ _11672_/B _11671_/A _11671_/B VPWR VGND sg13cmos5l_nor2_1
X_13482__1940 _13482_/RESET_B VPWR VGND sg13cmos5l_tiehi
X_10622_ _10622_/Y _10622_/A _10622_/B VPWR VGND sg13cmos5l_xnor2_1
X_14453__1050 _14453_/RESET_B VPWR VGND sg13cmos5l_tiehi
X_14390_ _14390_/Q clkload77/A _14390_/D _14390_/RESET_B VPWR VGND sg13cmos5l_dfrbpq_1
X_13410_ _13410_/Q clkload29/A _13410_/D _13410_/RESET_B VPWR VGND sg13cmos5l_dfrbpq_1
X_10553_ _14036_/D _10553_/A1 _10566_/B _10552_/Y VPWR VGND sg13cmos5l_o21ai_1
X_13341_ _13341_/Q clkload30/A _13341_/D _13341_/RESET_B VPWR VGND sg13cmos5l_dfrbpq_1
X_10484_ _14002_/D _10549_/A1 _10519_/B _10483_/Y VPWR VGND sg13cmos5l_o21ai_1
X_13272_ _13272_/Q clkload12/A _13272_/D fanout958/X VPWR VGND sg13cmos5l_dfrbpq_1
X_12223_ _12256_/B _14366_/Q _13251_/Q VPWR VGND sg13cmos5l_xnor2_1
XFILLER_69_609 VPWR VGND sg13cmos5l_fill_2
X_12154_ _12154_/Y _12154_/A _12154_/B _12154_/C VPWR VGND sg13cmos5l_nor3_1
X_11105_ _11105_/Y _11105_/A _11105_/B VPWR VGND sg13cmos5l_nor2_1
X_12085_ _12085_/Y _13637_/Q _12292_/B _12260_/B _13701_/Q VPWR VGND sg13cmos5l_a22oi_1
XFILLER_49_344 VPWR VGND sg13cmos5l_decap_8
X_11036_ _11041_/A _14110_/Q _08356_/C _11034_/X _11035_/Y _11036_/C1 VPWR VGND sg13cmos5l_a221oi_1
X_13257__1007 _13257_/RESET_B VPWR VGND sg13cmos5l_tiehi
XFILLER_49_388 VPWR VGND sg13cmos5l_decap_8
XFILLER_92_656 VPWR VGND sg13cmos5l_fill_1
X_13350__2072 _13350_/RESET_B VPWR VGND sg13cmos5l_tiehi
X_12987_ _14481_/D _12989_/B _12987_/B VPWR VGND sg13cmos5l_and2_1
XFILLER_91_199 VPWR VGND sg13cmos5l_fill_1
X_11938_ _11938_/Y _13632_/Q _11944_/A1 _11945_/S VPWR VGND sg13cmos5l_a21oi_1
XFILLER_60_575 VPWR VGND sg13cmos5l_decap_8
X_11869_ _11869_/Y _14448_/Q _12353_/B _11866_/Y _11623_/Y _11868_/Y VPWR VGND sg13cmos5l_a221oi_1
X_14657_ _14657_/Q clkload44/A _14657_/D _14657_/RESET_B VPWR VGND sg13cmos5l_dfrbpq_1
X_14588_ _14588_/Q _14631_/CLK _14588_/D _14588_/RESET_B VPWR VGND sg13cmos5l_dfrbpq_1
X_13608_ _13608_/Q _14065_/CLK _13608_/D _13608_/RESET_B VPWR VGND sg13cmos5l_dfrbpq_1
XFILLER_9_451 VPWR VGND sg13cmos5l_fill_2
X_13539_ _13539_/Q _14117_/CLK _13539_/D _13539_/RESET_B VPWR VGND sg13cmos5l_dfrbpq_1
X_13657__1734 _13657_/RESET_B VPWR VGND sg13cmos5l_tiehi
XFILLER_99_222 VPWR VGND sg13cmos5l_fill_2
X_14037__1354 _14037_/RESET_B VPWR VGND sg13cmos5l_tiehi
X_07962_ _07965_/A _14535_/Q _11039_/A2 _11039_/B1 _14499_/Q VPWR VGND sg13cmos5l_a22oi_1
X_09701_ _13619_/D _10355_/A1 _09706_/B _09700_/Y VPWR VGND sg13cmos5l_a21oi_1
X_07893_ _07897_/B _07893_/A _07893_/B _07893_/C VPWR VGND sg13cmos5l_nand3_1
X_13560__1862 _13560_/RESET_B VPWR VGND sg13cmos5l_tiehi
XFILLER_67_185 VPWR VGND sg13cmos5l_fill_1
XFILLER_83_612 VPWR VGND sg13cmos5l_fill_1
XFILLER_83_623 VPWR VGND sg13cmos5l_fill_1
X_09632_ _09632_/Y _14459_/Q _09638_/C _09631_/Y VPWR VGND sg13cmos5l_a21oi_1
XFILLER_55_358 VPWR VGND sg13cmos5l_fill_1
X_09563_ _09563_/Y _09571_/A _09570_/B VPWR VGND sg13cmos5l_nor2_1
XFILLER_82_177 VPWR VGND sg13cmos5l_fill_1
XFILLER_83_678 VPWR VGND sg13cmos5l_decap_4
X_08514_ _14595_/D _08838_/A _08514_/B VPWR VGND sg13cmos5l_xnor2_1
XFILLER_63_391 VPWR VGND sg13cmos5l_fill_1
X_09494_ _13587_/D _09511_/B _10355_/A1 _09493_/Y VPWR VGND sg13cmos5l_a21oi_1
X_08445_ _08445_/Y _08443_/Y _08444_/Y _09065_/A2 VPWR VGND sg13cmos5l_a21oi_1
X_08376_ _08376_/Y _08376_/A1 _08375_/X _07194_/A VPWR VGND sg13cmos5l_a21oi_1
X_07327_ _07327_/Y _07327_/A VPWR VGND sg13cmos5l_inv_1
X_07258_ _07258_/Y _11151_/B VPWR VGND sg13cmos5l_inv_1
X_07189_ _08989_/A _13307_/Q VPWR VGND sg13cmos5l_inv_1
XFILLER_3_649 VPWR VGND sg13cmos5l_fill_2
XFILLER_105_577 VPWR VGND sg13cmos5l_fill_2
Xfanout441 _10474_/B fanout445/X VPWR VGND sg13cmos5l_buf_1
Xfanout430 _10531_/B _10482_/Y VPWR VGND sg13cmos5l_buf_1
XFILLER_59_642 VPWR VGND sg13cmos5l_decap_8
Xfanout474 _12203_/B1 fanout484/X VPWR VGND sg13cmos5l_buf_1
Xfanout463 _12395_/B1 _12296_/B1 VPWR VGND sg13cmos5l_buf_1
Xfanout452 _11858_/B _08743_/B VPWR VGND sg13cmos5l_buf_1
XFILLER_47_826 VPWR VGND sg13cmos5l_fill_1
XFILLER_74_612 VPWR VGND sg13cmos5l_fill_1
XFILLER_86_461 VPWR VGND sg13cmos5l_fill_1
XFILLER_86_483 VPWR VGND sg13cmos5l_decap_8
Xfanout496 _12346_/A2 _12349_/A2 VPWR VGND sg13cmos5l_buf_1
Xfanout485 _11726_/B _08651_/Y VPWR VGND sg13cmos5l_buf_1
X_13890_ _13890_/Q clkload59/A _13890_/D _13890_/RESET_B VPWR VGND sg13cmos5l_dfrbpq_1
X_12910_ _14442_/D _12910_/A VPWR VGND sg13cmos5l_inv_1
X_12841_ _12841_/Y _14367_/Q _12861_/A2 fanout59/X _12840_/X VPWR VGND sg13cmos5l_a22oi_1
XFILLER_46_369 VPWR VGND sg13cmos5l_decap_4
XFILLER_62_818 VPWR VGND sg13cmos5l_fill_2
X_13735__1656 _13735_/RESET_B VPWR VGND sg13cmos5l_tiehi
X_12772_ _14424_/D _12094_/B _12771_/Y _12755_/A VPWR VGND sg13cmos5l_a21oi_1
X_11723_ _11723_/Y _11718_/Y _11722_/Y _08674_/A VPWR VGND sg13cmos5l_o21ai_1
X_14511_ _15890_/A _14532_/CLK _14511_/D fanout969/X VPWR VGND sg13cmos5l_dfrbpq_1
X_13423__1999 _13423_/RESET_B VPWR VGND sg13cmos5l_tiehi
XFILLER_30_726 VPWR VGND sg13cmos5l_fill_1
X_11654_ _11654_/Y _11708_/A _11654_/B VPWR VGND sg13cmos5l_nor2_1
X_14442_ _14442_/Q _14630_/CLK _14442_/D _14442_/RESET_B VPWR VGND sg13cmos5l_dfrbpq_1
XFILLER_70_1022 VPWR VGND sg13cmos5l_decap_8
X_10605_ _14062_/D fanout74/X _10604_/B _10604_/Y VPWR VGND sg13cmos5l_o21ai_1
Xfanout92 _09258_/S _09267_/S VPWR VGND sg13cmos5l_buf_1
Xfanout81 _09320_/S _09333_/S VPWR VGND sg13cmos5l_buf_1
Xfanout70 _12251_/A _12409_/A VPWR VGND sg13cmos5l_buf_1
X_11585_ _11586_/B _11595_/A _11599_/B _11585_/C VPWR VGND sg13cmos5l_nand3_1
X_14373_ _14373_/Q clkload74/A _14373_/D _14373_/RESET_B VPWR VGND sg13cmos5l_dfrbpq_1
X_13950__1441 _13950_/RESET_B VPWR VGND sg13cmos5l_tiehi
X_10536_ _14028_/D fanout77/X _10535_/B _10535_/Y VPWR VGND sg13cmos5l_o21ai_1
X_13324_ _13324_/Q clkload79/A _13324_/D _13324_/RESET_B VPWR VGND sg13cmos5l_dfrbpq_1
X_10467_ _13994_/D _10597_/A1 _10467_/A2 _10466_/Y VPWR VGND sg13cmos5l_a21oi_1
X_13255_ _13255_/Q clkload74/A _13255_/D _13255_/RESET_B VPWR VGND sg13cmos5l_dfrbpq_1
X_12206_ _12206_/Y _13801_/Q _12206_/B VPWR VGND sg13cmos5l_nand2b_1
XFILLER_9_1007 VPWR VGND sg13cmos5l_fill_2
X_10398_ _10398_/Y _10398_/A _10408_/B VPWR VGND sg13cmos5l_nor2_1
X_13368__2054 _13368_/RESET_B VPWR VGND sg13cmos5l_tiehi
X_13186_ _13239_/D _11901_/B _13194_/A2 _13190_/B1 _13185_/Y VPWR VGND sg13cmos5l_a22oi_1
X_12137_ _12137_/Y _14055_/Q _12397_/B _12399_/A2 _13735_/Q VPWR VGND sg13cmos5l_a22oi_1
X_12068_ _12068_/Y _12055_/Y _12056_/Y _12057_/Y _12419_/A2 _12378_/B1 VPWR VGND sg13cmos5l_a221oi_1
XFILLER_64_100 VPWR VGND sg13cmos5l_fill_1
X_11019_ _11020_/B _11019_/A _11019_/B _11019_/C _11019_/D VPWR VGND sg13cmos5l_nor4_1
XFILLER_64_155 VPWR VGND sg13cmos5l_fill_1
XFILLER_46_892 VPWR VGND sg13cmos5l_fill_2
XFILLER_52_328 VPWR VGND sg13cmos5l_fill_1
XFILLER_20_203 VPWR VGND sg13cmos5l_fill_1
X_08230_ _14258_/D _08281_/B _12553_/A _08229_/Y VPWR VGND sg13cmos5l_o21ai_1
X_08161_ _08161_/Y _08161_/A _08161_/B _08161_/C VPWR VGND sg13cmos5l_nand3_1
X_08092_ _08092_/Y _08964_/B _08092_/B VPWR VGND sg13cmos5l_nand2b_1
X_13578__1844 _13578_/RESET_B VPWR VGND sg13cmos5l_tiehi
Xclkload62 clkload62/Y clkload62/A VPWR VGND sg13cmos5l_inv_1
Xclkload51 clkload51/Y clkload51/A VPWR VGND sg13cmos5l_inv_1
Xclkload40 clkload40/Y clkload40/A VPWR VGND sg13cmos5l_inv_2
Xclkload73 clkload73/Y clkload73/A VPWR VGND sg13cmos5l_inv_2
Xhold3525 hold3525/X _14554_/Q VPWR VGND sg13cmos5l_dlygate4sd3_1
Xhold3514 hold3514/X _14076_/Q VPWR VGND sg13cmos5l_dlygate4sd3_1
Xhold3503 hold3503/X _14089_/Q VPWR VGND sg13cmos5l_dlygate4sd3_1
X_08994_ _08994_/Y _08994_/A _08994_/B VPWR VGND sg13cmos5l_nand2_1
Xhold2802 _09537_/A _13594_/Q VPWR VGND sg13cmos5l_dlygate4sd3_1
Xhold2813 _09946_/A _13739_/Q VPWR VGND sg13cmos5l_dlygate4sd3_1
Xhold3536 hold3536/X _14544_/Q VPWR VGND sg13cmos5l_dlygate4sd3_1
Xhold3547 hold3547/X _14557_/Q VPWR VGND sg13cmos5l_dlygate4sd3_1
Xhold3558 hold3558/X _14255_/Q VPWR VGND sg13cmos5l_dlygate4sd3_1
X_13813__1578 _13813_/RESET_B VPWR VGND sg13cmos5l_tiehi
X_07945_ _07947_/B _08424_/A _10653_/A _14438_/Q VPWR VGND sg13cmos5l_nand3b_1
Xhold2824 _14080_/D _10648_/Y VPWR VGND sg13cmos5l_dlygate4sd3_1
Xhold2835 _10352_/A _13938_/Q VPWR VGND sg13cmos5l_dlygate4sd3_1
Xhold2846 _10319_/A _13922_/Q VPWR VGND sg13cmos5l_dlygate4sd3_1
Xhold2857 _12475_/A _14387_/Q VPWR VGND sg13cmos5l_dlygate4sd3_1
Xhold3569 hold3569/X _13299_/Q VPWR VGND sg13cmos5l_dlygate4sd3_1
XFILLER_56_601 VPWR VGND sg13cmos5l_fill_2
Xhold2868 _09769_/A _13652_/Q VPWR VGND sg13cmos5l_dlygate4sd3_1
Xhold2879 _10169_/A _13848_/Q VPWR VGND sg13cmos5l_dlygate4sd3_1
XFILLER_84_943 VPWR VGND sg13cmos5l_fill_1
X_07876_ _14581_/D _10932_/A _10963_/C _10878_/A VPWR VGND sg13cmos5l_or3_1
X_09615_ _11437_/B _14426_/Q _14645_/Q _09615_/S VPWR VGND sg13cmos5l_mux2_1
XFILLER_16_509 VPWR VGND sg13cmos5l_decap_4
XFILLER_71_637 VPWR VGND sg13cmos5l_fill_2
X_09546_ _09546_/Y _09560_/S _14416_/Q VPWR VGND sg13cmos5l_nor2b_1
XFILLER_70_136 VPWR VGND sg13cmos5l_fill_1
X_09477_ _10416_/C _14235_/Q _14234_/Q VPWR VGND sg13cmos5l_or2_1
XFILLER_51_350 VPWR VGND sg13cmos5l_fill_2
XFILLER_54_1028 VPWR VGND sg13cmos5l_fill_1
X_08428_ _10651_/B _08431_/C _10654_/B VPWR VGND sg13cmos5l_nand2_1
X_08359_ _08359_/Y _08258_/S _07319_/Y _08214_/A VPWR VGND sg13cmos5l_a21oi_1
Xclkload1 clkload1/X clkload1/A VPWR VGND sg13cmos5l_buf_8
X_11370_ _11370_/Y _10982_/B _11366_/Y _11369_/Y VPWR VGND sg13cmos5l_a21oi_1
X_10321_ _10321_/Y _10321_/A _10343_/B VPWR VGND sg13cmos5l_nor2_1
XFILLER_106_831 VPWR VGND sg13cmos5l_decap_8
X_14377__1131 _14377_/RESET_B VPWR VGND sg13cmos5l_tiehi
X_13040_ _13043_/B _13040_/A _13040_/B _13040_/C _13040_/D VPWR VGND sg13cmos5l_nand4_1
X_10252_ _10252_/Y _10252_/A _10276_/B VPWR VGND sg13cmos5l_nor2_1
X_10183_ _10183_/Y _10183_/A _10189_/B VPWR VGND sg13cmos5l_nor2_1
XFILLER_66_409 VPWR VGND sg13cmos5l_fill_2
XFILLER_94_718 VPWR VGND sg13cmos5l_fill_2
Xfanout282 _10169_/B _10173_/B VPWR VGND sg13cmos5l_buf_1
Xfanout271 _10250_/B _10245_/A2 VPWR VGND sg13cmos5l_buf_1
Xfanout260 _10295_/B _10299_/B VPWR VGND sg13cmos5l_buf_1
X_13942_ _13942_/Q clkload20/A _13942_/D _13942_/RESET_B VPWR VGND sg13cmos5l_dfrbpq_1
Xfanout293 _09912_/B fanout300/X VPWR VGND sg13cmos5l_buf_1
X_13968__1423 _13968_/RESET_B VPWR VGND sg13cmos5l_tiehi
X_13873_ _13873_/Q clkload70/A _13873_/D _13873_/RESET_B VPWR VGND sg13cmos5l_dfrbpq_1
X_12824_ _12828_/D _12824_/A _12824_/B VPWR VGND sg13cmos5l_nand2_1
X_12755_ _14422_/D _12755_/A _12755_/B VPWR VGND sg13cmos5l_nor2_1
X_11706_ _11706_/Y _11699_/Y _11704_/Y _11705_/Y _11690_/Y VPWR VGND sg13cmos5l_a22oi_1
XFILLER_30_534 VPWR VGND sg13cmos5l_decap_4
X_12686_ _14416_/D _12686_/A _12686_/B _12686_/C _12686_/D VPWR VGND sg13cmos5l_nand4_1
XFILLER_30_589 VPWR VGND sg13cmos5l_fill_2
X_11637_ _11637_/Y _07720_/B _11868_/A2 _11816_/B1 _11636_/Y VPWR VGND sg13cmos5l_a22oi_1
X_14425_ _14425_/Q clkload77/A _14425_/D _14425_/RESET_B VPWR VGND sg13cmos5l_dfrbpq_1
XFILLER_11_792 VPWR VGND sg13cmos5l_fill_1
X_11568_ _11568_/Y _11556_/A _11565_/Y _11567_/Y VPWR VGND sg13cmos5l_a21oi_1
X_14356_ _14356_/Q clkload67/A _14356_/D _14356_/RESET_B VPWR VGND sg13cmos5l_dfrbpq_1
X_10519_ _10519_/Y _10519_/A _10519_/B VPWR VGND sg13cmos5l_nand2_1
X_13307_ _13307_/Q clkload24/A _13307_/D _13307_/RESET_B VPWR VGND sg13cmos5l_dfrbpq_1
X_11499_ _11555_/B _11499_/A _11499_/B VPWR VGND sg13cmos5l_nand2_1
X_14287_ _14287_/Q clkload25/A _14287_/D _14287_/RESET_B VPWR VGND sg13cmos5l_dfrbpq_1
X_13238_ _13238_/Q clkload71/A _13238_/D _13238_/RESET_B VPWR VGND sg13cmos5l_dfrbpq_1
X_13169_ _13169_/Y _13233_/Q _13180_/B VPWR VGND sg13cmos5l_nor2_1
XFILLER_27_2 VPWR VGND sg13cmos5l_fill_1
XFILLER_57_409 VPWR VGND sg13cmos5l_decap_8
X_07730_ _08458_/B _08455_/A _07729_/Y _07719_/Y VPWR VGND sg13cmos5l_a21oi_1
XFILLER_93_740 VPWR VGND sg13cmos5l_fill_1
X_07661_ _07661_/X _14395_/Q _12130_/A VPWR VGND sg13cmos5l_or2_1
XFILLER_53_626 VPWR VGND sg13cmos5l_decap_8
XFILLER_53_637 VPWR VGND sg13cmos5l_fill_1
X_07592_ _07593_/C _07592_/A _08989_/B VPWR VGND sg13cmos5l_xnor2_1
X_09400_ _09400_/X _14121_/Q hold3296/X _09405_/S VPWR VGND sg13cmos5l_mux2_1
XFILLER_80_456 VPWR VGND sg13cmos5l_fill_2
X_09331_ _13447_/D _09293_/A hold3012/X _09333_/S VPWR VGND sg13cmos5l_mux2_1
X_09262_ _13387_/D _08332_/A hold3345/X _09266_/S VPWR VGND sg13cmos5l_mux2_1
XFILLER_14_1001 VPWR VGND sg13cmos5l_fill_1
X_08213_ _08213_/X _13441_/Q _13409_/Q _13377_/Q _13345_/Q _08301_/S _11033_/S1 VPWR
+ VGND sg13cmos5l_mux4_1
X_09193_ _11606_/A _14341_/Q _09193_/B VPWR VGND sg13cmos5l_nand2_1
X_08144_ _13221_/D _08144_/A _08146_/B VPWR VGND sg13cmos5l_nor2_1
X_08075_ _08078_/B _08113_/A _09410_/A _08074_/Y VPWR VGND sg13cmos5l_a21oi_1
XFILLER_1_917 VPWR VGND sg13cmos5l_fill_1
Xhold3300 hold3300/X _13555_/Q VPWR VGND sg13cmos5l_dlygate4sd3_1
X_13252__1012 _13252_/RESET_B VPWR VGND sg13cmos5l_tiehi
XFILLER_102_311 VPWR VGND sg13cmos5l_fill_1
Xhold3333 hold3333/X _13444_/Q VPWR VGND sg13cmos5l_dlygate4sd3_1
Xhold3322 hold3322/X _13430_/Q VPWR VGND sg13cmos5l_dlygate4sd3_1
Xhold3311 hold3311/X _13401_/Q VPWR VGND sg13cmos5l_dlygate4sd3_1
Xhold2610 _08140_/A _13220_/Q VPWR VGND sg13cmos5l_dlygate4sd3_1
Xhold2621 _09191_/A _13328_/Q VPWR VGND sg13cmos5l_dlygate4sd3_1
Xhold3366 _10843_/B _14221_/Q VPWR VGND sg13cmos5l_dlygate4sd3_1
Xhold3355 _09028_/A _13296_/Q VPWR VGND sg13cmos5l_dlygate4sd3_1
Xhold3344 _10941_/A _14214_/Q VPWR VGND sg13cmos5l_dlygate4sd3_1
XFILLER_103_889 VPWR VGND sg13cmos5l_fill_1
XFILLER_69_770 VPWR VGND sg13cmos5l_decap_4
X_08977_ _08977_/Y _08977_/A _08977_/B VPWR VGND sg13cmos5l_nand2_1
Xhold2632 _09854_/A _13694_/Q VPWR VGND sg13cmos5l_dlygate4sd3_1
Xhold2643 _10904_/A _14199_/Q VPWR VGND sg13cmos5l_dlygate4sd3_1
Xhold2654 _12968_/A _14472_/Q VPWR VGND sg13cmos5l_dlygate4sd3_1
Xhold2665 _14478_/D _12980_/X VPWR VGND sg13cmos5l_dlygate4sd3_1
Xhold3399 hold3399/X _13435_/Q VPWR VGND sg13cmos5l_dlygate4sd3_1
Xhold3388 hold3388/X _13264_/Q VPWR VGND sg13cmos5l_dlygate4sd3_1
Xhold3377 _14575_/D _07958_/Y VPWR VGND sg13cmos5l_dlygate4sd3_1
X_07928_ _14570_/D _07921_/Y _07927_/Y _07917_/Y VPWR VGND sg13cmos5l_a21oi_1
Xhold2676 _14077_/D _10642_/Y VPWR VGND sg13cmos5l_dlygate4sd3_1
Xhold2687 _09783_/A _13659_/Q VPWR VGND sg13cmos5l_dlygate4sd3_1
Xhold2698 _09565_/A _13598_/Q VPWR VGND sg13cmos5l_dlygate4sd3_1
XFILLER_72_902 VPWR VGND sg13cmos5l_decap_8
XFILLER_84_784 VPWR VGND sg13cmos5l_fill_1
X_07859_ _07859_/Y _10981_/A _11715_/A _07858_/Y VPWR VGND sg13cmos5l_a21oi_1
XFILLER_16_339 VPWR VGND sg13cmos5l_fill_2
X_10870_ _14188_/D _10865_/Y _10943_/B _10869_/Y VPWR VGND sg13cmos5l_o21ai_1
X_09529_ _09529_/Y _09535_/A _11234_/B _09528_/Y VPWR VGND sg13cmos5l_a21oi_1
X_12540_ _14403_/D _07643_/A _12530_/B _12538_/Y _12539_/Y VPWR VGND sg13cmos5l_a22oi_1
X_12471_ _12474_/A _14386_/Q _12485_/B VPWR VGND sg13cmos5l_nand2_1
X_11422_ _11430_/B _11422_/A _11422_/B VPWR VGND sg13cmos5l_nand2_1
X_14210_ _14210_/Q _14614_/CLK _14210_/D _14210_/RESET_B VPWR VGND sg13cmos5l_dfrbpq_1
X_14636__2179 _14636_/RESET_B VPWR VGND sg13cmos5l_tiehi
X_14141_ _14141_/Q clkload26/A _14141_/D fanout985/X VPWR VGND sg13cmos5l_dfrbpq_1
X_11353_ _11353_/Y _11337_/A _11337_/B _11347_/B VPWR VGND sg13cmos5l_a21oi_1
X_10304_ _13914_/D _10565_/A1 _10341_/B _10303_/Y VPWR VGND sg13cmos5l_a21oi_1
X_11284_ _11286_/B _11284_/A _11298_/A _11328_/A VPWR VGND sg13cmos5l_nor3_1
X_14072_ _14072_/Q _14532_/CLK _14072_/D fanout968/X VPWR VGND sg13cmos5l_dfrbpq_1
X_10235_ _13880_/D _10561_/A1 _10238_/B _10234_/Y VPWR VGND sg13cmos5l_a21oi_1
X_13023_ _13027_/B _14499_/Q _14500_/Q _13026_/D VPWR VGND sg13cmos5l_nand3_1
Xfanout1000 _11011_/A _11000_/A VPWR VGND sg13cmos5l_buf_1
XFILLER_0_983 VPWR VGND sg13cmos5l_fill_2
XFILLER_86_63 VPWR VGND sg13cmos5l_fill_2
X_10166_ _13846_/D _10361_/A1 _10171_/B _10165_/Y VPWR VGND sg13cmos5l_a21oi_1
XFILLER_19_100 VPWR VGND sg13cmos5l_fill_2
X_10097_ _10097_/Y _10097_/A _10099_/B VPWR VGND sg13cmos5l_nand2_1
XFILLER_74_250 VPWR VGND sg13cmos5l_fill_2
X_13925_ _13925_/Q clkload64/A _13925_/D _13925_/RESET_B VPWR VGND sg13cmos5l_dfrbpq_1
XFILLER_47_497 VPWR VGND sg13cmos5l_decap_4
XFILLER_63_946 VPWR VGND sg13cmos5l_fill_1
X_14236__1241 _14236_/RESET_B VPWR VGND sg13cmos5l_tiehi
X_13856_ _13856_/Q _14048_/CLK _13856_/D _13856_/RESET_B VPWR VGND sg13cmos5l_dfrbpq_1
XFILLER_90_754 VPWR VGND sg13cmos5l_fill_2
X_12807_ _12809_/B _12823_/A _12808_/C _12828_/B VPWR VGND sg13cmos5l_o21ai_1
XFILLER_43_670 VPWR VGND sg13cmos5l_fill_1
XFILLER_62_489 VPWR VGND sg13cmos5l_decap_8
X_10999_ _11000_/B hold3362/X _10983_/B _10996_/Y hold3454/X VPWR VGND sg13cmos5l_a22oi_1
X_13787_ _13787_/Q clkload48/A _13787_/D _13787_/RESET_B VPWR VGND sg13cmos5l_dfrbpq_1
XFILLER_15_383 VPWR VGND sg13cmos5l_fill_1
X_12738_ _12738_/Y _12651_/Y _12737_/Y _11008_/A VPWR VGND sg13cmos5l_a21oi_1
X_12669_ _12669_/Y _12669_/A _12668_/Y VPWR VGND sg13cmos5l_nor2b_1
X_14408_ _14408_/Q clkload36/A _14408_/D _14408_/RESET_B VPWR VGND sg13cmos5l_dfrbpq_1
XFILLER_7_593 VPWR VGND sg13cmos5l_fill_2
X_14339_ _14339_/Q _14654_/CLK _14339_/D _14339_/RESET_B VPWR VGND sg13cmos5l_dfrbpq_1
X_08900_ _14653_/D hold2602/X _08900_/A2 _08899_/Y VPWR VGND sg13cmos5l_a21o_1
X_09880_ _09880_/Y _09880_/A _09882_/B VPWR VGND sg13cmos5l_nor2_1
XFILLER_32_0 VPWR VGND sg13cmos5l_fill_2
XFILLER_44_1027 VPWR VGND sg13cmos5l_fill_2
X_08831_ _08831_/Y _07691_/Y _08839_/B _08831_/B1 _07693_/A VPWR VGND sg13cmos5l_a22oi_1
XFILLER_100_826 VPWR VGND sg13cmos5l_fill_1
X_13730__1661 _13730_/RESET_B VPWR VGND sg13cmos5l_tiehi
XFILLER_85_559 VPWR VGND sg13cmos5l_fill_2
X_08762_ _08762_/Y _07261_/Y _07330_/Y _08761_/Y VPWR VGND sg13cmos5l_o21ai_1
XFILLER_39_987 VPWR VGND sg13cmos5l_fill_2
XFILLER_54_902 VPWR VGND sg13cmos5l_fill_1
X_07713_ _07713_/X _14378_/Q _11668_/A VPWR VGND sg13cmos5l_and2_1
X_08693_ _08693_/Y _08689_/Y _08690_/Y _08691_/Y _08692_/Y VPWR VGND sg13cmos5l_a22oi_1
XFILLER_53_412 VPWR VGND sg13cmos5l_fill_1
X_07644_ _08619_/A _07644_/A _07644_/B VPWR VGND sg13cmos5l_nand2_1
X_07575_ _07576_/C _14560_/Q _14562_/Q _14561_/Q _14559_/Q _07366_/A _07369_/B VPWR
+ VGND sg13cmos5l_mux4_1
XFILLER_34_681 VPWR VGND sg13cmos5l_fill_2
XFILLER_62_990 VPWR VGND sg13cmos5l_fill_1
X_09314_ _13430_/D _10683_/A1 hold3322/X _09320_/S VPWR VGND sg13cmos5l_mux2_1
X_09245_ _13370_/D _08170_/A hold3303/X _09258_/S VPWR VGND sg13cmos5l_mux2_1
X_09176_ _09176_/Y _14434_/Q _11530_/A VPWR VGND sg13cmos5l_nand2_1
X_08127_ _08127_/Y _13215_/Q _13214_/Q _08138_/B VPWR VGND sg13cmos5l_nand3_1
X_08058_ _08058_/Y _08113_/A _08058_/B VPWR VGND sg13cmos5l_nand2b_1
Xoutput25 uio_out[11] _15891_/X VPWR VGND sg13cmos5l_buf_1
Xoutput36 uio_out[7] _15887_/X VPWR VGND sg13cmos5l_buf_1
Xoutput47 uo_out[2] _08760_/Y VPWR VGND sg13cmos5l_buf_1
XFILLER_0_235 VPWR VGND sg13cmos5l_fill_2
XFILLER_1_747 VPWR VGND sg13cmos5l_fill_2
XFILLER_89_843 VPWR VGND sg13cmos5l_decap_8
X_10020_ _13775_/D fanout62/X _10023_/B _10019_/Y VPWR VGND sg13cmos5l_o21ai_1
Xhold3130 hold3130/X _13559_/Q VPWR VGND sg13cmos5l_dlygate4sd3_1
Xhold3141 _13506_/D _09394_/X VPWR VGND sg13cmos5l_dlygate4sd3_1
XFILLER_88_364 VPWR VGND sg13cmos5l_fill_2
Xhold2440 _10592_/A _14056_/Q VPWR VGND sg13cmos5l_dlygate4sd3_1
Xhold3152 _13340_/D _09211_/X VPWR VGND sg13cmos5l_dlygate4sd3_1
Xhold3163 hold3163/X _13522_/Q VPWR VGND sg13cmos5l_dlygate4sd3_1
Xhold3174 hold3174/X _13345_/Q VPWR VGND sg13cmos5l_dlygate4sd3_1
Xhold3185 hold3185/X _13394_/Q VPWR VGND sg13cmos5l_dlygate4sd3_1
XFILLER_57_740 VPWR VGND sg13cmos5l_fill_2
XFILLER_88_397 VPWR VGND sg13cmos5l_fill_1
Xhold2451 _08977_/A _13274_/Q VPWR VGND sg13cmos5l_dlygate4sd3_1
Xhold2462 _10060_/A _13795_/Q VPWR VGND sg13cmos5l_dlygate4sd3_1
Xhold2473 _10038_/A _13784_/Q VPWR VGND sg13cmos5l_dlygate4sd3_1
Xhold3196 _13486_/D _09373_/X VPWR VGND sg13cmos5l_dlygate4sd3_1
X_11971_ _11971_/Y _14017_/Q _11971_/A2 _12000_/B VPWR VGND sg13cmos5l_a21oi_1
Xhold2484 _10009_/A _13770_/Q VPWR VGND sg13cmos5l_dlygate4sd3_1
Xhold2495 _10624_/A _14068_/Q VPWR VGND sg13cmos5l_dlygate4sd3_1
XFILLER_17_637 VPWR VGND sg13cmos5l_fill_1
XFILLER_44_423 VPWR VGND sg13cmos5l_decap_4
X_10922_ _10922_/Y _10943_/A _10922_/B VPWR VGND sg13cmos5l_nor2_1
X_13710_ _13710_/Q clkload56/A _13710_/D _13710_/RESET_B VPWR VGND sg13cmos5l_dfrbpq_1
X_10853_ _14184_/D _10853_/A VPWR VGND sg13cmos5l_inv_1
X_13641_ _13641_/Q clkload63/A _13641_/D _13641_/RESET_B VPWR VGND sg13cmos5l_dfrbpq_1
XFILLER_53_990 VPWR VGND sg13cmos5l_fill_2
XFILLER_72_65 VPWR VGND sg13cmos5l_fill_1
X_10784_ _10784_/Y _10784_/A _10793_/B VPWR VGND sg13cmos5l_nand2_1
X_13572_ _13572_/Q _14621_/CLK _13572_/D _13572_/RESET_B VPWR VGND sg13cmos5l_dfrbpq_1
XFILLER_40_651 VPWR VGND sg13cmos5l_fill_2
X_12523_ _12523_/Y _12523_/A _12523_/B VPWR VGND sg13cmos5l_nand2_1
XFILLER_12_375 VPWR VGND sg13cmos5l_fill_1
X_13772__1619 _13772_/RESET_B VPWR VGND sg13cmos5l_tiehi
X_12454_ _12455_/B _08638_/A _13234_/Q _12453_/Y VPWR VGND sg13cmos5l_o21ai_1
X_11405_ _11405_/Y _11587_/A _11403_/B _12937_/B2 VPWR VGND sg13cmos5l_o21ai_1
X_12385_ _12385_/Y _12385_/A _12385_/B _12385_/C VPWR VGND sg13cmos5l_nor3_1
X_11336_ _11336_/Y _11391_/A _11336_/B VPWR VGND sg13cmos5l_xnor2_1
X_14124_ _14124_/Q clkload31/A _14124_/D _07198_/A VPWR VGND sg13cmos5l_dfrbpq_1
X_14055_ _14055_/Q _14064_/CLK _14055_/D _14055_/RESET_B VPWR VGND sg13cmos5l_dfrbpq_1
X_11267_ _11270_/A _11236_/Y _11252_/A _11253_/A VPWR VGND sg13cmos5l_o21ai_1
X_13006_ _13007_/B _14490_/Q _13005_/C _14491_/Q VPWR VGND sg13cmos5l_a21o_1
X_10218_ _13872_/D fanout57/X _10209_/B _10217_/Y VPWR VGND sg13cmos5l_a21oi_1
X_11198_ _11211_/A _14085_/Q _11214_/C VPWR VGND sg13cmos5l_nand2_1
XFILLER_0_791 VPWR VGND sg13cmos5l_decap_4
XFILLER_67_526 VPWR VGND sg13cmos5l_fill_1
XFILLER_94_334 VPWR VGND sg13cmos5l_fill_1
X_10149_ _10149_/Y _10149_/A _10153_/B VPWR VGND sg13cmos5l_nand2_1
XFILLER_48_751 VPWR VGND sg13cmos5l_fill_2
X_13908_ _13908_/Q clkload18/A _13908_/D _13908_/RESET_B VPWR VGND sg13cmos5l_dfrbpq_1
X_13839_ _13839_/Q clkload62/A _13839_/D _13839_/RESET_B VPWR VGND sg13cmos5l_dfrbpq_1
XFILLER_22_128 VPWR VGND sg13cmos5l_fill_1
X_07360_ _08961_/B _07369_/B _07369_/A VPWR VGND sg13cmos5l_nor2b_1
X_07291_ _07291_/Y _13252_/Q VPWR VGND sg13cmos5l_inv_1
X_09030_ _09030_/Y _09030_/A _09030_/B VPWR VGND sg13cmos5l_nand2_1
X_13748__1643 _13748_/RESET_B VPWR VGND sg13cmos5l_tiehi
X_13436__1986 _13436_/RESET_B VPWR VGND sg13cmos5l_tiehi
XFILLER_105_918 VPWR VGND sg13cmos5l_decap_8
X_09932_ _09932_/Y _09932_/A _09944_/B VPWR VGND sg13cmos5l_nor2_1
Xfanout815 _12405_/B _12861_/A2 VPWR VGND sg13cmos5l_buf_1
Xfanout804 fanout804/X _14617_/Q VPWR VGND sg13cmos5l_buf_1
X_09863_ _13698_/D _10385_/A1 _09862_/B _09862_/Y VPWR VGND sg13cmos5l_a21oi_1
Xfanout848 _11641_/A _11628_/A VPWR VGND sg13cmos5l_buf_1
Xfanout837 _12415_/A _14373_/Q VPWR VGND sg13cmos5l_buf_1
Xfanout826 _12538_/B _12545_/A VPWR VGND sg13cmos5l_buf_1
X_08814_ _14631_/D hold2335/X _08822_/B _08813_/Y VPWR VGND sg13cmos5l_a21o_1
X_09794_ _13664_/D _10381_/A1 _09793_/B _09793_/Y VPWR VGND sg13cmos5l_a21oi_1
Xfanout859 _09662_/S _14236_/Q VPWR VGND sg13cmos5l_buf_1
XFILLER_86_879 VPWR VGND sg13cmos5l_decap_8
X_08745_ _08745_/Y _08745_/A _08745_/B _08745_/C VPWR VGND sg13cmos5l_nand3_1
XFILLER_54_721 VPWR VGND sg13cmos5l_fill_2
X_13996__1395 _13996_/RESET_B VPWR VGND sg13cmos5l_tiehi
XFILLER_54_765 VPWR VGND sg13cmos5l_decap_8
XFILLER_81_540 VPWR VGND sg13cmos5l_fill_1
X_08676_ _08676_/Y _12449_/A _08676_/B VPWR VGND sg13cmos5l_nand2_1
X_14635__2178 _14635_/RESET_B VPWR VGND sg13cmos5l_tiehi
XFILLER_13_106 VPWR VGND sg13cmos5l_fill_1
XFILLER_53_275 VPWR VGND sg13cmos5l_fill_2
X_07627_ _07629_/C _08979_/A _07627_/B VPWR VGND sg13cmos5l_xor2_1
XFILLER_41_426 VPWR VGND sg13cmos5l_decap_8
XFILLER_41_448 VPWR VGND sg13cmos5l_fill_2
X_07558_ _07559_/C _07558_/A _07558_/B _07558_/C _07558_/D VPWR VGND sg13cmos5l_nor4_1
XFILLER_50_971 VPWR VGND sg13cmos5l_decap_4
XFILLER_21_150 VPWR VGND sg13cmos5l_fill_1
X_07489_ _14243_/D hold3444/X _13032_/C _07533_/S VPWR VGND sg13cmos5l_mux2_1
X_09228_ _13355_/D _08332_/A hold3153/X _09235_/S VPWR VGND sg13cmos5l_mux2_1
X_09159_ _09159_/Y _11511_/A _09158_/Y _09160_/A2 VPWR VGND sg13cmos5l_a21oi_1
X_12170_ _12170_/Y _13864_/Q _12174_/B _12401_/B1 _13672_/Q VPWR VGND sg13cmos5l_a22oi_1
X_11121_ _11121_/Y _11121_/A _11121_/B VPWR VGND sg13cmos5l_nor2_1
X_11052_ _14279_/D _11109_/A _11099_/B _11051_/Y VPWR VGND sg13cmos5l_a21oi_1
XFILLER_67_65 VPWR VGND sg13cmos5l_fill_2
X_10003_ _10003_/Y _10003_/A _10013_/B VPWR VGND sg13cmos5l_nand2_1
Xhold2270 _07343_/A _14582_/Q VPWR VGND sg13cmos5l_dlygate4sd3_1
Xhold2281 _14471_/D _12967_/Y VPWR VGND sg13cmos5l_dlygate4sd3_1
XFILLER_29_250 VPWR VGND sg13cmos5l_fill_2
XFILLER_76_389 VPWR VGND sg13cmos5l_decap_8
XFILLER_85_890 VPWR VGND sg13cmos5l_fill_1
Xhold2292 _10487_/A _14004_/Q VPWR VGND sg13cmos5l_dlygate4sd3_1
X_11954_ _14356_/D _11926_/A _11979_/A _11933_/Y _11953_/Y VPWR VGND sg13cmos5l_a22oi_1
X_13826__1565 _13826_/RESET_B VPWR VGND sg13cmos5l_tiehi
XFILLER_45_765 VPWR VGND sg13cmos5l_fill_2
X_10905_ _14199_/D _10943_/B _10897_/Y _10904_/Y VPWR VGND sg13cmos5l_o21ai_1
X_11885_ _11886_/C _13854_/Q _12203_/B1 _12005_/B _13662_/Q VPWR VGND sg13cmos5l_a22oi_1
X_10836_ _10873_/B _14254_/Q _14255_/Q VPWR VGND sg13cmos5l_nor2_1
X_13624_ _13624_/Q clkload25/A _13624_/D _13624_/RESET_B VPWR VGND sg13cmos5l_dfrbpq_1
XFILLER_9_611 VPWR VGND sg13cmos5l_fill_1
X_10767_ _10767_/Y _10766_/B _10765_/Y _10766_/Y VPWR VGND sg13cmos5l_o21ai_1
X_13555_ _13555_/Q _14292_/CLK _13555_/D _13555_/RESET_B VPWR VGND sg13cmos5l_dfrbpq_1
X_10698_ _14118_/D input11/X _08257_/A _10710_/S VPWR VGND sg13cmos5l_mux2_1
X_13486_ _13486_/Q clkload33/A _13486_/D _13486_/RESET_B VPWR VGND sg13cmos5l_dfrbpq_1
X_12506_ _14394_/D _12503_/B _12505_/Y _12503_/Y VPWR VGND sg13cmos5l_o21ai_1
X_14186__1291 _14186_/RESET_B VPWR VGND sg13cmos5l_tiehi
X_12437_ _12437_/Y _12445_/A _13228_/Q _12441_/B1 VPWR VGND sg13cmos5l_a21oi_1
X_14107_ _14107_/Q clkload29/A _14107_/D fanout996/X VPWR VGND sg13cmos5l_dfrbpq_1
X_12368_ _12368_/Y _12368_/A _12368_/B _12368_/C VPWR VGND sg13cmos5l_nand3_1
X_11319_ _14322_/D _11317_/Y _11318_/Y _11307_/Y VPWR VGND sg13cmos5l_o21ai_1
X_12299_ _12299_/Y _12403_/B1 _12291_/Y _12295_/Y _12298_/Y VPWR VGND sg13cmos5l_a22oi_1
X_14038_ _14038_/Q clkload49/A _14038_/D _14038_/RESET_B VPWR VGND sg13cmos5l_dfrbpq_1
XFILLER_55_507 VPWR VGND sg13cmos5l_decap_8
XFILLER_68_879 VPWR VGND sg13cmos5l_decap_8
XFILLER_95_654 VPWR VGND sg13cmos5l_fill_2
XFILLER_27_209 VPWR VGND sg13cmos5l_fill_1
X_08530_ _08530_/Y _08530_/A _08529_/X VPWR VGND sg13cmos5l_nor2b_1
XFILLER_24_927 VPWR VGND sg13cmos5l_fill_2
XFILLER_51_713 VPWR VGND sg13cmos5l_fill_1
X_08461_ _08464_/A _08502_/A _08461_/B _08461_/C VPWR VGND sg13cmos5l_nor3_1
XFILLER_51_724 VPWR VGND sg13cmos5l_fill_1
X_07412_ _07413_/D _07592_/A _07594_/A VPWR VGND sg13cmos5l_nand2b_1
X_08392_ _08392_/Y _08390_/S _07321_/Y _08404_/B1 VPWR VGND sg13cmos5l_a21oi_1
X_14313__1195 _14313_/RESET_B VPWR VGND sg13cmos5l_tiehi
X_07343_ _07343_/Y _07343_/A VPWR VGND sg13cmos5l_inv_1
XFILLER_12_27 VPWR VGND sg13cmos5l_fill_1
X_07274_ _07274_/Y _13236_/Q VPWR VGND sg13cmos5l_inv_1
X_09013_ _13287_/D _08989_/A _09012_/B _09012_/Y VPWR VGND sg13cmos5l_a21oi_1
XFILLER_105_737 VPWR VGND sg13cmos5l_fill_1
X_13904__1487 _13904_/RESET_B VPWR VGND sg13cmos5l_tiehi
X_09915_ _13723_/D _10567_/A1 _09924_/B _09914_/Y VPWR VGND sg13cmos5l_a21oi_1
Xfanout623 _07530_/B1 _07434_/Y VPWR VGND sg13cmos5l_buf_1
Xfanout612 _12945_/B2 _07933_/A VPWR VGND sg13cmos5l_buf_1
Xfanout601 _12012_/A1 _12322_/A1 VPWR VGND sg13cmos5l_buf_1
X_09846_ _09846_/Y _09846_/A _09846_/B VPWR VGND sg13cmos5l_nor2_1
Xfanout667 _10904_/B _10885_/C VPWR VGND sg13cmos5l_buf_1
Xfanout656 _12859_/A _12897_/A VPWR VGND sg13cmos5l_buf_1
Xfanout645 _12636_/C _11164_/X VPWR VGND sg13cmos5l_buf_1
Xfanout634 _12530_/B _12522_/B VPWR VGND sg13cmos5l_buf_1
XFILLER_86_654 VPWR VGND sg13cmos5l_fill_1
Xfanout689 _09065_/A2 _09075_/B1 VPWR VGND sg13cmos5l_buf_1
Xfanout678 _11197_/S _11308_/A VPWR VGND sg13cmos5l_buf_1
XFILLER_37_35 VPWR VGND sg13cmos5l_fill_1
XFILLER_73_304 VPWR VGND sg13cmos5l_fill_1
XFILLER_74_838 VPWR VGND sg13cmos5l_decap_8
XFILLER_85_175 VPWR VGND sg13cmos5l_fill_2
XFILLER_86_687 VPWR VGND sg13cmos5l_decap_4
X_09777_ _09777_/Y _09777_/A _09801_/B VPWR VGND sg13cmos5l_nor2_1
XFILLER_73_348 VPWR VGND sg13cmos5l_fill_1
X_08728_ _08728_/Y _13845_/Q _08744_/B1 _11837_/C1 VPWR VGND sg13cmos5l_a21oi_1
XFILLER_54_562 VPWR VGND sg13cmos5l_fill_1
XFILLER_82_871 VPWR VGND sg13cmos5l_decap_8
X_08659_ _08659_/Y _13970_/Q _12055_/B VPWR VGND sg13cmos5l_nand2_1
XFILLER_54_584 VPWR VGND sg13cmos5l_decap_8
X_11670_ _11670_/X _11682_/A _11682_/B VPWR VGND sg13cmos5l_xor2_1
X_10621_ _10624_/B _10622_/A _14066_/Q _10621_/C _10621_/D VPWR VGND sg13cmos5l_nand4_1
XFILLER_10_654 VPWR VGND sg13cmos5l_fill_1
X_10552_ _10552_/Y _10552_/A _10566_/B VPWR VGND sg13cmos5l_nand2_1
X_13340_ _13340_/Q clkload28/A _13340_/D _13340_/RESET_B VPWR VGND sg13cmos5l_dfrbpq_1
X_13271_ _13271_/Q clkload8/A _13271_/D fanout962/X VPWR VGND sg13cmos5l_dfrbpq_1
X_10483_ _10483_/Y _10483_/A _10519_/B VPWR VGND sg13cmos5l_nand2_1
X_12222_ _12256_/A _12216_/Y _12217_/Y _12221_/X _11993_/A _12219_/Y VPWR VGND sg13cmos5l_a221oi_1
XFILLER_64_1008 VPWR VGND sg13cmos5l_fill_2
XFILLER_64_1019 VPWR VGND sg13cmos5l_fill_1
XFILLER_97_908 VPWR VGND sg13cmos5l_fill_1
X_12153_ _12154_/C _12352_/A _12149_/Y _12152_/Y VPWR VGND sg13cmos5l_o21ai_1
X_11104_ _14293_/D _11107_/B _11102_/Y _11103_/Y VPWR VGND sg13cmos5l_a21oi_1
X_12084_ _12084_/Y _12080_/Y _12081_/Y _12082_/Y _12083_/Y VPWR VGND sg13cmos5l_a22oi_1
X_11035_ _11035_/Y _11035_/A1 _11032_/Y _11034_/A VPWR VGND sg13cmos5l_o21ai_1
XFILLER_77_654 VPWR VGND sg13cmos5l_decap_8
XFILLER_18_721 VPWR VGND sg13cmos5l_fill_2
XFILLER_18_732 VPWR VGND sg13cmos5l_fill_2
X_12986_ _12986_/X _14480_/Q _12985_/C hold3529/X VPWR VGND sg13cmos5l_a21o_1
XFILLER_17_264 VPWR VGND sg13cmos5l_fill_1
XFILLER_33_724 VPWR VGND sg13cmos5l_fill_1
XFILLER_60_510 VPWR VGND sg13cmos5l_decap_8
X_11937_ _11937_/Y _11937_/A _11937_/B _11937_/C VPWR VGND sg13cmos5l_nand3_1
XFILLER_60_554 VPWR VGND sg13cmos5l_fill_1
X_11868_ _11868_/Y _11901_/A _11868_/A2 _11840_/A _12686_/B VPWR VGND sg13cmos5l_a22oi_1
X_14656_ _14656_/Q clkload73/A _14656_/D _14656_/RESET_B VPWR VGND sg13cmos5l_dfrbpq_1
XFILLER_20_429 VPWR VGND sg13cmos5l_fill_1
XFILLER_60_598 VPWR VGND sg13cmos5l_fill_1
X_10819_ _10819_/X _14262_/Q _13166_/B VPWR VGND sg13cmos5l_and2_1
X_11799_ _11801_/C _11799_/A _11983_/A VPWR VGND sg13cmos5l_nand2_1
X_14587_ _14587_/Q clkload36/A _14587_/D _14587_/RESET_B VPWR VGND sg13cmos5l_dfrbpq_1
X_13607_ _13607_/Q _14064_/CLK _13607_/D _13607_/RESET_B VPWR VGND sg13cmos5l_dfrbpq_1
XFILLER_9_430 VPWR VGND sg13cmos5l_fill_1
X_13538_ _13538_/Q clkload29/A _13538_/D _13538_/RESET_B VPWR VGND sg13cmos5l_dfrbpq_1
X_13469_ _13469_/Q clkload30/A _13469_/D _13469_/RESET_B VPWR VGND sg13cmos5l_dfrbpq_1
X_14634__2177 _14634_/RESET_B VPWR VGND sg13cmos5l_tiehi
XFILLER_88_908 VPWR VGND sg13cmos5l_decap_8
XFILLER_102_718 VPWR VGND sg13cmos5l_fill_2
XFILLER_88_919 VPWR VGND sg13cmos5l_fill_1
X_07961_ _07961_/X _07961_/A _08409_/B VPWR VGND sg13cmos5l_and2_1
X_09700_ _09700_/Y _09700_/A _09706_/B VPWR VGND sg13cmos5l_nor2_1
XFILLER_56_805 VPWR VGND sg13cmos5l_decap_4
XFILLER_95_440 VPWR VGND sg13cmos5l_fill_1
X_07892_ _07896_/B _14183_/Q _14182_/Q _11202_/A _14213_/Q VPWR VGND sg13cmos5l_nor4_1
X_13698__1693 _13698_/RESET_B VPWR VGND sg13cmos5l_tiehi
XFILLER_28_529 VPWR VGND sg13cmos5l_decap_4
XFILLER_67_164 VPWR VGND sg13cmos5l_fill_1
XFILLER_95_484 VPWR VGND sg13cmos5l_decap_4
X_09631_ _09631_/Y _14459_/Q _09638_/C _09617_/A VPWR VGND sg13cmos5l_o21ai_1
X_09562_ _09570_/B _09575_/C _09575_/D VPWR VGND sg13cmos5l_nor2_1
XFILLER_64_860 VPWR VGND sg13cmos5l_decap_4
X_08513_ _08514_/B _08498_/A _08512_/Y _08511_/Y VPWR VGND sg13cmos5l_o21ai_1
X_09493_ _09493_/Y _09493_/A _09511_/B VPWR VGND sg13cmos5l_nor2_1
X_14400__1108 _14400_/RESET_B VPWR VGND sg13cmos5l_tiehi
X_08444_ _08444_/Y _14409_/Q _11197_/S VPWR VGND sg13cmos5l_nand2_1
X_08375_ _08375_/X _13582_/Q _13550_/Q _08375_/S VPWR VGND sg13cmos5l_mux2_1
XFILLER_104_1013 VPWR VGND sg13cmos5l_decap_8
XFILLER_20_930 VPWR VGND sg13cmos5l_fill_2
X_07326_ _07326_/Y _14616_/Q VPWR VGND sg13cmos5l_inv_1
X_07257_ _11601_/A _11556_/A VPWR VGND sg13cmos5l_inv_1
X_07188_ _08970_/A _13303_/Q VPWR VGND sg13cmos5l_inv_1
X_14456__1044 _14456_/RESET_B VPWR VGND sg13cmos5l_tiehi
Xfanout431 _10517_/B _10537_/B VPWR VGND sg13cmos5l_buf_1
Xfanout420 _10594_/B _10602_/B VPWR VGND sg13cmos5l_buf_1
Xfanout475 _12030_/B _12344_/B VPWR VGND sg13cmos5l_buf_1
Xfanout464 _12296_/B1 fanout465/X VPWR VGND sg13cmos5l_buf_1
Xfanout453 _08743_/B _08655_/Y VPWR VGND sg13cmos5l_buf_1
Xfanout442 _10470_/B _10478_/B VPWR VGND sg13cmos5l_buf_1
XFILLER_59_698 VPWR VGND sg13cmos5l_fill_2
X_09829_ _09829_/Y _10351_/A _10351_/B _09829_/C VPWR VGND sg13cmos5l_nor3_1
Xfanout497 _12200_/B1 _12349_/A2 VPWR VGND sg13cmos5l_buf_1
Xfanout486 _12236_/B1 _08651_/Y VPWR VGND sg13cmos5l_buf_1
XFILLER_104_62 VPWR VGND sg13cmos5l_fill_2
XFILLER_74_646 VPWR VGND sg13cmos5l_fill_1
X_12840_ _12840_/X _11092_/A _12559_/X _12879_/B1 VPWR VGND sg13cmos5l_a21o_1
XFILLER_27_540 VPWR VGND sg13cmos5l_fill_1
XFILLER_55_860 VPWR VGND sg13cmos5l_decap_8
XFILLER_70_830 VPWR VGND sg13cmos5l_decap_8
X_12771_ _12771_/Y _12859_/A _12769_/X _12770_/X fanout59/X VPWR VGND sg13cmos5l_a22oi_1
XFILLER_30_705 VPWR VGND sg13cmos5l_fill_2
XFILLER_54_392 VPWR VGND sg13cmos5l_fill_2
XFILLER_70_841 VPWR VGND sg13cmos5l_fill_2
X_11722_ _11722_/Y _08658_/S _11719_/X _11721_/Y VPWR VGND sg13cmos5l_a21oi_1
X_14510_ _15889_/A _14532_/CLK _14510_/D fanout968/X VPWR VGND sg13cmos5l_dfrbpq_1
X_13431__1991 _13431_/RESET_B VPWR VGND sg13cmos5l_tiehi
XFILLER_30_716 VPWR VGND sg13cmos5l_fill_2
X_11653_ _11654_/B _08711_/Y _11793_/A1 _11652_/Y VPWR VGND sg13cmos5l_o21ai_1
X_14441_ _14441_/Q clkload40/A _14441_/D _14441_/RESET_B VPWR VGND sg13cmos5l_dfrbpq_1
X_10604_ _10604_/Y _10604_/A _10604_/B VPWR VGND sg13cmos5l_nand2_1
Xfanout82 _09333_/S _09340_/S VPWR VGND sg13cmos5l_buf_1
Xfanout71 _12409_/A _12412_/A VPWR VGND sg13cmos5l_buf_1
Xfanout60 fanout60/X _12738_/Y VPWR VGND sg13cmos5l_buf_1
X_14372_ _14372_/Q clkload74/A _14372_/D _14372_/RESET_B VPWR VGND sg13cmos5l_dfrbpq_1
XFILLER_7_923 VPWR VGND sg13cmos5l_decap_8
X_11584_ _11585_/C _11584_/A _11584_/B _11608_/A VPWR VGND sg13cmos5l_nand3_1
Xfanout93 _09260_/S _09267_/S VPWR VGND sg13cmos5l_buf_1
X_13323_ _13323_/Q _14650_/CLK _13323_/D _13323_/RESET_B VPWR VGND sg13cmos5l_dfrbpq_1
X_10535_ _10535_/Y _10535_/A _10535_/B VPWR VGND sg13cmos5l_nand2_1
X_14409__1099 _14409_/RESET_B VPWR VGND sg13cmos5l_tiehi
X_10466_ _10466_/Y _10466_/A _10466_/B VPWR VGND sg13cmos5l_nor2_1
X_13254_ _13254_/Q clkload74/A _13254_/D _13254_/RESET_B VPWR VGND sg13cmos5l_dfrbpq_1
X_12205_ _12205_/Y _07288_/Y _12206_/B _12204_/Y VPWR VGND sg13cmos5l_a21oi_1
X_13185_ _13185_/Y _08923_/A _14092_/Q _13191_/B1 _14254_/Q VPWR VGND sg13cmos5l_a22oi_1
XFILLER_97_727 VPWR VGND sg13cmos5l_decap_4
X_10397_ _13960_/D _10397_/A1 _10402_/B _10396_/Y VPWR VGND sg13cmos5l_a21oi_1
X_12136_ _12154_/B _12136_/A _12136_/B _12136_/C _12136_/D VPWR VGND sg13cmos5l_nor4_1
XFILLER_78_952 VPWR VGND sg13cmos5l_fill_1
XFILLER_96_248 VPWR VGND sg13cmos5l_fill_1
X_12067_ _12067_/Y _12419_/A2 _12064_/Y _12065_/Y _12066_/Y _08674_/A VPWR VGND sg13cmos5l_a221oi_1
XFILLER_37_304 VPWR VGND sg13cmos5l_fill_1
XFILLER_38_838 VPWR VGND sg13cmos5l_fill_1
XFILLER_77_473 VPWR VGND sg13cmos5l_fill_1
XFILLER_78_996 VPWR VGND sg13cmos5l_fill_2
XFILLER_93_922 VPWR VGND sg13cmos5l_fill_1
X_11018_ _11019_/D _14567_/Q _11025_/A _14568_/Q _11024_/B VPWR VGND sg13cmos5l_nor4_1
XFILLER_77_495 VPWR VGND sg13cmos5l_fill_2
XFILLER_92_443 VPWR VGND sg13cmos5l_fill_2
XFILLER_18_551 VPWR VGND sg13cmos5l_fill_2
XFILLER_46_860 VPWR VGND sg13cmos5l_fill_2
X_12969_ _12973_/B _14472_/Q _14473_/Q _12969_/C VPWR VGND sg13cmos5l_and3_1
XFILLER_45_392 VPWR VGND sg13cmos5l_fill_2
XFILLER_60_362 VPWR VGND sg13cmos5l_decap_8
XFILLER_60_373 VPWR VGND sg13cmos5l_fill_1
XFILLER_61_874 VPWR VGND sg13cmos5l_decap_8
XFILLER_61_896 VPWR VGND sg13cmos5l_fill_1
X_14639_ _14639_/Q clkload68/A _14639_/D _14639_/RESET_B VPWR VGND sg13cmos5l_dfrbpq_1
XFILLER_20_248 VPWR VGND sg13cmos5l_fill_2
X_08160_ _08161_/C _14073_/Q _08207_/A2 _11039_/B1 _14494_/Q VPWR VGND sg13cmos5l_a22oi_1
X_08091_ _08094_/B _08052_/Y _09344_/A _08090_/Y VPWR VGND sg13cmos5l_a21oi_1
X_13606__1785 _13606_/RESET_B VPWR VGND sg13cmos5l_tiehi
Xclkload52 clkload52/Y clkload52/A VPWR VGND sg13cmos5l_inv_1
Xclkload41 clkload41/Y clkload41/A VPWR VGND sg13cmos5l_inv_4
Xclkload30 clkload30/Y clkload30/A VPWR VGND sg13cmos5l_inv_4
Xclkload74 clkload74/Y clkload74/A VPWR VGND sg13cmos5l_inv_4
Xclkload63 clkload63/X clkload63/A VPWR VGND sg13cmos5l_buf_8
Xhold3515 hold3515/X _14345_/Q VPWR VGND sg13cmos5l_dlygate4sd3_1
Xhold3504 hold3504/X _14088_/Q VPWR VGND sg13cmos5l_dlygate4sd3_1
X_13785__1606 _13785_/RESET_B VPWR VGND sg13cmos5l_tiehi
XFILLER_88_738 VPWR VGND sg13cmos5l_fill_1
X_08993_ _13277_/D _08994_/B _08991_/Y _08992_/Y VPWR VGND sg13cmos5l_o21ai_1
Xhold2803 _10424_/A _13973_/Q VPWR VGND sg13cmos5l_dlygate4sd3_1
Xhold2814 _09137_/A _13319_/Q VPWR VGND sg13cmos5l_dlygate4sd3_1
Xhold3537 hold3537/X _14273_/Q VPWR VGND sg13cmos5l_dlygate4sd3_1
Xhold3548 hold3548/X _13284_/Q VPWR VGND sg13cmos5l_dlygate4sd3_1
Xhold3559 hold3559/X _14488_/Q VPWR VGND sg13cmos5l_dlygate4sd3_1
Xhold3526 _10893_/A _14195_/Q VPWR VGND sg13cmos5l_dlygate4sd3_1
X_13821__1570 _13821_/RESET_B VPWR VGND sg13cmos5l_tiehi
X_13473__1949 _13473_/RESET_B VPWR VGND sg13cmos5l_tiehi
XFILLER_69_941 VPWR VGND sg13cmos5l_decap_4
X_07944_ _07948_/B _07944_/A _07944_/B _07944_/C VPWR VGND sg13cmos5l_nand3_1
Xhold2825 _10432_/A _13977_/Q VPWR VGND sg13cmos5l_dlygate4sd3_1
Xhold2836 _09882_/A _13708_/Q VPWR VGND sg13cmos5l_dlygate4sd3_1
Xhold2847 _10191_/A _13859_/Q VPWR VGND sg13cmos5l_dlygate4sd3_1
XFILLER_84_911 VPWR VGND sg13cmos5l_fill_1
X_07875_ _14563_/D _07875_/A _10416_/A _07875_/C VPWR VGND sg13cmos5l_nand3_1
Xhold2858 _10240_/A _13883_/Q VPWR VGND sg13cmos5l_dlygate4sd3_1
Xhold2869 _10916_/A _14204_/Q VPWR VGND sg13cmos5l_dlygate4sd3_1
XFILLER_29_849 VPWR VGND sg13cmos5l_fill_1
XFILLER_84_955 VPWR VGND sg13cmos5l_decap_4
X_09614_ _13605_/D _09682_/B _10326_/A1 _09608_/Y VPWR VGND sg13cmos5l_a21oi_1
XFILLER_55_145 VPWR VGND sg13cmos5l_fill_2
XFILLER_83_454 VPWR VGND sg13cmos5l_fill_1
XFILLER_83_465 VPWR VGND sg13cmos5l_fill_1
XFILLER_52_830 VPWR VGND sg13cmos5l_fill_1
XFILLER_64_690 VPWR VGND sg13cmos5l_fill_2
XFILLER_71_627 VPWR VGND sg13cmos5l_fill_2
XFILLER_93_1001 VPWR VGND sg13cmos5l_fill_1
X_09545_ _13595_/D _09544_/B _10371_/A1 _09544_/Y VPWR VGND sg13cmos5l_a21oi_1
XFILLER_24_532 VPWR VGND sg13cmos5l_fill_1
X_09476_ _10416_/B _10351_/A _10351_/B VPWR VGND sg13cmos5l_nor2_1
XFILLER_24_587 VPWR VGND sg13cmos5l_fill_1
X_08427_ _11029_/C _11149_/B _10654_/B VPWR VGND sg13cmos5l_nand2_1
XFILLER_11_215 VPWR VGND sg13cmos5l_fill_1
XFILLER_7_219 VPWR VGND sg13cmos5l_fill_1
X_08358_ _08358_/X _08363_/S _13389_/Q VPWR VGND sg13cmos5l_or2_1
Xclkload2 clkload2/X clkload2/A VPWR VGND sg13cmos5l_buf_8
XFILLER_20_793 VPWR VGND sg13cmos5l_fill_1
X_07309_ _07309_/Y _13351_/Q VPWR VGND sg13cmos5l_inv_1
X_08289_ _08289_/Y _08288_/S _07308_/Y _08165_/A VPWR VGND sg13cmos5l_a21oi_1
XFILLER_106_810 VPWR VGND sg13cmos5l_decap_8
X_10320_ _13922_/D _10385_/A1 _10319_/B _10319_/Y VPWR VGND sg13cmos5l_a21oi_1
X_10251_ _13888_/D _10381_/A1 _10250_/B _10250_/Y VPWR VGND sg13cmos5l_a21oi_1
XFILLER_106_865 VPWR VGND sg13cmos5l_fill_1
XFILLER_106_887 VPWR VGND sg13cmos5l_decap_8
XFILLER_79_749 VPWR VGND sg13cmos5l_fill_2
X_10182_ _13854_/D _10377_/A1 _10189_/B _10181_/Y VPWR VGND sg13cmos5l_a21oi_1
XFILLER_59_99 VPWR VGND sg13cmos5l_fill_1
Xfanout250 _10374_/B _10380_/B VPWR VGND sg13cmos5l_buf_1
X_13449__1973 _13449_/RESET_B VPWR VGND sg13cmos5l_tiehi
Xfanout283 _10213_/B _10211_/B VPWR VGND sg13cmos5l_buf_1
Xfanout272 _10245_/A2 _10248_/B VPWR VGND sg13cmos5l_buf_1
Xfanout261 _10315_/B _10299_/B VPWR VGND sg13cmos5l_buf_1
X_13941_ _13941_/Q clkload16/A _13941_/D _13941_/RESET_B VPWR VGND sg13cmos5l_dfrbpq_1
XFILLER_75_933 VPWR VGND sg13cmos5l_fill_2
XFILLER_75_966 VPWR VGND sg13cmos5l_fill_2
Xfanout294 _09944_/B fanout300/X VPWR VGND sg13cmos5l_buf_1
XFILLER_62_605 VPWR VGND sg13cmos5l_decap_8
XFILLER_74_465 VPWR VGND sg13cmos5l_fill_2
X_13872_ _13872_/Q clkload62/A _13872_/D _13872_/RESET_B VPWR VGND sg13cmos5l_dfrbpq_1
X_12823_ _12823_/X _12823_/A _12823_/B VPWR VGND sg13cmos5l_or2_1
XFILLER_15_532 VPWR VGND sg13cmos5l_fill_1
XFILLER_27_392 VPWR VGND sg13cmos5l_fill_1
X_14633__2176 _14633_/RESET_B VPWR VGND sg13cmos5l_tiehi
X_12754_ _12755_/B _14358_/Q _12861_/A2 _12750_/A _12751_/Y _12753_/Y VPWR VGND sg13cmos5l_a221oi_1
XFILLER_30_502 VPWR VGND sg13cmos5l_fill_1
XFILLER_70_660 VPWR VGND sg13cmos5l_fill_1
X_11705_ _11705_/Y _11691_/Y _11692_/Y _11693_/Y _11694_/Y _11865_/A VPWR VGND sg13cmos5l_a221oi_1
XFILLER_30_524 VPWR VGND sg13cmos5l_fill_1
XFILLER_30_546 VPWR VGND sg13cmos5l_fill_1
X_13863__1528 _13863_/RESET_B VPWR VGND sg13cmos5l_tiehi
X_12685_ _12686_/D _12650_/X _12684_/Y _12643_/A VPWR VGND sg13cmos5l_o21ai_1
X_11636_ _11636_/Y _11636_/A _11657_/B VPWR VGND sg13cmos5l_nand2_1
X_14424_ _14424_/Q clkload77/A _14424_/D _14424_/RESET_B VPWR VGND sg13cmos5l_dfrbpq_1
X_11567_ _11567_/Y _11556_/A _11566_/X _11586_/A VPWR VGND sg13cmos5l_o21ai_1
X_14355_ _14355_/Q clkload68/A _14355_/D _14355_/RESET_B VPWR VGND sg13cmos5l_dfrbpq_1
XFILLER_10_292 VPWR VGND sg13cmos5l_fill_1
XFILLER_6_252 VPWR VGND sg13cmos5l_fill_1
X_10518_ _14019_/D _10583_/A1 _10517_/B _10517_/Y VPWR VGND sg13cmos5l_o21ai_1
X_14286_ _14286_/Q clkload26/A _14286_/D _14286_/RESET_B VPWR VGND sg13cmos5l_dfrbpq_1
X_13306_ _13306_/Q clkload24/A _13306_/D _13306_/RESET_B VPWR VGND sg13cmos5l_dfrbpq_1
X_11498_ _11499_/B _11530_/A _11498_/B VPWR VGND sg13cmos5l_nand2_1
X_13237_ _13237_/Q clkload71/A _13237_/D _13237_/RESET_B VPWR VGND sg13cmos5l_dfrbpq_1
X_10449_ _13985_/D _10579_/A1 _10464_/B _10448_/Y VPWR VGND sg13cmos5l_a21oi_1
XFILLER_3_981 VPWR VGND sg13cmos5l_fill_1
XFILLER_69_215 VPWR VGND sg13cmos5l_fill_2
X_13168_ _13168_/Y _11258_/A _14087_/Q _08917_/X hold3532/X VPWR VGND sg13cmos5l_a22oi_1
X_12119_ _12121_/B _13702_/Q _12087_/B _12346_/B1 VPWR VGND sg13cmos5l_a21oi_1
X_13099_ _13102_/B _14531_/Q _14532_/Q _14533_/Q _13099_/D VPWR VGND sg13cmos5l_nand4_1
XFILLER_1_40 VPWR VGND sg13cmos5l_fill_2
XFILLER_66_933 VPWR VGND sg13cmos5l_decap_8
XFILLER_66_944 VPWR VGND sg13cmos5l_fill_2
X_07660_ _08867_/A _14394_/Q _14362_/Q VPWR VGND sg13cmos5l_xor2_1
XFILLER_25_318 VPWR VGND sg13cmos5l_fill_1
XFILLER_37_189 VPWR VGND sg13cmos5l_fill_2
XFILLER_80_424 VPWR VGND sg13cmos5l_decap_4
X_07591_ _07593_/B _07591_/A _08984_/B VPWR VGND sg13cmos5l_xnor2_1
XFILLER_18_392 VPWR VGND sg13cmos5l_fill_1
X_09330_ _13446_/D _08269_/A hold2968/X _09338_/S VPWR VGND sg13cmos5l_mux2_1
XFILLER_33_351 VPWR VGND sg13cmos5l_fill_2
X_09261_ _13386_/D _08320_/A hold3361/X _09266_/S VPWR VGND sg13cmos5l_mux2_1
XFILLER_21_535 VPWR VGND sg13cmos5l_fill_1
X_08212_ _08212_/X _13569_/Q _13537_/Q _13505_/Q _13473_/Q _08301_/S _11033_/S1 VPWR
+ VGND sg13cmos5l_mux4_1
X_09192_ _13328_/D _09197_/B _09190_/Y _09191_/Y VPWR VGND sg13cmos5l_a21oi_1
X_13839__1552 _13839_/RESET_B VPWR VGND sg13cmos5l_tiehi
X_08143_ _08146_/B _13221_/Q _08143_/B _08143_/C VPWR VGND sg13cmos5l_and3_1
X_13527__1895 _13527_/RESET_B VPWR VGND sg13cmos5l_tiehi
XFILLER_101_1027 VPWR VGND sg13cmos5l_fill_2
X_08074_ _08074_/Y _08074_/A VPWR VGND sg13cmos5l_inv_1
X_14350__1158 _14350_/RESET_B VPWR VGND sg13cmos5l_tiehi
XFILLER_1_907 VPWR VGND sg13cmos5l_decap_4
XFILLER_0_417 VPWR VGND sg13cmos5l_fill_2
XFILLER_1_929 VPWR VGND sg13cmos5l_decap_8
Xhold3334 hold3334/X _14173_/Q VPWR VGND sg13cmos5l_dlygate4sd3_1
Xhold3323 hold3323/X _13548_/Q VPWR VGND sg13cmos5l_dlygate4sd3_1
Xhold3312 hold3312/X _13579_/Q VPWR VGND sg13cmos5l_dlygate4sd3_1
Xhold3301 hold3301/X _13545_/Q VPWR VGND sg13cmos5l_dlygate4sd3_1
XFILLER_0_439 VPWR VGND sg13cmos5l_fill_2
XFILLER_76_708 VPWR VGND sg13cmos5l_decap_8
Xhold2600 _14211_/D _10933_/Y VPWR VGND sg13cmos5l_dlygate4sd3_1
Xhold2611 _13220_/D _08140_/Y VPWR VGND sg13cmos5l_dlygate4sd3_1
Xhold2622 _09832_/A _13683_/Q VPWR VGND sg13cmos5l_dlygate4sd3_1
Xhold3367 hold3367/X _14232_/Q VPWR VGND sg13cmos5l_dlygate4sd3_1
Xhold3356 hold3356/X _13552_/Q VPWR VGND sg13cmos5l_dlygate4sd3_1
Xhold3345 hold3345/X _13387_/Q VPWR VGND sg13cmos5l_dlygate4sd3_1
XFILLER_29_36 VPWR VGND sg13cmos5l_fill_2
XFILLER_57_911 VPWR VGND sg13cmos5l_fill_2
X_08976_ _08976_/Y _13294_/Q _08975_/A _08975_/Y VPWR VGND sg13cmos5l_a21oi_1
Xhold2633 _10167_/A _13847_/Q VPWR VGND sg13cmos5l_dlygate4sd3_1
Xhold2644 _10080_/A _13805_/Q VPWR VGND sg13cmos5l_dlygate4sd3_1
Xhold2655 _14472_/D _12968_/X VPWR VGND sg13cmos5l_dlygate4sd3_1
Xhold3389 _09179_/A _13326_/Q VPWR VGND sg13cmos5l_dlygate4sd3_1
Xhold3378 _08229_/A _14258_/Q VPWR VGND sg13cmos5l_dlygate4sd3_1
XFILLER_68_292 VPWR VGND sg13cmos5l_fill_2
X_07927_ _07927_/Y _07919_/Y _07997_/D _07925_/Y VPWR VGND sg13cmos5l_a21oi_1
Xhold2666 _09767_/A _13651_/Q VPWR VGND sg13cmos5l_dlygate4sd3_1
Xhold2677 _07321_/A _13423_/Q VPWR VGND sg13cmos5l_dlygate4sd3_1
Xhold2688 _10343_/A _13934_/Q VPWR VGND sg13cmos5l_dlygate4sd3_1
Xhold2699 _09888_/A _13711_/Q VPWR VGND sg13cmos5l_dlygate4sd3_1
XFILLER_29_679 VPWR VGND sg13cmos5l_fill_1
X_07858_ _07858_/Y _11715_/A _07857_/A _07857_/Y VPWR VGND sg13cmos5l_o21ai_1
X_07789_ _07791_/A _14400_/Q _12282_/A VPWR VGND sg13cmos5l_nor2_1
XFILLER_71_446 VPWR VGND sg13cmos5l_fill_2
X_09528_ _09528_/Y _14444_/Q _09522_/B _09527_/Y VPWR VGND sg13cmos5l_a21oi_1
XFILLER_101_74 VPWR VGND sg13cmos5l_fill_2
X_09459_ _09459_/X _14114_/Q hold3279/X _09471_/S VPWR VGND sg13cmos5l_mux2_1
X_12470_ _14385_/D _07691_/A _12466_/B _12468_/Y _12469_/Y VPWR VGND sg13cmos5l_a22oi_1
XFILLER_8_539 VPWR VGND sg13cmos5l_fill_2
X_11421_ _11422_/B _11450_/A _11421_/B VPWR VGND sg13cmos5l_nand2_1
X_11352_ _11401_/A _11352_/A _11352_/B _11352_/C _11352_/D VPWR VGND sg13cmos5l_nor4_1
X_14140_ _14140_/Q clkload26/A _14140_/D fanout987/X VPWR VGND sg13cmos5l_dfrbpq_1
X_10303_ _10303_/Y _10303_/A _10341_/B VPWR VGND sg13cmos5l_nor2_1
X_14326__1182 _14326_/RESET_B VPWR VGND sg13cmos5l_tiehi
XFILLER_3_233 VPWR VGND sg13cmos5l_fill_2
X_11283_ _11328_/A _11331_/A _11297_/B VPWR VGND sg13cmos5l_nor2b_1
X_14071_ _14071_/Q _14532_/CLK _14071_/D fanout968/X VPWR VGND sg13cmos5l_dfrbpq_1
X_10234_ _10234_/Y _10234_/A _10238_/B VPWR VGND sg13cmos5l_nor2_1
X_13022_ _14499_/D _13022_/A _13026_/D VPWR VGND sg13cmos5l_xor2_1
X_10165_ _10165_/Y _10165_/A _10171_/B VPWR VGND sg13cmos5l_nor2_1
Xfanout1001 _11000_/A fanout998/A VPWR VGND sg13cmos5l_buf_1
X_10096_ _13812_/D _10553_/A1 _10109_/B _10095_/Y VPWR VGND sg13cmos5l_o21ai_1
XFILLER_47_443 VPWR VGND sg13cmos5l_decap_4
XFILLER_47_454 VPWR VGND sg13cmos5l_fill_2
X_13924_ _13924_/Q _14020_/CLK _13924_/D _13924_/RESET_B VPWR VGND sg13cmos5l_dfrbpq_1
X_13917__1474 _13917_/RESET_B VPWR VGND sg13cmos5l_tiehi
X_13855_ _13855_/Q clkload60/A _13855_/D _13855_/RESET_B VPWR VGND sg13cmos5l_dfrbpq_1
XFILLER_62_457 VPWR VGND sg13cmos5l_fill_2
X_12806_ _12808_/C _12806_/A _12823_/B VPWR VGND sg13cmos5l_and2_1
XFILLER_90_799 VPWR VGND sg13cmos5l_fill_1
X_10998_ _14232_/D _10998_/A _10998_/B VPWR VGND sg13cmos5l_nor2_1
X_13786_ _13786_/Q clkload52/A _13786_/D _13786_/RESET_B VPWR VGND sg13cmos5l_dfrbpq_1
X_12737_ _12737_/Y _14231_/Q _12739_/B _12654_/B VPWR VGND sg13cmos5l_a21oi_1
X_12668_ _12668_/Y _14446_/Q _13236_/Q VPWR VGND sg13cmos5l_nand2_1
X_11619_ _11624_/B _11635_/A _11851_/A VPWR VGND sg13cmos5l_nor2_1
X_14407_ _14407_/Q clkload40/A _14407_/D _14407_/RESET_B VPWR VGND sg13cmos5l_dfrbpq_1
X_12599_ _12599_/Y _07456_/Y _12639_/C _12641_/A _12598_/X VPWR VGND sg13cmos5l_a22oi_1
X_14338_ _14338_/Q _14654_/CLK _14338_/D _14338_/RESET_B VPWR VGND sg13cmos5l_dfrbpq_1
X_13404__2018 _13404_/RESET_B VPWR VGND sg13cmos5l_tiehi
X_14269_ _14269_/Q clkload71/A _14269_/D _14269_/RESET_B VPWR VGND sg13cmos5l_dfrbpq_1
XFILLER_97_321 VPWR VGND sg13cmos5l_fill_1
X_08830_ _14635_/D hold2468/X _08841_/B _08829_/Y VPWR VGND sg13cmos5l_a21o_1
XFILLER_57_229 VPWR VGND sg13cmos5l_fill_2
X_08761_ _08761_/Y _13148_/A _14150_/Q _14134_/Q _14576_/Q VPWR VGND sg13cmos5l_a22oi_1
X_07712_ _07736_/A _14379_/Q _07712_/B VPWR VGND sg13cmos5l_nor2_1
X_08692_ _08692_/Y _13619_/Q _08738_/A2 _08747_/B _13683_/Q _11752_/S VPWR VGND sg13cmos5l_a221oi_1
XFILLER_39_999 VPWR VGND sg13cmos5l_fill_2
XFILLER_81_733 VPWR VGND sg13cmos5l_decap_4
X_07643_ _07644_/B _07643_/A _07810_/B VPWR VGND sg13cmos5l_nand2_1
XFILLER_80_221 VPWR VGND sg13cmos5l_fill_2
XFILLER_34_671 VPWR VGND sg13cmos5l_fill_2
XFILLER_41_608 VPWR VGND sg13cmos5l_fill_2
XFILLER_81_799 VPWR VGND sg13cmos5l_decap_4
X_07574_ _07576_/B _07574_/A _08964_/B VPWR VGND sg13cmos5l_xnor2_1
X_09313_ _13429_/D _09414_/A0 hold3080/X _09320_/S VPWR VGND sg13cmos5l_mux2_1
X_09244_ _13369_/D _08157_/A hold3169/X _09260_/S VPWR VGND sg13cmos5l_mux2_1
Xclkbuf_leaf_60_clk clkload69/A clkbuf_4_12_0_clk/X VPWR VGND sg13cmos5l_buf_8
X_14089__1318 _14089_/RESET_B VPWR VGND sg13cmos5l_tiehi
XFILLER_31_15 VPWR VGND sg13cmos5l_fill_1
X_09175_ _11562_/A _14338_/Q _09175_/B VPWR VGND sg13cmos5l_nand2_1
X_08126_ _08128_/A _08125_/A _08138_/B hold3439/X VPWR VGND sg13cmos5l_a21oi_1
X_08057_ _08057_/Y _08113_/A _13110_/B VPWR VGND sg13cmos5l_nand2_1
XFILLER_1_715 VPWR VGND sg13cmos5l_fill_1
Xoutput26 uio_out[12] _15892_/X VPWR VGND sg13cmos5l_buf_1
Xoutput37 uio_out[8] _15888_/X VPWR VGND sg13cmos5l_buf_1
Xoutput48 uo_out[3] _08762_/Y VPWR VGND sg13cmos5l_buf_1
X_14632__2175 _14632_/RESET_B VPWR VGND sg13cmos5l_tiehi
Xhold3120 hold3120/X _13361_/Q VPWR VGND sg13cmos5l_dlygate4sd3_1
Xhold3131 _13559_/D _09449_/X VPWR VGND sg13cmos5l_dlygate4sd3_1
Xhold3142 hold3142/X _13343_/Q VPWR VGND sg13cmos5l_dlygate4sd3_1
XFILLER_49_708 VPWR VGND sg13cmos5l_fill_2
XFILLER_76_516 VPWR VGND sg13cmos5l_fill_2
XFILLER_89_888 VPWR VGND sg13cmos5l_fill_1
Xhold2430 _09981_/A _13756_/Q VPWR VGND sg13cmos5l_dlygate4sd3_1
Xhold3153 hold3153/X _13355_/Q VPWR VGND sg13cmos5l_dlygate4sd3_1
Xhold3164 hold3164/X _13426_/Q VPWR VGND sg13cmos5l_dlygate4sd3_1
Xhold3175 hold3175/X _13562_/Q VPWR VGND sg13cmos5l_dlygate4sd3_1
X_08959_ _08959_/Y _08963_/S _08957_/Y _08958_/Y VPWR VGND sg13cmos5l_o21ai_1
Xhold2441 _10497_/A _14009_/Q VPWR VGND sg13cmos5l_dlygate4sd3_1
Xhold2452 _10493_/A _14007_/Q VPWR VGND sg13cmos5l_dlygate4sd3_1
Xhold2463 _10046_/A _13788_/Q VPWR VGND sg13cmos5l_dlygate4sd3_1
Xhold3186 _13394_/D _09270_/X VPWR VGND sg13cmos5l_dlygate4sd3_1
Xhold3197 hold3197/X _13536_/Q VPWR VGND sg13cmos5l_dlygate4sd3_1
XFILLER_57_752 VPWR VGND sg13cmos5l_decap_8
XFILLER_57_763 VPWR VGND sg13cmos5l_fill_1
X_11970_ _11970_/Y _13729_/Q _11998_/B1 _11971_/A2 _13985_/Q _12010_/C1 VPWR VGND
+ sg13cmos5l_a221oi_1
Xhold2474 _10712_/A _14131_/Q VPWR VGND sg13cmos5l_dlygate4sd3_1
Xhold2485 _10766_/A _14149_/Q VPWR VGND sg13cmos5l_dlygate4sd3_1
Xhold2496 _14068_/D _10624_/Y VPWR VGND sg13cmos5l_dlygate4sd3_1
XFILLER_44_402 VPWR VGND sg13cmos5l_decap_4
X_10921_ _14206_/D _10844_/Y _10922_/B _10920_/Y VPWR VGND sg13cmos5l_o21ai_1
XFILLER_16_115 VPWR VGND sg13cmos5l_fill_2
XFILLER_56_284 VPWR VGND sg13cmos5l_decap_8
XFILLER_25_660 VPWR VGND sg13cmos5l_fill_1
X_10852_ _10853_/A hold3373/X _10941_/B _10844_/D _10851_/Y VPWR VGND sg13cmos5l_a22oi_1
X_13640_ _13640_/Q clkload78/A _13640_/D _13640_/RESET_B VPWR VGND sg13cmos5l_dfrbpq_1
XFILLER_52_490 VPWR VGND sg13cmos5l_fill_1
XFILLER_71_287 VPWR VGND sg13cmos5l_fill_1
X_10783_ _10783_/Y _10792_/A _14299_/Q VPWR VGND sg13cmos5l_nand2_1
X_13571_ _13571_/Q _14117_/CLK _13571_/D _13571_/RESET_B VPWR VGND sg13cmos5l_dfrbpq_1
Xclkbuf_leaf_51_clk _14650_/CLK clkload7/A VPWR VGND sg13cmos5l_buf_8
X_12522_ _12522_/Y _14399_/Q _12522_/B VPWR VGND sg13cmos5l_nand2_1
XFILLER_13_899 VPWR VGND sg13cmos5l_fill_1
X_13780__1611 _13780_/RESET_B VPWR VGND sg13cmos5l_tiehi
X_12453_ _12453_/Y _08638_/A _11758_/Y _12460_/B VPWR VGND sg13cmos5l_a21oi_1
X_11404_ _11404_/Y _11413_/B _11400_/Y _11403_/X _11444_/A _11615_/C1 VPWR VGND sg13cmos5l_a221oi_1
X_12384_ _12385_/C _12408_/A1 _12379_/Y _12380_/Y VPWR VGND sg13cmos5l_o21ai_1
XFILLER_4_531 VPWR VGND sg13cmos5l_fill_2
X_11335_ _11350_/B _11334_/A _11393_/A _11326_/Y VPWR VGND sg13cmos5l_a21o_1
X_14123_ _14123_/Q clkload35/A _14123_/D fanout998/X VPWR VGND sg13cmos5l_dfrbpq_1
X_11266_ _11329_/A _14090_/Q _11302_/B VPWR VGND sg13cmos5l_xnor2_1
X_14054_ _14054_/Q clkload55/A _14054_/D _14054_/RESET_B VPWR VGND sg13cmos5l_dfrbpq_1
X_10217_ _10217_/Y _10217_/A _10217_/B VPWR VGND sg13cmos5l_nor2_1
X_13005_ _13009_/B _14491_/Q _14490_/Q _13005_/C VPWR VGND sg13cmos5l_nand3_1
XFILLER_95_825 VPWR VGND sg13cmos5l_fill_2
X_11197_ _11214_/C _14314_/Q _09506_/X _11197_/S VPWR VGND sg13cmos5l_mux2_1
X_10148_ _13838_/D fanout74/X _10147_/B _10147_/Y VPWR VGND sg13cmos5l_o21ai_1
X_10079_ _13804_/D fanout77/X _10078_/B _10078_/Y VPWR VGND sg13cmos5l_o21ai_1
XFILLER_48_774 VPWR VGND sg13cmos5l_decap_8
X_13907_ _13907_/Q clkload18/A _13907_/D _13907_/RESET_B VPWR VGND sg13cmos5l_dfrbpq_1
XFILLER_63_733 VPWR VGND sg13cmos5l_decap_8
X_13838_ _13838_/Q clkload55/A _13838_/D _13838_/RESET_B VPWR VGND sg13cmos5l_dfrbpq_1
X_13769_ _13769_/Q clkload59/A _13769_/D _13769_/RESET_B VPWR VGND sg13cmos5l_dfrbpq_1
X_07290_ _07290_/Y _13251_/Q VPWR VGND sg13cmos5l_inv_1
Xclkbuf_leaf_42_clk clkload66/A clkbuf_4_12_0_clk/X VPWR VGND sg13cmos5l_buf_8
XFILLER_11_1016 VPWR VGND sg13cmos5l_fill_2
XFILLER_8_870 VPWR VGND sg13cmos5l_fill_1
X_13307__2205 _13307_/RESET_B VPWR VGND sg13cmos5l_tiehi
X_09931_ _13731_/D _10583_/A1 _09952_/B _09930_/Y VPWR VGND sg13cmos5l_a21oi_1
Xfanout816 _12861_/A2 _14571_/Q VPWR VGND sg13cmos5l_buf_1
Xfanout805 _08781_/B2 _07959_/B VPWR VGND sg13cmos5l_buf_1
X_13643__1748 _13643_/RESET_B VPWR VGND sg13cmos5l_tiehi
X_09862_ _09862_/Y _09862_/A _09862_/B VPWR VGND sg13cmos5l_nor2_1
Xfanout849 _11628_/A _14343_/Q VPWR VGND sg13cmos5l_buf_1
Xfanout838 _12282_/A _14368_/Q VPWR VGND sg13cmos5l_buf_1
Xfanout827 _12545_/A fanout828/X VPWR VGND sg13cmos5l_buf_1
XFILLER_86_847 VPWR VGND sg13cmos5l_decap_4
X_08813_ _08813_/Y _08473_/A _08879_/A2 _08812_/Y VPWR VGND sg13cmos5l_o21ai_1
X_09793_ _09793_/Y _09793_/A _09793_/B VPWR VGND sg13cmos5l_nor2_1
X_08744_ _08745_/C _13942_/Q _08729_/B _08744_/B1 _13878_/Q VPWR VGND sg13cmos5l_a22oi_1
XFILLER_54_700 VPWR VGND sg13cmos5l_decap_4
X_14023__1368 _14023_/RESET_B VPWR VGND sg13cmos5l_tiehi
XFILLER_27_969 VPWR VGND sg13cmos5l_fill_2
XFILLER_38_295 VPWR VGND sg13cmos5l_fill_1
X_08675_ _08676_/B _08674_/A _08663_/Y _08668_/Y _08674_/Y VPWR VGND sg13cmos5l_a22oi_1
X_07626_ _07634_/A _08995_/A _07626_/B VPWR VGND sg13cmos5l_xnor2_1
X_07557_ _07558_/D _14552_/Q _13293_/Q VPWR VGND sg13cmos5l_xor2_1
Xclkbuf_leaf_33_clk _14238_/CLK clkload3/A VPWR VGND sg13cmos5l_buf_8
X_07488_ _13032_/C _07474_/Y _07479_/Y _07487_/Y VPWR VGND sg13cmos5l_a21oi_1
X_09227_ _13354_/D _08320_/A hold3214/X _09235_/S VPWR VGND sg13cmos5l_mux2_1
X_09158_ _09158_/Y _14431_/Q _11530_/A VPWR VGND sg13cmos5l_nand2_1
X_08109_ _13201_/D _08106_/Y _08108_/Y _13127_/A VPWR VGND sg13cmos5l_a21oi_1
X_09089_ _09089_/Y _09089_/A _09095_/B VPWR VGND sg13cmos5l_nor2_1
X_11120_ _14297_/D _11135_/B _11118_/Y _11119_/Y VPWR VGND sg13cmos5l_a21oi_1
XFILLER_27_1001 VPWR VGND sg13cmos5l_fill_1
XFILLER_104_985 VPWR VGND sg13cmos5l_decap_8
X_11051_ _11051_/Y _11051_/A _11099_/B VPWR VGND sg13cmos5l_nor2_1
X_13619__1772 _13619_/RESET_B VPWR VGND sg13cmos5l_tiehi
X_10002_ _13766_/D fanout79/X _10017_/B _10001_/Y VPWR VGND sg13cmos5l_o21ai_1
Xhold2260 _10485_/A _14003_/Q VPWR VGND sg13cmos5l_dlygate4sd3_1
Xhold2271 _14625_/D _08793_/Y VPWR VGND sg13cmos5l_dlygate4sd3_1
Xhold2282 _09993_/A _13762_/Q VPWR VGND sg13cmos5l_dlygate4sd3_1
Xhold2293 _10763_/A _14148_/Q VPWR VGND sg13cmos5l_dlygate4sd3_1
X_11953_ _11953_/Y _11979_/A _11953_/B VPWR VGND sg13cmos5l_nor2_1
X_13486__1936 _13486_/RESET_B VPWR VGND sg13cmos5l_tiehi
XFILLER_60_703 VPWR VGND sg13cmos5l_fill_1
XFILLER_83_87 VPWR VGND sg13cmos5l_fill_1
X_10904_ _10904_/Y _10904_/A _10904_/B VPWR VGND sg13cmos5l_nand2_1
X_11884_ _11886_/B _13598_/Q _11884_/B VPWR VGND sg13cmos5l_nand2_1
XFILLER_45_799 VPWR VGND sg13cmos5l_fill_2
X_10835_ _10835_/Y _10835_/A _10941_/B VPWR VGND sg13cmos5l_nand2_1
X_13623_ _13623_/Q clkload53/A _13623_/D _13623_/RESET_B VPWR VGND sg13cmos5l_dfrbpq_1
XFILLER_13_641 VPWR VGND sg13cmos5l_fill_2
Xclkbuf_leaf_24_clk clkload41/A clkload3/A VPWR VGND sg13cmos5l_buf_8
XFILLER_40_471 VPWR VGND sg13cmos5l_fill_2
X_10766_ _10766_/Y _10766_/A _10766_/B VPWR VGND sg13cmos5l_nand2_1
X_13554_ _13554_/Q _14102_/CLK _13554_/D _13554_/RESET_B VPWR VGND sg13cmos5l_dfrbpq_1
X_10697_ _14117_/D input10/X _09219_/A _10697_/S VPWR VGND sg13cmos5l_mux2_1
X_13485_ _13485_/Q clkload30/A _13485_/D _13485_/RESET_B VPWR VGND sg13cmos5l_dfrbpq_1
X_12505_ _12505_/Y _12504_/A _13247_/Q _12504_/Y VPWR VGND sg13cmos5l_o21ai_1
X_12436_ _14374_/D _11093_/A _12441_/B1 _12435_/Y _08676_/Y VPWR VGND sg13cmos5l_a22oi_1
X_14106_ _14106_/Q _14117_/CLK _14106_/D fanout996/X VPWR VGND sg13cmos5l_dfrbpq_1
X_13321__2101 _13321_/RESET_B VPWR VGND sg13cmos5l_tiehi
X_12367_ _12368_/C _13647_/Q _12373_/B _12377_/B1 _13711_/Q VPWR VGND sg13cmos5l_a22oi_1
XFILLER_4_383 VPWR VGND sg13cmos5l_fill_1
X_11318_ _11318_/Y _11243_/A _11311_/B _11318_/B1 VPWR VGND sg13cmos5l_o21ai_1
X_12298_ _12298_/Y _12296_/Y _12297_/Y _12403_/B1 VPWR VGND sg13cmos5l_a21oi_1
X_11249_ _11256_/D _11249_/A _11249_/B VPWR VGND sg13cmos5l_nand2_1
X_14037_ _14037_/Q clkload16/A _14037_/D _14037_/RESET_B VPWR VGND sg13cmos5l_dfrbpq_1
XFILLER_68_825 VPWR VGND sg13cmos5l_decap_8
XFILLER_68_836 VPWR VGND sg13cmos5l_decap_4
XFILLER_79_184 VPWR VGND sg13cmos5l_fill_2
XFILLER_68_869 VPWR VGND sg13cmos5l_decap_4
XFILLER_94_132 VPWR VGND sg13cmos5l_fill_1
XFILLER_67_379 VPWR VGND sg13cmos5l_decap_8
X_13354__2068 _13354_/RESET_B VPWR VGND sg13cmos5l_tiehi
XFILLER_75_390 VPWR VGND sg13cmos5l_fill_1
XFILLER_91_872 VPWR VGND sg13cmos5l_fill_2
X_08460_ _14585_/D _08460_/A _08460_/B VPWR VGND sg13cmos5l_xor2_1
XFILLER_51_736 VPWR VGND sg13cmos5l_decap_8
X_07411_ _07413_/C _14550_/Q _08964_/B _07587_/A VPWR VGND sg13cmos5l_o21ai_1
X_08391_ _08391_/Y _08388_/A _08390_/X _08391_/B1 VPWR VGND sg13cmos5l_a21oi_1
X_14631__2174 _14631_/RESET_B VPWR VGND sg13cmos5l_tiehi
X_14285__1223 _14285_/RESET_B VPWR VGND sg13cmos5l_tiehi
XFILLER_51_769 VPWR VGND sg13cmos5l_fill_1
XFILLER_92_0 VPWR VGND sg13cmos5l_fill_1
X_07342_ _07342_/Y _14146_/Q VPWR VGND sg13cmos5l_inv_1
Xclkbuf_leaf_15_clk _14622_/CLK clkbuf_4_6_0_clk/X VPWR VGND sg13cmos5l_buf_8
X_07273_ _07273_/Y _13624_/Q VPWR VGND sg13cmos5l_inv_1
X_09012_ _09012_/Y _09012_/A _09012_/B VPWR VGND sg13cmos5l_nor2_1
X_13876__1515 _13876_/RESET_B VPWR VGND sg13cmos5l_tiehi
XFILLER_104_237 VPWR VGND sg13cmos5l_fill_1
X_13564__1858 _13564_/RESET_B VPWR VGND sg13cmos5l_tiehi
XFILLER_99_961 VPWR VGND sg13cmos5l_fill_1
X_09914_ _09914_/Y _09914_/A _09924_/B VPWR VGND sg13cmos5l_nor2_1
Xfanout624 _12739_/A _12879_/B1 VPWR VGND sg13cmos5l_buf_1
Xfanout613 _12955_/B2 _12949_/B2 VPWR VGND sg13cmos5l_buf_1
Xfanout602 _12403_/B1 _12430_/A1 VPWR VGND sg13cmos5l_buf_1
XFILLER_101_922 VPWR VGND sg13cmos5l_decap_8
XFILLER_59_836 VPWR VGND sg13cmos5l_decap_4
XFILLER_98_482 VPWR VGND sg13cmos5l_fill_1
X_09845_ _13689_/D _10367_/A1 _09844_/B _09844_/Y VPWR VGND sg13cmos5l_a21oi_1
Xfanout657 _12897_/A _12727_/A1 VPWR VGND sg13cmos5l_buf_1
Xfanout646 _12637_/C _11156_/Y VPWR VGND sg13cmos5l_buf_1
Xfanout635 _12522_/B _12541_/B VPWR VGND sg13cmos5l_buf_1
XFILLER_59_858 VPWR VGND sg13cmos5l_fill_2
XFILLER_85_132 VPWR VGND sg13cmos5l_fill_2
XFILLER_86_666 VPWR VGND sg13cmos5l_decap_4
Xfanout679 _11234_/A _11308_/A VPWR VGND sg13cmos5l_buf_1
Xfanout668 _10885_/C _08943_/A2 VPWR VGND sg13cmos5l_buf_1
XFILLER_101_999 VPWR VGND sg13cmos5l_decap_8
XFILLER_74_828 VPWR VGND sg13cmos5l_fill_2
X_09776_ _13655_/D _10298_/A1 _09813_/B _09775_/Y VPWR VGND sg13cmos5l_a21oi_1
XFILLER_73_327 VPWR VGND sg13cmos5l_fill_1
XFILLER_73_338 VPWR VGND sg13cmos5l_fill_1
X_08727_ _08727_/Y _08727_/A _08727_/B _08727_/C VPWR VGND sg13cmos5l_nand3_1
XFILLER_27_766 VPWR VGND sg13cmos5l_fill_2
XFILLER_27_777 VPWR VGND sg13cmos5l_decap_4
X_08658_ _08658_/X _13746_/Q _13714_/Q _08658_/S VPWR VGND sg13cmos5l_mux2_1
XFILLER_54_574 VPWR VGND sg13cmos5l_fill_1
XFILLER_82_894 VPWR VGND sg13cmos5l_fill_2
X_07609_ _07632_/B _13286_/Q _07609_/B VPWR VGND sg13cmos5l_xor2_1
X_08589_ _08590_/C _08594_/A _08589_/B VPWR VGND sg13cmos5l_nor2_1
XFILLER_10_600 VPWR VGND sg13cmos5l_decap_8
XFILLER_10_611 VPWR VGND sg13cmos5l_fill_2
X_10620_ _14066_/D _10620_/A _10622_/B VPWR VGND sg13cmos5l_nor2b_1
X_10551_ _14035_/D _10551_/A1 _10566_/B _10550_/Y VPWR VGND sg13cmos5l_o21ai_1
X_10482_ _10482_/Y _10482_/A _10547_/B VPWR VGND sg13cmos5l_nand2_1
X_13270_ _13270_/Q clkload9/A _13270_/D fanout965/X VPWR VGND sg13cmos5l_dfrbpq_1
X_12221_ _12221_/X _12221_/A _12221_/B VPWR VGND sg13cmos5l_and2_1
XFILLER_2_843 VPWR VGND sg13cmos5l_fill_1
X_12152_ _12152_/Y _14458_/Q _12302_/A2 _12151_/Y VPWR VGND sg13cmos5l_a21oi_1
X_11103_ _11103_/Y _11103_/A _11107_/B VPWR VGND sg13cmos5l_nor2_1
X_12083_ _12083_/Y _13765_/Q _12200_/B1 _12195_/B _14021_/Q VPWR VGND sg13cmos5l_a22oi_1
X_11034_ _11034_/X _11034_/A _11034_/B VPWR VGND sg13cmos5l_or2_1
X_14363__1145 _14363_/RESET_B VPWR VGND sg13cmos5l_tiehi
XFILLER_49_357 VPWR VGND sg13cmos5l_decap_4
XFILLER_77_644 VPWR VGND sg13cmos5l_fill_2
XFILLER_65_828 VPWR VGND sg13cmos5l_decap_4
XFILLER_77_688 VPWR VGND sg13cmos5l_fill_2
X_14084__1323 _14084_/RESET_B VPWR VGND sg13cmos5l_tiehi
X_12985_ _12989_/B _14480_/Q _14481_/Q _12985_/C VPWR VGND sg13cmos5l_nand3_1
XFILLER_45_552 VPWR VGND sg13cmos5l_decap_4
XFILLER_73_861 VPWR VGND sg13cmos5l_fill_2
X_11936_ _11937_/C _13856_/Q _11944_/B2 _11862_/B _13664_/Q VPWR VGND sg13cmos5l_a22oi_1
XFILLER_73_883 VPWR VGND sg13cmos5l_fill_2
XFILLER_33_769 VPWR VGND sg13cmos5l_fill_1
X_11867_ _12686_/B _14352_/Q _11867_/B VPWR VGND sg13cmos5l_nand2_1
X_14655_ _14655_/Q clkload73/A _14655_/D _14655_/RESET_B VPWR VGND sg13cmos5l_dfrbpq_1
X_13954__1437 _13954_/RESET_B VPWR VGND sg13cmos5l_tiehi
XFILLER_14_972 VPWR VGND sg13cmos5l_fill_2
XFILLER_32_268 VPWR VGND sg13cmos5l_fill_1
X_10818_ _10818_/Y _14226_/Q _13166_/B VPWR VGND sg13cmos5l_nand2_1
X_11798_ _11801_/B _11798_/A _11798_/B VPWR VGND sg13cmos5l_nand2_1
X_14586_ _14586_/Q clkload36/A _14586_/D _14586_/RESET_B VPWR VGND sg13cmos5l_dfrbpq_1
X_13606_ _13606_/Q clkload64/A _13606_/D _13606_/RESET_B VPWR VGND sg13cmos5l_dfrbpq_1
X_10749_ _10749_/Y _10796_/B _10747_/Y _10748_/Y VPWR VGND sg13cmos5l_o21ai_1
X_13537_ _13537_/Q clkload32/A _13537_/D _13537_/RESET_B VPWR VGND sg13cmos5l_dfrbpq_1
X_13468_ _13468_/Q _14109_/CLK _13468_/D _13468_/RESET_B VPWR VGND sg13cmos5l_dfrbpq_1
X_13399_ _13399_/Q _14520_/CLK _13399_/D _13399_/RESET_B VPWR VGND sg13cmos5l_dfrbpq_1
X_12419_ _12419_/Y _14065_/Q _12419_/A2 _12428_/B1 _13809_/Q VPWR VGND sg13cmos5l_a22oi_1
X_07960_ _14579_/D _07891_/C _11614_/A VPWR VGND sg13cmos5l_nand2b_1
XFILLER_4_62 VPWR VGND sg13cmos5l_fill_1
Xclkbuf_leaf_4_clk _14532_/CLK clkbuf_4_0_0_clk/X VPWR VGND sg13cmos5l_buf_8
X_07891_ _07893_/C _14192_/Q _14187_/Q _07891_/C VPWR VGND sg13cmos5l_nor3_1
X_09630_ _11470_/B _14428_/Q _14647_/Q _09662_/S VPWR VGND sg13cmos5l_mux2_1
X_09561_ _09561_/Y _09575_/C _09575_/D VPWR VGND sg13cmos5l_nand2_1
X_08512_ _08512_/Y _07679_/A _08518_/A _07678_/Y VPWR VGND sg13cmos5l_o21ai_1
X_09492_ _09492_/Y _14438_/Q _09663_/B1 _09491_/X VPWR VGND sg13cmos5l_a21oi_1
X_08443_ _08443_/Y _14313_/Q _09073_/B VPWR VGND sg13cmos5l_nand2_1
XFILLER_11_419 VPWR VGND sg13cmos5l_fill_1
X_08374_ _08374_/Y _08411_/A _08372_/X _08373_/Y VPWR VGND sg13cmos5l_a21oi_1
XFILLER_32_780 VPWR VGND sg13cmos5l_fill_2
X_07325_ _08633_/B _14614_/Q VPWR VGND sg13cmos5l_inv_1
X_07256_ _07256_/Y _12405_/B VPWR VGND sg13cmos5l_inv_1
X_14441__1067 _14441_/RESET_B VPWR VGND sg13cmos5l_tiehi
X_07187_ _07187_/Y _14560_/Q VPWR VGND sg13cmos5l_inv_1
XFILLER_2_106 VPWR VGND sg13cmos5l_fill_2
XFILLER_99_780 VPWR VGND sg13cmos5l_decap_8
Xfanout432 _10537_/B _10539_/B VPWR VGND sg13cmos5l_buf_1
Xfanout421 _10602_/B _10604_/B VPWR VGND sg13cmos5l_buf_1
Xfanout410 _11099_/B _11111_/B VPWR VGND sg13cmos5l_buf_1
X_14272__2108 _14272_/RESET_B VPWR VGND sg13cmos5l_tiehi
XFILLER_58_110 VPWR VGND sg13cmos5l_fill_2
XFILLER_87_964 VPWR VGND sg13cmos5l_fill_2
Xfanout465 fanout465/X _08655_/Y VPWR VGND sg13cmos5l_buf_1
Xfanout454 _11966_/B fanout465/X VPWR VGND sg13cmos5l_buf_1
Xfanout443 _10480_/B fanout445/X VPWR VGND sg13cmos5l_buf_1
X_13417__2005 _13417_/RESET_B VPWR VGND sg13cmos5l_tiehi
XFILLER_101_774 VPWR VGND sg13cmos5l_fill_1
XFILLER_48_79 VPWR VGND sg13cmos5l_fill_2
XFILLER_58_165 VPWR VGND sg13cmos5l_fill_2
XFILLER_59_688 VPWR VGND sg13cmos5l_fill_2
X_09828_ _13681_/D fanout55/X _09827_/B _09827_/Y VPWR VGND sg13cmos5l_a21oi_1
Xfanout498 _12317_/B _12349_/A2 VPWR VGND sg13cmos5l_buf_1
Xfanout487 _08738_/A2 _11811_/B1 VPWR VGND sg13cmos5l_buf_1
Xfanout476 _12195_/B _12344_/B VPWR VGND sg13cmos5l_buf_1
X_09759_ _13648_/D fanout57/X _09758_/B _09758_/Y VPWR VGND sg13cmos5l_a21oi_1
XFILLER_55_872 VPWR VGND sg13cmos5l_decap_8
XFILLER_70_820 VPWR VGND sg13cmos5l_fill_1
X_12770_ _12770_/X _12891_/A1 _12573_/X _12739_/A VPWR VGND sg13cmos5l_a21o_1
X_11721_ _11721_/Y _07272_/Y _11730_/B1 _11720_/Y _08653_/B VPWR VGND sg13cmos5l_a22oi_1
XFILLER_70_875 VPWR VGND sg13cmos5l_decap_8
X_11652_ _11652_/Y _12577_/A _11686_/B _11650_/X _11851_/A _11651_/Y VPWR VGND sg13cmos5l_a221oi_1
X_14440_ _14440_/Q clkload40/A _14440_/D _14440_/RESET_B VPWR VGND sg13cmos5l_dfrbpq_1
X_13302__2210 _13302_/RESET_B VPWR VGND sg13cmos5l_tiehi
X_10603_ _14061_/D fanout75/X _10602_/B _10602_/Y VPWR VGND sg13cmos5l_o21ai_1
Xfanout83 _09338_/S _09341_/S VPWR VGND sg13cmos5l_buf_1
Xfanout72 _12412_/A _11622_/Y VPWR VGND sg13cmos5l_buf_1
Xfanout61 fanout61/X _09679_/Y VPWR VGND sg13cmos5l_buf_1
X_14371_ _14371_/Q clkload74/A _14371_/D _14371_/RESET_B VPWR VGND sg13cmos5l_dfrbpq_1
XFILLER_7_935 VPWR VGND sg13cmos5l_fill_2
X_11583_ _11599_/B _11584_/A _11584_/B _11608_/A VPWR VGND sg13cmos5l_a21o_1
Xfanout94 _09266_/S _09267_/S VPWR VGND sg13cmos5l_buf_1
X_13322_ _13322_/Q _14650_/CLK _13322_/D _13322_/RESET_B VPWR VGND sg13cmos5l_dfrbpq_1
XFILLER_10_496 VPWR VGND sg13cmos5l_fill_1
XFILLER_6_423 VPWR VGND sg13cmos5l_fill_1
X_10534_ _14027_/D _10534_/A1 _10535_/B _10533_/Y VPWR VGND sg13cmos5l_o21ai_1
X_14417__1091 _14417_/RESET_B VPWR VGND sg13cmos5l_tiehi
XFILLER_6_456 VPWR VGND sg13cmos5l_fill_1
X_10465_ _13993_/D _10595_/A1 _10464_/B _10464_/Y VPWR VGND sg13cmos5l_a21oi_1
X_13253_ _13253_/Q clkload80/A _13253_/D _13253_/RESET_B VPWR VGND sg13cmos5l_dfrbpq_1
X_10396_ _10396_/Y _10396_/A _10402_/B VPWR VGND sg13cmos5l_nor2_1
X_12204_ _12204_/Y _13769_/Q _12206_/B _11884_/B VPWR VGND sg13cmos5l_o21ai_1
X_13184_ _13238_/D _11846_/B _13184_/A2 _13182_/Y _13183_/Y VPWR VGND sg13cmos5l_a22oi_1
X_12135_ _12136_/D _12135_/A VPWR VGND sg13cmos5l_inv_1
X_14630__2173 _14630_/RESET_B VPWR VGND sg13cmos5l_tiehi
XFILLER_96_238 VPWR VGND sg13cmos5l_fill_2
X_12066_ _12066_/Y _13892_/Q _12058_/B _12243_/B1 VPWR VGND sg13cmos5l_a21oi_1
X_11017_ _11024_/B _14570_/Q _11635_/A VPWR VGND sg13cmos5l_or2_1
XFILLER_92_477 VPWR VGND sg13cmos5l_decap_8
XFILLER_46_872 VPWR VGND sg13cmos5l_fill_2
XFILLER_46_894 VPWR VGND sg13cmos5l_fill_1
XFILLER_80_628 VPWR VGND sg13cmos5l_fill_1
XFILLER_92_488 VPWR VGND sg13cmos5l_fill_1
X_12968_ _12968_/X _12968_/A _12969_/C VPWR VGND sg13cmos5l_xor2_1
XFILLER_45_382 VPWR VGND sg13cmos5l_fill_2
X_11919_ _12476_/B _11948_/B2 _11911_/Y _11917_/Y _11918_/Y VPWR VGND sg13cmos5l_a22oi_1
X_12899_ _12899_/Y _12415_/A _12405_/B _12738_/Y _12898_/Y VPWR VGND sg13cmos5l_a22oi_1
X_14638_ _14638_/Q clkload70/A _14638_/D _14638_/RESET_B VPWR VGND sg13cmos5l_dfrbpq_1
X_14222__1255 _14222_/RESET_B VPWR VGND sg13cmos5l_tiehi
XFILLER_60_396 VPWR VGND sg13cmos5l_fill_1
X_14569_ _14569_/Q clkload45/A _14569_/D _14569_/RESET_B VPWR VGND sg13cmos5l_dfrbpq_1
X_08090_ _08090_/Y _08090_/A VPWR VGND sg13cmos5l_inv_1
Xclkload20 clkload20/X clkload20/A VPWR VGND sg13cmos5l_buf_8
Xclkload53 clkload53/Y clkload53/A VPWR VGND sg13cmos5l_inv_2
Xclkload42 clkload42/X clkload42/A VPWR VGND sg13cmos5l_buf_8
Xclkload31 clkload31/Y clkload31/A VPWR VGND sg13cmos5l_inv_1
Xclkload75 clkload75/X clkload75/A VPWR VGND sg13cmos5l_buf_8
Xclkload64 clkload64/Y clkload64/A VPWR VGND sg13cmos5l_inv_2
XFILLER_47_1026 VPWR VGND sg13cmos5l_fill_2
Xhold3516 hold3516/X _14174_/Q VPWR VGND sg13cmos5l_dlygate4sd3_1
Xhold3505 _08447_/A _13301_/Q VPWR VGND sg13cmos5l_dlygate4sd3_1
X_08992_ _08992_/Y _08992_/A _08994_/B VPWR VGND sg13cmos5l_nand2_1
Xhold2804 _10480_/A _14001_/Q VPWR VGND sg13cmos5l_dlygate4sd3_1
Xhold3538 hold3538/X _14125_/Q VPWR VGND sg13cmos5l_dlygate4sd3_1
Xhold3549 hold3549/X _14086_/Q VPWR VGND sg13cmos5l_dlygate4sd3_1
Xhold3527 hold3527/X _14552_/Q VPWR VGND sg13cmos5l_dlygate4sd3_1
X_07943_ _14567_/D _07917_/Y _07939_/X _07942_/Y VPWR VGND sg13cmos5l_o21ai_1
Xhold2815 hold2815/X _13221_/Q VPWR VGND sg13cmos5l_dlygate4sd3_1
Xhold2826 _09781_/A _13658_/Q VPWR VGND sg13cmos5l_dlygate4sd3_1
Xhold2837 _10282_/A _13904_/Q VPWR VGND sg13cmos5l_dlygate4sd3_1
Xhold2848 _09924_/A _13728_/Q VPWR VGND sg13cmos5l_dlygate4sd3_1
X_13481__1941 _13481_/RESET_B VPWR VGND sg13cmos5l_tiehi
XFILLER_69_986 VPWR VGND sg13cmos5l_fill_2
XFILLER_96_772 VPWR VGND sg13cmos5l_decap_8
XFILLER_96_783 VPWR VGND sg13cmos5l_fill_1
X_07874_ _07875_/C _14217_/Q _07862_/X _07864_/X _14201_/Q VPWR VGND sg13cmos5l_a22oi_1
Xhold2859 _09785_/A _13660_/Q VPWR VGND sg13cmos5l_dlygate4sd3_1
XFILLER_83_433 VPWR VGND sg13cmos5l_fill_2
X_09613_ _09613_/Y _09639_/A _11421_/B _09616_/B _09612_/Y VPWR VGND sg13cmos5l_a22oi_1
XFILLER_83_444 VPWR VGND sg13cmos5l_fill_2
X_09544_ _09544_/Y _09544_/A _09544_/B VPWR VGND sg13cmos5l_nor2_1
X_09475_ _09475_/X _14130_/Q hold3248/X _09475_/S VPWR VGND sg13cmos5l_mux2_1
XFILLER_34_59 VPWR VGND sg13cmos5l_fill_2
XFILLER_51_363 VPWR VGND sg13cmos5l_decap_8
XFILLER_54_1008 VPWR VGND sg13cmos5l_fill_2
X_08426_ _10654_/B _10998_/A _15882_/A VPWR VGND sg13cmos5l_nor2_1
XFILLER_20_750 VPWR VGND sg13cmos5l_fill_1
X_08357_ _08357_/X _13517_/Q _13485_/Q _08363_/S VPWR VGND sg13cmos5l_mux2_1
Xclkload3 clkload3/X clkload3/A VPWR VGND sg13cmos5l_buf_8
XFILLER_50_36 VPWR VGND sg13cmos5l_fill_1
X_07308_ _07308_/Y _07308_/A VPWR VGND sg13cmos5l_inv_1
X_08288_ _08288_/X _13575_/Q _13543_/Q _08288_/S VPWR VGND sg13cmos5l_mux2_1
X_13256__1008 _13256_/RESET_B VPWR VGND sg13cmos5l_tiehi
X_07239_ _11121_/A _14381_/Q VPWR VGND sg13cmos5l_inv_1
X_10250_ _10250_/Y _10250_/A _10250_/B VPWR VGND sg13cmos5l_nor2_1
X_10181_ _10181_/Y _10181_/A _10189_/B VPWR VGND sg13cmos5l_nor2_1
XFILLER_105_398 VPWR VGND sg13cmos5l_fill_2
Xfanout240 _10563_/A1 _09529_/Y VPWR VGND sg13cmos5l_buf_1
XFILLER_59_452 VPWR VGND sg13cmos5l_decap_8
Xfanout273 _10238_/B _10248_/B VPWR VGND sg13cmos5l_buf_1
Xfanout262 _10299_/B _10341_/B VPWR VGND sg13cmos5l_buf_1
Xfanout251 _10380_/B _10368_/B VPWR VGND sg13cmos5l_buf_1
X_13940_ _13940_/Q clkload18/A _13940_/D _13940_/RESET_B VPWR VGND sg13cmos5l_dfrbpq_1
XFILLER_75_945 VPWR VGND sg13cmos5l_decap_4
Xfanout295 _09942_/B _09956_/B VPWR VGND sg13cmos5l_buf_1
Xfanout284 _10189_/B _10211_/B VPWR VGND sg13cmos5l_buf_1
XFILLER_19_349 VPWR VGND sg13cmos5l_fill_1
XFILLER_74_444 VPWR VGND sg13cmos5l_fill_2
X_13871_ _13871_/Q _14065_/CLK _13871_/D _13871_/RESET_B VPWR VGND sg13cmos5l_dfrbpq_1
X_13656__1735 _13656_/RESET_B VPWR VGND sg13cmos5l_tiehi
XFILLER_90_937 VPWR VGND sg13cmos5l_decap_8
X_12822_ _12822_/Y _12828_/B _12828_/C VPWR VGND sg13cmos5l_nor2_1
X_12753_ _12753_/Y _12753_/A _12738_/Y VPWR VGND sg13cmos5l_nor2b_1
X_11704_ _11704_/Y _11700_/Y _11701_/Y _11702_/Y _11703_/Y _08674_/A VPWR VGND sg13cmos5l_a221oi_1
X_14423_ _14423_/Q _14453_/CLK _14423_/D _14423_/RESET_B VPWR VGND sg13cmos5l_dfrbpq_1
X_14036__1355 _14036_/RESET_B VPWR VGND sg13cmos5l_tiehi
X_13871__1520 _13871_/RESET_B VPWR VGND sg13cmos5l_tiehi
X_12684_ _12684_/Y _12715_/A _12684_/B VPWR VGND sg13cmos5l_nor2_1
XFILLER_24_70 VPWR VGND sg13cmos5l_fill_1
X_11635_ _11635_/Y _11635_/A _11635_/B VPWR VGND sg13cmos5l_nand2_1
XFILLER_7_732 VPWR VGND sg13cmos5l_fill_2
X_11566_ _11566_/X _11566_/A _11575_/C VPWR VGND sg13cmos5l_xor2_1
X_14354_ _14354_/Q clkload68/A _14354_/D _14354_/RESET_B VPWR VGND sg13cmos5l_dfrbpq_1
X_10517_ _10517_/Y _10517_/A _10517_/B VPWR VGND sg13cmos5l_nand2_1
X_14285_ _14285_/Q clkload25/A _14285_/D _14285_/RESET_B VPWR VGND sg13cmos5l_dfrbpq_1
X_13305_ _13305_/Q clkload24/A _13305_/D _13305_/RESET_B VPWR VGND sg13cmos5l_dfrbpq_1
X_11497_ _11497_/Y _11497_/A _11560_/B VPWR VGND sg13cmos5l_nand2_1
X_13236_ _13236_/Q _14630_/CLK _13236_/D _13236_/RESET_B VPWR VGND sg13cmos5l_dfrbpq_1
X_10448_ _10448_/Y _10448_/A _10464_/B VPWR VGND sg13cmos5l_nor2_1
XFILLER_97_514 VPWR VGND sg13cmos5l_decap_4
X_10379_ _13951_/D _10379_/A1 _10384_/B _10378_/Y VPWR VGND sg13cmos5l_a21oi_1
X_13167_ _13232_/D _13166_/B _13165_/Y _13166_/Y VPWR VGND sg13cmos5l_a21oi_1
X_12118_ _12121_/A _13894_/Q _12195_/B VPWR VGND sg13cmos5l_nand2_1
X_13098_ _13100_/A _13101_/C _13101_/D hold2845/X VPWR VGND sg13cmos5l_a21oi_1
X_12049_ _12049_/Y _12286_/A _12049_/B _12077_/B VPWR VGND sg13cmos5l_nand3_1
XFILLER_93_731 VPWR VGND sg13cmos5l_decap_4
XFILLER_19_850 VPWR VGND sg13cmos5l_fill_2
XFILLER_65_455 VPWR VGND sg13cmos5l_fill_1
XFILLER_92_230 VPWR VGND sg13cmos5l_fill_1
XFILLER_81_926 VPWR VGND sg13cmos5l_decap_4
X_07590_ _07593_/A _07590_/A _07590_/B _07590_/C _07590_/D VPWR VGND sg13cmos5l_nand4_1
XFILLER_46_691 VPWR VGND sg13cmos5l_fill_2
X_09260_ _13385_/D _09225_/A hold3052/X _09260_/S VPWR VGND sg13cmos5l_mux2_1
X_08211_ _08211_/Y _08356_/C _08206_/X _08210_/Y _11036_/C1 VPWR VGND sg13cmos5l_a22oi_1
X_09191_ _09191_/Y _09191_/A _09197_/B VPWR VGND sg13cmos5l_nor2_1
X_08142_ _08144_/A _08143_/B _08143_/C hold2815/X VPWR VGND sg13cmos5l_a21oi_1
X_13499__1923 _13499_/RESET_B VPWR VGND sg13cmos5l_tiehi
XFILLER_101_1006 VPWR VGND sg13cmos5l_decap_8
X_08073_ _08074_/A _08053_/A _08072_/Y _08058_/B VPWR VGND sg13cmos5l_a21oi_1
XFILLER_106_129 VPWR VGND sg13cmos5l_fill_2
X_13734__1657 _13734_/RESET_B VPWR VGND sg13cmos5l_tiehi
XFILLER_103_803 VPWR VGND sg13cmos5l_fill_2
Xhold3324 hold3324/X _13371_/Q VPWR VGND sg13cmos5l_dlygate4sd3_1
Xhold3313 _13579_/D _09469_/X VPWR VGND sg13cmos5l_dlygate4sd3_1
Xhold3302 _13545_/D _09434_/X VPWR VGND sg13cmos5l_dlygate4sd3_1
XFILLER_103_869 VPWR VGND sg13cmos5l_fill_2
X_08975_ _08975_/Y _08975_/A _08975_/B VPWR VGND sg13cmos5l_nor2_1
Xhold2601 _10380_/A _13952_/Q VPWR VGND sg13cmos5l_dlygate4sd3_1
Xhold2612 _09930_/A _13731_/Q VPWR VGND sg13cmos5l_dlygate4sd3_1
Xhold3357 _13552_/D _09441_/X VPWR VGND sg13cmos5l_dlygate4sd3_1
Xhold3346 hold3346/X _13464_/Q VPWR VGND sg13cmos5l_dlygate4sd3_1
Xhold3335 _11004_/B _11003_/Y VPWR VGND sg13cmos5l_dlygate4sd3_1
XFILLER_102_379 VPWR VGND sg13cmos5l_fill_1
X_07926_ _07997_/D _14570_/Q _08000_/A VPWR VGND sg13cmos5l_and2_1
Xhold2623 _09726_/A _13632_/Q VPWR VGND sg13cmos5l_dlygate4sd3_1
Xhold2634 _10974_/A _14227_/Q VPWR VGND sg13cmos5l_dlygate4sd3_1
Xhold2645 _10458_/A _13990_/Q VPWR VGND sg13cmos5l_dlygate4sd3_1
Xhold2656 _09912_/A _13722_/Q VPWR VGND sg13cmos5l_dlygate4sd3_1
Xhold3379 hold3379/X _13482_/Q VPWR VGND sg13cmos5l_dlygate4sd3_1
Xhold3368 _09007_/A _13283_/Q VPWR VGND sg13cmos5l_dlygate4sd3_1
XFILLER_68_271 VPWR VGND sg13cmos5l_fill_2
XFILLER_84_731 VPWR VGND sg13cmos5l_decap_8
Xhold2667 _10278_/A _13902_/Q VPWR VGND sg13cmos5l_dlygate4sd3_1
Xhold2678 _10918_/A _14205_/Q VPWR VGND sg13cmos5l_dlygate4sd3_1
Xhold2689 _09892_/A _13713_/Q VPWR VGND sg13cmos5l_dlygate4sd3_1
XFILLER_29_669 VPWR VGND sg13cmos5l_fill_2
XFILLER_56_466 VPWR VGND sg13cmos5l_fill_1
X_07857_ _07857_/Y _07857_/A _07857_/B VPWR VGND sg13cmos5l_nand2_1
XFILLER_16_308 VPWR VGND sg13cmos5l_fill_2
X_07788_ _07788_/Y _08893_/A VPWR VGND sg13cmos5l_inv_1
X_09527_ _09527_/Y _14444_/Q _09522_/B _09663_/B1 VPWR VGND sg13cmos5l_o21ai_1
XFILLER_24_341 VPWR VGND sg13cmos5l_fill_1
XFILLER_40_812 VPWR VGND sg13cmos5l_fill_2
XFILLER_101_64 VPWR VGND sg13cmos5l_fill_1
XFILLER_52_694 VPWR VGND sg13cmos5l_fill_2
X_09458_ _09458_/X _14113_/Q hold3260/X _09471_/S VPWR VGND sg13cmos5l_mux2_1
X_13367__2055 _13367_/RESET_B VPWR VGND sg13cmos5l_tiehi
XFILLER_40_878 VPWR VGND sg13cmos5l_fill_2
X_08409_ _08409_/Y _09307_/A _08409_/B _08409_/C VPWR VGND sg13cmos5l_nand3_1
X_09389_ _13501_/D _10690_/A1 hold3137/X _09405_/S VPWR VGND sg13cmos5l_mux2_1
X_11420_ _11420_/Y _11420_/A _11436_/B VPWR VGND sg13cmos5l_nand2_1
X_11351_ _11351_/Y _11351_/A _11351_/B VPWR VGND sg13cmos5l_xnor2_1
X_10302_ _13913_/D _10367_/A1 _10315_/B _10301_/Y VPWR VGND sg13cmos5l_a21oi_1
X_14298__1210 _14298_/RESET_B VPWR VGND sg13cmos5l_tiehi
X_11282_ _11297_/B _14091_/Q _11302_/C VPWR VGND sg13cmos5l_nand2_1
X_14070_ _14070_/Q clkload9/A _14070_/D fanout968/X VPWR VGND sg13cmos5l_dfrbpq_1
XFILLER_10_72 VPWR VGND sg13cmos5l_fill_1
X_10233_ _13879_/D _10298_/A1 _10238_/B _10232_/Y VPWR VGND sg13cmos5l_a21oi_1
X_13021_ _13021_/Y _13021_/A _13021_/B VPWR VGND sg13cmos5l_xnor2_1
XFILLER_106_696 VPWR VGND sg13cmos5l_decap_8
XFILLER_79_536 VPWR VGND sg13cmos5l_fill_1
X_10164_ _13845_/D _10555_/A1 _10185_/B _10163_/Y VPWR VGND sg13cmos5l_a21oi_1
Xfanout1002 fanout998/A input1/X VPWR VGND sg13cmos5l_buf_1
XFILLER_0_963 VPWR VGND sg13cmos5l_decap_8
XFILLER_86_65 VPWR VGND sg13cmos5l_fill_1
XFILLER_0_985 VPWR VGND sg13cmos5l_fill_1
XFILLER_75_720 VPWR VGND sg13cmos5l_fill_1
X_10095_ _10095_/Y _10095_/A _10109_/B VPWR VGND sg13cmos5l_nand2_1
X_13889__1502 _13889_/RESET_B VPWR VGND sg13cmos5l_tiehi
X_13923_ _13923_/Q clkload58/A _13923_/D _13923_/RESET_B VPWR VGND sg13cmos5l_dfrbpq_1
XFILLER_63_915 VPWR VGND sg13cmos5l_decap_8
XFILLER_74_252 VPWR VGND sg13cmos5l_fill_1
X_13854_ _13854_/Q clkload51/A _13854_/D _13854_/RESET_B VPWR VGND sg13cmos5l_dfrbpq_1
X_13577__1845 _13577_/RESET_B VPWR VGND sg13cmos5l_tiehi
XFILLER_63_959 VPWR VGND sg13cmos5l_fill_2
X_12805_ _12823_/B _14457_/Q _13247_/Q _13248_/Q _14458_/Q VPWR VGND sg13cmos5l_a22oi_1
XFILLER_71_970 VPWR VGND sg13cmos5l_decap_8
XFILLER_71_981 VPWR VGND sg13cmos5l_decap_8
XFILLER_90_778 VPWR VGND sg13cmos5l_decap_8
X_10997_ _10998_/B hold3310/X _10983_/B _10996_/Y hold3367/X VPWR VGND sg13cmos5l_a22oi_1
X_13785_ _13785_/Q _14048_/CLK _13785_/D _13785_/RESET_B VPWR VGND sg13cmos5l_dfrbpq_1
X_13812__1579 _13812_/RESET_B VPWR VGND sg13cmos5l_tiehi
X_12736_ _12739_/B _11161_/C _12635_/Y _12735_/Y VPWR VGND sg13cmos5l_o21ai_1
X_12667_ _12669_/A _14446_/Q _13236_/Q VPWR VGND sg13cmos5l_nor2_1
X_11618_ _11622_/C _14238_/Q _14572_/Q _11618_/C VPWR VGND sg13cmos5l_nand3_1
X_14406_ _14406_/Q clkload45/A _14406_/D _14406_/RESET_B VPWR VGND sg13cmos5l_dfrbpq_1
X_14337_ _14337_/Q clkload79/A _14337_/D _14337_/RESET_B VPWR VGND sg13cmos5l_dfrbpq_1
X_12598_ _12598_/X _12637_/A _12598_/B VPWR VGND sg13cmos5l_and2_1
X_11549_ _11551_/B _11577_/C _11580_/A _11549_/C VPWR VGND sg13cmos5l_nand3_1
X_13412__2010 _13412_/RESET_B VPWR VGND sg13cmos5l_tiehi
XFILLER_83_1001 VPWR VGND sg13cmos5l_fill_1
X_14268_ _14268_/Q clkload72/A _14268_/D _14268_/RESET_B VPWR VGND sg13cmos5l_dfrbpq_1
X_14199_ _14199_/Q clkload72/A _14199_/D _14199_/RESET_B VPWR VGND sg13cmos5l_dfrbpq_1
X_13219_ _13219_/Q _14532_/CLK _13219_/D fanout974/X VPWR VGND sg13cmos5l_dfrbpq_1
XFILLER_38_400 VPWR VGND sg13cmos5l_fill_1
X_08760_ _08760_/Y _07261_/Y _07329_/Y _08759_/Y VPWR VGND sg13cmos5l_o21ai_1
XFILLER_18_0 VPWR VGND sg13cmos5l_fill_2
XFILLER_66_753 VPWR VGND sg13cmos5l_fill_1
X_07711_ _08473_/A _07711_/A _08479_/A VPWR VGND sg13cmos5l_nand2_1
X_08691_ _08691_/Y _13939_/Q _11749_/B _08748_/B1 _13875_/Q VPWR VGND sg13cmos5l_a22oi_1
XFILLER_39_989 VPWR VGND sg13cmos5l_fill_1
X_07642_ _07642_/Y _07644_/A VPWR VGND sg13cmos5l_inv_1
X_07573_ _07576_/A _07573_/A _12963_/C VPWR VGND sg13cmos5l_xnor2_1
X_09312_ _09312_/X _14101_/Q hold3298/X _09320_/S VPWR VGND sg13cmos5l_mux2_1
X_14376__1132 _14376_/RESET_B VPWR VGND sg13cmos5l_tiehi
X_09243_ _13368_/D _10685_/A1 hold3387/X _09258_/S VPWR VGND sg13cmos5l_mux2_1
X_14097__1310 _14097_/RESET_B VPWR VGND sg13cmos5l_tiehi
X_09174_ _13325_/D _09173_/B _09172_/Y _09173_/Y VPWR VGND sg13cmos5l_a21oi_1
X_08125_ _13214_/D _08125_/A _08138_/B VPWR VGND sg13cmos5l_xor2_1
X_13967__1424 _13967_/RESET_B VPWR VGND sg13cmos5l_tiehi
X_08056_ _08058_/B _13128_/B _09343_/D VPWR VGND sg13cmos5l_nand2b_1
Xoutput27 uio_out[13] _15893_/X VPWR VGND sg13cmos5l_buf_1
Xoutput38 uio_out[9] _15889_/X VPWR VGND sg13cmos5l_buf_1
Xoutput49 uo_out[4] _08764_/Y VPWR VGND sg13cmos5l_buf_1
XFILLER_0_237 VPWR VGND sg13cmos5l_fill_1
Xhold3110 _09872_/A _13703_/Q VPWR VGND sg13cmos5l_dlygate4sd3_1
Xhold3121 hold3121/X _13483_/Q VPWR VGND sg13cmos5l_dlygate4sd3_1
Xhold3132 hold3132/X _13418_/Q VPWR VGND sg13cmos5l_dlygate4sd3_1
Xhold2420 _14141_/D _10743_/Y VPWR VGND sg13cmos5l_dlygate4sd3_1
Xhold2431 _10606_/A _14063_/Q VPWR VGND sg13cmos5l_dlygate4sd3_1
Xhold3143 hold3143/X _13489_/Q VPWR VGND sg13cmos5l_dlygate4sd3_1
Xhold3154 hold3154/X _13533_/Q VPWR VGND sg13cmos5l_dlygate4sd3_1
Xhold3165 hold3165/X _13490_/Q VPWR VGND sg13cmos5l_dlygate4sd3_1
Xhold3176 _13562_/D _09452_/X VPWR VGND sg13cmos5l_dlygate4sd3_1
XFILLER_57_731 VPWR VGND sg13cmos5l_decap_4
XFILLER_5_1001 VPWR VGND sg13cmos5l_fill_1
X_08958_ _08958_/Y _08958_/A _08963_/S VPWR VGND sg13cmos5l_nand2_1
Xhold2442 _11220_/A _14316_/Q VPWR VGND sg13cmos5l_dlygate4sd3_1
Xhold2453 _10751_/A _14144_/Q VPWR VGND sg13cmos5l_dlygate4sd3_1
Xhold2464 _10050_/A _13790_/Q VPWR VGND sg13cmos5l_dlygate4sd3_1
Xhold3187 hold3187/X _13563_/Q VPWR VGND sg13cmos5l_dlygate4sd3_1
Xhold3198 _13536_/D _09425_/X VPWR VGND sg13cmos5l_dlygate4sd3_1
XFILLER_102_198 VPWR VGND sg13cmos5l_fill_1
XFILLER_57_742 VPWR VGND sg13cmos5l_fill_1
X_07909_ _14573_/D _11016_/B _07930_/B _07908_/Y VPWR VGND sg13cmos5l_o21ai_1
X_08889_ _08889_/Y _08889_/A _08894_/B VPWR VGND sg13cmos5l_nand2_1
Xhold2475 _14131_/D _10713_/Y VPWR VGND sg13cmos5l_dlygate4sd3_1
Xhold2486 _14149_/D _10767_/Y VPWR VGND sg13cmos5l_dlygate4sd3_1
Xhold2497 _10121_/A _13825_/Q VPWR VGND sg13cmos5l_dlygate4sd3_1
XFILLER_29_488 VPWR VGND sg13cmos5l_fill_2
XFILLER_72_723 VPWR VGND sg13cmos5l_fill_2
X_10920_ _10920_/Y _10920_/A _10941_/B VPWR VGND sg13cmos5l_nand2_1
X_10851_ _10851_/Y _10851_/A _10871_/C VPWR VGND sg13cmos5l_nor2_1
XFILLER_52_480 VPWR VGND sg13cmos5l_fill_2
XFILLER_53_992 VPWR VGND sg13cmos5l_fill_1
X_10782_ _10782_/Y _10781_/B _10780_/Y _10781_/Y VPWR VGND sg13cmos5l_o21ai_1
X_13570_ _13570_/Q clkload29/A _13570_/D _13570_/RESET_B VPWR VGND sg13cmos5l_dfrbpq_1
XFILLER_40_653 VPWR VGND sg13cmos5l_fill_1
X_12521_ _14398_/D _12530_/B _12520_/Y _12518_/Y VPWR VGND sg13cmos5l_o21ai_1
XFILLER_9_838 VPWR VGND sg13cmos5l_fill_2
X_12452_ _12455_/A _12452_/A _12460_/B VPWR VGND sg13cmos5l_nand2_1
XFILLER_8_348 VPWR VGND sg13cmos5l_fill_2
X_11403_ _11403_/X _11403_/A _11403_/B VPWR VGND sg13cmos5l_xor2_1
X_12383_ _12383_/Y _14372_/Q _12383_/A2 _12382_/Y VPWR VGND sg13cmos5l_o21ai_1
X_11334_ _11336_/B _11334_/A _11393_/A VPWR VGND sg13cmos5l_and2_1
X_14122_ _14122_/Q clkload37/A _14122_/D _11000_/A VPWR VGND sg13cmos5l_dfrbpq_1
X_11265_ _11284_/A _14090_/Q _11302_/B VPWR VGND sg13cmos5l_and2_1
X_14053_ _14053_/Q _14053_/CLK _14053_/D _14053_/RESET_B VPWR VGND sg13cmos5l_dfrbpq_1
XFILLER_106_471 VPWR VGND sg13cmos5l_fill_1
X_10216_ _13871_/D fanout61/X _10219_/B _10215_/Y VPWR VGND sg13cmos5l_a21oi_1
X_13004_ _14490_/D _13004_/A _13005_/C VPWR VGND sg13cmos5l_xor2_1
XFILLER_79_355 VPWR VGND sg13cmos5l_fill_1
X_11196_ _11196_/Y _11196_/A _11196_/B VPWR VGND sg13cmos5l_nand2_1
X_10147_ _10147_/Y _10147_/A _10147_/B VPWR VGND sg13cmos5l_nand2_1
XFILLER_48_753 VPWR VGND sg13cmos5l_fill_1
X_10078_ _10078_/Y _10078_/A _10078_/B VPWR VGND sg13cmos5l_nand2_1
X_13906_ _13906_/Q clkload53/A _13906_/D _13906_/RESET_B VPWR VGND sg13cmos5l_dfrbpq_1
XFILLER_35_447 VPWR VGND sg13cmos5l_fill_2
X_13837_ _13837_/Q _14053_/CLK _13837_/D _13837_/RESET_B VPWR VGND sg13cmos5l_dfrbpq_1
X_13251__1013 _13251_/RESET_B VPWR VGND sg13cmos5l_tiehi
XFILLER_15_160 VPWR VGND sg13cmos5l_fill_2
X_13768_ _13768_/Q clkload78/A _13768_/D _13768_/RESET_B VPWR VGND sg13cmos5l_dfrbpq_1
Xclkbuf_0_clk clkbuf_0_clk/X clk VPWR VGND sg13cmos5l_buf_8
X_12719_ _12732_/A _14451_/Q _13241_/Q VPWR VGND sg13cmos5l_nand2_1
X_13699_ _13699_/Q clkload57/A _13699_/D _13699_/RESET_B VPWR VGND sg13cmos5l_dfrbpq_1
XFILLER_11_1028 VPWR VGND sg13cmos5l_fill_1
XFILLER_7_381 VPWR VGND sg13cmos5l_fill_2
X_09930_ _09930_/Y _09930_/A _09952_/B VPWR VGND sg13cmos5l_nor2_1
Xfanout806 _07959_/B _14578_/Q VPWR VGND sg13cmos5l_buf_1
X_09861_ _13697_/D _10514_/A1 _09862_/B _09860_/Y VPWR VGND sg13cmos5l_a21oi_1
Xfanout839 _12187_/A _14365_/Q VPWR VGND sg13cmos5l_buf_1
Xfanout828 fanout828/X _14569_/Q VPWR VGND sg13cmos5l_buf_1
Xfanout817 _12449_/A _08646_/A VPWR VGND sg13cmos5l_buf_1
X_13651__1740 _13651_/RESET_B VPWR VGND sg13cmos5l_tiehi
X_08812_ _08812_/Y _07709_/Y _08808_/B _08831_/B1 _07711_/A VPWR VGND sg13cmos5l_a22oi_1
X_09792_ _13663_/D _10379_/A1 _09797_/B _09791_/Y VPWR VGND sg13cmos5l_a21oi_1
X_08743_ _08745_/B _13686_/Q _08743_/B VPWR VGND sg13cmos5l_nand2_1
XFILLER_94_881 VPWR VGND sg13cmos5l_fill_2
X_14031__1360 _14031_/RESET_B VPWR VGND sg13cmos5l_tiehi
XFILLER_26_16 VPWR VGND sg13cmos5l_fill_2
XFILLER_54_723 VPWR VGND sg13cmos5l_fill_1
XFILLER_81_531 VPWR VGND sg13cmos5l_fill_1
X_08674_ _08674_/Y _08674_/A _08674_/B VPWR VGND sg13cmos5l_nor2_1
XFILLER_42_929 VPWR VGND sg13cmos5l_fill_2
XFILLER_81_553 VPWR VGND sg13cmos5l_fill_2
X_07625_ _07626_/B _13288_/Q _07625_/B VPWR VGND sg13cmos5l_xnor2_1
X_07556_ _07558_/C _14555_/Q _13296_/Q VPWR VGND sg13cmos5l_xor2_1
XFILLER_50_951 VPWR VGND sg13cmos5l_fill_1
XFILLER_21_163 VPWR VGND sg13cmos5l_fill_1
X_07487_ _07487_/Y _08157_/B _07486_/Y _12964_/A VPWR VGND sg13cmos5l_o21ai_1
X_09226_ _13353_/D _07312_/Y _09234_/S _09225_/Y VPWR VGND sg13cmos5l_a21oi_1
X_09157_ _11511_/A _14335_/Q _09163_/B VPWR VGND sg13cmos5l_nand2_1
X_08108_ _08108_/Y _08108_/A _13110_/B _08108_/C VPWR VGND sg13cmos5l_nand3_1
X_09088_ _09088_/Y _14355_/Q _09106_/A2 _09087_/Y VPWR VGND sg13cmos5l_a21oi_1
X_14235__1242 _14235_/RESET_B VPWR VGND sg13cmos5l_tiehi
X_08039_ _08044_/A _14539_/Q _08039_/B VPWR VGND sg13cmos5l_xnor2_1
XFILLER_104_964 VPWR VGND sg13cmos5l_decap_8
X_11050_ _14278_/D _11105_/A _11107_/B _11049_/Y VPWR VGND sg13cmos5l_a21oi_1
XFILLER_49_539 VPWR VGND sg13cmos5l_fill_1
XFILLER_77_826 VPWR VGND sg13cmos5l_fill_1
X_10001_ _10001_/Y _10001_/A _10017_/B VPWR VGND sg13cmos5l_nand2_1
XFILLER_67_67 VPWR VGND sg13cmos5l_fill_1
XFILLER_92_807 VPWR VGND sg13cmos5l_decap_8
Xhold2250 _11469_/A _14332_/Q VPWR VGND sg13cmos5l_dlygate4sd3_1
Xhold2261 _10125_/A _13827_/Q VPWR VGND sg13cmos5l_dlygate4sd3_1
Xhold2272 _10007_/A _13769_/Q VPWR VGND sg13cmos5l_dlygate4sd3_1
XFILLER_85_870 VPWR VGND sg13cmos5l_decap_8
Xhold2283 _11407_/A _14328_/Q VPWR VGND sg13cmos5l_dlygate4sd3_1
Xhold2294 _14148_/D _10764_/Y VPWR VGND sg13cmos5l_dlygate4sd3_1
XFILLER_45_734 VPWR VGND sg13cmos5l_fill_1
X_11952_ _11953_/B _12097_/A1 _12480_/B _11951_/Y VPWR VGND sg13cmos5l_o21ai_1
XFILLER_45_767 VPWR VGND sg13cmos5l_fill_1
X_10903_ _14198_/D _10922_/B _10897_/Y _10902_/Y VPWR VGND sg13cmos5l_o21ai_1
X_11883_ _11886_/A _13918_/Q _11969_/A2 _12010_/C1 VPWR VGND sg13cmos5l_a21oi_1
XFILLER_60_748 VPWR VGND sg13cmos5l_fill_1
X_10834_ _10834_/Y _10941_/B VPWR VGND sg13cmos5l_inv_1
X_13622_ _13622_/Q clkload50/A _13622_/D _13622_/RESET_B VPWR VGND sg13cmos5l_dfrbpq_1
XFILLER_60_759 VPWR VGND sg13cmos5l_fill_2
X_13553_ _13553_/Q clkload34/A _13553_/D _13553_/RESET_B VPWR VGND sg13cmos5l_dfrbpq_1
XFILLER_13_664 VPWR VGND sg13cmos5l_fill_2
XFILLER_8_101 VPWR VGND sg13cmos5l_fill_1
X_10765_ _10765_/Y _10801_/A _14293_/Q VPWR VGND sg13cmos5l_nand2_1
X_12504_ _12504_/Y _12504_/A _12504_/B VPWR VGND sg13cmos5l_nand2_1
XFILLER_8_145 VPWR VGND sg13cmos5l_decap_4
X_10696_ _14116_/D input9/X _09288_/A _10697_/S VPWR VGND sg13cmos5l_mux2_1
X_13484_ _13484_/Q _14238_/CLK _13484_/D _13484_/RESET_B VPWR VGND sg13cmos5l_dfrbpq_1
X_12435_ _12435_/Y _12445_/A _14169_/Q _12441_/B1 VPWR VGND sg13cmos5l_a21oi_1
XFILLER_5_841 VPWR VGND sg13cmos5l_fill_2
X_12366_ _12368_/B _13903_/Q _12366_/B VPWR VGND sg13cmos5l_nand2_1
X_11317_ _11317_/Y _11316_/A _11313_/Y _11315_/Y _11316_/Y _11615_/C1 VPWR VGND sg13cmos5l_a221oi_1
X_14105_ _14105_/Q _14105_/CLK _14105_/D fanout995/X VPWR VGND sg13cmos5l_dfrbpq_1
X_12297_ _12297_/Y _13612_/Q _12292_/B _12297_/B1 _13868_/Q _12297_/C1 VPWR VGND sg13cmos5l_a221oi_1
X_11248_ _11249_/B _11293_/A _11248_/B VPWR VGND sg13cmos5l_nand2_1
X_14036_ _14036_/Q clkload17/A _14036_/D _14036_/RESET_B VPWR VGND sg13cmos5l_dfrbpq_1
X_11179_ _11189_/B _11179_/A _11179_/B VPWR VGND sg13cmos5l_or2_1
XFILLER_95_656 VPWR VGND sg13cmos5l_fill_1
X_13362__2060 _13362_/RESET_B VPWR VGND sg13cmos5l_tiehi
XFILLER_36_745 VPWR VGND sg13cmos5l_fill_2
XFILLER_24_918 VPWR VGND sg13cmos5l_fill_2
XFILLER_24_929 VPWR VGND sg13cmos5l_fill_1
XFILLER_63_542 VPWR VGND sg13cmos5l_fill_2
X_07410_ _07413_/B _14548_/Q _07434_/C _07374_/Y VPWR VGND sg13cmos5l_o21ai_1
X_08390_ _08390_/X _13583_/Q _13551_/Q _08390_/S VPWR VGND sg13cmos5l_mux2_1
XFILLER_50_247 VPWR VGND sg13cmos5l_fill_1
X_07341_ _07341_/Y _14145_/Q VPWR VGND sg13cmos5l_inv_1
X_13669__1722 _13669_/RESET_B VPWR VGND sg13cmos5l_tiehi
X_07272_ _07272_/Y _13752_/Q VPWR VGND sg13cmos5l_inv_1
X_09011_ _13286_/D hold3434/X _08984_/A _09012_/B VPWR VGND sg13cmos5l_mux2_1
XFILLER_105_717 VPWR VGND sg13cmos5l_decap_8
XFILLER_105_728 VPWR VGND sg13cmos5l_decap_8
X_14049__1342 _14049_/RESET_B VPWR VGND sg13cmos5l_tiehi
X_09913_ _13722_/D _10369_/A1 _09912_/B _09912_/Y VPWR VGND sg13cmos5l_a21oi_1
Xfanout614 _11558_/B1 _12949_/B2 VPWR VGND sg13cmos5l_buf_1
Xfanout603 _12430_/A1 _12322_/A1 VPWR VGND sg13cmos5l_buf_1
X_13572__1850 _13572_/RESET_B VPWR VGND sg13cmos5l_tiehi
XFILLER_99_995 VPWR VGND sg13cmos5l_decap_8
X_09844_ _09844_/Y _09844_/A _09844_/B VPWR VGND sg13cmos5l_nor2_1
Xfanout658 _12727_/A1 _11007_/Y VPWR VGND sg13cmos5l_buf_1
Xfanout647 _11121_/B _11109_/B VPWR VGND sg13cmos5l_buf_1
Xfanout636 _12541_/B fanout637/X VPWR VGND sg13cmos5l_buf_1
Xfanout625 _12879_/B1 _12653_/X VPWR VGND sg13cmos5l_buf_1
XFILLER_58_358 VPWR VGND sg13cmos5l_fill_2
XFILLER_86_634 VPWR VGND sg13cmos5l_fill_1
Xfanout669 _13196_/A2 _13194_/A2 VPWR VGND sg13cmos5l_buf_1
XFILLER_101_978 VPWR VGND sg13cmos5l_decap_8
X_09775_ _09775_/Y _09775_/A _09813_/B VPWR VGND sg13cmos5l_nor2_1
XFILLER_67_881 VPWR VGND sg13cmos5l_fill_2
X_08726_ _08727_/C _14037_/Q _11749_/B _08744_/B1 _13973_/Q VPWR VGND sg13cmos5l_a22oi_1
XFILLER_54_553 VPWR VGND sg13cmos5l_decap_8
X_08657_ _08657_/Y _13810_/Q _12060_/B _11727_/B VPWR VGND sg13cmos5l_a21oi_1
X_07608_ _07630_/A _13289_/Q _08999_/A VPWR VGND sg13cmos5l_nor2b_1
XFILLER_81_394 VPWR VGND sg13cmos5l_decap_8
X_08588_ _08588_/Y _07784_/A _08593_/A _07803_/Y VPWR VGND sg13cmos5l_a21oi_1
X_07539_ _07540_/D _14546_/Q _13299_/Q VPWR VGND sg13cmos5l_xor2_1
X_10550_ _10550_/Y _10550_/A _10566_/B VPWR VGND sg13cmos5l_nand2_1
X_09209_ _13338_/D _08170_/A hold3231/X _09225_/B VPWR VGND sg13cmos5l_mux2_1
X_10481_ _14001_/D fanout56/X _10480_/B _10480_/Y VPWR VGND sg13cmos5l_a21oi_1
XFILLER_5_115 VPWR VGND sg13cmos5l_fill_1
X_12220_ _12221_/B _12220_/A _12216_/Y VPWR VGND sg13cmos5l_nor2b_1
X_12151_ _12151_/Y _12192_/A _12164_/C _12382_/A _12150_/Y VPWR VGND sg13cmos5l_a22oi_1
X_11102_ _11102_/Y _08861_/A _11121_/B _11101_/Y VPWR VGND sg13cmos5l_a21oi_1
X_12082_ _12082_/Y _13829_/Q _12260_/B _12293_/B1 VPWR VGND sg13cmos5l_a21oi_1
XFILLER_77_623 VPWR VGND sg13cmos5l_fill_2
X_11033_ _11034_/B _13437_/Q _13405_/Q _13373_/Q _13341_/Q _08301_/S _11033_/S1 VPWR
+ VGND sg13cmos5l_mux4_1
XFILLER_76_111 VPWR VGND sg13cmos5l_fill_2
X_13747__1644 _13747_/RESET_B VPWR VGND sg13cmos5l_tiehi
X_12984_ _14480_/D _12984_/A _12985_/C VPWR VGND sg13cmos5l_xor2_1
X_11935_ _11937_/B _13920_/Q _11939_/B VPWR VGND sg13cmos5l_nand2_1
X_13435__1987 _13435_/RESET_B VPWR VGND sg13cmos5l_tiehi
XFILLER_45_597 VPWR VGND sg13cmos5l_decap_8
X_14654_ _14654_/Q _14654_/CLK _14654_/D _14654_/RESET_B VPWR VGND sg13cmos5l_dfrbpq_1
X_11866_ _11866_/Y _11856_/Y _11866_/B VPWR VGND sg13cmos5l_nand2b_1
X_13605_ _13605_/Q clkload64/A _13605_/D _13605_/RESET_B VPWR VGND sg13cmos5l_dfrbpq_1
XFILLER_32_258 VPWR VGND sg13cmos5l_fill_2
X_10817_ _14168_/D _10871_/A _10974_/A _10817_/C VPWR VGND sg13cmos5l_nor3_1
X_11797_ _11798_/B _14350_/Q _13235_/Q _11983_/A VPWR VGND sg13cmos5l_a21oi_1
X_14585_ _14585_/Q clkload36/A _14585_/D _14585_/RESET_B VPWR VGND sg13cmos5l_dfrbpq_1
XFILLER_9_421 VPWR VGND sg13cmos5l_fill_1
X_10748_ _10748_/Y _10748_/A _10796_/B VPWR VGND sg13cmos5l_nand2_1
X_13536_ _13536_/Q clkload32/A _13536_/D _13536_/RESET_B VPWR VGND sg13cmos5l_dfrbpq_1
X_13467_ _13467_/Q clkload29/A _13467_/D _13467_/RESET_B VPWR VGND sg13cmos5l_dfrbpq_1
X_10679_ _14099_/D input2/X _10679_/A1 _10685_/S VPWR VGND sg13cmos5l_mux2_1
X_12418_ _12418_/Y _07846_/X _12416_/Y _12417_/Y _11672_/A _11624_/B VPWR VGND sg13cmos5l_a221oi_1
X_13995__1396 _13995_/RESET_B VPWR VGND sg13cmos5l_tiehi
X_13398_ _13398_/Q clkload27/A _13398_/D _13398_/RESET_B VPWR VGND sg13cmos5l_dfrbpq_1
X_12349_ _12349_/Y _13614_/Q _12349_/A2 _12349_/B1 _13678_/Q _12349_/C1 VPWR VGND
+ sg13cmos5l_a221oi_1
XFILLER_87_409 VPWR VGND sg13cmos5l_fill_1
XFILLER_96_932 VPWR VGND sg13cmos5l_decap_8
X_14019_ _14019_/Q clkload57/A _14019_/D _14019_/RESET_B VPWR VGND sg13cmos5l_dfrbpq_1
XFILLER_95_431 VPWR VGND sg13cmos5l_decap_8
X_07890_ _07897_/A _07890_/A _07890_/B _07890_/C VPWR VGND sg13cmos5l_nand3_1
XFILLER_95_464 VPWR VGND sg13cmos5l_decap_8
X_09560_ _11308_/B _14418_/Q _14637_/Q _09560_/S VPWR VGND sg13cmos5l_mux2_1
XFILLER_24_704 VPWR VGND sg13cmos5l_fill_1
X_08511_ _08511_/Y _07752_/Y _08510_/Y _08498_/A VPWR VGND sg13cmos5l_o21ai_1
X_09491_ _09491_/X _09509_/A _09491_/B VPWR VGND sg13cmos5l_and2_1
XFILLER_24_737 VPWR VGND sg13cmos5l_fill_2
XFILLER_36_575 VPWR VGND sg13cmos5l_fill_2
X_08442_ _14617_/D _07354_/B _13197_/A2 _08440_/Y _08441_/Y VPWR VGND sg13cmos5l_a22oi_1
XFILLER_17_1001 VPWR VGND sg13cmos5l_fill_1
XFILLER_51_578 VPWR VGND sg13cmos5l_fill_1
X_08373_ _08373_/Y _08411_/A _08373_/B VPWR VGND sg13cmos5l_nor2_1
XFILLER_32_792 VPWR VGND sg13cmos5l_fill_1
X_07324_ _07324_/Y _07324_/A VPWR VGND sg13cmos5l_inv_1
X_07255_ _07255_/Y _11466_/A VPWR VGND sg13cmos5l_inv_1
X_07186_ _07186_/Y _07186_/A VPWR VGND sg13cmos5l_inv_1
X_13825__1566 _13825_/RESET_B VPWR VGND sg13cmos5l_tiehi
XFILLER_87_921 VPWR VGND sg13cmos5l_fill_2
XFILLER_87_932 VPWR VGND sg13cmos5l_fill_1
Xfanout422 _10610_/B _10604_/B VPWR VGND sg13cmos5l_buf_1
Xfanout411 _11111_/B fanout414/X VPWR VGND sg13cmos5l_buf_1
Xfanout400 _10941_/B _10934_/B VPWR VGND sg13cmos5l_buf_1
XFILLER_86_431 VPWR VGND sg13cmos5l_fill_2
Xfanout466 _11725_/B _08653_/Y VPWR VGND sg13cmos5l_buf_1
Xfanout455 _12005_/B fanout465/X VPWR VGND sg13cmos5l_buf_1
Xfanout444 _10478_/B fanout445/X VPWR VGND sg13cmos5l_buf_1
Xfanout433 _10535_/B _10545_/B VPWR VGND sg13cmos5l_buf_1
XFILLER_58_144 VPWR VGND sg13cmos5l_fill_2
X_09827_ _09827_/Y _09827_/A _09827_/B VPWR VGND sg13cmos5l_nor2_1
Xfanout499 _12349_/A2 fanout505/X VPWR VGND sg13cmos5l_buf_1
Xfanout488 _11805_/A2 _11811_/B1 VPWR VGND sg13cmos5l_buf_1
Xfanout477 _12344_/B fanout484/X VPWR VGND sg13cmos5l_buf_1
XFILLER_39_380 VPWR VGND sg13cmos5l_fill_2
XFILLER_86_497 VPWR VGND sg13cmos5l_fill_2
X_09758_ _09758_/Y _09758_/A _09758_/B VPWR VGND sg13cmos5l_nor2_1
X_14185__1292 _14185_/RESET_B VPWR VGND sg13cmos5l_tiehi
XFILLER_104_64 VPWR VGND sg13cmos5l_fill_1
X_08709_ _08709_/Y _08748_/B1 _08707_/X _08708_/X _08738_/A2 VPWR VGND sg13cmos5l_a22oi_1
XFILLER_42_512 VPWR VGND sg13cmos5l_decap_8
X_09689_ _11605_/B _14437_/Q _14656_/Q _09689_/S VPWR VGND sg13cmos5l_mux2_1
X_11720_ _11720_/Y _14008_/Q _08652_/A _11780_/B VPWR VGND sg13cmos5l_o21ai_1
XFILLER_54_394 VPWR VGND sg13cmos5l_fill_1
X_11651_ _11651_/Y _11671_/A _11868_/A2 _11816_/B1 _11628_/Y VPWR VGND sg13cmos5l_a22oi_1
XFILLER_80_45 VPWR VGND sg13cmos5l_fill_1
X_10602_ _10602_/Y _10602_/A _10602_/B VPWR VGND sg13cmos5l_nand2_1
X_11582_ _11608_/A _11598_/A _11587_/B VPWR VGND sg13cmos5l_xnor2_1
Xfanout73 fanout73/X _09672_/Y VPWR VGND sg13cmos5l_buf_1
Xfanout62 fanout62/X _09679_/Y VPWR VGND sg13cmos5l_buf_1
X_14370_ _14370_/Q _14654_/CLK _14370_/D _14370_/RESET_B VPWR VGND sg13cmos5l_dfrbpq_1
X_10533_ _10533_/Y _10533_/A _10535_/B VPWR VGND sg13cmos5l_nand2_1
Xfanout95 _09268_/S _09267_/S VPWR VGND sg13cmos5l_buf_1
Xfanout84 _09341_/S _09340_/S VPWR VGND sg13cmos5l_buf_1
X_13321_ _13321_/Q clkload81/A _13321_/D _13321_/RESET_B VPWR VGND sg13cmos5l_dfrbpq_1
X_10464_ _10464_/Y _10464_/A _10464_/B VPWR VGND sg13cmos5l_nor2_1
X_13252_ _13252_/Q clkload80/A _13252_/D _13252_/RESET_B VPWR VGND sg13cmos5l_dfrbpq_1
X_10395_ _13959_/D _10395_/A1 _10402_/B _10394_/Y VPWR VGND sg13cmos5l_a21oi_1
X_12203_ _12203_/Y _13993_/Q _12203_/A2 _12203_/B1 VPWR VGND sg13cmos5l_o21ai_1
X_13183_ _13183_/Y _10978_/B _14250_/Q _14177_/Q _11192_/A _13184_/A2 VPWR VGND sg13cmos5l_a221oi_1
X_12134_ _12135_/A _12134_/A _12134_/B VPWR VGND sg13cmos5l_nand2_1
XFILLER_77_420 VPWR VGND sg13cmos5l_fill_1
X_12065_ _12065_/Y _13860_/Q _12234_/B VPWR VGND sg13cmos5l_nand2_1
X_14312__1196 _14312_/RESET_B VPWR VGND sg13cmos5l_tiehi
XFILLER_93_913 VPWR VGND sg13cmos5l_decap_8
X_11016_ _11019_/C _14568_/Q _11016_/B VPWR VGND sg13cmos5l_and2_1
XFILLER_92_423 VPWR VGND sg13cmos5l_decap_8
XFILLER_92_434 VPWR VGND sg13cmos5l_fill_1
XFILLER_18_553 VPWR VGND sg13cmos5l_fill_1
XFILLER_80_607 VPWR VGND sg13cmos5l_decap_8
X_12967_ _12967_/Y _14470_/Q _12967_/B VPWR VGND sg13cmos5l_xnor2_1
XFILLER_18_597 VPWR VGND sg13cmos5l_fill_2
XFILLER_45_394 VPWR VGND sg13cmos5l_fill_1
XFILLER_61_843 VPWR VGND sg13cmos5l_decap_8
X_11918_ _11918_/Y _11912_/Y _11913_/Y _11948_/B2 VPWR VGND sg13cmos5l_a21oi_1
X_13903__1488 _13903_/RESET_B VPWR VGND sg13cmos5l_tiehi
X_12898_ _12898_/Y _11161_/B _12635_/Y _12654_/B VPWR VGND sg13cmos5l_o21ai_1
XFILLER_61_887 VPWR VGND sg13cmos5l_fill_2
X_11849_ _11851_/B _11873_/A _11849_/B _11982_/B VPWR VGND sg13cmos5l_nand3_1
X_14637_ _14637_/Q clkload70/A _14637_/D _14637_/RESET_B VPWR VGND sg13cmos5l_dfrbpq_1
XFILLER_60_386 VPWR VGND sg13cmos5l_decap_4
X_14568_ _14568_/Q clkload45/A _14568_/D _14568_/RESET_B VPWR VGND sg13cmos5l_dfrbpq_1
Xclkload10 clkload10/X clkload10/A VPWR VGND sg13cmos5l_buf_8
X_14499_ _14499_/Q clkload15/A _14499_/D fanout978/X VPWR VGND sg13cmos5l_dfrbpq_1
X_13519_ _13519_/Q clkload33/A _13519_/D _13519_/RESET_B VPWR VGND sg13cmos5l_dfrbpq_1
Xclkload43 clkload43/Y clkload43/A VPWR VGND sg13cmos5l_inv_2
Xclkload32 clkload32/X clkload32/A VPWR VGND sg13cmos5l_buf_8
Xclkload21 clkload21/X clkload21/A VPWR VGND sg13cmos5l_buf_8
Xclkload76 clkload76/X clkload76/A VPWR VGND sg13cmos5l_buf_8
Xclkload65 clkload65/Y clkload65/A VPWR VGND sg13cmos5l_inv_2
Xclkload54 clkload54/Y clkload54/A VPWR VGND sg13cmos5l_inv_4
XFILLER_48_0 VPWR VGND sg13cmos5l_fill_1
XFILLER_5_490 VPWR VGND sg13cmos5l_decap_4
Xhold3506 hold3506/X _14096_/Q VPWR VGND sg13cmos5l_dlygate4sd3_1
XFILLER_87_217 VPWR VGND sg13cmos5l_fill_1
X_08991_ _08991_/Y _13297_/Q _08996_/B _08990_/Y VPWR VGND sg13cmos5l_a21oi_1
Xhold2805 _11077_/A _14287_/Q VPWR VGND sg13cmos5l_dlygate4sd3_1
Xhold3539 _10963_/B _14211_/Q VPWR VGND sg13cmos5l_dlygate4sd3_1
Xhold3528 hold3528/X _14540_/Q VPWR VGND sg13cmos5l_dlygate4sd3_1
Xhold3517 _07183_/A _14308_/Q VPWR VGND sg13cmos5l_dlygate4sd3_1
XFILLER_69_954 VPWR VGND sg13cmos5l_decap_4
X_07942_ _07942_/Y _11014_/B _07947_/A _08000_/C _07942_/D VPWR VGND sg13cmos5l_nand4_1
Xhold2816 _10963_/C _14210_/Q VPWR VGND sg13cmos5l_dlygate4sd3_1
Xhold2827 _10175_/A _13851_/Q VPWR VGND sg13cmos5l_dlygate4sd3_1
Xhold2838 _09119_/A _13316_/Q VPWR VGND sg13cmos5l_dlygate4sd3_1
X_14452__1052 _14452_/RESET_B VPWR VGND sg13cmos5l_tiehi
X_07873_ _10416_/A _14567_/Q _11011_/A VPWR VGND sg13cmos5l_nand2_1
Xhold2849 _09101_/A _13313_/Q VPWR VGND sg13cmos5l_dlygate4sd3_1
X_09612_ _09612_/Y _09639_/A _09612_/B VPWR VGND sg13cmos5l_nor2_1
XFILLER_55_147 VPWR VGND sg13cmos5l_fill_1
X_09543_ _09543_/Y _09556_/A _11263_/B _09540_/X _09542_/Y VPWR VGND sg13cmos5l_a22oi_1
X_14459__1039 _14459_/RESET_B VPWR VGND sg13cmos5l_tiehi
XFILLER_52_821 VPWR VGND sg13cmos5l_decap_8
XFILLER_64_681 VPWR VGND sg13cmos5l_fill_1
XFILLER_24_523 VPWR VGND sg13cmos5l_decap_8
X_09474_ _09474_/X _14129_/Q hold3239/X _09474_/S VPWR VGND sg13cmos5l_mux2_1
XFILLER_24_578 VPWR VGND sg13cmos5l_fill_2
X_08425_ _08435_/B _11011_/A _11149_/B _08436_/B VPWR VGND sg13cmos5l_nand3_1
X_08356_ _08356_/Y _09230_/A _08409_/B _08356_/C VPWR VGND sg13cmos5l_nand3_1
X_07307_ _07307_/Y _13350_/Q VPWR VGND sg13cmos5l_inv_1
Xclkload4 clkload4/X clkload4/A VPWR VGND sg13cmos5l_buf_8
X_08287_ _08287_/X _08288_/S _13447_/Q VPWR VGND sg13cmos5l_or2_1
X_07238_ _07238_/Y _11765_/A VPWR VGND sg13cmos5l_inv_1
X_07169_ _09589_/A _14453_/Q VPWR VGND sg13cmos5l_inv_1
XFILLER_106_845 VPWR VGND sg13cmos5l_decap_8
XFILLER_106_856 VPWR VGND sg13cmos5l_fill_1
X_10180_ _13853_/D _10375_/A1 _10185_/B _10179_/Y VPWR VGND sg13cmos5l_a21oi_1
XFILLER_59_420 VPWR VGND sg13cmos5l_fill_2
Xfanout241 _10367_/A1 _09529_/Y VPWR VGND sg13cmos5l_buf_1
Xfanout230 _10013_/B _10023_/B VPWR VGND sg13cmos5l_buf_1
XFILLER_47_604 VPWR VGND sg13cmos5l_decap_4
Xfanout274 _10248_/B _10221_/Y VPWR VGND sg13cmos5l_buf_1
Xfanout263 _10343_/B _10319_/B VPWR VGND sg13cmos5l_buf_1
Xfanout252 _10408_/B _10384_/B VPWR VGND sg13cmos5l_buf_1
XFILLER_101_572 VPWR VGND sg13cmos5l_fill_1
Xfanout296 _09952_/B _09956_/B VPWR VGND sg13cmos5l_buf_1
Xfanout285 _10209_/B _10217_/B VPWR VGND sg13cmos5l_buf_1
X_13870_ _13870_/Q clkload56/A _13870_/D _13870_/RESET_B VPWR VGND sg13cmos5l_dfrbpq_1
X_12821_ _14429_/D _12818_/Y _12820_/Y _12893_/B1 VPWR VGND sg13cmos5l_a21oi_1
XFILLER_34_309 VPWR VGND sg13cmos5l_fill_2
XFILLER_15_523 VPWR VGND sg13cmos5l_decap_8
X_12752_ _12753_/A _11092_/A _12553_/Y _12739_/A VPWR VGND sg13cmos5l_a21oi_1
X_11703_ _11703_/Y _13879_/Q _11697_/B _11725_/B VPWR VGND sg13cmos5l_a21oi_1
X_12683_ _12684_/B _11150_/X _12570_/X _12571_/X _11157_/A VPWR VGND sg13cmos5l_a22oi_1
X_11634_ _14342_/D _11708_/A _11632_/Y _11633_/Y VPWR VGND sg13cmos5l_o21ai_1
X_14422_ _14422_/Q clkload77/A _14422_/D _14422_/RESET_B VPWR VGND sg13cmos5l_dfrbpq_1
X_13697__1694 _13697_/RESET_B VPWR VGND sg13cmos5l_tiehi
X_11565_ _11565_/Y _11577_/D _11565_/B VPWR VGND sg13cmos5l_xnor2_1
X_14353_ _14353_/Q clkload68/A _14353_/D _14353_/RESET_B VPWR VGND sg13cmos5l_dfrbpq_1
X_10516_ _14018_/D _10581_/A1 _10517_/B _10515_/Y VPWR VGND sg13cmos5l_o21ai_1
X_11496_ _14333_/D _11494_/Y _11495_/Y _11481_/Y VPWR VGND sg13cmos5l_o21ai_1
X_14284_ _14284_/Q _14299_/CLK _14284_/D _14284_/RESET_B VPWR VGND sg13cmos5l_dfrbpq_1
X_13304_ _13304_/Q _14621_/CLK _13304_/D _13304_/RESET_B VPWR VGND sg13cmos5l_dfrbpq_1
X_10447_ _13984_/D _10577_/A1 _10446_/B _10446_/Y VPWR VGND sg13cmos5l_a21oi_1
X_13235_ _13235_/Q clkload71/A _13235_/D _13235_/RESET_B VPWR VGND sg13cmos5l_dfrbpq_1
XFILLER_69_217 VPWR VGND sg13cmos5l_fill_1
XFILLER_97_526 VPWR VGND sg13cmos5l_fill_1
X_10378_ _10378_/Y _10378_/A _10384_/B VPWR VGND sg13cmos5l_nor2_1
X_13166_ _13166_/Y _13232_/Q _13166_/B VPWR VGND sg13cmos5l_nor2_1
XFILLER_97_559 VPWR VGND sg13cmos5l_fill_1
X_12117_ _12117_/Y _13926_/Q _12319_/A2 _12195_/B _13862_/Q _12203_/A2 VPWR VGND sg13cmos5l_a221oi_1
X_13097_ _13101_/D _14528_/Q _14526_/Q _14532_/Q _13097_/D VPWR VGND sg13cmos5l_and4_1
XFILLER_66_902 VPWR VGND sg13cmos5l_fill_2
X_12048_ _12077_/B _12047_/A _12047_/C _12102_/A VPWR VGND sg13cmos5l_o21ai_1
XFILLER_65_401 VPWR VGND sg13cmos5l_fill_2
XFILLER_1_42 VPWR VGND sg13cmos5l_fill_1
XFILLER_66_957 VPWR VGND sg13cmos5l_decap_8
XFILLER_46_670 VPWR VGND sg13cmos5l_decap_8
XFILLER_81_916 VPWR VGND sg13cmos5l_decap_4
XFILLER_93_798 VPWR VGND sg13cmos5l_decap_4
X_13999_ _13999_/Q _14065_/CLK _13999_/D _13999_/RESET_B VPWR VGND sg13cmos5l_dfrbpq_1
XFILLER_46_681 VPWR VGND sg13cmos5l_fill_2
XFILLER_34_876 VPWR VGND sg13cmos5l_fill_2
XFILLER_45_191 VPWR VGND sg13cmos5l_fill_1
XFILLER_60_183 VPWR VGND sg13cmos5l_fill_2
X_08210_ _08210_/Y _08210_/A _08210_/B _08210_/C VPWR VGND sg13cmos5l_nand3_1
X_09190_ _09190_/Y _14372_/Q _09196_/A2 _09189_/Y VPWR VGND sg13cmos5l_a21oi_1
X_08141_ _08143_/C _13219_/Q _13220_/Q _08141_/C _08141_/D VPWR VGND sg13cmos5l_and4_1
X_08072_ _08072_/Y _09410_/A VPWR VGND sg13cmos5l_inv_1
XFILLER_0_419 VPWR VGND sg13cmos5l_fill_1
XFILLER_103_815 VPWR VGND sg13cmos5l_fill_1
Xhold3325 hold3325/X _13538_/Q VPWR VGND sg13cmos5l_dlygate4sd3_1
Xhold3314 _07251_/A _13259_/Q VPWR VGND sg13cmos5l_dlygate4sd3_1
Xhold3303 hold3303/X _13370_/Q VPWR VGND sg13cmos5l_dlygate4sd3_1
X_08974_ _08975_/B _08974_/A _08974_/B VPWR VGND sg13cmos5l_xnor2_1
Xhold2602 hold2602/X _14610_/Q VPWR VGND sg13cmos5l_dlygate4sd3_1
Xhold2613 _09712_/A _13625_/Q VPWR VGND sg13cmos5l_dlygate4sd3_1
Xhold3358 hold3358/X _13465_/Q VPWR VGND sg13cmos5l_dlygate4sd3_1
Xhold3347 _13464_/D _09351_/X VPWR VGND sg13cmos5l_dlygate4sd3_1
Xhold3336 hold3336/X _13484_/Q VPWR VGND sg13cmos5l_dlygate4sd3_1
X_13430__1992 _13430_/RESET_B VPWR VGND sg13cmos5l_tiehi
XFILLER_57_913 VPWR VGND sg13cmos5l_fill_1
X_07925_ _07925_/Y _14227_/Q _10817_/C _07924_/Y VPWR VGND sg13cmos5l_o21ai_1
Xhold2624 _10404_/A _13964_/Q VPWR VGND sg13cmos5l_dlygate4sd3_1
Xhold2635 _09060_/A _13306_/Q VPWR VGND sg13cmos5l_dlygate4sd3_1
Xhold2646 _09916_/A _13724_/Q VPWR VGND sg13cmos5l_dlygate4sd3_1
Xhold3369 hold3369/X _14280_/Q VPWR VGND sg13cmos5l_dlygate4sd3_1
Xhold2657 _10952_/A _14219_/Q VPWR VGND sg13cmos5l_dlygate4sd3_1
Xhold2668 _09834_/A _13684_/Q VPWR VGND sg13cmos5l_dlygate4sd3_1
Xhold2679 _10354_/A _13939_/Q VPWR VGND sg13cmos5l_dlygate4sd3_1
XFILLER_29_659 VPWR VGND sg13cmos5l_fill_1
X_07856_ _07857_/B _08000_/A _07856_/B VPWR VGND sg13cmos5l_nand2_1
XFILLER_44_607 VPWR VGND sg13cmos5l_decap_8
XFILLER_56_478 VPWR VGND sg13cmos5l_decap_4
XFILLER_72_916 VPWR VGND sg13cmos5l_fill_2
X_07787_ _08893_/A _08895_/A _08610_/A VPWR VGND sg13cmos5l_nor2b_1
XFILLER_71_448 VPWR VGND sg13cmos5l_fill_1
X_09526_ _11234_/B _14413_/Q _14632_/Q _09532_/S VPWR VGND sg13cmos5l_mux2_1
XFILLER_25_887 VPWR VGND sg13cmos5l_fill_2
X_09457_ _09457_/X _14112_/Q hold3108/X _09471_/S VPWR VGND sg13cmos5l_mux2_1
XFILLER_80_982 VPWR VGND sg13cmos5l_fill_1
X_08408_ _14272_/D hold3524/X _12621_/B _08421_/S VPWR VGND sg13cmos5l_mux2_1
X_09388_ _13500_/D _08194_/A hold3194/X _09401_/S VPWR VGND sg13cmos5l_mux2_1
X_08339_ _08339_/Y _08338_/S _07315_/Y _08339_/B1 VPWR VGND sg13cmos5l_a21oi_1
Xheichips26_loopcache_rv_2220 uio_oe[8] VPWR VGND sg13cmos5l_tiehi
X_11350_ _11351_/B _11363_/A _11350_/B VPWR VGND sg13cmos5l_nand2_1
X_10301_ _10301_/Y _10301_/A _10315_/B VPWR VGND sg13cmos5l_nor2_1
XFILLER_3_213 VPWR VGND sg13cmos5l_decap_4
X_11281_ _11331_/A _14091_/Q _11302_/C VPWR VGND sg13cmos5l_nor2_1
X_13020_ _13026_/D _14496_/Q _14497_/Q _14498_/Q _13020_/D VPWR VGND sg13cmos5l_and4_1
XFILLER_106_653 VPWR VGND sg13cmos5l_fill_2
X_10232_ _10232_/Y _10232_/A _10238_/B VPWR VGND sg13cmos5l_nor2_1
X_10163_ _10163_/Y _10163_/A _10185_/B VPWR VGND sg13cmos5l_nor2_1
Xfanout1003 _10848_/A _10865_/B VPWR VGND sg13cmos5l_buf_1
XFILLER_0_942 VPWR VGND sg13cmos5l_decap_8
XFILLER_0_997 VPWR VGND sg13cmos5l_decap_8
X_10094_ _13811_/D _10551_/A1 _10109_/B _10093_/Y VPWR VGND sg13cmos5l_o21ai_1
XFILLER_47_456 VPWR VGND sg13cmos5l_fill_1
X_13922_ _13922_/Q clkload59/A _13922_/D _13922_/RESET_B VPWR VGND sg13cmos5l_dfrbpq_1
XFILLER_47_478 VPWR VGND sg13cmos5l_fill_2
XFILLER_90_702 VPWR VGND sg13cmos5l_fill_2
X_13853_ _13853_/Q clkload47/A _13853_/D _13853_/RESET_B VPWR VGND sg13cmos5l_dfrbpq_1
X_13605__1786 _13605_/RESET_B VPWR VGND sg13cmos5l_tiehi
XFILLER_16_821 VPWR VGND sg13cmos5l_fill_2
X_12804_ _12828_/B _14459_/Q _13249_/Q VPWR VGND sg13cmos5l_xnor2_1
XFILLER_62_459 VPWR VGND sg13cmos5l_fill_1
XFILLER_90_768 VPWR VGND sg13cmos5l_fill_2
X_10996_ _10996_/Y _10978_/B _11019_/A _10983_/B VPWR VGND sg13cmos5l_a21oi_1
X_13784_ _13784_/Q _14631_/CLK _13784_/D _13784_/RESET_B VPWR VGND sg13cmos5l_dfrbpq_1
XFILLER_16_898 VPWR VGND sg13cmos5l_fill_1
XFILLER_30_301 VPWR VGND sg13cmos5l_fill_2
X_13784__1607 _13784_/RESET_B VPWR VGND sg13cmos5l_tiehi
X_12735_ _12735_/Y _12735_/A _12735_/B _12735_/C VPWR VGND sg13cmos5l_nand3_1
XFILLER_70_492 VPWR VGND sg13cmos5l_fill_1
X_13820__1571 _13820_/RESET_B VPWR VGND sg13cmos5l_tiehi
X_12666_ _12673_/C _12650_/X _12665_/Y _12643_/A VPWR VGND sg13cmos5l_o21ai_1
X_11617_ _14341_/D _11615_/Y _11616_/Y _11604_/Y VPWR VGND sg13cmos5l_o21ai_1
X_14405_ _14405_/Q clkload74/A _14405_/D _14405_/RESET_B VPWR VGND sg13cmos5l_dfrbpq_1
X_12597_ _12597_/Y _12636_/C _12595_/Y _12596_/X _12637_/C VPWR VGND sg13cmos5l_a22oi_1
X_11548_ _11549_/C _11523_/A _11523_/B _11547_/Y VPWR VGND sg13cmos5l_o21ai_1
X_14336_ _14336_/Q clkload79/A _14336_/D _14336_/RESET_B VPWR VGND sg13cmos5l_dfrbpq_1
XFILLER_7_552 VPWR VGND sg13cmos5l_fill_2
X_11479_ _11479_/Y _11466_/A _11493_/B _12955_/B2 VPWR VGND sg13cmos5l_o21ai_1
X_14267_ _14267_/Q clkload72/A _14267_/D _14267_/RESET_B VPWR VGND sg13cmos5l_dfrbpq_1
X_14198_ _14198_/Q clkload72/A _14198_/D _14198_/RESET_B VPWR VGND sg13cmos5l_dfrbpq_1
X_13218_ _13218_/Q clkload10/A _13218_/D fanout974/X VPWR VGND sg13cmos5l_dfrbpq_1
X_13149_ _13258_/D _13149_/A1 input18/X _13148_/Y VPWR VGND sg13cmos5l_a21oi_1
XFILLER_100_807 VPWR VGND sg13cmos5l_decap_4
XFILLER_39_935 VPWR VGND sg13cmos5l_fill_2
X_07710_ _08479_/A _14380_/Q _11711_/A VPWR VGND sg13cmos5l_nand2_1
XFILLER_66_765 VPWR VGND sg13cmos5l_fill_1
X_08690_ _08690_/Y _13843_/Q _08748_/B1 _08747_/B _13651_/Q _08688_/X VPWR VGND sg13cmos5l_a221oi_1
XFILLER_54_927 VPWR VGND sg13cmos5l_fill_1
XFILLER_81_702 VPWR VGND sg13cmos5l_fill_2
XFILLER_93_573 VPWR VGND sg13cmos5l_fill_2
X_07641_ _07644_/A _14403_/Q _14371_/Q VPWR VGND sg13cmos5l_nand2_1
X_07572_ _07582_/C _07570_/A _08989_/B _07571_/Y VPWR VGND sg13cmos5l_a21oi_1
XFILLER_53_459 VPWR VGND sg13cmos5l_fill_2
XFILLER_62_971 VPWR VGND sg13cmos5l_decap_8
X_09311_ _13427_/D _09445_/A0 hold3138/X _09333_/S VPWR VGND sg13cmos5l_mux2_1
XFILLER_61_470 VPWR VGND sg13cmos5l_fill_1
XFILLER_21_345 VPWR VGND sg13cmos5l_fill_2
XFILLER_61_492 VPWR VGND sg13cmos5l_fill_2
X_09242_ _13367_/D _09416_/A0 hold3147/X _09258_/S VPWR VGND sg13cmos5l_mux2_1
XFILLER_21_356 VPWR VGND sg13cmos5l_fill_2
X_09173_ _09173_/Y _09173_/A _09173_/B VPWR VGND sg13cmos5l_nor2_1
X_13448__1974 _13448_/RESET_B VPWR VGND sg13cmos5l_tiehi
X_08124_ _08138_/B _08977_/B _08141_/C VPWR VGND sg13cmos5l_nor2b_1
X_08055_ _09343_/D _08055_/A _08055_/B VPWR VGND sg13cmos5l_nor2_1
Xoutput28 uio_out[14] _15894_/X VPWR VGND sg13cmos5l_buf_1
Xoutput39 uo_out[0] _08756_/Y VPWR VGND sg13cmos5l_buf_1
Xhold3100 _10272_/A _13899_/Q VPWR VGND sg13cmos5l_dlygate4sd3_1
Xhold3111 hold3111/X _13494_/Q VPWR VGND sg13cmos5l_dlygate4sd3_1
Xhold3122 hold3122/X _13374_/Q VPWR VGND sg13cmos5l_dlygate4sd3_1
Xhold3133 hold3133/X _13397_/Q VPWR VGND sg13cmos5l_dlygate4sd3_1
Xhold2410 _14156_/D _10788_/Y VPWR VGND sg13cmos5l_dlygate4sd3_1
Xhold2421 _11247_/A _14318_/Q VPWR VGND sg13cmos5l_dlygate4sd3_1
Xhold3144 hold3144/X _13454_/Q VPWR VGND sg13cmos5l_dlygate4sd3_1
Xhold3155 hold3155/X _13572_/Q VPWR VGND sg13cmos5l_dlygate4sd3_1
Xhold3166 hold3166/X _13334_/Q VPWR VGND sg13cmos5l_dlygate4sd3_1
XFILLER_103_689 VPWR VGND sg13cmos5l_fill_2
XFILLER_76_518 VPWR VGND sg13cmos5l_fill_1
X_08957_ _08957_/Y _13290_/Q _08960_/B _08956_/Y VPWR VGND sg13cmos5l_a21oi_1
Xhold2432 _13064_/A _14517_/Q VPWR VGND sg13cmos5l_dlygate4sd3_1
Xhold2443 _10127_/A _13828_/Q VPWR VGND sg13cmos5l_dlygate4sd3_1
Xhold2454 _14144_/D _10752_/Y VPWR VGND sg13cmos5l_dlygate4sd3_1
Xhold3177 hold3177/X _13461_/Q VPWR VGND sg13cmos5l_dlygate4sd3_1
Xhold3188 _13563_/D _09453_/X VPWR VGND sg13cmos5l_dlygate4sd3_1
Xhold3199 hold3199/X _13378_/Q VPWR VGND sg13cmos5l_dlygate4sd3_1
X_13862__1529 _13862_/RESET_B VPWR VGND sg13cmos5l_tiehi
X_07908_ _07908_/Y _10848_/A _10987_/B _07944_/B _07908_/D VPWR VGND sg13cmos5l_nand4_1
X_08888_ _14650_/D hold2571/X _08900_/A2 _08887_/Y VPWR VGND sg13cmos5l_a21o_1
Xhold2465 _10846_/A _14183_/Q VPWR VGND sg13cmos5l_dlygate4sd3_1
Xhold2476 _10610_/A _14065_/Q VPWR VGND sg13cmos5l_dlygate4sd3_1
Xhold2487 _12975_/A _14475_/Q VPWR VGND sg13cmos5l_dlygate4sd3_1
Xhold2498 _11342_/A _14324_/Q VPWR VGND sg13cmos5l_dlygate4sd3_1
X_07839_ _07843_/B _07839_/A _07839_/B VPWR VGND sg13cmos5l_nor2_1
XFILLER_16_117 VPWR VGND sg13cmos5l_fill_1
XFILLER_16_128 VPWR VGND sg13cmos5l_fill_2
XFILLER_44_415 VPWR VGND sg13cmos5l_fill_2
XFILLER_71_223 VPWR VGND sg13cmos5l_fill_2
X_10850_ _10871_/C _10865_/B _14254_/Q _14255_/Q _10877_/A VPWR VGND sg13cmos5l_nand4_1
XFILLER_25_640 VPWR VGND sg13cmos5l_fill_2
XFILLER_25_651 VPWR VGND sg13cmos5l_decap_8
X_09509_ _09509_/Y _09509_/A _09509_/B VPWR VGND sg13cmos5l_nor2_1
X_10781_ _10781_/Y _14154_/Q _10781_/B VPWR VGND sg13cmos5l_nand2_1
XFILLER_13_846 VPWR VGND sg13cmos5l_fill_2
XFILLER_13_868 VPWR VGND sg13cmos5l_fill_2
XFILLER_9_806 VPWR VGND sg13cmos5l_fill_1
X_12520_ _12520_/Y _12523_/A _13251_/Q _12519_/Y VPWR VGND sg13cmos5l_o21ai_1
X_12451_ _14380_/D _12447_/S _12450_/Y _12448_/Y VPWR VGND sg13cmos5l_o21ai_1
X_11402_ _11402_/Y _11431_/A VPWR VGND sg13cmos5l_inv_1
X_14121_ _14121_/Q clkload28/A _14121_/D fanout995/X VPWR VGND sg13cmos5l_dfrbpq_1
X_12382_ _12382_/Y _12382_/A _12382_/B VPWR VGND sg13cmos5l_nand2_1
X_11333_ _11393_/A _14092_/Q _11311_/B _11328_/B _11331_/Y _11332_/Y VPWR VGND sg13cmos5l_a221oi_1
X_11264_ _11302_/B _11264_/A _11264_/B VPWR VGND sg13cmos5l_nand2_1
X_14052_ _14052_/Q clkload70/A _14052_/D _14052_/RESET_B VPWR VGND sg13cmos5l_dfrbpq_1
XFILLER_4_588 VPWR VGND sg13cmos5l_fill_1
X_10215_ _10215_/Y _10215_/A _10219_/B VPWR VGND sg13cmos5l_nor2_1
X_13003_ _13003_/Y _13003_/A _13003_/B VPWR VGND sg13cmos5l_xnor2_1
XFILLER_67_507 VPWR VGND sg13cmos5l_decap_8
X_11195_ _14313_/D _11190_/Y _11194_/Y _11184_/Y VPWR VGND sg13cmos5l_o21ai_1
X_10146_ _13837_/D fanout76/X _10146_/A2 _10145_/Y VPWR VGND sg13cmos5l_o21ai_1
X_10077_ _13803_/D _10534_/A1 _10078_/B _10076_/Y VPWR VGND sg13cmos5l_o21ai_1
X_13838__1553 _13838_/RESET_B VPWR VGND sg13cmos5l_tiehi
X_13905_ _13905_/Q clkload70/A _13905_/D _13905_/RESET_B VPWR VGND sg13cmos5l_dfrbpq_1
X_13526__1896 _13526_/RESET_B VPWR VGND sg13cmos5l_tiehi
XFILLER_48_798 VPWR VGND sg13cmos5l_fill_2
X_13836_ _13836_/Q clkload61/A _13836_/D _13836_/RESET_B VPWR VGND sg13cmos5l_dfrbpq_1
XFILLER_44_971 VPWR VGND sg13cmos5l_fill_1
XFILLER_62_267 VPWR VGND sg13cmos5l_fill_1
X_10979_ _10979_/Y _10978_/B _14195_/Q _14570_/Q VPWR VGND sg13cmos5l_o21ai_1
X_13767_ _13767_/Q _14064_/CLK _13767_/D _13767_/RESET_B VPWR VGND sg13cmos5l_dfrbpq_1
X_12718_ _14419_/D _12716_/Y _12717_/Y _12755_/A VPWR VGND sg13cmos5l_a21oi_1
XFILLER_31_665 VPWR VGND sg13cmos5l_fill_2
X_13698_ _13698_/Q clkload59/A _13698_/D _13698_/RESET_B VPWR VGND sg13cmos5l_dfrbpq_1
X_12649_ _14413_/D _12686_/A _12649_/B _12649_/C _12649_/D VPWR VGND sg13cmos5l_nand4_1
XFILLER_11_1018 VPWR VGND sg13cmos5l_fill_1
XFILLER_8_861 VPWR VGND sg13cmos5l_fill_1
XFILLER_7_85 VPWR VGND sg13cmos5l_fill_2
X_14319_ _14319_/Q clkload65/A _14319_/D _14319_/RESET_B VPWR VGND sg13cmos5l_dfrbpq_1
X_09860_ _09860_/Y _09860_/A _09862_/B VPWR VGND sg13cmos5l_nor2_1
Xfanout807 _12643_/A _12601_/A VPWR VGND sg13cmos5l_buf_1
XFILLER_30_0 VPWR VGND sg13cmos5l_fill_2
XFILLER_98_665 VPWR VGND sg13cmos5l_fill_2
Xfanout829 _11143_/A2 _11151_/B VPWR VGND sg13cmos5l_buf_1
Xfanout818 _08638_/A _08646_/A VPWR VGND sg13cmos5l_buf_1
X_08811_ _14630_/D _08811_/A VPWR VGND sg13cmos5l_inv_1
X_09791_ _09791_/Y _09791_/A _09797_/B VPWR VGND sg13cmos5l_nor2_1
XFILLER_100_659 VPWR VGND sg13cmos5l_fill_1
X_08742_ _08745_/A _13622_/Q _11809_/A2 _11753_/S VPWR VGND sg13cmos5l_a21oi_1
XFILLER_66_551 VPWR VGND sg13cmos5l_fill_2
X_08673_ _08674_/B _08673_/A _08673_/B _08673_/C _08673_/D VPWR VGND sg13cmos5l_nor4_1
XFILLER_39_798 VPWR VGND sg13cmos5l_fill_2
X_07624_ _07630_/B _13288_/Q _07625_/B VPWR VGND sg13cmos5l_nand2_1
X_14289__1219 _14289_/RESET_B VPWR VGND sg13cmos5l_tiehi
XFILLER_42_919 VPWR VGND sg13cmos5l_fill_1
X_14325__1183 _14325_/RESET_B VPWR VGND sg13cmos5l_tiehi
XFILLER_35_982 VPWR VGND sg13cmos5l_fill_1
X_07555_ _07558_/B _14558_/Q _13299_/Q VPWR VGND sg13cmos5l_xor2_1
X_07486_ _07486_/Y _07486_/A _07486_/B _07486_/C _07486_/D VPWR VGND sg13cmos5l_nand4_1
XFILLER_22_665 VPWR VGND sg13cmos5l_decap_4
X_09225_ _09225_/Y _09225_/A _09225_/B VPWR VGND sg13cmos5l_nor2_1
X_14563__2109 _14563_/RESET_B VPWR VGND sg13cmos5l_tiehi
X_09156_ _13322_/D _09161_/B _09154_/Y _09155_/Y VPWR VGND sg13cmos5l_a21oi_1
X_08107_ _08108_/C _09377_/A _08095_/Y _08111_/B _08961_/B VPWR VGND sg13cmos5l_a22oi_1
X_09087_ _09087_/Y _11322_/A _09086_/Y _09106_/A2 VPWR VGND sg13cmos5l_a21oi_1
X_13916__1475 _13916_/RESET_B VPWR VGND sg13cmos5l_tiehi
X_08038_ _08045_/C _14546_/Q _08038_/B VPWR VGND sg13cmos5l_xnor2_1
X_10000_ _13765_/D _10587_/A1 _10017_/B _09999_/Y VPWR VGND sg13cmos5l_o21ai_1
XFILLER_103_464 VPWR VGND sg13cmos5l_fill_2
XFILLER_49_507 VPWR VGND sg13cmos5l_fill_2
X_09989_ _09989_/Y _09989_/A _09989_/B VPWR VGND sg13cmos5l_nand2_1
Xhold2240 _14538_/D _13109_/Y VPWR VGND sg13cmos5l_dlygate4sd3_1
Xhold2251 _13069_/A _14520_/Q VPWR VGND sg13cmos5l_dlygate4sd3_1
Xhold2262 _10058_/A _13794_/Q VPWR VGND sg13cmos5l_dlygate4sd3_1
Xhold2273 _10044_/A _13787_/Q VPWR VGND sg13cmos5l_dlygate4sd3_1
XFILLER_92_819 VPWR VGND sg13cmos5l_fill_2
Xhold2284 _10026_/A _13778_/Q VPWR VGND sg13cmos5l_dlygate4sd3_1
Xhold2295 _10483_/A _14002_/Q VPWR VGND sg13cmos5l_dlygate4sd3_1
X_11951_ _11951_/Y _14451_/Q _12380_/B _11949_/Y _11950_/Y VPWR VGND sg13cmos5l_a22oi_1
X_10902_ _10902_/Y _10993_/B _10904_/B VPWR VGND sg13cmos5l_nand2_1
X_11882_ _11882_/Y _11878_/Y _11879_/Y _11880_/Y _11881_/Y VPWR VGND sg13cmos5l_a22oi_1
X_13403__2019 _13403_/RESET_B VPWR VGND sg13cmos5l_tiehi
XFILLER_60_727 VPWR VGND sg13cmos5l_decap_4
X_10833_ _10833_/Y _12802_/A _10865_/C VPWR VGND sg13cmos5l_nor2_1
X_13621_ _13621_/Q clkload16/A _13621_/D _13621_/RESET_B VPWR VGND sg13cmos5l_dfrbpq_1
X_10764_ _10764_/Y _10763_/B _10762_/Y _10763_/Y VPWR VGND sg13cmos5l_o21ai_1
X_13552_ _13552_/Q _14238_/CLK _13552_/D _13552_/RESET_B VPWR VGND sg13cmos5l_dfrbpq_1
X_12503_ _12503_/Y _14394_/Q _12503_/B VPWR VGND sg13cmos5l_nand2_1
X_10695_ _14115_/D input2/X hold3463/X _10709_/S VPWR VGND sg13cmos5l_mux2_1
X_13483_ _13483_/Q clkload34/A _13483_/D _13483_/RESET_B VPWR VGND sg13cmos5l_dfrbpq_1
X_12434_ _12434_/Y _11025_/A _14568_/Q _10865_/B VPWR VGND sg13cmos5l_o21ai_1
Xclkbuf_leaf_101_clk clkload11/A clkbuf_4_0_0_clk/X VPWR VGND sg13cmos5l_buf_8
X_12365_ _12368_/A _13967_/Q _12419_/A2 _12242_/B VPWR VGND sg13cmos5l_a21oi_1
X_11316_ _11316_/Y _11316_/A _11337_/A VPWR VGND sg13cmos5l_nor2_1
X_14104_ _14104_/Q _14105_/CLK _14104_/D fanout995/X VPWR VGND sg13cmos5l_dfrbpq_1
X_12296_ _12296_/Y _13932_/Q _12296_/A2 _12296_/B1 _13676_/Q VPWR VGND sg13cmos5l_a22oi_1
X_14035_ _14035_/Q clkload17/A _14035_/D _14035_/RESET_B VPWR VGND sg13cmos5l_dfrbpq_1
XFILLER_106_291 VPWR VGND sg13cmos5l_fill_1
X_11247_ _11247_/Y _11247_/A _11262_/B VPWR VGND sg13cmos5l_nand2_1
X_11178_ _11179_/B _14179_/Q _11214_/A VPWR VGND sg13cmos5l_xnor2_1
X_14088__1319 _14088_/RESET_B VPWR VGND sg13cmos5l_tiehi
XFILLER_0_580 VPWR VGND sg13cmos5l_decap_8
X_10129_ _10129_/Y _10129_/A _10147_/B VPWR VGND sg13cmos5l_nand2_1
XFILLER_76_860 VPWR VGND sg13cmos5l_fill_1
XFILLER_76_871 VPWR VGND sg13cmos5l_fill_1
XFILLER_91_874 VPWR VGND sg13cmos5l_fill_1
XFILLER_17_993 VPWR VGND sg13cmos5l_fill_2
X_13819_ _13819_/Q _14042_/CLK _13819_/D _13819_/RESET_B VPWR VGND sg13cmos5l_dfrbpq_1
X_07340_ _07340_/Y _14144_/Q VPWR VGND sg13cmos5l_inv_1
XFILLER_32_963 VPWR VGND sg13cmos5l_fill_1
XFILLER_31_484 VPWR VGND sg13cmos5l_fill_1
X_07271_ _07271_/Y _13944_/Q VPWR VGND sg13cmos5l_inv_1
X_09010_ _13285_/D hold3475/X _08979_/A _09012_/B VPWR VGND sg13cmos5l_mux2_1
XFILLER_78_0 VPWR VGND sg13cmos5l_fill_2
XFILLER_8_691 VPWR VGND sg13cmos5l_fill_1
XFILLER_104_206 VPWR VGND sg13cmos5l_fill_2
XFILLER_99_974 VPWR VGND sg13cmos5l_fill_1
X_09912_ _09912_/Y _09912_/A _09912_/B VPWR VGND sg13cmos5l_nor2_1
Xfanout615 _12949_/B2 _12961_/B2 VPWR VGND sg13cmos5l_buf_1
Xfanout604 _12322_/A1 _08639_/Y VPWR VGND sg13cmos5l_buf_1
XFILLER_59_816 VPWR VGND sg13cmos5l_decap_8
XFILLER_59_827 VPWR VGND sg13cmos5l_decap_4
X_09843_ _13688_/D _10561_/A1 _09846_/B _09842_/Y VPWR VGND sg13cmos5l_a21oi_1
Xfanout648 _11109_/B _11105_/B VPWR VGND sg13cmos5l_buf_1
Xfanout637 fanout637/X _12434_/Y VPWR VGND sg13cmos5l_buf_1
Xfanout626 _12447_/S fanout637/X VPWR VGND sg13cmos5l_buf_1
XFILLER_101_968 VPWR VGND sg13cmos5l_decap_4
Xfanout659 _10685_/S _10692_/S VPWR VGND sg13cmos5l_buf_1
X_09774_ _13654_/D _10361_/A1 _09773_/B _09773_/Y VPWR VGND sg13cmos5l_a21oi_1
XFILLER_96_1001 VPWR VGND sg13cmos5l_fill_1
X_08725_ _08727_/B _13781_/Q _08725_/B VPWR VGND sg13cmos5l_nand2_1
XFILLER_82_841 VPWR VGND sg13cmos5l_decap_8
X_08656_ _08656_/Y _08653_/B _11719_/S VPWR VGND sg13cmos5l_nand2b_1
XFILLER_54_598 VPWR VGND sg13cmos5l_decap_8
X_07607_ _07631_/A _09048_/A _07607_/B VPWR VGND sg13cmos5l_xor2_1
X_08587_ _14606_/D _08593_/A _08587_/B VPWR VGND sg13cmos5l_xnor2_1
X_07538_ _07540_/C _14540_/Q _13293_/Q VPWR VGND sg13cmos5l_xor2_1
XFILLER_22_440 VPWR VGND sg13cmos5l_fill_1
XFILLER_50_793 VPWR VGND sg13cmos5l_fill_2
X_07469_ _07470_/D _14472_/Q _07530_/B1 _07528_/B1 _14488_/Q VPWR VGND sg13cmos5l_a22oi_1
X_09208_ _13337_/D _08157_/A hold3184/X _09208_/S VPWR VGND sg13cmos5l_mux2_1
X_10480_ _10480_/Y _10480_/A _10480_/B VPWR VGND sg13cmos5l_nor2_1
X_09139_ _11471_/A _14332_/Q _09163_/B VPWR VGND sg13cmos5l_nand2_1
X_14468__1021 _14468_/RESET_B VPWR VGND sg13cmos5l_tiehi
X_12150_ _12150_/Y _14362_/Q _12164_/B VPWR VGND sg13cmos5l_nand2_1
X_11101_ _11101_/Y _11101_/A _11121_/B VPWR VGND sg13cmos5l_nor2_1
X_12081_ _12081_/Y _13989_/Q _12290_/A2 _12260_/B _13797_/Q _12297_/C1 VPWR VGND sg13cmos5l_a221oi_1
XFILLER_89_451 VPWR VGND sg13cmos5l_fill_2
X_11032_ _11032_/Y _11032_/A VPWR VGND sg13cmos5l_inv_1
XFILLER_49_337 VPWR VGND sg13cmos5l_decap_8
XFILLER_89_484 VPWR VGND sg13cmos5l_fill_2
X_12983_ _14479_/D _12985_/C _12983_/B VPWR VGND sg13cmos5l_nor2_1
XFILLER_73_863 VPWR VGND sg13cmos5l_fill_1
X_11934_ _11937_/A _13600_/Q _11944_/A1 _11934_/B1 VPWR VGND sg13cmos5l_a21oi_1
X_13306__2206 _13306_/RESET_B VPWR VGND sg13cmos5l_tiehi
X_14653_ _14653_/Q _14654_/CLK _14653_/D _14653_/RESET_B VPWR VGND sg13cmos5l_dfrbpq_1
X_11865_ _11866_/B _11865_/A _11865_/B _11865_/C VPWR VGND sg13cmos5l_nand3_1
X_13604_ _13604_/Q clkload52/A _13604_/D _13604_/RESET_B VPWR VGND sg13cmos5l_dfrbpq_1
XFILLER_60_568 VPWR VGND sg13cmos5l_decap_8
X_10816_ _10816_/Y _07330_/Y _10816_/A2 _10815_/Y VPWR VGND sg13cmos5l_a21oi_1
X_11796_ _11983_/A _14351_/Q _13236_/Q VPWR VGND sg13cmos5l_xor2_1
X_14584_ _14584_/Q clkload36/A _14584_/D _14584_/RESET_B VPWR VGND sg13cmos5l_dfrbpq_1
X_13642__1749 _13642_/RESET_B VPWR VGND sg13cmos5l_tiehi
X_10747_ _10747_/Y _10801_/A _14287_/Q VPWR VGND sg13cmos5l_nand2_1
X_13535_ _13535_/Q _13568_/CLK _13535_/D _13535_/RESET_B VPWR VGND sg13cmos5l_dfrbpq_1
XFILLER_40_281 VPWR VGND sg13cmos5l_fill_2
X_10678_ _10694_/S _14575_/Q input19/X VPWR VGND sg13cmos5l_nand2_1
X_13466_ _13466_/Q _14117_/CLK _13466_/D _13466_/RESET_B VPWR VGND sg13cmos5l_dfrbpq_1
X_12417_ _12417_/Y _12417_/A _12417_/B VPWR VGND sg13cmos5l_nor2_1
X_14022__1369 _14022_/RESET_B VPWR VGND sg13cmos5l_tiehi
X_13397_ _13397_/Q _14292_/CLK _13397_/D _13397_/RESET_B VPWR VGND sg13cmos5l_dfrbpq_1
X_12348_ _12348_/Y _13934_/Q _12348_/A2 _12344_/B _13870_/Q VPWR VGND sg13cmos5l_a22oi_1
X_12279_ _12279_/Y _14462_/Q _12302_/A2 _12258_/Y _12259_/Y _12278_/X VPWR VGND sg13cmos5l_a221oi_1
XFILLER_68_613 VPWR VGND sg13cmos5l_fill_2
XFILLER_96_922 VPWR VGND sg13cmos5l_decap_4
X_14018_ _14018_/Q clkload46/A _14018_/D _14018_/RESET_B VPWR VGND sg13cmos5l_dfrbpq_1
XFILLER_96_999 VPWR VGND sg13cmos5l_fill_2
X_08510_ _08510_/Y _08517_/B _08502_/B VPWR VGND sg13cmos5l_nor2b_1
X_09490_ _09491_/B _14407_/Q _14626_/Q _09532_/S VPWR VGND sg13cmos5l_mux2_1
XFILLER_24_727 VPWR VGND sg13cmos5l_fill_1
X_08441_ _08441_/Y _11656_/A _09065_/A2 _13197_/A2 VPWR VGND sg13cmos5l_a21oi_1
XFILLER_51_535 VPWR VGND sg13cmos5l_decap_4
X_08372_ _08372_/X _13518_/Q _13486_/Q _08416_/S VPWR VGND sg13cmos5l_mux2_1
X_07323_ _07323_/Y _13360_/Q VPWR VGND sg13cmos5l_inv_1
X_13618__1773 _13618_/RESET_B VPWR VGND sg13cmos5l_tiehi
XFILLER_104_1027 VPWR VGND sg13cmos5l_fill_2
X_07254_ _08916_/B _14226_/Q VPWR VGND sg13cmos5l_inv_1
X_07185_ _07185_/Y _07185_/A VPWR VGND sg13cmos5l_inv_1
XFILLER_105_526 VPWR VGND sg13cmos5l_fill_1
X_13485__1937 _13485_/RESET_B VPWR VGND sg13cmos5l_tiehi
XFILLER_105_559 VPWR VGND sg13cmos5l_fill_2
Xfanout423 _10608_/B _10604_/B VPWR VGND sg13cmos5l_buf_1
Xfanout412 _11147_/B fanout414/X VPWR VGND sg13cmos5l_buf_1
Xfanout401 _10932_/B _10952_/B VPWR VGND sg13cmos5l_buf_1
XFILLER_58_112 VPWR VGND sg13cmos5l_fill_1
Xfanout456 _12345_/B1 _12349_/B1 VPWR VGND sg13cmos5l_buf_1
Xfanout445 fanout445/X _10467_/A2 VPWR VGND sg13cmos5l_buf_1
Xfanout434 _10545_/B _10539_/B VPWR VGND sg13cmos5l_buf_1
XFILLER_74_605 VPWR VGND sg13cmos5l_decap_8
XFILLER_87_966 VPWR VGND sg13cmos5l_fill_1
X_09826_ _13680_/D fanout57/X _09825_/B _09825_/Y VPWR VGND sg13cmos5l_a21oi_1
Xfanout489 _11809_/A2 _11811_/B1 VPWR VGND sg13cmos5l_buf_1
Xfanout478 _12366_/B _12427_/A2 VPWR VGND sg13cmos5l_buf_1
Xfanout467 _12243_/B1 _08653_/Y VPWR VGND sg13cmos5l_buf_1
XFILLER_58_167 VPWR VGND sg13cmos5l_fill_1
XFILLER_74_627 VPWR VGND sg13cmos5l_fill_1
XFILLER_86_476 VPWR VGND sg13cmos5l_decap_8
X_09757_ _13647_/D fanout61/X _09760_/B _09756_/Y VPWR VGND sg13cmos5l_a21oi_1
XFILLER_39_392 VPWR VGND sg13cmos5l_fill_2
X_08708_ _08708_/X _13748_/Q _13716_/Q _11752_/S VPWR VGND sg13cmos5l_mux2_1
X_09688_ _13616_/D _09682_/B fanout57/X _09682_/Y VPWR VGND sg13cmos5l_a21oi_1
X_08639_ _08639_/Y _12445_/A _14176_/Q _08638_/X VPWR VGND sg13cmos5l_a21oi_1
X_13320__2102 _13320_/RESET_B VPWR VGND sg13cmos5l_tiehi
X_11650_ _11650_/X _11650_/A _11650_/B VPWR VGND sg13cmos5l_xor2_1
XFILLER_23_771 VPWR VGND sg13cmos5l_fill_2
X_10601_ _14060_/D fanout77/X _10608_/B _10600_/Y VPWR VGND sg13cmos5l_o21ai_1
X_11581_ _11610_/A _11598_/A _11587_/B VPWR VGND sg13cmos5l_nand2_1
Xfanout74 fanout74/X _09672_/Y VPWR VGND sg13cmos5l_buf_1
Xfanout63 _11708_/A _11738_/S VPWR VGND sg13cmos5l_buf_1
X_10532_ _14026_/D _10532_/A1 _10531_/B _10531_/Y VPWR VGND sg13cmos5l_o21ai_1
Xfanout96 _09267_/S _09236_/Y VPWR VGND sg13cmos5l_buf_1
Xfanout85 _09340_/S _09309_/Y VPWR VGND sg13cmos5l_buf_1
X_13320_ _13320_/Q clkload81/A _13320_/D _13320_/RESET_B VPWR VGND sg13cmos5l_dfrbpq_1
XFILLER_7_937 VPWR VGND sg13cmos5l_fill_1
XFILLER_7_959 VPWR VGND sg13cmos5l_fill_2
X_10463_ _13992_/D _10593_/A1 _10480_/B _10462_/Y VPWR VGND sg13cmos5l_a21oi_1
X_13353__2069 _13353_/RESET_B VPWR VGND sg13cmos5l_tiehi
X_13251_ _13251_/Q clkload80/A _13251_/D _13251_/RESET_B VPWR VGND sg13cmos5l_dfrbpq_1
X_10394_ _10394_/Y _10394_/A _10402_/B VPWR VGND sg13cmos5l_nor2_1
X_12202_ _12202_/Y _14025_/Q _12206_/B VPWR VGND sg13cmos5l_nor2_1
X_13182_ _13182_/Y _14226_/Q _13162_/B hold3537/X VPWR VGND sg13cmos5l_o21ai_1
X_12133_ _12136_/C _12134_/A _12133_/B _12134_/B VPWR VGND sg13cmos5l_nor3_1
XFILLER_78_900 VPWR VGND sg13cmos5l_fill_1
X_12064_ _12064_/Y _13956_/Q _12242_/B _12063_/Y VPWR VGND sg13cmos5l_o21ai_1
X_14284__1224 _14284_/RESET_B VPWR VGND sg13cmos5l_tiehi
XFILLER_77_432 VPWR VGND sg13cmos5l_decap_8
X_11015_ _14239_/D _14239_/Q _11618_/C _07864_/X VPWR VGND sg13cmos5l_a21o_1
XFILLER_93_958 VPWR VGND sg13cmos5l_decap_8
Xfanout990 fanout990/X fanout991/X VPWR VGND sg13cmos5l_buf_1
XFILLER_46_874 VPWR VGND sg13cmos5l_fill_1
XFILLER_61_800 VPWR VGND sg13cmos5l_fill_1
XFILLER_73_660 VPWR VGND sg13cmos5l_fill_1
X_12966_ _12969_/C _14470_/Q _14471_/Q VPWR VGND sg13cmos5l_nor2b_1
XFILLER_61_855 VPWR VGND sg13cmos5l_fill_1
XFILLER_72_170 VPWR VGND sg13cmos5l_fill_2
X_11917_ _11917_/Y _11917_/A _11917_/B _11917_/C VPWR VGND sg13cmos5l_nand3_1
X_13875__1516 _13875_/RESET_B VPWR VGND sg13cmos5l_tiehi
X_12897_ _12897_/Y _12897_/A _12897_/B _12897_/C VPWR VGND sg13cmos5l_nand3_1
X_11848_ _11982_/B _11848_/A _11873_/B VPWR VGND sg13cmos5l_nand2_1
X_14636_ _14636_/Q clkload68/A _14636_/D _14636_/RESET_B VPWR VGND sg13cmos5l_dfrbpq_1
X_13911__1480 _13911_/RESET_B VPWR VGND sg13cmos5l_tiehi
X_13563__1859 _13563_/RESET_B VPWR VGND sg13cmos5l_tiehi
XFILLER_13_270 VPWR VGND sg13cmos5l_fill_1
X_14567_ _14567_/Q clkload45/A _14567_/D _14567_/RESET_B VPWR VGND sg13cmos5l_dfrbpq_1
X_11779_ _11779_/Y _13594_/Q _11785_/B _11726_/B VPWR VGND sg13cmos5l_a21oi_1
X_13518_ _13518_/Q _13568_/CLK _13518_/D _13518_/RESET_B VPWR VGND sg13cmos5l_dfrbpq_1
X_14498_ _14498_/Q _14576_/CLK _14498_/D fanout976/X VPWR VGND sg13cmos5l_dfrbpq_1
Xclkload44 clkload44/Y clkload44/A VPWR VGND sg13cmos5l_inv_1
Xclkload33 clkload33/X clkload33/A VPWR VGND sg13cmos5l_buf_8
Xclkload22 clkload22/Y clkload22/A VPWR VGND sg13cmos5l_inv_1
Xclkload11 clkload11/Y clkload11/A VPWR VGND sg13cmos5l_inv_8
X_13449_ _13449_/Q clkload37/A _13449_/D _13449_/RESET_B VPWR VGND sg13cmos5l_dfrbpq_1
X_13329__2093 _13329_/RESET_B VPWR VGND sg13cmos5l_tiehi
Xclkload77 clkload77/X clkload77/A VPWR VGND sg13cmos5l_buf_8
Xclkload66 clkload66/Y clkload66/A VPWR VGND sg13cmos5l_inv_1
Xclkload55 clkload55/Y clkload55/A VPWR VGND sg13cmos5l_inv_1
XFILLER_47_1028 VPWR VGND sg13cmos5l_fill_1
Xhold3507 _09038_/A _13302_/Q VPWR VGND sg13cmos5l_dlygate4sd3_1
X_08990_ _08990_/Y _08996_/B _08990_/B VPWR VGND sg13cmos5l_nor2_1
Xhold3529 hold3529/X _14481_/Q VPWR VGND sg13cmos5l_dlygate4sd3_1
Xhold3518 _07263_/A _14087_/Q VPWR VGND sg13cmos5l_dlygate4sd3_1
X_07941_ _07942_/D _14438_/Q _10653_/A _08000_/A VPWR VGND sg13cmos5l_nand3_1
Xhold2806 _09890_/A _13712_/Q VPWR VGND sg13cmos5l_dlygate4sd3_1
Xhold2817 _14210_/D _10931_/Y VPWR VGND sg13cmos5l_dlygate4sd3_1
Xhold2828 _10464_/A _13993_/Q VPWR VGND sg13cmos5l_dlygate4sd3_1
Xhold2839 _11073_/A _14286_/Q VPWR VGND sg13cmos5l_dlygate4sd3_1
X_07872_ _07872_/Y _10981_/A _11014_/A VPWR VGND sg13cmos5l_nor2_1
XFILLER_56_627 VPWR VGND sg13cmos5l_fill_1
XFILLER_84_947 VPWR VGND sg13cmos5l_decap_4
X_09611_ _09612_/B _14456_/Q _09611_/B VPWR VGND sg13cmos5l_nor2_1
XFILLER_84_969 VPWR VGND sg13cmos5l_decap_4
X_09542_ _09542_/Y _09556_/A _09549_/B VPWR VGND sg13cmos5l_nor2_1
XFILLER_36_373 VPWR VGND sg13cmos5l_fill_2
X_09473_ _13583_/D _09304_/A hold3079/X _09474_/S VPWR VGND sg13cmos5l_mux2_1
Xclkbuf_leaf_90_clk _14299_/CLK clkload1/A VPWR VGND sg13cmos5l_buf_8
XFILLER_51_343 VPWR VGND sg13cmos5l_decap_8
X_08424_ _08436_/B _08424_/A _11029_/B VPWR VGND sg13cmos5l_nand2_1
XFILLER_52_899 VPWR VGND sg13cmos5l_fill_2
X_08355_ _14268_/D hold3532/X _12570_/B _08368_/S VPWR VGND sg13cmos5l_mux2_1
X_13539__1883 _13539_/RESET_B VPWR VGND sg13cmos5l_tiehi
X_07306_ _07306_/Y _13414_/Q VPWR VGND sg13cmos5l_inv_1
Xclkload5 clkload5/X clkload5/A VPWR VGND sg13cmos5l_buf_8
X_14362__1146 _14362_/RESET_B VPWR VGND sg13cmos5l_tiehi
X_08286_ _08286_/Y _08288_/S _13383_/Q _08285_/Y VPWR VGND sg13cmos5l_o21ai_1
X_07237_ _07237_/Y _14351_/Q VPWR VGND sg13cmos5l_inv_1
XFILLER_106_824 VPWR VGND sg13cmos5l_decap_8
X_07168_ _09616_/A _14457_/Q VPWR VGND sg13cmos5l_inv_1
X_14083__1324 _14083_/RESET_B VPWR VGND sg13cmos5l_tiehi
Xfanout231 _10023_/B _10021_/B VPWR VGND sg13cmos5l_buf_1
Xfanout220 _10086_/B _10088_/B VPWR VGND sg13cmos5l_buf_1
X_13953__1438 _13953_/RESET_B VPWR VGND sg13cmos5l_tiehi
XFILLER_87_741 VPWR VGND sg13cmos5l_fill_2
XFILLER_87_752 VPWR VGND sg13cmos5l_fill_2
Xfanout264 _10319_/B _10341_/B VPWR VGND sg13cmos5l_buf_1
Xfanout253 _10384_/B _10406_/B VPWR VGND sg13cmos5l_buf_1
Xfanout242 _10425_/A1 _10555_/A1 VPWR VGND sg13cmos5l_buf_1
X_09809_ _09809_/Y _09809_/A _09825_/B VPWR VGND sg13cmos5l_nor2_1
Xfanout297 _09948_/B _09958_/B VPWR VGND sg13cmos5l_buf_1
Xfanout286 _10217_/B _10211_/B VPWR VGND sg13cmos5l_buf_1
Xfanout275 _10278_/B _10276_/B VPWR VGND sg13cmos5l_buf_1
XFILLER_90_906 VPWR VGND sg13cmos5l_fill_2
X_12820_ _12820_/Y _12187_/A _12861_/A2 fanout59/X _12819_/X VPWR VGND sg13cmos5l_a22oi_1
XFILLER_28_863 VPWR VGND sg13cmos5l_fill_2
XFILLER_55_682 VPWR VGND sg13cmos5l_fill_2
X_12751_ _12751_/Y _12789_/A _12788_/A _12792_/A VPWR VGND sg13cmos5l_a21oi_1
XFILLER_70_641 VPWR VGND sg13cmos5l_decap_4
X_11702_ _11702_/Y _13847_/Q _11702_/B VPWR VGND sg13cmos5l_nand2_1
Xclkbuf_leaf_81_clk _14048_/CLK clkbuf_4_8_0_clk/X VPWR VGND sg13cmos5l_buf_8
X_12682_ _12686_/C _12676_/Y _12680_/Y _12681_/Y VPWR VGND sg13cmos5l_o21ai_1
XFILLER_30_538 VPWR VGND sg13cmos5l_fill_1
X_11633_ _11633_/Y _11636_/A _11708_/A VPWR VGND sg13cmos5l_nand2_1
X_14421_ _14421_/Q clkload67/A _14421_/D _14421_/RESET_B VPWR VGND sg13cmos5l_dfrbpq_1
XFILLER_7_734 VPWR VGND sg13cmos5l_fill_1
X_11564_ _11565_/B _11564_/A _11564_/B VPWR VGND sg13cmos5l_nand2_1
X_14352_ _14352_/Q clkload68/A _14352_/D _14352_/RESET_B VPWR VGND sg13cmos5l_dfrbpq_1
X_14338__1170 _14338_/RESET_B VPWR VGND sg13cmos5l_tiehi
XFILLER_6_233 VPWR VGND sg13cmos5l_fill_2
X_10515_ _10515_/Y _10515_/A _10517_/B VPWR VGND sg13cmos5l_nand2_1
X_11495_ _11495_/Y _11466_/A _11504_/B _12955_/B2 VPWR VGND sg13cmos5l_o21ai_1
X_14283_ _14283_/Q clkload25/A _14283_/D _14283_/RESET_B VPWR VGND sg13cmos5l_dfrbpq_1
X_13303_ _13303_/Q clkload26/A _13303_/D _13303_/RESET_B VPWR VGND sg13cmos5l_dfrbpq_1
X_10446_ _10446_/Y _10446_/A _10446_/B VPWR VGND sg13cmos5l_nor2_1
X_13234_ _13234_/Q clkload71/A _13234_/D _13234_/RESET_B VPWR VGND sg13cmos5l_dfrbpq_1
X_10377_ _13950_/D _10377_/A1 _10410_/B _10376_/Y VPWR VGND sg13cmos5l_a21oi_1
X_13165_ _13165_/Y _11258_/A _14086_/Q _08917_/X hold3502/X VPWR VGND sg13cmos5l_a22oi_1
X_12116_ _12116_/Y _13606_/Q _12200_/B1 _12087_/B _13670_/Q VPWR VGND sg13cmos5l_a22oi_1
X_13096_ _13097_/D _14527_/Q _14529_/Q _14530_/Q _14531_/Q VPWR VGND sg13cmos5l_and4_1
XFILLER_2_494 VPWR VGND sg13cmos5l_decap_4
X_12047_ _12049_/B _12047_/A _12102_/A _12047_/C VPWR VGND sg13cmos5l_or3_1
X_13929__1462 _13929_/RESET_B VPWR VGND sg13cmos5l_tiehi
XFILLER_1_32 VPWR VGND sg13cmos5l_decap_4
XFILLER_66_925 VPWR VGND sg13cmos5l_decap_4
XFILLER_93_711 VPWR VGND sg13cmos5l_decap_8
X_14440__1068 _14440_/RESET_B VPWR VGND sg13cmos5l_tiehi
XFILLER_34_800 VPWR VGND sg13cmos5l_fill_2
X_13998_ _13998_/Q clkload55/A _13998_/D _13998_/RESET_B VPWR VGND sg13cmos5l_dfrbpq_1
XFILLER_46_693 VPWR VGND sg13cmos5l_fill_1
XFILLER_73_490 VPWR VGND sg13cmos5l_decap_8
X_14599__2142 _14599_/RESET_B VPWR VGND sg13cmos5l_tiehi
X_12949_ _12950_/A _14462_/Q _11541_/B _11555_/C _12949_/B2 VPWR VGND sg13cmos5l_a22oi_1
XFILLER_61_663 VPWR VGND sg13cmos5l_decap_4
Xclkbuf_leaf_72_clk _14053_/CLK clkbuf_4_10_0_clk/X VPWR VGND sg13cmos5l_buf_8
X_14455__1046 _14455_/RESET_B VPWR VGND sg13cmos5l_tiehi
XFILLER_61_685 VPWR VGND sg13cmos5l_fill_2
X_14619_ _14619_/Q _14622_/CLK _14619_/D _14619_/RESET_B VPWR VGND sg13cmos5l_dfrbpq_1
X_08140_ _08140_/Y _08140_/A _08140_/B VPWR VGND sg13cmos5l_xnor2_1
X_13416__2006 _13416_/RESET_B VPWR VGND sg13cmos5l_tiehi
X_08071_ _09410_/A _08087_/B _08087_/A VPWR VGND sg13cmos5l_nor2b_1
XFILLER_103_805 VPWR VGND sg13cmos5l_fill_1
Xhold3315 hold3315/X _13263_/Q VPWR VGND sg13cmos5l_dlygate4sd3_1
Xhold3304 hold3304/X _13470_/Q VPWR VGND sg13cmos5l_dlygate4sd3_1
XFILLER_88_538 VPWR VGND sg13cmos5l_fill_2
X_08973_ _13273_/D _08977_/B _08972_/Y _08969_/Y VPWR VGND sg13cmos5l_o21ai_1
Xhold2603 _09952_/A _13742_/Q VPWR VGND sg13cmos5l_dlygate4sd3_1
Xhold3348 hold3348/X _13388_/Q VPWR VGND sg13cmos5l_dlygate4sd3_1
Xhold3337 _13040_/A _15885_/A VPWR VGND sg13cmos5l_dlygate4sd3_1
Xhold3326 hold3326/X _13331_/Q VPWR VGND sg13cmos5l_dlygate4sd3_1
X_13301__2211 _13301_/RESET_B VPWR VGND sg13cmos5l_tiehi
XFILLER_57_903 VPWR VGND sg13cmos5l_fill_1
X_07924_ _07924_/Y _14224_/Q _14579_/Q _07944_/C VPWR VGND sg13cmos5l_o21ai_1
Xhold2614 _09752_/A _13645_/Q VPWR VGND sg13cmos5l_dlygate4sd3_1
Xhold2625 _07329_/A _14166_/Q VPWR VGND sg13cmos5l_dlygate4sd3_1
Xhold2636 _10400_/A _13962_/Q VPWR VGND sg13cmos5l_dlygate4sd3_1
Xhold2647 _10303_/A _13914_/Q VPWR VGND sg13cmos5l_dlygate4sd3_1
Xhold3359 _13465_/D _09352_/X VPWR VGND sg13cmos5l_dlygate4sd3_1
Xhold2658 _09728_/A _13633_/Q VPWR VGND sg13cmos5l_dlygate4sd3_1
Xhold2669 _09866_/A _13700_/Q VPWR VGND sg13cmos5l_dlygate4sd3_1
XFILLER_56_457 VPWR VGND sg13cmos5l_decap_4
X_07855_ _07856_/B _14239_/Q _10987_/B _14572_/Q _14241_/Q VPWR VGND sg13cmos5l_a22oi_1
XFILLER_45_27 VPWR VGND sg13cmos5l_fill_2
XFILLER_72_928 VPWR VGND sg13cmos5l_decap_4
X_07786_ _08610_/A _14401_/Q _14369_/Q VPWR VGND sg13cmos5l_nand2_1
X_14416__1092 _14416_/RESET_B VPWR VGND sg13cmos5l_tiehi
X_09525_ _13592_/D _09544_/B _10496_/A1 _09524_/Y VPWR VGND sg13cmos5l_a21oi_1
X_09456_ _13566_/D _07961_/A hold3370/X _09471_/S VPWR VGND sg13cmos5l_mux2_1
Xclkbuf_leaf_63_clk _14065_/CLK clkload5/A VPWR VGND sg13cmos5l_buf_8
XFILLER_52_696 VPWR VGND sg13cmos5l_fill_1
X_08407_ _12621_/B _08405_/Y _08406_/X _08397_/Y VPWR VGND sg13cmos5l_o21ai_1
X_09387_ _13499_/D _08182_/A hold3341/X _09401_/S VPWR VGND sg13cmos5l_mux2_1
X_08338_ _08338_/X _13579_/Q _13547_/Q _08338_/S VPWR VGND sg13cmos5l_mux2_1
X_08269_ _08269_/Y _08269_/A _08397_/B _08344_/C VPWR VGND sg13cmos5l_nand3_1
Xheichips26_loopcache_rv_2221 uio_oe[9] VPWR VGND sg13cmos5l_tiehi
X_10300_ _13912_/D _10496_/A1 _10299_/B _10299_/Y VPWR VGND sg13cmos5l_a21oi_1
X_11280_ _11302_/C _09175_/B _09548_/B _09067_/Y VPWR VGND sg13cmos5l_o21ai_1
X_10231_ _13878_/D _10361_/A1 _10230_/B _10230_/Y VPWR VGND sg13cmos5l_a21oi_1
XFILLER_105_120 VPWR VGND sg13cmos5l_fill_1
XFILLER_0_921 VPWR VGND sg13cmos5l_decap_8
X_10162_ _13844_/D _10357_/A1 _10171_/B _10161_/Y VPWR VGND sg13cmos5l_a21oi_1
Xfanout1004 _10865_/B _12686_/A VPWR VGND sg13cmos5l_buf_1
X_10093_ _10093_/Y _10093_/A _10109_/B VPWR VGND sg13cmos5l_nand2_1
X_14221__1256 _14221_/RESET_B VPWR VGND sg13cmos5l_tiehi
XFILLER_102_860 VPWR VGND sg13cmos5l_decap_8
X_13921_ _13921_/Q clkload58/A _13921_/D _13921_/RESET_B VPWR VGND sg13cmos5l_dfrbpq_1
XFILLER_75_744 VPWR VGND sg13cmos5l_fill_1
XFILLER_63_906 VPWR VGND sg13cmos5l_decap_4
X_13852_ _13852_/Q clkload46/A _13852_/D _13852_/RESET_B VPWR VGND sg13cmos5l_dfrbpq_1
XFILLER_74_276 VPWR VGND sg13cmos5l_fill_1
X_13783_ _13783_/Q _14299_/CLK _13783_/D _13783_/RESET_B VPWR VGND sg13cmos5l_dfrbpq_1
X_12803_ _12817_/A _14459_/Q _13249_/Q VPWR VGND sg13cmos5l_nand2_1
XFILLER_15_354 VPWR VGND sg13cmos5l_fill_1
XFILLER_55_490 VPWR VGND sg13cmos5l_fill_1
X_10995_ _14231_/D _10989_/Y _10993_/Y _10994_/Y VPWR VGND sg13cmos5l_a21oi_1
Xclkbuf_leaf_54_clk clkload75/A clkbuf_4_14_0_clk/X VPWR VGND sg13cmos5l_buf_8
X_12734_ _12734_/Y _12731_/Y _12732_/Y _12733_/Y VPWR VGND sg13cmos5l_o21ai_1
XFILLER_35_71 VPWR VGND sg13cmos5l_fill_1
X_13480__1942 _13480_/RESET_B VPWR VGND sg13cmos5l_tiehi
X_12665_ _12665_/Y _12715_/A _12665_/B VPWR VGND sg13cmos5l_nor2_1
X_11616_ _11616_/Y _11587_/A _11611_/B _12961_/B2 VPWR VGND sg13cmos5l_o21ai_1
X_14404_ _14404_/Q clkload74/A _14404_/D _14404_/RESET_B VPWR VGND sg13cmos5l_dfrbpq_1
X_12596_ _12596_/X _12735_/A _12596_/B VPWR VGND sg13cmos5l_and2_1
X_11547_ _11547_/Y _11577_/A _11577_/B VPWR VGND sg13cmos5l_nor2_1
X_14335_ _14335_/Q clkload79/A _14335_/D _14335_/RESET_B VPWR VGND sg13cmos5l_dfrbpq_1
X_11478_ _11478_/Y _11556_/A _11474_/Y _11492_/A _11477_/Y _11615_/C1 VPWR VGND sg13cmos5l_a221oi_1
X_14266_ _14266_/Q clkload38/A _14266_/D _14266_/RESET_B VPWR VGND sg13cmos5l_dfrbpq_1
XFILLER_98_825 VPWR VGND sg13cmos5l_fill_2
X_10429_ _13975_/D _10559_/A1 _10466_/B _10428_/Y VPWR VGND sg13cmos5l_a21oi_1
X_14197_ _14197_/Q _14217_/CLK _14197_/D _14197_/RESET_B VPWR VGND sg13cmos5l_dfrbpq_1
X_13217_ _13217_/Q clkload10/A _13217_/D fanout974/X VPWR VGND sg13cmos5l_dfrbpq_1
X_13148_ _13148_/Y _13148_/A input18/X VPWR VGND sg13cmos5l_nor2_1
XFILLER_39_925 VPWR VGND sg13cmos5l_fill_1
X_13079_ _14524_/D _13079_/A _13080_/C VPWR VGND sg13cmos5l_xor2_1
XFILLER_18_2 VPWR VGND sg13cmos5l_fill_1
X_07640_ _13209_/D hold2231/X _10780_/A _07640_/B1 VPWR VGND sg13cmos5l_o21ai_1
X_13255__1009 _13255_/RESET_B VPWR VGND sg13cmos5l_tiehi
XFILLER_93_585 VPWR VGND sg13cmos5l_fill_1
X_07571_ _07571_/Y _07571_/A _08984_/B VPWR VGND sg13cmos5l_xnor2_1
X_09310_ _13426_/D _10679_/A1 hold3164/X _09333_/S VPWR VGND sg13cmos5l_mux2_1
Xclkbuf_leaf_45_clk _14217_/CLK clkload6/A VPWR VGND sg13cmos5l_buf_8
XFILLER_21_335 VPWR VGND sg13cmos5l_fill_1
X_09241_ _13366_/D _10683_/A1 hold3284/X _09258_/S VPWR VGND sg13cmos5l_mux2_1
X_09172_ _09172_/Y _14369_/Q _09178_/A2 _09171_/Y VPWR VGND sg13cmos5l_a21oi_1
X_08123_ _08123_/Y _08123_/A _08123_/B VPWR VGND sg13cmos5l_xnor2_1
X_08054_ _13110_/B _13128_/B _08095_/B _08055_/B VPWR VGND sg13cmos5l_nand3b_1
X_14573__1062 _14573_/RESET_B VPWR VGND sg13cmos5l_tiehi
X_13655__1736 _13655_/RESET_B VPWR VGND sg13cmos5l_tiehi
Xoutput29 uio_out[15] _15895_/X VPWR VGND sg13cmos5l_buf_1
Xhold3101 hold3101/X _13393_/Q VPWR VGND sg13cmos5l_dlygate4sd3_1
Xhold3112 _13494_/D _09382_/X VPWR VGND sg13cmos5l_dlygate4sd3_1
Xhold3123 _13016_/A _14496_/Q VPWR VGND sg13cmos5l_dlygate4sd3_1
XFILLER_103_668 VPWR VGND sg13cmos5l_fill_2
Xhold2400 _11358_/A _14325_/Q VPWR VGND sg13cmos5l_dlygate4sd3_1
Xhold2411 _10550_/A _14035_/Q VPWR VGND sg13cmos5l_dlygate4sd3_1
Xhold2422 _10139_/A _13834_/Q VPWR VGND sg13cmos5l_dlygate4sd3_1
Xhold3134 hold3134/X _13570_/Q VPWR VGND sg13cmos5l_dlygate4sd3_1
Xhold3145 hold3145/X _13349_/Q VPWR VGND sg13cmos5l_dlygate4sd3_1
Xhold3156 _13572_/D _09462_/X VPWR VGND sg13cmos5l_dlygate4sd3_1
Xhold3167 _09807_/A _13671_/Q VPWR VGND sg13cmos5l_dlygate4sd3_1
XFILLER_57_711 VPWR VGND sg13cmos5l_fill_1
X_08956_ _08956_/Y _08956_/A _08960_/B VPWR VGND sg13cmos5l_nor2_1
Xhold2433 _10622_/A _14067_/Q VPWR VGND sg13cmos5l_dlygate4sd3_1
Xhold2444 _13102_/A _14534_/Q VPWR VGND sg13cmos5l_dlygate4sd3_1
Xhold2455 _08151_/A _13225_/Q VPWR VGND sg13cmos5l_dlygate4sd3_1
Xhold3178 hold3178/X _13203_/Q VPWR VGND sg13cmos5l_dlygate4sd3_1
Xhold3189 hold3189/X _13382_/Q VPWR VGND sg13cmos5l_dlygate4sd3_1
X_14035__1356 _14035_/RESET_B VPWR VGND sg13cmos5l_tiehi
X_13870__1521 _13870_/RESET_B VPWR VGND sg13cmos5l_tiehi
XFILLER_29_413 VPWR VGND sg13cmos5l_fill_2
X_07907_ _07908_/D _10987_/A _11014_/B VPWR VGND sg13cmos5l_nand2b_1
X_08887_ _08887_/Y _08593_/B _08902_/A2 _08886_/Y VPWR VGND sg13cmos5l_o21ai_1
Xhold2466 _10802_/A _14161_/Q VPWR VGND sg13cmos5l_dlygate4sd3_1
Xhold2477 _10586_/A _14053_/Q VPWR VGND sg13cmos5l_dlygate4sd3_1
Xhold2488 _10727_/A _14136_/Q VPWR VGND sg13cmos5l_dlygate4sd3_1
XFILLER_17_619 VPWR VGND sg13cmos5l_fill_1
X_07838_ _07839_/B _08619_/A _08619_/B _07838_/C VPWR VGND sg13cmos5l_nand3_1
Xhold2499 _13031_/A _14503_/Q VPWR VGND sg13cmos5l_dlygate4sd3_1
XFILLER_44_427 VPWR VGND sg13cmos5l_fill_1
XFILLER_56_298 VPWR VGND sg13cmos5l_fill_1
XFILLER_72_725 VPWR VGND sg13cmos5l_fill_1
XFILLER_71_235 VPWR VGND sg13cmos5l_fill_2
XFILLER_72_769 VPWR VGND sg13cmos5l_decap_4
X_07769_ _07769_/Y _07764_/A _14359_/Q _07768_/Y VPWR VGND sg13cmos5l_a21oi_1
X_09508_ _09508_/Y _14441_/Q _12589_/A _14439_/Q VPWR VGND sg13cmos5l_nand3_1
Xclkbuf_leaf_36_clk clkload45/A clkload3/A VPWR VGND sg13cmos5l_buf_8
XFILLER_53_983 VPWR VGND sg13cmos5l_decap_8
XFILLER_80_780 VPWR VGND sg13cmos5l_decap_8
X_10780_ _10780_/Y _10780_/A _11123_/A VPWR VGND sg13cmos5l_nand2_1
XFILLER_40_622 VPWR VGND sg13cmos5l_fill_1
XFILLER_52_482 VPWR VGND sg13cmos5l_fill_1
X_09439_ _13550_/D _09302_/A hold3003/X _09442_/S VPWR VGND sg13cmos5l_mux2_1
X_12450_ _12450_/Y _12449_/A _13233_/Q _12449_/Y VPWR VGND sg13cmos5l_o21ai_1
X_11401_ _11431_/A _11401_/A _11401_/B _11401_/C _11403_/B VPWR VGND sg13cmos5l_nand4_1
X_14239__1238 _14239_/RESET_B VPWR VGND sg13cmos5l_tiehi
X_14120_ _14120_/Q clkload28/A _14120_/D fanout995/X VPWR VGND sg13cmos5l_dfrbpq_1
X_12381_ _12382_/B _14370_/Q _12405_/B VPWR VGND sg13cmos5l_nand2_1
X_11332_ _11332_/Y _07265_/Y _11352_/B _11312_/A VPWR VGND sg13cmos5l_a21oi_1
X_11263_ _11264_/B _11293_/A _11263_/B VPWR VGND sg13cmos5l_nand2_1
X_14598__2141 _14598_/RESET_B VPWR VGND sg13cmos5l_tiehi
X_14051_ _14051_/Q clkload57/A _14051_/D _14051_/RESET_B VPWR VGND sg13cmos5l_dfrbpq_1
XFILLER_97_44 VPWR VGND sg13cmos5l_fill_2
X_10214_ _13870_/D fanout73/X _10213_/B _10213_/Y VPWR VGND sg13cmos5l_a21oi_1
X_11194_ _11194_/Y _11200_/B _11192_/X _11193_/Y _10982_/Y VPWR VGND sg13cmos5l_a22oi_1
X_13002_ _13005_/C _14488_/Q _14487_/Q _14489_/Q _13002_/D VPWR VGND sg13cmos5l_and4_1
X_10145_ _10145_/Y _10145_/A _10147_/B VPWR VGND sg13cmos5l_nand2_1
XFILLER_0_773 VPWR VGND sg13cmos5l_decap_4
XFILLER_0_795 VPWR VGND sg13cmos5l_fill_1
X_10076_ _10076_/Y _10076_/A _10078_/B VPWR VGND sg13cmos5l_nand2_1
X_13498__1924 _13498_/RESET_B VPWR VGND sg13cmos5l_tiehi
XFILLER_47_265 VPWR VGND sg13cmos5l_fill_1
XFILLER_48_766 VPWR VGND sg13cmos5l_decap_4
XFILLER_75_574 VPWR VGND sg13cmos5l_decap_4
X_13904_ _13904_/Q clkload61/A _13904_/D _13904_/RESET_B VPWR VGND sg13cmos5l_dfrbpq_1
XFILLER_63_747 VPWR VGND sg13cmos5l_fill_1
XFILLER_90_533 VPWR VGND sg13cmos5l_decap_4
X_13835_ _13835_/Q _14028_/CLK _13835_/D _13835_/RESET_B VPWR VGND sg13cmos5l_dfrbpq_1
XFILLER_35_449 VPWR VGND sg13cmos5l_fill_1
Xclkbuf_leaf_27_clk clkload32/A clkload2/A VPWR VGND sg13cmos5l_buf_8
XFILLER_15_162 VPWR VGND sg13cmos5l_fill_1
X_10978_ _10980_/B _14657_/Q _10978_/B VPWR VGND sg13cmos5l_nand2b_1
X_13766_ _13766_/Q clkload56/A _13766_/D _13766_/RESET_B VPWR VGND sg13cmos5l_dfrbpq_1
X_13733__1658 _13733_/RESET_B VPWR VGND sg13cmos5l_tiehi
XFILLER_16_696 VPWR VGND sg13cmos5l_fill_1
X_13697_ _13697_/Q clkload58/A _13697_/D _13697_/RESET_B VPWR VGND sg13cmos5l_dfrbpq_1
X_12717_ _12717_/Y _14355_/Q _12164_/B _12897_/A _12713_/Y VPWR VGND sg13cmos5l_a22oi_1
XFILLER_31_655 VPWR VGND sg13cmos5l_fill_1
X_12648_ _12649_/D _12658_/B _12648_/B _12648_/C VPWR VGND sg13cmos5l_nand3b_1
X_12579_ _12579_/Y _12565_/X _12577_/X _12578_/Y VPWR VGND sg13cmos5l_a21oi_1
XFILLER_7_75 VPWR VGND sg13cmos5l_fill_1
X_14318_ _14318_/Q clkload65/A _14318_/D _14318_/RESET_B VPWR VGND sg13cmos5l_dfrbpq_1
X_14249_ _14249_/Q clkload43/A _14249_/D _14249_/RESET_B VPWR VGND sg13cmos5l_dfrbpq_1
XFILLER_98_644 VPWR VGND sg13cmos5l_fill_2
XFILLER_98_655 VPWR VGND sg13cmos5l_fill_1
X_08810_ _08811_/A _08469_/A _08819_/B _08822_/B hold3236/X _08809_/Y VPWR VGND sg13cmos5l_a221oi_1
Xfanout819 _08646_/A _11025_/A VPWR VGND sg13cmos5l_buf_1
Xfanout808 _12601_/A _14573_/Q VPWR VGND sg13cmos5l_buf_1
X_09790_ _13662_/D _10377_/A1 _09827_/B _09789_/Y VPWR VGND sg13cmos5l_a21oi_1
X_13366__2056 _13366_/RESET_B VPWR VGND sg13cmos5l_tiehi
XFILLER_38_221 VPWR VGND sg13cmos5l_fill_1
X_08741_ _08741_/Y _08737_/Y _08738_/Y _08739_/Y _08740_/Y _11788_/C1 VPWR VGND sg13cmos5l_a221oi_1
XFILLER_38_254 VPWR VGND sg13cmos5l_fill_2
XFILLER_39_777 VPWR VGND sg13cmos5l_fill_2
X_08672_ _08673_/D _13682_/Q _11727_/B VPWR VGND sg13cmos5l_nor2_1
XFILLER_26_18 VPWR VGND sg13cmos5l_fill_1
XFILLER_38_265 VPWR VGND sg13cmos5l_fill_2
XFILLER_54_714 VPWR VGND sg13cmos5l_decap_8
XFILLER_54_747 VPWR VGND sg13cmos5l_decap_4
XFILLER_81_511 VPWR VGND sg13cmos5l_decap_8
X_07623_ _07623_/Y _13030_/A _08155_/B VPWR VGND sg13cmos5l_nor2_1
X_14297__1211 _14297_/RESET_B VPWR VGND sg13cmos5l_tiehi
XFILLER_53_235 VPWR VGND sg13cmos5l_fill_1
XFILLER_54_758 VPWR VGND sg13cmos5l_decap_8
XFILLER_81_555 VPWR VGND sg13cmos5l_fill_1
Xclkbuf_leaf_18_clk _14102_/CLK clkload0/A VPWR VGND sg13cmos5l_buf_8
XFILLER_41_408 VPWR VGND sg13cmos5l_decap_8
XFILLER_41_419 VPWR VGND sg13cmos5l_decap_8
X_07554_ _07558_/A _14553_/Q _13294_/Q VPWR VGND sg13cmos5l_xor2_1
X_07485_ _07486_/D _13210_/Q _07530_/A2 _07481_/Y _14470_/Q VPWR VGND sg13cmos5l_a22oi_1
X_13709__1682 _13709_/RESET_B VPWR VGND sg13cmos5l_tiehi
X_09224_ _13352_/D _09295_/A hold3278/X _09230_/B VPWR VGND sg13cmos5l_mux2_1
X_09155_ _09155_/Y _09155_/A _09161_/B VPWR VGND sg13cmos5l_nor2_1
X_13888__1503 _13888_/RESET_B VPWR VGND sg13cmos5l_tiehi
X_08106_ _08106_/Y _08113_/A _09377_/A _13119_/B VPWR VGND sg13cmos5l_nand3_1
X_09086_ _09086_/Y _14419_/Q _11408_/A VPWR VGND sg13cmos5l_nand2_1
X_13576__1846 _13576_/RESET_B VPWR VGND sg13cmos5l_tiehi
X_08037_ _08045_/B _14543_/Q _08037_/B VPWR VGND sg13cmos5l_xnor2_1
XFILLER_104_999 VPWR VGND sg13cmos5l_decap_8
X_09988_ _13759_/D _10575_/A1 _09989_/B _09987_/Y VPWR VGND sg13cmos5l_o21ai_1
Xhold2230 _07946_/B _14566_/Q VPWR VGND sg13cmos5l_dlygate4sd3_1
XFILLER_76_349 VPWR VGND sg13cmos5l_fill_1
X_08939_ _13254_/D _07293_/Y _13188_/A2 _13192_/B1 _08938_/Y VPWR VGND sg13cmos5l_a22oi_1
Xhold2241 _10091_/A _13810_/Q VPWR VGND sg13cmos5l_dlygate4sd3_1
Xhold2252 _14520_/D _13069_/Y VPWR VGND sg13cmos5l_dlygate4sd3_1
Xhold2263 _10153_/A _13841_/Q VPWR VGND sg13cmos5l_dlygate4sd3_1
XFILLER_18_917 VPWR VGND sg13cmos5l_fill_1
X_11950_ _11950_/Y _11950_/A _12164_/C VPWR VGND sg13cmos5l_nand2_1
Xhold2274 _09967_/A _13749_/Q VPWR VGND sg13cmos5l_dlygate4sd3_1
Xhold2285 _10147_/A _13838_/Q VPWR VGND sg13cmos5l_dlygate4sd3_1
Xhold2296 _09983_/A _13757_/Q VPWR VGND sg13cmos5l_dlygate4sd3_1
XFILLER_17_405 VPWR VGND sg13cmos5l_fill_2
X_10901_ _14197_/D _10873_/Y _10897_/Y _10900_/Y VPWR VGND sg13cmos5l_o21ai_1
XFILLER_72_555 VPWR VGND sg13cmos5l_fill_2
X_11881_ _11881_/Y _14014_/Q _12366_/B _12377_/B1 _13822_/Q VPWR VGND sg13cmos5l_a22oi_1
X_13411__2011 _13411_/RESET_B VPWR VGND sg13cmos5l_tiehi
X_10832_ _14180_/D _14265_/D _14180_/Q _10832_/S VPWR VGND sg13cmos5l_mux2_1
X_13620_ _13620_/Q clkload17/A _13620_/D _13620_/RESET_B VPWR VGND sg13cmos5l_dfrbpq_1
X_10763_ _10763_/Y _10763_/A _10763_/B VPWR VGND sg13cmos5l_nand2_1
X_13551_ _13551_/Q clkload34/A _13551_/D _13551_/RESET_B VPWR VGND sg13cmos5l_dfrbpq_1
XFILLER_41_964 VPWR VGND sg13cmos5l_fill_2
X_12502_ _14393_/D _12503_/B _12501_/Y _12499_/Y VPWR VGND sg13cmos5l_o21ai_1
X_10694_ _14114_/D input8/X _08206_/A _10694_/S VPWR VGND sg13cmos5l_mux2_1
X_13482_ _13482_/Q clkload35/A _13482_/D _13482_/RESET_B VPWR VGND sg13cmos5l_dfrbpq_1
X_12433_ _14373_/D _12418_/Y _12432_/Y _12413_/Y VPWR VGND sg13cmos5l_o21ai_1
X_12364_ _12385_/B _12364_/A _12364_/B _12364_/C _12364_/D VPWR VGND sg13cmos5l_nor4_1
X_11315_ _11315_/Y _11352_/A _11352_/B VPWR VGND sg13cmos5l_nand2_1
X_14103_ _14103_/Q _14105_/CLK _14103_/D fanout995/X VPWR VGND sg13cmos5l_dfrbpq_1
X_12295_ _12295_/Y _12295_/A _12295_/B _12295_/C VPWR VGND sg13cmos5l_nand3_1
X_14375__1133 _14375_/RESET_B VPWR VGND sg13cmos5l_tiehi
X_14034_ _14034_/Q clkload53/A _14034_/D _14034_/RESET_B VPWR VGND sg13cmos5l_dfrbpq_1
X_11246_ _14317_/D _11244_/Y _11245_/Y _11233_/Y VPWR VGND sg13cmos5l_o21ai_1
X_11177_ _11189_/A _14179_/Q _11214_/A VPWR VGND sg13cmos5l_nand2_1
X_10128_ _13828_/D _10128_/A1 _10139_/B _10127_/Y VPWR VGND sg13cmos5l_o21ai_1
X_14096__1311 _14096_/RESET_B VPWR VGND sg13cmos5l_tiehi
X_10059_ _13794_/D _10581_/A1 _10072_/B _10058_/Y VPWR VGND sg13cmos5l_o21ai_1
XFILLER_75_382 VPWR VGND sg13cmos5l_fill_1
XFILLER_76_883 VPWR VGND sg13cmos5l_decap_8
XFILLER_36_747 VPWR VGND sg13cmos5l_fill_1
X_13966__1425 _13966_/RESET_B VPWR VGND sg13cmos5l_tiehi
XFILLER_51_706 VPWR VGND sg13cmos5l_decap_8
X_13818_ _13818_/Q clkload52/A _13818_/D _13818_/RESET_B VPWR VGND sg13cmos5l_dfrbpq_1
X_13749_ _13749_/Q clkload49/A _13749_/D _13749_/RESET_B VPWR VGND sg13cmos5l_dfrbpq_1
X_07270_ _07270_/Y _13231_/Q VPWR VGND sg13cmos5l_inv_1
X_09911_ _13721_/D _10563_/A1 _09910_/B _09910_/Y VPWR VGND sg13cmos5l_a21oi_1
Xclkbuf_leaf_7_clk clkload15/A clkload0/A VPWR VGND sg13cmos5l_buf_8
XFILLER_98_430 VPWR VGND sg13cmos5l_fill_1
Xfanout605 _08113_/A _08052_/Y VPWR VGND sg13cmos5l_buf_1
XFILLER_101_903 VPWR VGND sg13cmos5l_fill_1
X_09842_ _09842_/Y _09842_/A _09846_/B VPWR VGND sg13cmos5l_nor2_1
Xfanout649 _11105_/B _11093_/B VPWR VGND sg13cmos5l_buf_1
Xfanout638 _11868_/A2 _11635_/B VPWR VGND sg13cmos5l_buf_1
Xfanout627 _12441_/B1 fanout637/X VPWR VGND sg13cmos5l_buf_1
Xfanout616 _12961_/B2 _07933_/A VPWR VGND sg13cmos5l_buf_1
XFILLER_86_625 VPWR VGND sg13cmos5l_decap_4
X_09773_ _09773_/Y _09773_/A _09773_/B VPWR VGND sg13cmos5l_nor2_1
X_08724_ _08727_/A _13717_/Q _11809_/A2 _11788_/C1 VPWR VGND sg13cmos5l_a21oi_1
XFILLER_2_1017 VPWR VGND sg13cmos5l_fill_2
XFILLER_2_1028 VPWR VGND sg13cmos5l_fill_1
XFILLER_39_563 VPWR VGND sg13cmos5l_fill_1
XFILLER_82_864 VPWR VGND sg13cmos5l_decap_8
X_08655_ _08655_/Y _08655_/A _08652_/A VPWR VGND sg13cmos5l_nor2b_1
X_07606_ _07607_/B _13284_/Q _07606_/B VPWR VGND sg13cmos5l_xnor2_1
X_08586_ _08587_/B _08603_/C _07784_/A _08585_/Y VPWR VGND sg13cmos5l_a21oi_1
X_14597__2140 _14597_/RESET_B VPWR VGND sg13cmos5l_tiehi
X_07537_ _07540_/B _14543_/Q _13296_/Q VPWR VGND sg13cmos5l_xor2_1
X_07468_ _07470_/C _13211_/Q _07530_/A2 _07467_/Y _13146_/A VPWR VGND sg13cmos5l_a22oi_1
X_07399_ _07402_/B _07414_/A _07399_/B _07592_/A _07399_/D VPWR VGND sg13cmos5l_nor4_1
X_09207_ _13336_/D _10685_/A1 hold3277/X _09208_/S VPWR VGND sg13cmos5l_mux2_1
X_09138_ _13319_/D _09137_/B _09136_/Y _09137_/Y VPWR VGND sg13cmos5l_a21oi_1
X_09069_ _09069_/Y _09067_/Y _09068_/Y _09075_/B1 VPWR VGND sg13cmos5l_a21oi_1
X_11100_ _14292_/D _11099_/B _11098_/Y _11099_/Y VPWR VGND sg13cmos5l_a21oi_1
X_12080_ _12080_/Y _14053_/Q _12319_/A2 _12200_/B1 _13733_/Q VPWR VGND sg13cmos5l_a22oi_1
X_13250__1014 _13250_/RESET_B VPWR VGND sg13cmos5l_tiehi
XFILLER_104_774 VPWR VGND sg13cmos5l_fill_2
X_11031_ _11032_/A _13565_/Q _13533_/Q _13501_/Q _13469_/Q _08301_/S _11033_/S1 VPWR
+ VGND sg13cmos5l_mux4_1
XFILLER_49_316 VPWR VGND sg13cmos5l_decap_4
X_14189__1288 _14189_/RESET_B VPWR VGND sg13cmos5l_tiehi
XFILLER_58_850 VPWR VGND sg13cmos5l_decap_8
XFILLER_58_861 VPWR VGND sg13cmos5l_fill_1
XFILLER_65_809 VPWR VGND sg13cmos5l_fill_1
XFILLER_45_500 VPWR VGND sg13cmos5l_decap_4
X_12982_ _12983_/B _12980_/A _12981_/C hold2685/X VPWR VGND sg13cmos5l_a21oi_1
X_11933_ _11933_/Y _11981_/A _11930_/Y _11932_/Y VPWR VGND sg13cmos5l_o21ai_1
XFILLER_60_503 VPWR VGND sg13cmos5l_decap_8
X_11864_ _11865_/C _11864_/A _11864_/B _11864_/C VPWR VGND sg13cmos5l_nand3_1
X_14652_ _14652_/Q clkload79/A _14652_/D _14652_/RESET_B VPWR VGND sg13cmos5l_dfrbpq_1
X_10815_ _10815_/Y _14310_/Q _10759_/A _10816_/A2 VPWR VGND sg13cmos5l_a21oi_1
X_13603_ _13603_/Q clkload59/A _13603_/D _13603_/RESET_B VPWR VGND sg13cmos5l_dfrbpq_1
X_11795_ _14350_/D _07238_/Y _11870_/A _11769_/Y _11794_/Y VPWR VGND sg13cmos5l_a22oi_1
X_14583_ _14583_/Q clkload36/A _14583_/D _14583_/RESET_B VPWR VGND sg13cmos5l_dfrbpq_1
X_13650__1741 _13650_/RESET_B VPWR VGND sg13cmos5l_tiehi
XFILLER_40_260 VPWR VGND sg13cmos5l_fill_2
XFILLER_41_772 VPWR VGND sg13cmos5l_fill_2
X_10746_ _10746_/Y _10796_/B _10744_/Y _10745_/Y VPWR VGND sg13cmos5l_o21ai_1
X_13534_ _13534_/Q clkload31/A _13534_/D _13534_/RESET_B VPWR VGND sg13cmos5l_dfrbpq_1
X_10677_ _14098_/D _10751_/B _08006_/Y _10676_/Y VPWR VGND sg13cmos5l_o21ai_1
X_13465_ _13465_/Q _14621_/CLK _13465_/D _13465_/RESET_B VPWR VGND sg13cmos5l_dfrbpq_1
X_12416_ _12416_/Y _12416_/A _12416_/B VPWR VGND sg13cmos5l_xnor2_1
X_14030__1361 _14030_/RESET_B VPWR VGND sg13cmos5l_tiehi
X_13396_ _13396_/Q clkload27/A _13396_/D _13396_/RESET_B VPWR VGND sg13cmos5l_dfrbpq_1
X_12347_ _12347_/Y _12347_/A _12347_/B _12347_/C VPWR VGND sg13cmos5l_nand3_1
X_12278_ _12278_/X _12385_/A _12278_/B VPWR VGND sg13cmos5l_or2_1
X_11229_ _11229_/Y _11242_/A _11228_/Y _11193_/A VPWR VGND sg13cmos5l_o21ai_1
X_14017_ _14017_/Q clkload57/A _14017_/D _14017_/RESET_B VPWR VGND sg13cmos5l_dfrbpq_1
XFILLER_68_625 VPWR VGND sg13cmos5l_fill_2
XFILLER_56_809 VPWR VGND sg13cmos5l_fill_1
XFILLER_64_820 VPWR VGND sg13cmos5l_fill_1
XFILLER_82_116 VPWR VGND sg13cmos5l_fill_2
XFILLER_95_477 VPWR VGND sg13cmos5l_decap_8
XFILLER_95_488 VPWR VGND sg13cmos5l_fill_1
XFILLER_48_393 VPWR VGND sg13cmos5l_decap_4
XFILLER_64_853 VPWR VGND sg13cmos5l_decap_8
XFILLER_64_864 VPWR VGND sg13cmos5l_fill_1
X_08440_ _08440_/Y _09065_/A2 _08440_/B VPWR VGND sg13cmos5l_nand2b_1
X_14234__1243 _14234_/RESET_B VPWR VGND sg13cmos5l_tiehi
XFILLER_24_739 VPWR VGND sg13cmos5l_fill_1
XFILLER_90_0 VPWR VGND sg13cmos5l_fill_2
X_08371_ _08373_/B _08416_/S _13390_/Q _08370_/Y VPWR VGND sg13cmos5l_o21ai_1
XFILLER_104_1006 VPWR VGND sg13cmos5l_decap_8
X_07322_ _07322_/Y _13424_/Q VPWR VGND sg13cmos5l_inv_1
X_07253_ _07905_/B _14568_/Q VPWR VGND sg13cmos5l_inv_1
X_07184_ _07184_/Y _07184_/A VPWR VGND sg13cmos5l_inv_1
XFILLER_101_700 VPWR VGND sg13cmos5l_decap_8
Xfanout413 _11107_/B fanout414/X VPWR VGND sg13cmos5l_buf_1
Xfanout402 _10952_/B _10934_/B VPWR VGND sg13cmos5l_buf_1
XFILLER_101_711 VPWR VGND sg13cmos5l_fill_2
XFILLER_99_794 VPWR VGND sg13cmos5l_fill_1
X_09825_ _09825_/Y _09825_/A _09825_/B VPWR VGND sg13cmos5l_nor2_1
Xfanout457 _12087_/B _12349_/B1 VPWR VGND sg13cmos5l_buf_1
Xfanout446 _10467_/A2 _10417_/Y VPWR VGND sg13cmos5l_buf_1
Xfanout435 _10539_/B _10482_/Y VPWR VGND sg13cmos5l_buf_1
Xfanout424 _10604_/B _10577_/A2 VPWR VGND sg13cmos5l_buf_1
Xfanout479 _12290_/A2 _12297_/B1 VPWR VGND sg13cmos5l_buf_1
Xfanout468 _08748_/B1 _08744_/B1 VPWR VGND sg13cmos5l_buf_1
XFILLER_101_788 VPWR VGND sg13cmos5l_decap_8
X_09756_ _09756_/Y _09756_/A _09760_/B VPWR VGND sg13cmos5l_nor2_1
XFILLER_27_533 VPWR VGND sg13cmos5l_decap_8
XFILLER_39_382 VPWR VGND sg13cmos5l_fill_1
XFILLER_55_853 VPWR VGND sg13cmos5l_decap_8
X_08707_ _08707_/X _14004_/Q _13972_/Q _11752_/S VPWR VGND sg13cmos5l_mux2_1
X_09687_ _09687_/Y _09691_/A _11591_/B _09690_/B _09686_/Y VPWR VGND sg13cmos5l_a22oi_1
XFILLER_15_706 VPWR VGND sg13cmos5l_fill_2
XFILLER_54_363 VPWR VGND sg13cmos5l_fill_1
X_08638_ _08638_/X _08638_/A _14179_/Q VPWR VGND sg13cmos5l_and2_1
XFILLER_54_385 VPWR VGND sg13cmos5l_decap_8
XFILLER_70_889 VPWR VGND sg13cmos5l_fill_1
X_08569_ _14604_/D _08575_/A _08569_/B VPWR VGND sg13cmos5l_xnor2_1
XFILLER_11_934 VPWR VGND sg13cmos5l_fill_2
X_10600_ _10600_/Y _10600_/A _10608_/B VPWR VGND sg13cmos5l_nand2_1
X_11580_ _11584_/B _11580_/A _11580_/B VPWR VGND sg13cmos5l_and2_1
Xfanout64 _11870_/A _11738_/S VPWR VGND sg13cmos5l_buf_1
X_10531_ _10531_/Y _10531_/A _10531_/B VPWR VGND sg13cmos5l_nand2_1
Xfanout97 _09225_/B _09234_/S VPWR VGND sg13cmos5l_buf_1
Xfanout86 _09280_/S _09293_/B VPWR VGND sg13cmos5l_buf_1
Xfanout75 fanout75/X _09665_/Y VPWR VGND sg13cmos5l_buf_1
X_13250_ _13250_/Q clkload80/A _13250_/D _13250_/RESET_B VPWR VGND sg13cmos5l_dfrbpq_1
X_10462_ _10462_/Y _10462_/A _10478_/B VPWR VGND sg13cmos5l_nor2_1
X_12201_ _12201_/Y _12199_/Y _12200_/Y _12351_/A1 VPWR VGND sg13cmos5l_a21oi_1
X_13361__2061 _13361_/RESET_B VPWR VGND sg13cmos5l_tiehi
X_10393_ _13958_/D fanout79/X _10408_/B _10392_/Y VPWR VGND sg13cmos5l_a21oi_1
X_13181_ _13237_/D _13180_/B _13179_/Y _13180_/Y VPWR VGND sg13cmos5l_a21oi_1
X_12132_ _12136_/B _12132_/A _12220_/A VPWR VGND sg13cmos5l_nor2_1
XFILLER_96_219 VPWR VGND sg13cmos5l_fill_1
X_12063_ _12063_/Y _13924_/Q _12242_/B VPWR VGND sg13cmos5l_nand2b_1
X_11014_ _14238_/D _11014_/A _11014_/B _11014_/C VPWR VGND sg13cmos5l_nor3_1
XFILLER_65_606 VPWR VGND sg13cmos5l_fill_2
XFILLER_77_466 VPWR VGND sg13cmos5l_decap_8
X_13668__1723 _13668_/RESET_B VPWR VGND sg13cmos5l_tiehi
XFILLER_77_488 VPWR VGND sg13cmos5l_decap_8
Xfanout980 fanout980/X fanout994/X VPWR VGND sg13cmos5l_buf_1
Xfanout991 fanout991/X fanout993/X VPWR VGND sg13cmos5l_buf_1
XFILLER_58_691 VPWR VGND sg13cmos5l_fill_2
X_12965_ _14470_/D _11043_/A _14470_/Q _12965_/S VPWR VGND sg13cmos5l_mux2_1
X_11916_ _11917_/C _13887_/Q _11916_/A2 _11858_/B _13695_/Q VPWR VGND sg13cmos5l_a22oi_1
X_14048__1343 _14048_/RESET_B VPWR VGND sg13cmos5l_tiehi
X_12896_ _12897_/C _12895_/A _12895_/B _12895_/C VPWR VGND sg13cmos5l_o21ai_1
XFILLER_60_355 VPWR VGND sg13cmos5l_fill_2
XFILLER_61_889 VPWR VGND sg13cmos5l_fill_1
X_11847_ _11873_/B _14353_/Q _13238_/Q VPWR VGND sg13cmos5l_nand2_1
X_14635_ _14635_/Q clkload69/A _14635_/D _14635_/RESET_B VPWR VGND sg13cmos5l_dfrbpq_1
X_11778_ _11778_/Y _13626_/Q _12058_/B VPWR VGND sg13cmos5l_nand2_1
X_14566_ _14566_/Q clkload42/A _14566_/D _14566_/RESET_B VPWR VGND sg13cmos5l_dfrbpq_1
X_13571__1851 _13571_/RESET_B VPWR VGND sg13cmos5l_tiehi
X_10729_ _10729_/Y _10759_/A _14281_/Q VPWR VGND sg13cmos5l_nand2_1
X_13517_ _13517_/Q clkload30/A _13517_/D _13517_/RESET_B VPWR VGND sg13cmos5l_dfrbpq_1
X_14497_ _14497_/Q _14576_/CLK _14497_/D fanout976/X VPWR VGND sg13cmos5l_dfrbpq_1
Xclkload34 clkload34/Y clkload34/A VPWR VGND sg13cmos5l_inv_4
Xclkload23 clkload23/Y clkload23/A VPWR VGND sg13cmos5l_inv_1
Xclkload12 clkload12/Y clkload12/A VPWR VGND sg13cmos5l_inv_2
X_13448_ _13448_/Q clkload31/A _13448_/D _13448_/RESET_B VPWR VGND sg13cmos5l_dfrbpq_1
Xclkload78 clkload78/X clkload78/A VPWR VGND sg13cmos5l_buf_8
Xclkload67 clkload67/Y clkload67/A VPWR VGND sg13cmos5l_inv_2
Xclkload56 clkload56/Y clkload56/A VPWR VGND sg13cmos5l_inv_2
Xclkload45 clkload45/Y clkload45/A VPWR VGND sg13cmos5l_inv_2
X_13379_ _13379_/Q clkload37/A _13379_/D _13379_/RESET_B VPWR VGND sg13cmos5l_dfrbpq_1
XFILLER_69_901 VPWR VGND sg13cmos5l_fill_1
XFILLER_88_709 VPWR VGND sg13cmos5l_decap_4
X_07940_ _08000_/C _10987_/A _07940_/B VPWR VGND sg13cmos5l_nor2_1
Xhold3519 hold3519/X _14452_/Q VPWR VGND sg13cmos5l_dlygate4sd3_1
Xhold3508 _12479_/A _14388_/Q VPWR VGND sg13cmos5l_dlygate4sd3_1
XFILLER_69_934 VPWR VGND sg13cmos5l_decap_8
XFILLER_69_945 VPWR VGND sg13cmos5l_fill_1
Xhold2807 _09682_/A _13616_/Q VPWR VGND sg13cmos5l_dlygate4sd3_1
Xhold2818 _09906_/A _13719_/Q VPWR VGND sg13cmos5l_dlygate4sd3_1
Xhold2829 _10438_/A _13980_/Q VPWR VGND sg13cmos5l_dlygate4sd3_1
XFILLER_96_742 VPWR VGND sg13cmos5l_fill_2
X_07871_ _07875_/A _11715_/A _07858_/Y hold3442/X VPWR VGND sg13cmos5l_o21ai_1
XFILLER_83_425 VPWR VGND sg13cmos5l_fill_2
X_09610_ _09616_/B _14456_/Q _09611_/B VPWR VGND sg13cmos5l_nand2_1
X_09541_ _09549_/B _14446_/Q _09555_/D VPWR VGND sg13cmos5l_and2_1
XFILLER_36_330 VPWR VGND sg13cmos5l_fill_2
XFILLER_51_300 VPWR VGND sg13cmos5l_fill_2
X_09472_ _13582_/D _09302_/A hold3273/X _09475_/S VPWR VGND sg13cmos5l_mux2_1
XFILLER_52_867 VPWR VGND sg13cmos5l_fill_2
XFILLER_52_878 VPWR VGND sg13cmos5l_fill_2
X_08423_ _08423_/Y _10653_/A _14239_/Q _10987_/A VPWR VGND sg13cmos5l_nor3_1
X_08354_ _12570_/B _08352_/Y _08353_/X _08344_/Y VPWR VGND sg13cmos5l_o21ai_1
X_07305_ _07305_/Y _13349_/Q VPWR VGND sg13cmos5l_inv_1
X_08285_ _08285_/Y _08288_/S _07309_/Y _08202_/A VPWR VGND sg13cmos5l_a21oi_1
Xclkload6 clkload6/X clkload6/A VPWR VGND sg13cmos5l_buf_8
X_07236_ _07236_/Y _14383_/Q VPWR VGND sg13cmos5l_inv_1
X_13746__1645 _13746_/RESET_B VPWR VGND sg13cmos5l_tiehi
XFILLER_106_803 VPWR VGND sg13cmos5l_decap_8
XFILLER_3_418 VPWR VGND sg13cmos5l_fill_2
X_07167_ _07167_/Y _14461_/Q VPWR VGND sg13cmos5l_inv_1
X_13434__1988 _13434_/RESET_B VPWR VGND sg13cmos5l_tiehi
XFILLER_8_1001 VPWR VGND sg13cmos5l_fill_1
Xfanout232 _10021_/B fanout233/X VPWR VGND sg13cmos5l_buf_1
Xfanout221 _10088_/B fanout222/X VPWR VGND sg13cmos5l_buf_1
Xfanout210 _10153_/B _10090_/Y VPWR VGND sg13cmos5l_buf_1
X_13961__1430 _13961_/RESET_B VPWR VGND sg13cmos5l_tiehi
Xfanout265 _10345_/B _10349_/B VPWR VGND sg13cmos5l_buf_1
Xfanout254 _10410_/B _10414_/B VPWR VGND sg13cmos5l_buf_1
Xfanout243 _10555_/A1 _09503_/Y VPWR VGND sg13cmos5l_buf_1
XFILLER_47_639 VPWR VGND sg13cmos5l_decap_4
XFILLER_59_466 VPWR VGND sg13cmos5l_fill_2
XFILLER_75_926 VPWR VGND sg13cmos5l_decap_8
X_09808_ _13671_/D _10395_/A1 _09817_/B _09807_/Y VPWR VGND sg13cmos5l_a21oi_1
Xfanout298 _09958_/B _09956_/B VPWR VGND sg13cmos5l_buf_1
Xfanout287 _10219_/B _10211_/B VPWR VGND sg13cmos5l_buf_1
Xfanout276 _10276_/B _10221_/Y VPWR VGND sg13cmos5l_buf_1
XFILLER_46_116 VPWR VGND sg13cmos5l_fill_1
XFILLER_75_959 VPWR VGND sg13cmos5l_decap_8
XFILLER_86_285 VPWR VGND sg13cmos5l_fill_2
X_09739_ _13638_/D fanout79/X _09754_/B _09738_/Y VPWR VGND sg13cmos5l_a21oi_1
XFILLER_55_650 VPWR VGND sg13cmos5l_decap_8
XFILLER_90_918 VPWR VGND sg13cmos5l_fill_1
XFILLER_27_385 VPWR VGND sg13cmos5l_fill_1
X_13994__1397 _13994_/RESET_B VPWR VGND sg13cmos5l_tiehi
X_13379__2043 _13379_/RESET_B VPWR VGND sg13cmos5l_tiehi
X_12750_ _12750_/Y _12750_/A VPWR VGND sg13cmos5l_inv_1
XFILLER_15_569 VPWR VGND sg13cmos5l_fill_1
XFILLER_42_322 VPWR VGND sg13cmos5l_fill_2
XFILLER_43_856 VPWR VGND sg13cmos5l_fill_2
X_11701_ _11701_/Y _13623_/Q _11697_/B _11726_/B VPWR VGND sg13cmos5l_a21oi_1
X_12681_ _12681_/Y _12676_/Y _12680_/Y _12792_/A VPWR VGND sg13cmos5l_a21oi_1
XFILLER_42_377 VPWR VGND sg13cmos5l_decap_4
X_11632_ _11632_/Y _08676_/B _11623_/Y _11631_/Y VPWR VGND sg13cmos5l_a21oi_1
X_14420_ _14420_/Q clkload67/A _14420_/D _14420_/RESET_B VPWR VGND sg13cmos5l_dfrbpq_1
XFILLER_23_591 VPWR VGND sg13cmos5l_fill_2
X_14351_ _14351_/Q clkload68/A _14351_/D _14351_/RESET_B VPWR VGND sg13cmos5l_dfrbpq_1
XFILLER_10_230 VPWR VGND sg13cmos5l_fill_1
X_11563_ _11577_/D _11563_/A _11575_/C VPWR VGND sg13cmos5l_xnor2_1
X_13302_ _13302_/Q _14621_/CLK _13302_/D _13302_/RESET_B VPWR VGND sg13cmos5l_dfrbpq_1
X_10514_ _14017_/D _10514_/A1 _10517_/B _10513_/Y VPWR VGND sg13cmos5l_o21ai_1
X_11494_ _11494_/Y _11490_/Y _11491_/Y _11492_/Y _11614_/A _11557_/A VPWR VGND sg13cmos5l_a221oi_1
X_14282_ _14282_/Q clkload22/A _14282_/D _14282_/RESET_B VPWR VGND sg13cmos5l_dfrbpq_1
XFILLER_7_779 VPWR VGND sg13cmos5l_decap_4
X_10445_ _13983_/D _10575_/A1 _10446_/B _10444_/Y VPWR VGND sg13cmos5l_a21oi_1
X_13233_ _13233_/Q clkload72/A _13233_/D _13233_/RESET_B VPWR VGND sg13cmos5l_dfrbpq_1
X_13164_ _13231_/D _07270_/Y _13164_/A2 _13162_/Y _13163_/Y VPWR VGND sg13cmos5l_a22oi_1
X_10376_ _10376_/Y _10376_/A _10410_/B VPWR VGND sg13cmos5l_nor2_1
X_12115_ _12115_/Y _12111_/Y _12112_/Y _12113_/Y _12114_/Y VPWR VGND sg13cmos5l_a22oi_1
XFILLER_78_731 VPWR VGND sg13cmos5l_fill_1
X_13095_ _13095_/Y _13095_/A _13095_/B VPWR VGND sg13cmos5l_xnor2_1
XFILLER_49_81 VPWR VGND sg13cmos5l_fill_2
X_12046_ _12047_/C _14359_/Q _13244_/Q _12023_/C VPWR VGND sg13cmos5l_a21o_1
X_13589__1833 _13589_/RESET_B VPWR VGND sg13cmos5l_tiehi
XFILLER_93_701 VPWR VGND sg13cmos5l_fill_2
XFILLER_93_789 VPWR VGND sg13cmos5l_fill_1
X_13997_ _13997_/Q _14053_/CLK _13997_/D _13997_/RESET_B VPWR VGND sg13cmos5l_dfrbpq_1
XFILLER_18_374 VPWR VGND sg13cmos5l_fill_2
XFILLER_80_417 VPWR VGND sg13cmos5l_decap_8
X_13824__1567 _13824_/RESET_B VPWR VGND sg13cmos5l_tiehi
X_12948_ _14461_/D _12948_/A VPWR VGND sg13cmos5l_inv_1
XFILLER_61_631 VPWR VGND sg13cmos5l_decap_8
X_12879_ _12879_/X _12891_/A1 _12608_/Y _12879_/B1 VPWR VGND sg13cmos5l_a21o_1
X_14618_ _14618_/Q clkload24/A _14618_/D _14618_/RESET_B VPWR VGND sg13cmos5l_dfrbpq_1
X_14549_ _14549_/Q clkload12/A _14549_/D fanout957/X VPWR VGND sg13cmos5l_dfrbpq_1
X_08070_ _13203_/D _13127_/A _08070_/B _08070_/C VPWR VGND sg13cmos5l_nor3_1
X_14184__1293 _14184_/RESET_B VPWR VGND sg13cmos5l_tiehi
Xhold3316 hold3316/X _13518_/Q VPWR VGND sg13cmos5l_dlygate4sd3_1
Xhold3305 _13470_/D _09357_/X VPWR VGND sg13cmos5l_dlygate4sd3_1
XFILLER_103_828 VPWR VGND sg13cmos5l_decap_8
X_08972_ _08972_/Y _13293_/Q _08975_/A _08971_/Y VPWR VGND sg13cmos5l_a21oi_1
Xhold2604 hold2604/X _14537_/Q VPWR VGND sg13cmos5l_dlygate4sd3_1
Xhold3349 hold3349/X _13554_/Q VPWR VGND sg13cmos5l_dlygate4sd3_1
Xhold3338 hold3338/X _13573_/Q VPWR VGND sg13cmos5l_dlygate4sd3_1
Xhold3327 hold3327/X _15889_/A VPWR VGND sg13cmos5l_dlygate4sd3_1
X_07923_ _10817_/C _10848_/A _11019_/B VPWR VGND sg13cmos5l_nand2_1
Xhold2615 _10280_/A _13903_/Q VPWR VGND sg13cmos5l_dlygate4sd3_1
Xhold2626 _14166_/D _10814_/Y VPWR VGND sg13cmos5l_dlygate4sd3_1
Xhold2637 _13003_/A _14489_/Q VPWR VGND sg13cmos5l_dlygate4sd3_1
X_07854_ _07857_/A _10987_/A _11618_/C VPWR VGND sg13cmos5l_nand2_1
Xhold2648 _09932_/A _13732_/Q VPWR VGND sg13cmos5l_dlygate4sd3_1
Xhold2659 _10356_/A _13940_/Q VPWR VGND sg13cmos5l_dlygate4sd3_1
XFILLER_84_745 VPWR VGND sg13cmos5l_fill_2
X_14388__1120 _14388_/RESET_B VPWR VGND sg13cmos5l_tiehi
X_07785_ _08895_/A _14401_/Q _14369_/Q VPWR VGND sg13cmos5l_nor2_1
XFILLER_83_277 VPWR VGND sg13cmos5l_fill_2
X_09524_ _09524_/Y _09524_/A _09544_/B VPWR VGND sg13cmos5l_nor2_1
X_09455_ _09455_/X hold3126/X _13565_/Q _09471_/S VPWR VGND sg13cmos5l_mux2_1
XFILLER_25_889 VPWR VGND sg13cmos5l_fill_1
X_08406_ _08406_/X _08400_/Y _08401_/Y _08406_/B1 VPWR VGND sg13cmos5l_a21o_1
X_09386_ _13498_/D _08170_/A hold3363/X _09401_/S VPWR VGND sg13cmos5l_mux2_1
XFILLER_20_550 VPWR VGND sg13cmos5l_fill_1
X_08337_ _08337_/X _08338_/S _13451_/Q VPWR VGND sg13cmos5l_or2_1
X_14311__1197 _14311_/RESET_B VPWR VGND sg13cmos5l_tiehi
X_13979__1412 _13979_/RESET_B VPWR VGND sg13cmos5l_tiehi
X_08268_ _14261_/D hold3440/X _12585_/B _08368_/S VPWR VGND sg13cmos5l_mux2_1
Xheichips26_loopcache_rv_2222 uio_oe[10] VPWR VGND sg13cmos5l_tiehi
X_07219_ _07656_/A _14397_/Q VPWR VGND sg13cmos5l_inv_1
X_08199_ _08199_/Y _08199_/A1 _08194_/X _08198_/Y _11036_/C1 VPWR VGND sg13cmos5l_a22oi_1
X_10230_ _10230_/Y _10230_/A _10230_/B VPWR VGND sg13cmos5l_nor2_1
X_10161_ _10161_/Y _10161_/A _10171_/B VPWR VGND sg13cmos5l_nor2_1
X_13902__1489 _13902_/RESET_B VPWR VGND sg13cmos5l_tiehi
X_10092_ _13810_/D _10549_/A1 _10107_/B _10091_/Y VPWR VGND sg13cmos5l_o21ai_1
Xfanout1005 _12686_/A _12843_/A VPWR VGND sg13cmos5l_buf_1
XFILLER_0_977 VPWR VGND sg13cmos5l_fill_1
X_13920_ _13920_/Q _14048_/CLK _13920_/D _13920_/RESET_B VPWR VGND sg13cmos5l_dfrbpq_1
XFILLER_102_894 VPWR VGND sg13cmos5l_fill_1
XFILLER_47_447 VPWR VGND sg13cmos5l_fill_1
XFILLER_59_274 VPWR VGND sg13cmos5l_fill_2
XFILLER_75_734 VPWR VGND sg13cmos5l_fill_1
X_13851_ _13851_/Q _14042_/CLK _13851_/D _13851_/RESET_B VPWR VGND sg13cmos5l_dfrbpq_1
XFILLER_90_748 VPWR VGND sg13cmos5l_fill_2
X_10994_ _10994_/Y _14231_/Q _10989_/Y _10848_/A VPWR VGND sg13cmos5l_o21ai_1
X_13782_ _13782_/Q clkload49/A _13782_/D _13782_/RESET_B VPWR VGND sg13cmos5l_dfrbpq_1
X_12802_ _14427_/D _12802_/A _12802_/B VPWR VGND sg13cmos5l_nor2_1
XFILLER_43_642 VPWR VGND sg13cmos5l_decap_8
XFILLER_71_962 VPWR VGND sg13cmos5l_decap_4
X_12733_ _12733_/Y _12731_/Y _12732_/Y _12792_/A VPWR VGND sg13cmos5l_a21oi_1
XFILLER_71_995 VPWR VGND sg13cmos5l_fill_2
XFILLER_31_837 VPWR VGND sg13cmos5l_fill_1
X_14403_ _14403_/Q clkload74/A _14403_/D _14403_/RESET_B VPWR VGND sg13cmos5l_dfrbpq_1
X_12664_ _12665_/B _11150_/X _12559_/X _12560_/X _11157_/A VPWR VGND sg13cmos5l_a22oi_1
X_11615_ _11615_/Y _11614_/A _11607_/Y _11612_/Y _11614_/Y _11615_/C1 VPWR VGND sg13cmos5l_a221oi_1
X_12595_ _12595_/Y _12595_/A _12735_/A VPWR VGND sg13cmos5l_nor2b_1
XFILLER_11_572 VPWR VGND sg13cmos5l_fill_1
XFILLER_7_532 VPWR VGND sg13cmos5l_fill_2
X_11546_ _11580_/A _11555_/C _11553_/A _11598_/A VPWR VGND sg13cmos5l_o21ai_1
X_14334_ _14334_/Q clkload79/A _14334_/D _14334_/RESET_B VPWR VGND sg13cmos5l_dfrbpq_1
XFILLER_7_554 VPWR VGND sg13cmos5l_fill_1
X_14265_ _14265_/Q clkload40/A _14265_/D _14265_/RESET_B VPWR VGND sg13cmos5l_dfrbpq_1
X_11477_ _11477_/Y _11556_/A _11477_/B VPWR VGND sg13cmos5l_nor2_1
X_13216_ _13216_/Q clkload10/A _13216_/D fanout974/X VPWR VGND sg13cmos5l_dfrbpq_1
X_10428_ _10428_/Y _10428_/A _10466_/B VPWR VGND sg13cmos5l_nor2_1
X_14196_ _14196_/Q clkload72/A _14196_/D _14196_/RESET_B VPWR VGND sg13cmos5l_dfrbpq_1
XFILLER_3_771 VPWR VGND sg13cmos5l_decap_4
X_10359_ _13941_/D _10425_/A1 _10366_/B _10358_/Y VPWR VGND sg13cmos5l_a21oi_1
X_13147_ _13259_/D _07251_/Y input19/X _10685_/S VPWR VGND sg13cmos5l_o21ai_1
X_13078_ _14523_/D _13078_/A _13078_/B VPWR VGND sg13cmos5l_xor2_1
XFILLER_25_4 VPWR VGND sg13cmos5l_fill_1
XFILLER_39_937 VPWR VGND sg13cmos5l_fill_1
X_12029_ _12029_/Y _12025_/Y _12026_/Y _12027_/Y _12028_/Y VPWR VGND sg13cmos5l_a22oi_1
XFILLER_66_734 VPWR VGND sg13cmos5l_decap_4
XFILLER_19_650 VPWR VGND sg13cmos5l_decap_8
XFILLER_81_704 VPWR VGND sg13cmos5l_fill_1
XFILLER_93_575 VPWR VGND sg13cmos5l_fill_1
XFILLER_25_119 VPWR VGND sg13cmos5l_fill_1
XFILLER_47_992 VPWR VGND sg13cmos5l_fill_2
X_07570_ _07582_/B _07570_/A _08989_/B VPWR VGND sg13cmos5l_or2_1
XFILLER_34_620 VPWR VGND sg13cmos5l_fill_2
XFILLER_90_1019 VPWR VGND sg13cmos5l_fill_1
X_09240_ _13365_/D _09414_/A0 hold3171/X _09260_/S VPWR VGND sg13cmos5l_mux2_1
XFILLER_61_494 VPWR VGND sg13cmos5l_fill_1
XFILLER_21_358 VPWR VGND sg13cmos5l_fill_1
X_09171_ _09171_/Y _11543_/A _09170_/Y _09178_/A2 VPWR VGND sg13cmos5l_a21oi_1
X_08122_ _08141_/C _13211_/Q _13210_/Q _13212_/Q _13213_/Q VPWR VGND sg13cmos5l_and4_1
X_08053_ _08055_/B _08053_/A _08049_/B VPWR VGND sg13cmos5l_nor2b_1
Xhold3102 hold3102/X _13504_/Q VPWR VGND sg13cmos5l_dlygate4sd3_1
Xhold3113 hold3113/X _13380_/Q VPWR VGND sg13cmos5l_dlygate4sd3_1
Xhold3124 hold3124/X _13384_/Q VPWR VGND sg13cmos5l_dlygate4sd3_1
X_08955_ _13269_/D _08038_/B hold3428/X _10799_/B VPWR VGND sg13cmos5l_mux2_1
Xhold2401 _10056_/A _13793_/Q VPWR VGND sg13cmos5l_dlygate4sd3_1
Xhold2412 _10739_/A _14140_/Q VPWR VGND sg13cmos5l_dlygate4sd3_1
Xhold3135 hold3135/X _13421_/Q VPWR VGND sg13cmos5l_dlygate4sd3_1
Xhold3146 hold3146/X _13513_/Q VPWR VGND sg13cmos5l_dlygate4sd3_1
Xhold3157 hold3157/X _13455_/Q VPWR VGND sg13cmos5l_dlygate4sd3_1
XFILLER_29_403 VPWR VGND sg13cmos5l_decap_4
XFILLER_76_509 VPWR VGND sg13cmos5l_decap_8
X_07906_ _07930_/B _07944_/B _07944_/C VPWR VGND sg13cmos5l_nand2_1
Xhold2423 _10141_/A _13835_/Q VPWR VGND sg13cmos5l_dlygate4sd3_1
Xhold2434 _14067_/D _10622_/Y VPWR VGND sg13cmos5l_dlygate4sd3_1
Xhold2445 _14534_/D _13102_/Y VPWR VGND sg13cmos5l_dlygate4sd3_1
Xhold3168 hold3168/X _13485_/Q VPWR VGND sg13cmos5l_dlygate4sd3_1
Xhold3179 _10173_/A _13850_/Q VPWR VGND sg13cmos5l_dlygate4sd3_1
XFILLER_97_892 VPWR VGND sg13cmos5l_decap_4
X_08886_ _08886_/Y _08594_/B _08894_/B _08885_/Y VPWR VGND sg13cmos5l_a21oi_1
Xhold2456 _13225_/D _08151_/Y VPWR VGND sg13cmos5l_dlygate4sd3_1
Xhold2467 _14161_/D _10803_/Y VPWR VGND sg13cmos5l_dlygate4sd3_1
Xhold2478 _08969_/A _13273_/Q VPWR VGND sg13cmos5l_dlygate4sd3_1
Xhold2489 _14136_/D _10728_/Y VPWR VGND sg13cmos5l_dlygate4sd3_1
X_14329__1179 _14329_/RESET_B VPWR VGND sg13cmos5l_tiehi
X_13696__1695 _13696_/RESET_B VPWR VGND sg13cmos5l_tiehi
X_07837_ _14582_/D _14374_/Q _11636_/A VPWR VGND sg13cmos5l_xor2_1
X_07768_ _07768_/Y _07768_/A _08540_/B VPWR VGND sg13cmos5l_nor2_1
XFILLER_71_225 VPWR VGND sg13cmos5l_fill_1
X_09507_ _09509_/B _12589_/A _12577_/A _14441_/Q VPWR VGND sg13cmos5l_a21oi_1
X_07699_ _08495_/A _07699_/A _08497_/A VPWR VGND sg13cmos5l_nand2_1
XFILLER_25_697 VPWR VGND sg13cmos5l_decap_4
XFILLER_40_645 VPWR VGND sg13cmos5l_fill_2
X_09438_ _13549_/D _09230_/A hold3085/X _09438_/S VPWR VGND sg13cmos5l_mux2_1
X_09369_ _13482_/D _08320_/A hold3379/X _09376_/S VPWR VGND sg13cmos5l_mux2_1
X_11400_ _11400_/Y _11399_/A _11456_/A _11444_/A VPWR VGND sg13cmos5l_a21oi_1
X_12380_ _12380_/Y _14466_/Q _12380_/B VPWR VGND sg13cmos5l_nand2_1
X_11331_ _11331_/Y _11331_/A _11298_/B VPWR VGND sg13cmos5l_nor2b_1
XFILLER_106_441 VPWR VGND sg13cmos5l_decap_8
X_11262_ _11262_/Y _11262_/A _11262_/B VPWR VGND sg13cmos5l_nand2_1
X_14050_ _14050_/Q clkload58/A _14050_/D _14050_/RESET_B VPWR VGND sg13cmos5l_dfrbpq_1
XFILLER_4_579 VPWR VGND sg13cmos5l_fill_1
X_10213_ _10213_/Y _10213_/A _10213_/B VPWR VGND sg13cmos5l_nor2_1
X_11193_ _11193_/Y _11193_/A _11203_/A VPWR VGND sg13cmos5l_nand2_1
X_13001_ _14488_/D _13003_/B _13001_/B VPWR VGND sg13cmos5l_and2_1
X_10144_ _13836_/D fanout78/X _10143_/B _10143_/Y VPWR VGND sg13cmos5l_o21ai_1
X_10075_ _13802_/D _10532_/A1 _10074_/B _10074_/Y VPWR VGND sg13cmos5l_o21ai_1
Xhold2990 _09922_/A _13727_/Q VPWR VGND sg13cmos5l_dlygate4sd3_1
X_13903_ _13903_/Q _14020_/CLK _13903_/D _13903_/RESET_B VPWR VGND sg13cmos5l_dfrbpq_1
XFILLER_35_406 VPWR VGND sg13cmos5l_fill_2
X_13834_ _13834_/Q clkload51/A _13834_/D _13834_/RESET_B VPWR VGND sg13cmos5l_dfrbpq_1
XFILLER_90_556 VPWR VGND sg13cmos5l_fill_2
X_10977_ _14228_/D _10943_/A _10973_/Y _10976_/Y VPWR VGND sg13cmos5l_o21ai_1
X_13765_ _13765_/Q clkload64/A _13765_/D _13765_/RESET_B VPWR VGND sg13cmos5l_dfrbpq_1
X_13741__1650 _13741_/RESET_B VPWR VGND sg13cmos5l_tiehi
XFILLER_31_623 VPWR VGND sg13cmos5l_fill_1
XFILLER_43_483 VPWR VGND sg13cmos5l_fill_2
X_13696_ _13696_/Q clkload48/A _13696_/D _13696_/RESET_B VPWR VGND sg13cmos5l_dfrbpq_1
X_12716_ _12716_/Y _12650_/X _12715_/Y _12601_/A VPWR VGND sg13cmos5l_o21ai_1
XFILLER_31_667 VPWR VGND sg13cmos5l_fill_1
X_12647_ _12658_/B _12646_/A _12646_/B _12646_/C VPWR VGND sg13cmos5l_a21oi_1
X_12578_ _12578_/Y _12565_/X _12577_/X _12648_/B VPWR VGND sg13cmos5l_o21ai_1
XFILLER_7_87 VPWR VGND sg13cmos5l_fill_1
X_11529_ _11529_/Y _11529_/A _11541_/B VPWR VGND sg13cmos5l_nand2_1
X_14317_ _14317_/Q _14630_/CLK _14317_/D _14317_/RESET_B VPWR VGND sg13cmos5l_dfrbpq_1
X_14248_ _14248_/Q clkload43/A _14248_/D _14248_/RESET_B VPWR VGND sg13cmos5l_dfrbpq_1
X_14179_ _14179_/Q clkload39/A _14179_/D _14179_/RESET_B VPWR VGND sg13cmos5l_dfrbpq_1
Xfanout809 _10987_/B _14573_/Q VPWR VGND sg13cmos5l_buf_1
XFILLER_79_870 VPWR VGND sg13cmos5l_decap_4
XFILLER_79_881 VPWR VGND sg13cmos5l_fill_1
X_08740_ _08740_/Y _14006_/Q _11754_/B2 _11753_/S VPWR VGND sg13cmos5l_a21oi_1
XFILLER_16_0 VPWR VGND sg13cmos5l_fill_2
XFILLER_54_704 VPWR VGND sg13cmos5l_fill_2
XFILLER_66_553 VPWR VGND sg13cmos5l_fill_1
X_08671_ _08673_/C _13618_/Q _11726_/B VPWR VGND sg13cmos5l_nor2_1
XFILLER_81_501 VPWR VGND sg13cmos5l_fill_2
X_07622_ _08155_/B _08098_/B _07622_/B VPWR VGND sg13cmos5l_or2_1
X_07553_ _07559_/B _14559_/Q _14561_/Q _14560_/Q _14562_/Q _13291_/Q _13290_/Q VPWR
+ VGND sg13cmos5l_mux4_1
X_07484_ _07486_/C _14066_/Q _07465_/B _07530_/B1 _14471_/Q VPWR VGND sg13cmos5l_a22oi_1
X_09223_ _13351_/D _09293_/A hold3063/X _09225_/B VPWR VGND sg13cmos5l_mux2_1
X_09154_ _09154_/Y _14366_/Q _09160_/A2 _09153_/Y VPWR VGND sg13cmos5l_a21oi_1
X_08105_ _13200_/D _08102_/Y _08104_/Y _13140_/A VPWR VGND sg13cmos5l_a21oi_1
X_09085_ _11322_/A _14323_/Q _09175_/B VPWR VGND sg13cmos5l_nand2_1
X_13604__1787 _13604_/RESET_B VPWR VGND sg13cmos5l_tiehi
X_08036_ _08045_/A _14542_/Q _08036_/B VPWR VGND sg13cmos5l_xnor2_1
XFILLER_89_612 VPWR VGND sg13cmos5l_fill_2
XFILLER_89_645 VPWR VGND sg13cmos5l_fill_2
X_13783__1608 _13783_/RESET_B VPWR VGND sg13cmos5l_tiehi
XFILLER_103_466 VPWR VGND sg13cmos5l_fill_1
XFILLER_104_978 VPWR VGND sg13cmos5l_decap_8
XFILLER_89_678 VPWR VGND sg13cmos5l_fill_2
X_09987_ _09987_/Y _09987_/A _09989_/B VPWR VGND sg13cmos5l_nand2_1
X_08938_ _08938_/Y _14269_/Q _13191_/B1 _08938_/B1 VPWR VGND sg13cmos5l_a21oi_1
Xhold2231 hold2231/X _14577_/Q VPWR VGND sg13cmos5l_dlygate4sd3_1
Xhold2242 _10600_/A _14060_/Q VPWR VGND sg13cmos5l_dlygate4sd3_1
Xhold2253 _11449_/A _14331_/Q VPWR VGND sg13cmos5l_dlygate4sd3_1
Xhold2264 _12996_/A _14486_/Q VPWR VGND sg13cmos5l_dlygate4sd3_1
XFILLER_29_233 VPWR VGND sg13cmos5l_fill_2
XFILLER_57_553 VPWR VGND sg13cmos5l_fill_1
X_08869_ _08870_/C _08869_/A _08869_/B VPWR VGND sg13cmos5l_nand2_1
Xhold2275 _10584_/A _14052_/Q VPWR VGND sg13cmos5l_dlygate4sd3_1
Xhold2286 _11509_/A _14335_/Q VPWR VGND sg13cmos5l_dlygate4sd3_1
Xhold2297 _11132_/A _14301_/Q VPWR VGND sg13cmos5l_dlygate4sd3_1
XFILLER_57_597 VPWR VGND sg13cmos5l_decap_4
X_10900_ _10900_/Y _10900_/A _10939_/B VPWR VGND sg13cmos5l_nand2_1
XFILLER_84_394 VPWR VGND sg13cmos5l_fill_2
X_11880_ _11880_/Y _13758_/Q _11884_/B _12242_/B VPWR VGND sg13cmos5l_a21oi_1
X_10831_ _14179_/D _14264_/D _14179_/Q _10832_/S VPWR VGND sg13cmos5l_mux2_1
XFILLER_13_634 VPWR VGND sg13cmos5l_decap_8
XFILLER_16_74 VPWR VGND sg13cmos5l_fill_1
XFILLER_53_781 VPWR VGND sg13cmos5l_fill_1
X_10762_ _10762_/Y _10774_/A _14292_/Q VPWR VGND sg13cmos5l_nand2_1
X_13550_ _13550_/Q clkload33/A _13550_/D _13550_/RESET_B VPWR VGND sg13cmos5l_dfrbpq_1
X_13481_ _13481_/Q clkload37/A _13481_/D _13481_/RESET_B VPWR VGND sg13cmos5l_dfrbpq_1
X_12501_ _12501_/Y _12504_/A _13246_/Q _12500_/Y VPWR VGND sg13cmos5l_o21ai_1
X_10693_ _14113_/D input7/X _07985_/A _10694_/S VPWR VGND sg13cmos5l_mux2_1
X_12432_ _12432_/Y _12431_/Y _12432_/B VPWR VGND sg13cmos5l_nand2b_1
X_12363_ _12364_/D _12363_/A VPWR VGND sg13cmos5l_inv_1
XFILLER_4_310 VPWR VGND sg13cmos5l_fill_2
X_11314_ _11337_/A _11352_/A _11352_/B VPWR VGND sg13cmos5l_nor2_1
X_12294_ _12295_/C _13900_/Q _12144_/B _12395_/B1 _13708_/Q VPWR VGND sg13cmos5l_a22oi_1
X_14102_ _14102_/Q _14102_/CLK _14102_/D fanout996/X VPWR VGND sg13cmos5l_dfrbpq_1
X_11245_ _11245_/Y _08914_/B _11256_/C _12913_/B2 VPWR VGND sg13cmos5l_o21ai_1
X_14033_ _14033_/Q _14640_/CLK _14033_/D _14033_/RESET_B VPWR VGND sg13cmos5l_dfrbpq_1
X_11176_ _11176_/Y _11176_/A VPWR VGND sg13cmos5l_inv_1
X_13759__1632 _13759_/RESET_B VPWR VGND sg13cmos5l_tiehi
X_10127_ _10127_/Y _10127_/A _10139_/B VPWR VGND sg13cmos5l_nand2_1
XFILLER_76_851 VPWR VGND sg13cmos5l_fill_1
X_10058_ _10058_/Y _10058_/A _10072_/B VPWR VGND sg13cmos5l_nand2_1
X_13447__1975 _13447_/RESET_B VPWR VGND sg13cmos5l_tiehi
XFILLER_91_865 VPWR VGND sg13cmos5l_decap_8
XFILLER_51_729 VPWR VGND sg13cmos5l_decap_8
XFILLER_90_364 VPWR VGND sg13cmos5l_fill_1
X_13817_ _13817_/Q _14048_/CLK _13817_/D _13817_/RESET_B VPWR VGND sg13cmos5l_dfrbpq_1
XFILLER_17_995 VPWR VGND sg13cmos5l_fill_1
X_13748_ _13748_/Q clkload17/A _13748_/D _13748_/RESET_B VPWR VGND sg13cmos5l_dfrbpq_1
X_13679_ _13679_/Q _14020_/CLK _13679_/D _13679_/RESET_B VPWR VGND sg13cmos5l_dfrbpq_1
XFILLER_8_660 VPWR VGND sg13cmos5l_fill_2
X_14646__2189 _14646_/RESET_B VPWR VGND sg13cmos5l_tiehi
X_09910_ _09910_/Y _09910_/A _09910_/B VPWR VGND sg13cmos5l_nor2_1
Xfanout606 _12907_/B2 _11318_/B1 VPWR VGND sg13cmos5l_buf_1
XFILLER_101_915 VPWR VGND sg13cmos5l_decap_8
XFILLER_98_453 VPWR VGND sg13cmos5l_fill_2
X_09841_ _13687_/D _10559_/A1 _09846_/B _09840_/Y VPWR VGND sg13cmos5l_a21oi_1
Xfanout639 _12164_/C _11635_/B VPWR VGND sg13cmos5l_buf_1
Xfanout628 _12460_/B _12466_/B VPWR VGND sg13cmos5l_buf_1
Xfanout617 _07933_/A _07872_/Y VPWR VGND sg13cmos5l_buf_1
XFILLER_100_425 VPWR VGND sg13cmos5l_fill_2
X_09772_ _13653_/D _10555_/A1 _09773_/B _09771_/Y VPWR VGND sg13cmos5l_a21oi_1
XFILLER_39_553 VPWR VGND sg13cmos5l_decap_4
XFILLER_67_851 VPWR VGND sg13cmos5l_decap_8
X_08723_ _08723_/Y _08721_/Y _08722_/Y _11753_/S VPWR VGND sg13cmos5l_a21oi_1
XFILLER_54_512 VPWR VGND sg13cmos5l_decap_4
XFILLER_67_895 VPWR VGND sg13cmos5l_fill_2
XFILLER_27_759 VPWR VGND sg13cmos5l_fill_2
X_08654_ _08654_/Y _13778_/Q _12055_/B VPWR VGND sg13cmos5l_nand2_1
X_07605_ _07627_/B _07609_/B _07605_/B VPWR VGND sg13cmos5l_nand2_1
X_08585_ _08585_/Y _08603_/C _08589_/B VPWR VGND sg13cmos5l_nor2_1
X_07536_ _07540_/A _14541_/Q _13294_/Q VPWR VGND sg13cmos5l_xor2_1
XFILLER_50_762 VPWR VGND sg13cmos5l_decap_4
XFILLER_50_795 VPWR VGND sg13cmos5l_fill_1
X_07467_ _07467_/Y _07614_/A _12963_/A _07467_/C VPWR VGND sg13cmos5l_nor3_1
X_09206_ _13335_/D _09416_/A0 hold3050/X _09208_/S VPWR VGND sg13cmos5l_mux2_1
X_07398_ _07399_/D _14548_/Q _07434_/C _07594_/A VPWR VGND sg13cmos5l_o21ai_1
X_13837__1554 _13837_/RESET_B VPWR VGND sg13cmos5l_tiehi
X_09137_ _09137_/Y _09137_/A _09137_/B VPWR VGND sg13cmos5l_nor2_1
X_09068_ _09068_/Y _14416_/Q _11293_/A VPWR VGND sg13cmos5l_nand2_1
X_13525__1897 _13525_/RESET_B VPWR VGND sg13cmos5l_tiehi
X_08019_ _08041_/B _08970_/A _08050_/A _08018_/Y VPWR VGND sg13cmos5l_o21ai_1
XFILLER_89_431 VPWR VGND sg13cmos5l_fill_1
XFILLER_77_604 VPWR VGND sg13cmos5l_fill_2
XFILLER_77_615 VPWR VGND sg13cmos5l_fill_2
XFILLER_89_453 VPWR VGND sg13cmos5l_fill_1
X_11030_ _14242_/D _14242_/Q _13197_/A2 _11029_/Y VPWR VGND sg13cmos5l_a21o_1
XFILLER_89_486 VPWR VGND sg13cmos5l_fill_1
XFILLER_89_497 VPWR VGND sg13cmos5l_fill_2
X_14197__1280 _14197_/RESET_B VPWR VGND sg13cmos5l_tiehi
XFILLER_58_895 VPWR VGND sg13cmos5l_decap_4
XFILLER_92_629 VPWR VGND sg13cmos5l_fill_2
X_12981_ _12985_/C _14478_/Q _14479_/Q _12981_/C VPWR VGND sg13cmos5l_and3_1
XFILLER_17_225 VPWR VGND sg13cmos5l_fill_2
XFILLER_27_40 VPWR VGND sg13cmos5l_fill_2
XFILLER_27_51 VPWR VGND sg13cmos5l_fill_1
X_11932_ _11932_/Y _12136_/A _11958_/B VPWR VGND sg13cmos5l_nor2_1
XFILLER_17_247 VPWR VGND sg13cmos5l_fill_1
XFILLER_27_84 VPWR VGND sg13cmos5l_fill_1
X_11863_ _11864_/C _13949_/Q _11915_/B _11916_/A2 _13885_/Q VPWR VGND sg13cmos5l_a22oi_1
X_14651_ _14651_/Q clkload79/A _14651_/D _14651_/RESET_B VPWR VGND sg13cmos5l_dfrbpq_1
XFILLER_60_548 VPWR VGND sg13cmos5l_fill_1
X_10814_ _10814_/Y _07329_/Y _10816_/A2 _10813_/Y VPWR VGND sg13cmos5l_a21oi_1
X_13602_ _13602_/Q clkload60/A _13602_/D _13602_/RESET_B VPWR VGND sg13cmos5l_dfrbpq_1
X_11794_ _11794_/Y _11870_/A _11794_/B VPWR VGND sg13cmos5l_nor2_1
X_14582_ _14582_/Q clkload45/A _14582_/D _14582_/RESET_B VPWR VGND sg13cmos5l_dfrbpq_1
XFILLER_13_475 VPWR VGND sg13cmos5l_fill_2
X_10745_ _10745_/Y _10745_/A _10796_/B VPWR VGND sg13cmos5l_nand2_1
X_13533_ _13533_/Q clkload30/A _13533_/D _13533_/RESET_B VPWR VGND sg13cmos5l_dfrbpq_1
X_10676_ _10676_/Y _10676_/A _10796_/B VPWR VGND sg13cmos5l_nand2_1
X_13464_ _13464_/Q _14105_/CLK _13464_/D _13464_/RESET_B VPWR VGND sg13cmos5l_dfrbpq_1
X_13395_ _13395_/Q _14292_/CLK _13395_/D _13395_/RESET_B VPWR VGND sg13cmos5l_dfrbpq_1
X_12415_ _12416_/B _12415_/A _13227_/Q VPWR VGND sg13cmos5l_xnor2_1
X_12346_ _12347_/C _13646_/Q _12346_/A2 _12346_/B1 VPWR VGND sg13cmos5l_a21oi_1
X_12277_ _12278_/B _12352_/A _12523_/B _12276_/Y VPWR VGND sg13cmos5l_o21ai_1
X_14324__1184 _14324_/RESET_B VPWR VGND sg13cmos5l_tiehi
X_11228_ _11228_/Y _11256_/A _11228_/B VPWR VGND sg13cmos5l_nor2_1
X_14016_ _14016_/Q _14048_/CLK _14016_/D _14016_/RESET_B VPWR VGND sg13cmos5l_dfrbpq_1
XFILLER_68_615 VPWR VGND sg13cmos5l_fill_1
XFILLER_68_637 VPWR VGND sg13cmos5l_fill_2
XFILLER_96_946 VPWR VGND sg13cmos5l_decap_8
X_11159_ _14308_/D _07183_/Y _11166_/A2 _11158_/Y _10654_/B VPWR VGND sg13cmos5l_a22oi_1
XFILLER_95_445 VPWR VGND sg13cmos5l_fill_1
XFILLER_76_692 VPWR VGND sg13cmos5l_decap_4
X_13915__1476 _13915_/RESET_B VPWR VGND sg13cmos5l_tiehi
XFILLER_63_364 VPWR VGND sg13cmos5l_decap_4
XFILLER_91_662 VPWR VGND sg13cmos5l_fill_1
XFILLER_36_589 VPWR VGND sg13cmos5l_fill_2
XFILLER_63_397 VPWR VGND sg13cmos5l_fill_1
X_08370_ _08370_/Y _13358_/Q _08416_/S VPWR VGND sg13cmos5l_nand2b_1
X_07321_ _07321_/Y _07321_/A VPWR VGND sg13cmos5l_inv_1
XFILLER_20_924 VPWR VGND sg13cmos5l_fill_1
XFILLER_31_283 VPWR VGND sg13cmos5l_fill_1
X_07252_ _07252_/Y _12523_/A VPWR VGND sg13cmos5l_inv_1
X_07183_ _07183_/Y _07183_/A VPWR VGND sg13cmos5l_inv_1
XFILLER_99_740 VPWR VGND sg13cmos5l_fill_2
XFILLER_99_773 VPWR VGND sg13cmos5l_fill_2
Xfanout414 fanout414/X _10657_/Y VPWR VGND sg13cmos5l_buf_1
Xfanout403 _10934_/B _10833_/Y VPWR VGND sg13cmos5l_buf_1
XFILLER_59_637 VPWR VGND sg13cmos5l_fill_1
X_09824_ _13679_/D fanout61/X _09827_/B _09823_/Y VPWR VGND sg13cmos5l_a21oi_1
Xfanout447 _11727_/B _08656_/Y VPWR VGND sg13cmos5l_buf_1
Xfanout436 _10432_/B _10436_/B VPWR VGND sg13cmos5l_buf_1
Xfanout425 _10577_/A2 _10547_/Y VPWR VGND sg13cmos5l_buf_1
Xfanout469 _11754_/B2 _08744_/B1 VPWR VGND sg13cmos5l_buf_1
Xfanout458 _12349_/B1 fanout465/X VPWR VGND sg13cmos5l_buf_1
X_09755_ _13646_/D fanout73/X _09754_/B _09754_/Y VPWR VGND sg13cmos5l_a21oi_1
XFILLER_39_394 VPWR VGND sg13cmos5l_fill_1
XFILLER_55_832 VPWR VGND sg13cmos5l_fill_2
XFILLER_73_139 VPWR VGND sg13cmos5l_fill_1
X_08706_ _08706_/Y _14036_/Q _08687_/Y _08705_/X _08747_/B VPWR VGND sg13cmos5l_a22oi_1
X_09686_ _09686_/Y _09691_/A _09686_/B VPWR VGND sg13cmos5l_nor2_1
XFILLER_66_191 VPWR VGND sg13cmos5l_fill_2
X_08637_ _14657_/D _08637_/A _08637_/B _08637_/C VPWR VGND sg13cmos5l_nand3_1
XFILLER_81_150 VPWR VGND sg13cmos5l_fill_1
XFILLER_81_161 VPWR VGND sg13cmos5l_fill_1
X_08568_ _08569_/B _08572_/A _08571_/B _08567_/Y VPWR VGND sg13cmos5l_o21ai_1
X_07519_ _07519_/Y _07519_/A _08168_/A VPWR VGND sg13cmos5l_nand2_1
X_08499_ _08500_/B _08498_/A _08496_/Y _08497_/Y _08498_/Y VPWR VGND sg13cmos5l_a22oi_1
Xfanout65 _11738_/S _12412_/A VPWR VGND sg13cmos5l_buf_1
X_10530_ _14025_/D _10595_/A1 _10537_/B _10529_/Y VPWR VGND sg13cmos5l_o21ai_1
Xfanout98 _09208_/S _09234_/S VPWR VGND sg13cmos5l_buf_1
Xfanout87 _09293_/B _09297_/S VPWR VGND sg13cmos5l_buf_1
Xfanout76 fanout76/X _09665_/Y VPWR VGND sg13cmos5l_buf_1
X_10461_ _13991_/D _10591_/A1 _10470_/B _10460_/Y VPWR VGND sg13cmos5l_a21oi_1
XFILLER_10_489 VPWR VGND sg13cmos5l_decap_8
X_12200_ _12200_/Y _13961_/Q _12319_/A2 _12200_/B1 _13641_/Q _12346_/B1 VPWR VGND
+ sg13cmos5l_a221oi_1
X_10392_ _10392_/Y _10392_/A _10408_/B VPWR VGND sg13cmos5l_nor2_1
X_13180_ _13180_/Y _13237_/Q _13180_/B VPWR VGND sg13cmos5l_nor2_1
X_12131_ _12220_/A _12110_/A _12134_/B VPWR VGND sg13cmos5l_nand2b_1
X_12062_ _12062_/Y _12058_/Y _12059_/Y _12060_/Y _12061_/Y VPWR VGND sg13cmos5l_a22oi_1
XFILLER_77_401 VPWR VGND sg13cmos5l_fill_1
X_11013_ _11014_/C _10987_/A _11012_/B _11012_/Y VPWR VGND sg13cmos5l_a21oi_1
Xfanout970 fanout970/X fanout973/X VPWR VGND sg13cmos5l_buf_1
XFILLER_64_106 VPWR VGND sg13cmos5l_fill_2
Xfanout981 fanout981/X fanout988/X VPWR VGND sg13cmos5l_buf_1
Xfanout992 fanout992/X fanout993/X VPWR VGND sg13cmos5l_buf_1
X_14645__2188 _14645_/RESET_B VPWR VGND sg13cmos5l_tiehi
X_12964_ _12965_/S _12964_/A _12964_/B _12964_/C VPWR VGND sg13cmos5l_nand3_1
X_11915_ _11917_/B _13951_/Q _11915_/B VPWR VGND sg13cmos5l_nand2_1
X_12895_ _12897_/B _12895_/A _12895_/B _12895_/C VPWR VGND sg13cmos5l_or3_1
X_11846_ _11848_/A _11846_/A _11846_/B VPWR VGND sg13cmos5l_nand2_1
X_14634_ _14634_/Q clkload69/A _14634_/D _14634_/RESET_B VPWR VGND sg13cmos5l_dfrbpq_1
X_11777_ _11777_/Y _14042_/Q _11945_/S VPWR VGND sg13cmos5l_nand2_1
X_14565_ _14565_/Q clkload72/A _14565_/D _14565_/RESET_B VPWR VGND sg13cmos5l_dfrbpq_1
XFILLER_41_581 VPWR VGND sg13cmos5l_fill_1
XFILLER_9_210 VPWR VGND sg13cmos5l_fill_1
X_10728_ _10728_/Y _10808_/S _10726_/Y _10727_/Y VPWR VGND sg13cmos5l_o21ai_1
X_13516_ _13516_/Q clkload34/A _13516_/D _13516_/RESET_B VPWR VGND sg13cmos5l_dfrbpq_1
XFILLER_9_265 VPWR VGND sg13cmos5l_fill_2
X_14496_ _14496_/Q _14576_/CLK _14496_/D fanout976/X VPWR VGND sg13cmos5l_dfrbpq_1
X_10659_ _14084_/D _10658_/Y hold3451/X _10659_/S VPWR VGND sg13cmos5l_mux2_1
Xclkload35 clkload35/X clkload35/A VPWR VGND sg13cmos5l_buf_8
Xclkload24 clkload24/Y clkload24/A VPWR VGND sg13cmos5l_inv_4
Xclkload13 clkload13/Y clkload13/A VPWR VGND sg13cmos5l_inv_16
X_13447_ _13447_/Q clkload28/A _13447_/D _13447_/RESET_B VPWR VGND sg13cmos5l_dfrbpq_1
Xclkload68 clkload68/Y clkload68/A VPWR VGND sg13cmos5l_inv_4
Xclkload57 clkload57/Y clkload57/A VPWR VGND sg13cmos5l_inv_1
Xclkload46 clkload46/Y clkload46/A VPWR VGND sg13cmos5l_inv_1
X_13378_ _13378_/Q clkload41/A _13378_/D _13378_/RESET_B VPWR VGND sg13cmos5l_dfrbpq_1
Xclkload79 clkload79/Y clkload79/A VPWR VGND sg13cmos5l_inv_2
X_12329_ _12330_/C _12329_/A _12329_/B VPWR VGND sg13cmos5l_and2_1
Xhold3509 hold3509/X _13299_/Q VPWR VGND sg13cmos5l_dlygate4sd3_1
Xhold2808 _09914_/A _13723_/Q VPWR VGND sg13cmos5l_dlygate4sd3_1
Xhold2819 _10420_/A _13971_/Q VPWR VGND sg13cmos5l_dlygate4sd3_1
X_07870_ _14564_/D _07259_/Y _07859_/Y _07869_/Y VPWR VGND sg13cmos5l_o21ai_1
XFILLER_37_810 VPWR VGND sg13cmos5l_fill_1
X_09540_ _09540_/X _14446_/Q _09555_/D VPWR VGND sg13cmos5l_or2_1
X_09471_ _13581_/D _09230_/A hold3217/X _09471_/S VPWR VGND sg13cmos5l_mux2_1
XFILLER_36_375 VPWR VGND sg13cmos5l_fill_1
X_08422_ _08422_/Y _14240_/Q _10987_/A VPWR VGND sg13cmos5l_nor2_1
XFILLER_51_356 VPWR VGND sg13cmos5l_fill_2
XFILLER_51_378 VPWR VGND sg13cmos5l_fill_1
X_08353_ _08353_/X _08347_/Y _08348_/Y _08406_/B1 VPWR VGND sg13cmos5l_a21o_1
X_07304_ _07304_/Y _13413_/Q VPWR VGND sg13cmos5l_inv_1
X_08284_ _08284_/Y _11034_/A _08283_/X _08311_/C1 VPWR VGND sg13cmos5l_a21oi_1
X_07235_ _07235_/Y _11821_/A VPWR VGND sg13cmos5l_inv_1
Xclkload7 clkload7/X clkload7/A VPWR VGND sg13cmos5l_buf_8
X_07166_ _07166_/Y _14462_/Q VPWR VGND sg13cmos5l_inv_1
X_13442__1980 _13442_/RESET_B VPWR VGND sg13cmos5l_tiehi
X_13305__2207 _13305_/RESET_B VPWR VGND sg13cmos5l_tiehi
XFILLER_59_49 VPWR VGND sg13cmos5l_fill_1
Xfanout222 fanout222/X _10025_/Y VPWR VGND sg13cmos5l_buf_1
Xfanout211 _10044_/B _10052_/B VPWR VGND sg13cmos5l_buf_1
Xfanout200 _10109_/B _10119_/B VPWR VGND sg13cmos5l_buf_1
XFILLER_59_445 VPWR VGND sg13cmos5l_decap_8
XFILLER_87_743 VPWR VGND sg13cmos5l_fill_1
Xfanout255 _10402_/B _10414_/B VPWR VGND sg13cmos5l_buf_1
Xfanout244 _13040_/C _07416_/Y VPWR VGND sg13cmos5l_buf_1
Xfanout233 fanout233/X _09960_/Y VPWR VGND sg13cmos5l_buf_1
X_07999_ _10961_/A _10960_/B VPWR VGND sg13cmos5l_inv_1
X_09807_ _09807_/Y _09807_/A _09817_/B VPWR VGND sg13cmos5l_nor2_1
Xfanout299 _09956_/B fanout300/X VPWR VGND sg13cmos5l_buf_1
Xfanout288 _10211_/B _10173_/B VPWR VGND sg13cmos5l_buf_1
Xfanout277 _10280_/B _10284_/B VPWR VGND sg13cmos5l_buf_1
Xfanout266 _10339_/B _10347_/B VPWR VGND sg13cmos5l_buf_1
X_09738_ _09738_/Y _09738_/A _09754_/B VPWR VGND sg13cmos5l_nor2_1
XFILLER_28_865 VPWR VGND sg13cmos5l_fill_1
XFILLER_90_908 VPWR VGND sg13cmos5l_fill_1
X_09669_ _09671_/B _12856_/A _09670_/C _14465_/Q VPWR VGND sg13cmos5l_a21oi_1
XFILLER_54_194 VPWR VGND sg13cmos5l_fill_1
X_11700_ _11700_/Y _13591_/Q _11702_/B VPWR VGND sg13cmos5l_nand2_1
X_12680_ _12680_/Y _12699_/A _12680_/B VPWR VGND sg13cmos5l_nand2b_1
XFILLER_70_687 VPWR VGND sg13cmos5l_fill_2
X_11631_ _11631_/Y _11628_/Y _11672_/A _11627_/Y VPWR VGND sg13cmos5l_o21ai_1
X_11562_ _11575_/C _11562_/A _11562_/B VPWR VGND sg13cmos5l_nand2_1
X_14350_ _14350_/Q clkload69/A _14350_/D _14350_/RESET_B VPWR VGND sg13cmos5l_dfrbpq_1
X_10513_ _10513_/Y _10513_/A _10517_/B VPWR VGND sg13cmos5l_nand2_1
X_13301_ _13301_/Q clkload24/A _13301_/D _13301_/RESET_B VPWR VGND sg13cmos5l_dfrbpq_1
XFILLER_6_235 VPWR VGND sg13cmos5l_fill_1
X_11493_ _11555_/A _11493_/A _11493_/B _11504_/B VPWR VGND sg13cmos5l_and3_1
X_14281_ _14281_/Q clkload22/A _14281_/D _14281_/RESET_B VPWR VGND sg13cmos5l_dfrbpq_1
X_10444_ _10444_/Y _10444_/A _10446_/B VPWR VGND sg13cmos5l_nor2_1
X_13232_ _13232_/Q clkload45/A _13232_/D _13232_/RESET_B VPWR VGND sg13cmos5l_dfrbpq_1
XFILLER_3_920 VPWR VGND sg13cmos5l_decap_4
X_10375_ _13949_/D _10375_/A1 _10374_/B _10374_/Y VPWR VGND sg13cmos5l_a21oi_1
X_13163_ _13163_/Y _11192_/A _14085_/Q _13159_/B hold3061/X _13164_/A2 VPWR VGND sg13cmos5l_a221oi_1
XFILLER_97_507 VPWR VGND sg13cmos5l_decap_8
X_12114_ _12114_/Y _14022_/Q _12030_/B _12346_/B1 VPWR VGND sg13cmos5l_a21oi_1
XFILLER_3_997 VPWR VGND sg13cmos5l_fill_1
XFILLER_97_518 VPWR VGND sg13cmos5l_fill_1
X_13094_ _14531_/D _13094_/A _13099_/D VPWR VGND sg13cmos5l_xor2_1
XFILLER_105_892 VPWR VGND sg13cmos5l_decap_4
X_12045_ _12102_/A _12093_/A _13245_/Q VPWR VGND sg13cmos5l_xor2_1
X_13617__1774 _13617_/RESET_B VPWR VGND sg13cmos5l_tiehi
XFILLER_93_724 VPWR VGND sg13cmos5l_decap_4
XFILLER_93_757 VPWR VGND sg13cmos5l_decap_8
X_13996_ _13996_/Q _14028_/CLK _13996_/D _13996_/RESET_B VPWR VGND sg13cmos5l_dfrbpq_1
XFILLER_61_610 VPWR VGND sg13cmos5l_fill_1
X_12947_ _12948_/A _14461_/Q _11541_/B _11555_/B _12949_/B2 VPWR VGND sg13cmos5l_a22oi_1
X_13484__1938 _13484_/RESET_B VPWR VGND sg13cmos5l_tiehi
X_12878_ _12878_/X _12884_/B _12876_/Y _12877_/Y VPWR VGND sg13cmos5l_a21o_1
XFILLER_21_518 VPWR VGND sg13cmos5l_decap_4
X_11829_ _11829_/Y _14012_/Q _11971_/A2 _11945_/S VPWR VGND sg13cmos5l_a21oi_1
X_14617_ _14617_/Q clkload24/A _14617_/D _14617_/RESET_B VPWR VGND sg13cmos5l_dfrbpq_1
X_14548_ _14548_/Q clkload12/A _14548_/D fanout957/X VPWR VGND sg13cmos5l_dfrbpq_1
X_14479_ _14479_/Q clkload10/A _14479_/D fanout975/X VPWR VGND sg13cmos5l_dfrbpq_1
Xhold3306 hold3306/X _13535_/Q VPWR VGND sg13cmos5l_dlygate4sd3_1
X_08971_ _08971_/Y _08975_/A _08971_/B VPWR VGND sg13cmos5l_nor2_1
Xhold3339 _13573_/D _09463_/X VPWR VGND sg13cmos5l_dlygate4sd3_1
Xhold3328 _13050_/A _13048_/Y VPWR VGND sg13cmos5l_dlygate4sd3_1
Xhold3317 _13518_/D _09406_/X VPWR VGND sg13cmos5l_dlygate4sd3_1
X_07922_ _11019_/B _12468_/A _14226_/Q VPWR VGND sg13cmos5l_nor2_1
Xhold2605 _13108_/A _13106_/Y VPWR VGND sg13cmos5l_dlygate4sd3_1
Xhold2616 _09777_/A _13656_/Q VPWR VGND sg13cmos5l_dlygate4sd3_1
Xhold2627 _09742_/A _13640_/Q VPWR VGND sg13cmos5l_dlygate4sd3_1
Xhold2638 _14489_/D _13003_/Y VPWR VGND sg13cmos5l_dlygate4sd3_1
XFILLER_96_573 VPWR VGND sg13cmos5l_fill_1
X_07853_ _11618_/C _11014_/A _11014_/B VPWR VGND sg13cmos5l_nor2_1
Xhold2649 _09844_/A _13689_/Q VPWR VGND sg13cmos5l_dlygate4sd3_1
XFILLER_84_724 VPWR VGND sg13cmos5l_decap_8
XFILLER_83_234 VPWR VGND sg13cmos5l_fill_1
XFILLER_83_245 VPWR VGND sg13cmos5l_fill_1
X_07784_ _07784_/Y _07784_/A VPWR VGND sg13cmos5l_inv_1
XFILLER_43_109 VPWR VGND sg13cmos5l_fill_2
X_09523_ _09523_/Y _09535_/A _11221_/B _09520_/Y _09522_/Y VPWR VGND sg13cmos5l_a22oi_1
XFILLER_64_492 VPWR VGND sg13cmos5l_decap_8
X_09454_ _13564_/D _08194_/A hold3292/X _09467_/S VPWR VGND sg13cmos5l_mux2_1
XFILLER_101_35 VPWR VGND sg13cmos5l_fill_2
XFILLER_52_687 VPWR VGND sg13cmos5l_fill_2
X_08405_ _08405_/Y _08405_/A1 _08403_/X _08404_/Y _08402_/X _08405_/C1 VPWR VGND sg13cmos5l_a221oi_1
X_09385_ _13497_/D _08157_/A hold3258/X _09396_/S VPWR VGND sg13cmos5l_mux2_1
X_08336_ _08336_/Y _08388_/A _08333_/X _08419_/A1 VPWR VGND sg13cmos5l_a21oi_1
X_14283__1225 _14283_/RESET_B VPWR VGND sg13cmos5l_tiehi
X_08267_ _12585_/B _08265_/Y _08266_/X _08257_/Y VPWR VGND sg13cmos5l_o21ai_1
Xheichips26_loopcache_rv_2223 uio_oe[11] VPWR VGND sg13cmos5l_tiehi
X_07218_ _12193_/A _14366_/Q VPWR VGND sg13cmos5l_inv_1
X_08198_ _08198_/Y _08198_/A _08198_/B _08198_/C VPWR VGND sg13cmos5l_nand3_1
X_14644__2187 _14644_/RESET_B VPWR VGND sg13cmos5l_tiehi
XFILLER_106_689 VPWR VGND sg13cmos5l_decap_8
XFILLER_79_518 VPWR VGND sg13cmos5l_decap_8
XFILLER_79_529 VPWR VGND sg13cmos5l_fill_2
X_10160_ _13843_/D _10355_/A1 _10171_/B _10159_/Y VPWR VGND sg13cmos5l_a21oi_1
X_13874__1517 _13874_/RESET_B VPWR VGND sg13cmos5l_tiehi
XFILLER_0_956 VPWR VGND sg13cmos5l_decap_8
XFILLER_102_840 VPWR VGND sg13cmos5l_decap_4
X_10091_ _10091_/Y _10091_/A _10107_/B VPWR VGND sg13cmos5l_nand2_1
Xfanout1006 _12843_/A input1/X VPWR VGND sg13cmos5l_buf_1
X_13910__1481 _13910_/RESET_B VPWR VGND sg13cmos5l_tiehi
XFILLER_19_30 VPWR VGND sg13cmos5l_fill_2
XFILLER_59_264 VPWR VGND sg13cmos5l_fill_1
X_13850_ _13850_/Q clkload52/A _13850_/D _13850_/RESET_B VPWR VGND sg13cmos5l_dfrbpq_1
XFILLER_56_982 VPWR VGND sg13cmos5l_decap_4
XFILLER_90_716 VPWR VGND sg13cmos5l_decap_4
X_10993_ _10993_/Y _11007_/A _10993_/B VPWR VGND sg13cmos5l_nand2_1
X_13781_ _13781_/Q clkload16/A _13781_/D _13781_/RESET_B VPWR VGND sg13cmos5l_dfrbpq_1
X_13328__2094 _13328_/RESET_B VPWR VGND sg13cmos5l_tiehi
X_12801_ _12802_/B _12859_/A _12799_/X _12800_/X fanout59/X _12162_/Y VPWR VGND sg13cmos5l_a221oi_1
X_12732_ _12732_/Y _12732_/A _12732_/B VPWR VGND sg13cmos5l_nand2_1
XFILLER_42_153 VPWR VGND sg13cmos5l_fill_1
XFILLER_43_698 VPWR VGND sg13cmos5l_fill_2
X_14402_ _14402_/Q clkload74/A _14402_/D _14402_/RESET_B VPWR VGND sg13cmos5l_dfrbpq_1
X_12663_ _14414_/D _12686_/A _12663_/B _12663_/C _12663_/D VPWR VGND sg13cmos5l_nand4_1
XFILLER_11_540 VPWR VGND sg13cmos5l_fill_1
X_11614_ _11614_/Y _11614_/A _11614_/B VPWR VGND sg13cmos5l_nor2_1
X_14451__1054 _14451_/RESET_B VPWR VGND sg13cmos5l_tiehi
X_12594_ _14409_/D _12594_/A _12594_/B VPWR VGND sg13cmos5l_nor2_1
X_11545_ _11577_/C _11563_/A _11553_/B VPWR VGND sg13cmos5l_xnor2_1
X_14333_ _14333_/Q clkload79/A _14333_/D _14333_/RESET_B VPWR VGND sg13cmos5l_dfrbpq_1
X_11476_ _11492_/A _11476_/A _11476_/B _11476_/C _11493_/B VPWR VGND sg13cmos5l_nand4_1
X_14264_ _14264_/Q clkload39/A _14264_/D _14264_/RESET_B VPWR VGND sg13cmos5l_dfrbpq_1
XFILLER_100_1021 VPWR VGND sg13cmos5l_decap_8
X_10427_ _13974_/D _10557_/A1 _10432_/B _10426_/Y VPWR VGND sg13cmos5l_a21oi_1
X_13215_ _13215_/Q clkload10/A _13215_/D fanout974/X VPWR VGND sg13cmos5l_dfrbpq_1
X_14195_ _14195_/Q clkload44/A _14195_/D _14195_/RESET_B VPWR VGND sg13cmos5l_dfrbpq_1
X_10358_ _10358_/Y _10358_/A _10366_/B VPWR VGND sg13cmos5l_nor2_1
X_13146_ _14562_/D _13146_/A _13146_/B VPWR VGND sg13cmos5l_nor2_1
X_10289_ _10289_/Y _10289_/A _10295_/B VPWR VGND sg13cmos5l_nor2_1
X_13077_ _13080_/C _13078_/A _13078_/B VPWR VGND sg13cmos5l_and2_1
XFILLER_66_702 VPWR VGND sg13cmos5l_fill_2
XFILLER_78_540 VPWR VGND sg13cmos5l_decap_4
X_12028_ _12028_/Y _13763_/Q _12346_/A2 _12346_/B1 VPWR VGND sg13cmos5l_a21oi_1
X_13538__1884 _13538_/RESET_B VPWR VGND sg13cmos5l_tiehi
XFILLER_93_532 VPWR VGND sg13cmos5l_decap_4
X_14361__1147 _14361_/RESET_B VPWR VGND sg13cmos5l_tiehi
XFILLER_34_610 VPWR VGND sg13cmos5l_fill_2
X_14082__1325 _14082_/RESET_B VPWR VGND sg13cmos5l_tiehi
X_13979_ _13979_/Q _14042_/CLK _13979_/D _13979_/RESET_B VPWR VGND sg13cmos5l_dfrbpq_1
XFILLER_62_996 VPWR VGND sg13cmos5l_fill_2
X_09170_ _09170_/Y _14433_/Q _11530_/A VPWR VGND sg13cmos5l_nand2_1
X_13952__1439 _13952_/RESET_B VPWR VGND sg13cmos5l_tiehi
X_08121_ _08121_/Y _08121_/A _08121_/B VPWR VGND sg13cmos5l_xnor2_1
X_08052_ _08052_/Y _10780_/A _12997_/C VPWR VGND sg13cmos5l_nor2_1
Xhold3103 hold3103/X _13360_/Q VPWR VGND sg13cmos5l_dlygate4sd3_1
Xhold3114 hold3114/X _13537_/Q VPWR VGND sg13cmos5l_dlygate4sd3_1
X_08954_ _13268_/D _08043_/B hold3470/X _10778_/B VPWR VGND sg13cmos5l_mux2_1
Xhold2402 _10032_/A _13781_/Q VPWR VGND sg13cmos5l_dlygate4sd3_1
Xhold2413 _14140_/D _10740_/Y VPWR VGND sg13cmos5l_dlygate4sd3_1
Xhold3125 hold3125/X _13362_/Q VPWR VGND sg13cmos5l_dlygate4sd3_1
Xhold3136 hold3136/X _13517_/Q VPWR VGND sg13cmos5l_dlygate4sd3_1
Xhold3147 hold3147/X _13367_/Q VPWR VGND sg13cmos5l_dlygate4sd3_1
Xhold3158 hold3158/X _13477_/Q VPWR VGND sg13cmos5l_dlygate4sd3_1
XFILLER_69_540 VPWR VGND sg13cmos5l_decap_8
X_07905_ _07944_/C _11014_/A _07905_/B VPWR VGND sg13cmos5l_nor2_1
Xhold2424 _10578_/A _14049_/Q VPWR VGND sg13cmos5l_dlygate4sd3_1
Xhold2435 _11541_/A _14337_/Q VPWR VGND sg13cmos5l_dlygate4sd3_1
Xhold2446 _09969_/A _13750_/Q VPWR VGND sg13cmos5l_dlygate4sd3_1
Xhold3169 hold3169/X _13369_/Q VPWR VGND sg13cmos5l_dlygate4sd3_1
XFILLER_57_735 VPWR VGND sg13cmos5l_fill_1
XFILLER_99_1023 VPWR VGND sg13cmos5l_decap_4
X_08885_ _08885_/Y _08885_/A _08895_/B VPWR VGND sg13cmos5l_nor2_1
Xhold2457 _10529_/A _14025_/Q VPWR VGND sg13cmos5l_dlygate4sd3_1
Xhold2468 hold2468/X _14592_/Q VPWR VGND sg13cmos5l_dlygate4sd3_1
Xhold2479 _08967_/A _13272_/Q VPWR VGND sg13cmos5l_dlygate4sd3_1
X_07836_ _08469_/A _07836_/A _08808_/A VPWR VGND sg13cmos5l_nor2_1
X_14337__1171 _14337_/RESET_B VPWR VGND sg13cmos5l_tiehi
X_07767_ _08538_/A _07767_/A _07767_/B VPWR VGND sg13cmos5l_nand2_1
XFILLER_71_237 VPWR VGND sg13cmos5l_fill_1
X_09506_ _09506_/X _14410_/Q _14629_/Q _09532_/S VPWR VGND sg13cmos5l_mux2_1
X_07698_ _07705_/A _08498_/B _07698_/B VPWR VGND sg13cmos5l_nor2_1
XFILLER_52_473 VPWR VGND sg13cmos5l_decap_8
X_09437_ _13548_/D _08344_/A hold3323/X _09442_/S VPWR VGND sg13cmos5l_mux2_1
XFILLER_40_668 VPWR VGND sg13cmos5l_fill_1
X_09368_ _13481_/D _09225_/A hold2982/X _09368_/S VPWR VGND sg13cmos5l_mux2_1
X_13928__1463 _13928_/RESET_B VPWR VGND sg13cmos5l_tiehi
X_08319_ _14265_/D _14265_/Q _12640_/B _11042_/S VPWR VGND sg13cmos5l_mux2_1
X_09299_ _13419_/D _08332_/A hold3274/X _09307_/B VPWR VGND sg13cmos5l_mux2_1
X_11330_ _11334_/A _11270_/A _11270_/B _11329_/Y VPWR VGND sg13cmos5l_o21ai_1
XFILLER_106_420 VPWR VGND sg13cmos5l_fill_2
XFILLER_106_431 VPWR VGND sg13cmos5l_decap_4
XFILLER_21_97 VPWR VGND sg13cmos5l_fill_2
X_11261_ _14318_/D _11259_/Y _11260_/Y _11247_/Y VPWR VGND sg13cmos5l_o21ai_1
XFILLER_106_464 VPWR VGND sg13cmos5l_decap_8
XFILLER_97_46 VPWR VGND sg13cmos5l_fill_1
X_10212_ _13869_/D fanout75/X _10211_/B _10211_/Y VPWR VGND sg13cmos5l_a21oi_1
X_11192_ _11192_/X _11192_/A _11192_/B VPWR VGND sg13cmos5l_and2_1
X_13000_ _13001_/B _14487_/Q _13002_/D hold3559/X VPWR VGND sg13cmos5l_a21o_1
X_10143_ _10143_/Y _10143_/A _10143_/B VPWR VGND sg13cmos5l_nand2_1
XFILLER_43_1000 VPWR VGND sg13cmos5l_fill_2
XFILLER_88_871 VPWR VGND sg13cmos5l_decap_8
X_10074_ _10074_/Y _10074_/A _10074_/B VPWR VGND sg13cmos5l_nand2_1
XFILLER_87_392 VPWR VGND sg13cmos5l_fill_2
Xhold2980 _10297_/A _13911_/Q VPWR VGND sg13cmos5l_dlygate4sd3_1
Xhold2991 _10450_/A _13986_/Q VPWR VGND sg13cmos5l_dlygate4sd3_1
X_13902_ _13902_/Q clkload56/A _13902_/D _13902_/RESET_B VPWR VGND sg13cmos5l_dfrbpq_1
X_13415__2007 _13415_/RESET_B VPWR VGND sg13cmos5l_tiehi
X_13833_ _13833_/Q clkload59/A _13833_/D _13833_/RESET_B VPWR VGND sg13cmos5l_dfrbpq_1
XFILLER_43_440 VPWR VGND sg13cmos5l_decap_8
X_10976_ _10976_/Y _10976_/A _10976_/B VPWR VGND sg13cmos5l_nand2_1
X_13764_ _13764_/Q clkload52/A _13764_/D _13764_/RESET_B VPWR VGND sg13cmos5l_dfrbpq_1
X_13695_ _13695_/Q clkload51/A _13695_/D _13695_/RESET_B VPWR VGND sg13cmos5l_dfrbpq_1
X_12715_ _12715_/Y _12715_/A _12715_/B VPWR VGND sg13cmos5l_nor2_1
X_13300__2212 _13300_/RESET_B VPWR VGND sg13cmos5l_tiehi
X_12646_ _12648_/C _12646_/A _12646_/B _12646_/C VPWR VGND sg13cmos5l_nand3_1
X_14316_ _14316_/Q _14630_/CLK _14316_/D _14316_/RESET_B VPWR VGND sg13cmos5l_dfrbpq_1
X_12577_ _12577_/X _12577_/A _13229_/Q VPWR VGND sg13cmos5l_xor2_1
XFILLER_7_66 VPWR VGND sg13cmos5l_fill_1
X_11528_ _14335_/D _11526_/Y _11527_/Y _11509_/Y VPWR VGND sg13cmos5l_o21ai_1
X_14379__1129 _14379_/RESET_B VPWR VGND sg13cmos5l_tiehi
X_11459_ _11460_/B _11517_/A _11459_/B VPWR VGND sg13cmos5l_nor2_1
X_14415__1093 _14415_/RESET_B VPWR VGND sg13cmos5l_tiehi
X_14247_ _14247_/Q clkload43/A _14247_/D _14247_/RESET_B VPWR VGND sg13cmos5l_dfrbpq_1
XFILLER_98_613 VPWR VGND sg13cmos5l_fill_2
X_14178_ _14178_/Q clkload39/A _14178_/D _14178_/RESET_B VPWR VGND sg13cmos5l_dfrbpq_1
XFILLER_98_646 VPWR VGND sg13cmos5l_fill_1
X_13129_ _14551_/D hold3554/X _08039_/B _13136_/S VPWR VGND sg13cmos5l_mux2_1
XFILLER_66_543 VPWR VGND sg13cmos5l_decap_4
X_08670_ _08673_/B _13938_/Q _08687_/B VPWR VGND sg13cmos5l_nor2_1
XFILLER_66_598 VPWR VGND sg13cmos5l_decap_4
XFILLER_94_874 VPWR VGND sg13cmos5l_decap_8
X_07621_ _13030_/B _08098_/B _07622_/B VPWR VGND sg13cmos5l_nor2_1
XFILLER_81_524 VPWR VGND sg13cmos5l_decap_8
XFILLER_81_546 VPWR VGND sg13cmos5l_decap_8
X_07552_ _07559_/A _07552_/A _07552_/B _07552_/C _07552_/D VPWR VGND sg13cmos5l_nor4_1
X_14643__2186 _14643_/RESET_B VPWR VGND sg13cmos5l_tiehi
XFILLER_35_996 VPWR VGND sg13cmos5l_fill_1
XFILLER_50_944 VPWR VGND sg13cmos5l_fill_2
X_07483_ _07486_/B _14523_/Q _07512_/B _07527_/B1 _15884_/A VPWR VGND sg13cmos5l_a22oi_1
X_09222_ _13350_/D _08269_/A hold3014/X _09230_/B VPWR VGND sg13cmos5l_mux2_1
X_09153_ _09153_/Y _11499_/A _09152_/Y _09160_/A2 VPWR VGND sg13cmos5l_a21oi_1
X_14220__1257 _14220_/RESET_B VPWR VGND sg13cmos5l_tiehi
X_08104_ _08104_/Y _08104_/A _13110_/B _08104_/C VPWR VGND sg13cmos5l_nand3_1
X_09084_ _13310_/D _09095_/B _09082_/Y _09083_/Y VPWR VGND sg13cmos5l_a21oi_1
X_08035_ _08049_/B _13207_/Q _08033_/A _09342_/B VPWR VGND sg13cmos5l_o21ai_1
XFILLER_104_957 VPWR VGND sg13cmos5l_decap_8
XFILLER_77_819 VPWR VGND sg13cmos5l_decap_8
X_09986_ _13758_/D _10573_/A1 _10023_/B _09985_/Y VPWR VGND sg13cmos5l_o21ai_1
X_13791__1600 _13791_/RESET_B VPWR VGND sg13cmos5l_tiehi
X_08937_ _08937_/Y _07292_/Y _13188_/A2 _13192_/B1 _08936_/Y VPWR VGND sg13cmos5l_a22oi_1
Xhold2232 _14574_/D _07418_/Y VPWR VGND sg13cmos5l_dlygate4sd3_1
Xhold2243 _11115_/A _14296_/Q VPWR VGND sg13cmos5l_dlygate4sd3_1
Xhold2254 _10517_/A _14019_/Q VPWR VGND sg13cmos5l_dlygate4sd3_1
X_08868_ _08870_/B _08559_/B _08861_/C _08848_/B _08558_/A VPWR VGND sg13cmos5l_a22oi_1
Xhold2265 _14486_/D _12996_/Y VPWR VGND sg13cmos5l_dlygate4sd3_1
Xhold2276 _11233_/A _14317_/Q VPWR VGND sg13cmos5l_dlygate4sd3_1
Xhold2287 _09961_/A _13746_/Q VPWR VGND sg13cmos5l_dlygate4sd3_1
XFILLER_57_576 VPWR VGND sg13cmos5l_fill_1
X_07819_ _07843_/A _08908_/A _08904_/A VPWR VGND sg13cmos5l_nor2_1
Xhold2298 _14157_/D _10791_/Y VPWR VGND sg13cmos5l_dlygate4sd3_1
X_08799_ _08799_/Y _08455_/A _08879_/A2 _08798_/Y VPWR VGND sg13cmos5l_o21ai_1
XFILLER_26_985 VPWR VGND sg13cmos5l_fill_1
XFILLER_53_760 VPWR VGND sg13cmos5l_fill_1
XFILLER_72_557 VPWR VGND sg13cmos5l_fill_1
X_10830_ _14178_/D _14263_/D _14178_/Q _10832_/S VPWR VGND sg13cmos5l_mux2_1
X_10761_ _10761_/Y _10766_/B _10759_/Y _10760_/Y VPWR VGND sg13cmos5l_o21ai_1
X_10692_ _14112_/D input6/X _07973_/A _10692_/S VPWR VGND sg13cmos5l_mux2_1
X_13480_ _13480_/Q clkload28/A _13480_/D _13480_/RESET_B VPWR VGND sg13cmos5l_dfrbpq_1
X_12500_ _12500_/Y _12504_/A _12500_/B VPWR VGND sg13cmos5l_nand2_1
X_12431_ _12431_/Y _14468_/Q _11638_/Y _12545_/B _11638_/B _12165_/A VPWR VGND sg13cmos5l_a221oi_1
XFILLER_8_138 VPWR VGND sg13cmos5l_decap_8
XFILLER_8_149 VPWR VGND sg13cmos5l_fill_2
X_12362_ _12363_/A _12362_/A _12362_/B VPWR VGND sg13cmos5l_nand2_1
XFILLER_4_322 VPWR VGND sg13cmos5l_fill_2
X_11313_ _11313_/Y _11327_/B _11313_/B VPWR VGND sg13cmos5l_xnor2_1
X_12293_ _12295_/B _13964_/Q _12426_/B _12293_/B1 VPWR VGND sg13cmos5l_a21oi_1
X_14101_ _14101_/Q _14105_/CLK _14101_/D fanout995/X VPWR VGND sg13cmos5l_dfrbpq_1
X_11244_ _11244_/Y _11258_/A _11241_/X _11243_/Y _10982_/Y VPWR VGND sg13cmos5l_a22oi_1
X_14032_ _14032_/Q clkload78/A _14032_/D _14032_/RESET_B VPWR VGND sg13cmos5l_dfrbpq_1
X_11175_ _11176_/A _11192_/A _11214_/A _11193_/A VPWR VGND sg13cmos5l_o21ai_1
X_10126_ _13827_/D _10583_/A1 _10147_/B _10125_/Y VPWR VGND sg13cmos5l_o21ai_1
X_10057_ _13793_/D _10579_/A1 _10072_/B _10056_/Y VPWR VGND sg13cmos5l_o21ai_1
XFILLER_48_598 VPWR VGND sg13cmos5l_fill_1
XFILLER_63_535 VPWR VGND sg13cmos5l_decap_8
XFILLER_75_395 VPWR VGND sg13cmos5l_decap_8
XFILLER_63_557 VPWR VGND sg13cmos5l_fill_1
X_13816_ _13816_/Q _14631_/CLK _13816_/D _13816_/RESET_B VPWR VGND sg13cmos5l_dfrbpq_1
X_13654__1737 _13654_/RESET_B VPWR VGND sg13cmos5l_tiehi
X_10959_ _14221_/D _10959_/A VPWR VGND sg13cmos5l_inv_1
X_13747_ _13747_/Q clkload50/A _13747_/D _13747_/RESET_B VPWR VGND sg13cmos5l_dfrbpq_1
XFILLER_85_4 VPWR VGND sg13cmos5l_fill_2
X_13678_ _13678_/Q clkload55/A _13678_/D _13678_/RESET_B VPWR VGND sg13cmos5l_dfrbpq_1
X_14034__1357 _14034_/RESET_B VPWR VGND sg13cmos5l_tiehi
X_12629_ _12631_/B _14443_/Q _13233_/Q VPWR VGND sg13cmos5l_xnor2_1
XFILLER_98_410 VPWR VGND sg13cmos5l_fill_2
XFILLER_99_955 VPWR VGND sg13cmos5l_fill_1
XFILLER_99_988 VPWR VGND sg13cmos5l_decap_8
X_09840_ _09840_/Y _09840_/A _09846_/B VPWR VGND sg13cmos5l_nor2_1
Xfanout629 _12466_/B fanout637/X VPWR VGND sg13cmos5l_buf_1
Xfanout618 _11039_/B1 _07528_/B1 VPWR VGND sg13cmos5l_buf_1
Xfanout607 _12913_/B2 _11318_/B1 VPWR VGND sg13cmos5l_buf_1
X_09771_ _09771_/Y _09771_/A _09773_/B VPWR VGND sg13cmos5l_nor2_1
X_08722_ _08722_/Y _14005_/Q _08744_/B1 _08725_/B _13813_/Q VPWR VGND sg13cmos5l_a22oi_1
XFILLER_82_800 VPWR VGND sg13cmos5l_decap_8
X_14238__1239 _14238_/RESET_B VPWR VGND sg13cmos5l_tiehi
XFILLER_26_226 VPWR VGND sg13cmos5l_fill_1
XFILLER_27_749 VPWR VGND sg13cmos5l_fill_1
XFILLER_39_598 VPWR VGND sg13cmos5l_fill_2
XFILLER_66_395 VPWR VGND sg13cmos5l_decap_8
XFILLER_82_855 VPWR VGND sg13cmos5l_fill_1
X_08653_ _08653_/Y _11719_/S _08653_/B VPWR VGND sg13cmos5l_nand2b_1
XFILLER_54_568 VPWR VGND sg13cmos5l_fill_2
X_07604_ _07605_/B _13284_/Q _07606_/B _13285_/Q VPWR VGND sg13cmos5l_a21o_1
X_08584_ _08589_/B _08535_/B _08583_/Y _08581_/Y VPWR VGND sg13cmos5l_o21ai_1
X_07535_ _13030_/A input20/X input22/X _07535_/C VPWR VGND sg13cmos5l_nand3_1
X_07466_ _07470_/B _14524_/Q _07512_/B _07527_/B1 _15885_/A VPWR VGND sg13cmos5l_a22oi_1
XFILLER_22_476 VPWR VGND sg13cmos5l_fill_2
XFILLER_23_988 VPWR VGND sg13cmos5l_fill_2
X_09205_ _13334_/D _10683_/A1 hold3166/X _09208_/S VPWR VGND sg13cmos5l_mux2_1
X_07397_ _07397_/Y _07629_/A _07407_/B _07397_/C VPWR VGND sg13cmos5l_nand3_1
X_09136_ _09136_/Y _12130_/A _11029_/B _09135_/Y VPWR VGND sg13cmos5l_a21oi_1
X_13497__1925 _13497_/RESET_B VPWR VGND sg13cmos5l_tiehi
X_09067_ _09067_/Y _14320_/Q _09073_/B VPWR VGND sg13cmos5l_nand2_1
X_08018_ _08018_/Y _08050_/A _13273_/Q VPWR VGND sg13cmos5l_nand2_1
X_13732__1659 _13732_/RESET_B VPWR VGND sg13cmos5l_tiehi
XFILLER_104_776 VPWR VGND sg13cmos5l_fill_1
X_09969_ _09969_/Y _09969_/A _09969_/B VPWR VGND sg13cmos5l_nand2_1
XFILLER_76_148 VPWR VGND sg13cmos5l_fill_2
X_12980_ _12980_/X _12980_/A _12981_/C VPWR VGND sg13cmos5l_xor2_1
XFILLER_100_993 VPWR VGND sg13cmos5l_decap_8
XFILLER_27_30 VPWR VGND sg13cmos5l_fill_1
X_11931_ _11958_/B _11930_/A _11930_/B _11928_/Y VPWR VGND sg13cmos5l_a21oi_1
XFILLER_73_888 VPWR VGND sg13cmos5l_decap_4
X_11862_ _11864_/B _13693_/Q _11862_/B VPWR VGND sg13cmos5l_nand2_1
X_14650_ _14650_/Q _14650_/CLK _14650_/D _14650_/RESET_B VPWR VGND sg13cmos5l_dfrbpq_1
XFILLER_32_229 VPWR VGND sg13cmos5l_fill_2
X_10813_ _10813_/Y _14309_/Q _10759_/A _10816_/A2 VPWR VGND sg13cmos5l_a21oi_1
X_14581_ _14581_/Q clkload73/A _14581_/D _14581_/RESET_B VPWR VGND sg13cmos5l_dfrbpq_1
X_13601_ _13601_/Q clkload59/A _13601_/D _13601_/RESET_B VPWR VGND sg13cmos5l_dfrbpq_1
XFILLER_53_590 VPWR VGND sg13cmos5l_decap_4
X_11793_ _11794_/B _11793_/A1 _11789_/Y _11792_/Y VPWR VGND sg13cmos5l_o21ai_1
X_13532_ _13532_/Q _14109_/CLK _13532_/D _13532_/RESET_B VPWR VGND sg13cmos5l_dfrbpq_1
XFILLER_41_774 VPWR VGND sg13cmos5l_fill_1
X_10744_ _10744_/Y _10798_/A _14286_/Q VPWR VGND sg13cmos5l_nand2_1
X_13365__2057 _13365_/RESET_B VPWR VGND sg13cmos5l_tiehi
XFILLER_40_295 VPWR VGND sg13cmos5l_fill_2
X_10675_ _14097_/D _14273_/D _11611_/A _10675_/S VPWR VGND sg13cmos5l_mux2_1
X_13463_ _13463_/Q _14105_/CLK _13463_/D _13463_/RESET_B VPWR VGND sg13cmos5l_dfrbpq_1
X_13394_ _13394_/Q _14102_/CLK _13394_/D _13394_/RESET_B VPWR VGND sg13cmos5l_dfrbpq_1
X_12414_ _12416_/A _12387_/Y _12389_/Y _12388_/Y VPWR VGND sg13cmos5l_o21ai_1
XFILLER_5_620 VPWR VGND sg13cmos5l_fill_2
X_12345_ _12347_/B _13966_/Q _12348_/A2 _12345_/B1 _13710_/Q VPWR VGND sg13cmos5l_a22oi_1
X_14296__1212 _14296_/RESET_B VPWR VGND sg13cmos5l_tiehi
XFILLER_5_697 VPWR VGND sg13cmos5l_fill_2
X_12276_ _12276_/Y _12282_/A _12383_/A2 _12275_/Y VPWR VGND sg13cmos5l_o21ai_1
X_14642__2185 _14642_/RESET_B VPWR VGND sg13cmos5l_tiehi
X_11227_ _11242_/A _11256_/A _11228_/B VPWR VGND sg13cmos5l_and2_1
X_14015_ _14015_/Q clkload60/A _14015_/D _14015_/RESET_B VPWR VGND sg13cmos5l_dfrbpq_1
XFILLER_68_627 VPWR VGND sg13cmos5l_fill_1
XFILLER_95_402 VPWR VGND sg13cmos5l_fill_1
X_11158_ _11158_/Y _08435_/B _11157_/X _11149_/Y VPWR VGND sg13cmos5l_o21ai_1
X_13708__1683 _13708_/RESET_B VPWR VGND sg13cmos5l_tiehi
X_10109_ _10109_/Y _10109_/A _10109_/B VPWR VGND sg13cmos5l_nand2_1
XFILLER_48_340 VPWR VGND sg13cmos5l_decap_8
XFILLER_64_811 VPWR VGND sg13cmos5l_decap_8
X_11089_ _11089_/Y _11089_/A _11147_/B VPWR VGND sg13cmos5l_nor2_1
XFILLER_48_384 VPWR VGND sg13cmos5l_fill_1
XFILLER_82_118 VPWR VGND sg13cmos5l_fill_1
X_13887__1504 _13887_/RESET_B VPWR VGND sg13cmos5l_tiehi
XFILLER_63_332 VPWR VGND sg13cmos5l_decap_8
X_13575__1847 _13575_/RESET_B VPWR VGND sg13cmos5l_tiehi
XFILLER_17_771 VPWR VGND sg13cmos5l_fill_1
XFILLER_23_218 VPWR VGND sg13cmos5l_fill_2
X_07320_ _07320_/Y _07320_/A VPWR VGND sg13cmos5l_inv_1
X_07251_ _07251_/Y _07251_/A VPWR VGND sg13cmos5l_inv_1
X_07182_ _08616_/A _08625_/A VPWR VGND sg13cmos5l_inv_1
X_13410__2012 _13410_/RESET_B VPWR VGND sg13cmos5l_tiehi
Xfanout404 _11123_/B _11141_/B VPWR VGND sg13cmos5l_buf_1
X_09823_ _09823_/Y _09823_/A _09827_/B VPWR VGND sg13cmos5l_nor2_1
Xfanout448 _12238_/B1 _08656_/Y VPWR VGND sg13cmos5l_buf_1
Xfanout437 _10436_/B _10446_/B VPWR VGND sg13cmos5l_buf_1
Xfanout426 _10497_/B _10501_/B VPWR VGND sg13cmos5l_buf_1
Xfanout415 _10566_/B _10576_/B VPWR VGND sg13cmos5l_buf_1
XFILLER_59_649 VPWR VGND sg13cmos5l_decap_4
Xfanout459 _12377_/B1 fanout465/X VPWR VGND sg13cmos5l_buf_1
XFILLER_55_800 VPWR VGND sg13cmos5l_fill_2
X_09754_ _09754_/Y _09754_/A _09754_/B VPWR VGND sg13cmos5l_nor2_1
XFILLER_95_991 VPWR VGND sg13cmos5l_fill_2
X_08705_ _08705_/X _13812_/Q _13780_/Q _11752_/S VPWR VGND sg13cmos5l_mux2_1
X_09685_ _09690_/B _14467_/Q _09685_/B VPWR VGND sg13cmos5l_nand2_1
XFILLER_15_708 VPWR VGND sg13cmos5l_fill_1
X_08636_ _08637_/C _14192_/Q _08633_/B _07326_/Y _14188_/Q VPWR VGND sg13cmos5l_a22oi_1
Xclkbuf_leaf_93_clk clkload16/A clkbuf_4_2_0_clk/X VPWR VGND sg13cmos5l_buf_8
XFILLER_42_505 VPWR VGND sg13cmos5l_fill_2
XFILLER_70_858 VPWR VGND sg13cmos5l_fill_2
X_08567_ _08567_/Y _08572_/A _08567_/B VPWR VGND sg13cmos5l_nand2_1
X_14374__1134 _14374_/RESET_B VPWR VGND sg13cmos5l_tiehi
X_07518_ _07518_/Y _13033_/A VPWR VGND sg13cmos5l_inv_1
X_08498_ _08498_/Y _08498_/A _08498_/B VPWR VGND sg13cmos5l_nor2_1
Xfanout55 fanout55/X fanout56/X VPWR VGND sg13cmos5l_buf_1
X_07449_ _07450_/B _07526_/A1 _07447_/X _07448_/Y VPWR VGND sg13cmos5l_o21ai_1
Xfanout99 _09235_/S _09234_/S VPWR VGND sg13cmos5l_buf_1
Xfanout88 _09307_/B _09306_/S VPWR VGND sg13cmos5l_buf_1
Xfanout77 fanout77/X _09660_/Y VPWR VGND sg13cmos5l_buf_1
Xfanout66 _11979_/A _12154_/A VPWR VGND sg13cmos5l_buf_1
X_14095__1312 _14095_/RESET_B VPWR VGND sg13cmos5l_tiehi
X_10460_ _10460_/Y _10460_/A _10470_/B VPWR VGND sg13cmos5l_nor2_1
X_09119_ _09119_/Y _09119_/A _09137_/B VPWR VGND sg13cmos5l_nor2_1
X_10391_ _13957_/D _10587_/A1 _10402_/B _10390_/Y VPWR VGND sg13cmos5l_a21oi_1
X_12130_ _12134_/B _12130_/A _13248_/Q VPWR VGND sg13cmos5l_xor2_1
X_13965__1426 _13965_/RESET_B VPWR VGND sg13cmos5l_tiehi
X_12061_ _12061_/Y _13668_/Q _12057_/B _12238_/B1 VPWR VGND sg13cmos5l_a21oi_1
XFILLER_77_413 VPWR VGND sg13cmos5l_decap_8
X_11012_ _11012_/Y _14195_/Q _11012_/B VPWR VGND sg13cmos5l_nor2_1
XFILLER_77_457 VPWR VGND sg13cmos5l_fill_2
XFILLER_78_958 VPWR VGND sg13cmos5l_fill_2
Xfanout960 fanout960/X fanout962/X VPWR VGND sg13cmos5l_buf_1
XFILLER_92_405 VPWR VGND sg13cmos5l_fill_2
Xfanout971 _09199_/A fanout973/X VPWR VGND sg13cmos5l_buf_1
Xfanout982 fanout982/X fanout983/X VPWR VGND sg13cmos5l_buf_1
Xfanout993 fanout993/X fanout994/X VPWR VGND sg13cmos5l_buf_1
X_12963_ _12964_/C _12963_/A _12963_/B _12963_/C VPWR VGND sg13cmos5l_nor3_1
XFILLER_18_568 VPWR VGND sg13cmos5l_fill_2
X_11914_ _11917_/A _13631_/Q _11914_/A2 _11783_/B VPWR VGND sg13cmos5l_a21oi_1
Xclkbuf_leaf_84_clk _14045_/CLK clkload4/A VPWR VGND sg13cmos5l_buf_8
XFILLER_45_365 VPWR VGND sg13cmos5l_decap_4
X_14633_ _14633_/Q clkload69/A _14633_/D _14633_/RESET_B VPWR VGND sg13cmos5l_dfrbpq_1
X_12894_ _12895_/C _14468_/Q _13227_/Q VPWR VGND sg13cmos5l_xor2_1
X_11845_ _14352_/D _07235_/Y _11870_/A _11844_/Y VPWR VGND sg13cmos5l_a21oi_1
XFILLER_60_357 VPWR VGND sg13cmos5l_fill_1
XFILLER_60_379 VPWR VGND sg13cmos5l_fill_2
X_11776_ _11776_/Y _14010_/Q _11695_/B _11725_/B VPWR VGND sg13cmos5l_a21oi_1
X_14564_ _14564_/Q clkload72/A _14564_/D _14564_/RESET_B VPWR VGND sg13cmos5l_dfrbpq_1
X_10727_ _10727_/Y _10727_/A _10808_/S VPWR VGND sg13cmos5l_nand2_1
X_14495_ _14495_/Q _14576_/CLK _14495_/D fanout976/X VPWR VGND sg13cmos5l_dfrbpq_1
X_13515_ _13515_/Q clkload34/A _13515_/D _13515_/RESET_B VPWR VGND sg13cmos5l_dfrbpq_1
X_13446_ _13446_/Q clkload42/A _13446_/D _13446_/RESET_B VPWR VGND sg13cmos5l_dfrbpq_1
X_10658_ _10658_/Y _10657_/A _11029_/C _10654_/Y VPWR VGND sg13cmos5l_o21ai_1
Xclkload25 clkload25/Y clkload25/A VPWR VGND sg13cmos5l_inv_1
Xclkload14 clkload14/Y clkload14/A VPWR VGND sg13cmos5l_inv_1
X_10589_ _14054_/D fanout80/X _10602_/B _10588_/Y VPWR VGND sg13cmos5l_o21ai_1
Xclkload69 clkload69/Y clkload69/A VPWR VGND sg13cmos5l_inv_1
Xclkload58 clkload58/Y clkload58/A VPWR VGND sg13cmos5l_inv_1
Xclkload47 clkload47/Y clkload47/A VPWR VGND sg13cmos5l_inv_2
Xclkload36 clkload36/Y clkload36/A VPWR VGND sg13cmos5l_inv_4
X_13377_ _13377_/Q clkload31/A _13377_/D _13377_/RESET_B VPWR VGND sg13cmos5l_dfrbpq_1
X_12328_ _14369_/D _12301_/A _12251_/A _12309_/Y _12327_/Y VPWR VGND sg13cmos5l_a22oi_1
X_12259_ _12259_/Y _12256_/C _12255_/Y _12136_/A VPWR VGND sg13cmos5l_a21oi_1
Xhold2809 _11051_/A _14279_/Q VPWR VGND sg13cmos5l_dlygate4sd3_1
XFILLER_69_958 VPWR VGND sg13cmos5l_fill_1
XFILLER_96_744 VPWR VGND sg13cmos5l_fill_1
XFILLER_49_682 VPWR VGND sg13cmos5l_decap_8
XFILLER_83_427 VPWR VGND sg13cmos5l_fill_1
XFILLER_52_803 VPWR VGND sg13cmos5l_fill_1
XFILLER_64_630 VPWR VGND sg13cmos5l_decap_8
XFILLER_64_641 VPWR VGND sg13cmos5l_fill_2
X_09470_ _09470_/X _14125_/Q hold3331/X _09475_/S VPWR VGND sg13cmos5l_mux2_1
Xclkbuf_leaf_75_clk clkload57/A clkbuf_4_10_0_clk/X VPWR VGND sg13cmos5l_buf_8
X_14467__1023 _14467_/RESET_B VPWR VGND sg13cmos5l_tiehi
XFILLER_51_302 VPWR VGND sg13cmos5l_fill_1
XFILLER_91_471 VPWR VGND sg13cmos5l_decap_8
X_08421_ _14273_/D _14273_/Q _12636_/B _08421_/S VPWR VGND sg13cmos5l_mux2_1
X_08352_ _08352_/Y _08388_/A _08350_/X _08351_/Y _08349_/X _08391_/B1 VPWR VGND sg13cmos5l_a221oi_1
XFILLER_60_880 VPWR VGND sg13cmos5l_decap_8
X_07303_ _07303_/Y _07303_/A VPWR VGND sg13cmos5l_inv_1
X_08283_ _08283_/X _13511_/Q _13479_/Q _08283_/S VPWR VGND sg13cmos5l_mux2_1
X_14188__1289 _14188_/RESET_B VPWR VGND sg13cmos5l_tiehi
X_07234_ _11846_/A _14353_/Q VPWR VGND sg13cmos5l_inv_1
Xclkload8 clkload8/Y clkload8/A VPWR VGND sg13cmos5l_inv_2
X_07165_ _09657_/A _14463_/Q VPWR VGND sg13cmos5l_inv_1
XFILLER_106_838 VPWR VGND sg13cmos5l_decap_8
XFILLER_59_39 VPWR VGND sg13cmos5l_fill_1
XFILLER_87_700 VPWR VGND sg13cmos5l_fill_2
Xfanout223 _09979_/B _09989_/B VPWR VGND sg13cmos5l_buf_1
Xfanout212 _10034_/B _10052_/B VPWR VGND sg13cmos5l_buf_1
Xfanout201 _10099_/B _10119_/B VPWR VGND sg13cmos5l_buf_1
XFILLER_87_733 VPWR VGND sg13cmos5l_fill_2
Xfanout256 _10412_/B _10414_/B VPWR VGND sg13cmos5l_buf_1
Xfanout245 _08379_/C1 _08204_/A1 VPWR VGND sg13cmos5l_buf_1
Xfanout234 _10569_/A1 _09550_/Y VPWR VGND sg13cmos5l_buf_1
XFILLER_75_16 VPWR VGND sg13cmos5l_fill_2
X_07998_ _07998_/Y _14240_/Q _08000_/A _11014_/B VPWR VGND sg13cmos5l_nand3_1
X_09806_ _13670_/D fanout80/X _09821_/B _09805_/Y VPWR VGND sg13cmos5l_a21oi_1
Xfanout289 _10173_/B _10156_/Y VPWR VGND sg13cmos5l_buf_1
Xfanout278 _10274_/B _10284_/B VPWR VGND sg13cmos5l_buf_1
Xfanout267 _10347_/B _10349_/B VPWR VGND sg13cmos5l_buf_1
X_14428__1080 _14428_/RESET_B VPWR VGND sg13cmos5l_tiehi
XFILLER_86_287 VPWR VGND sg13cmos5l_fill_1
X_09737_ _13637_/D _10326_/A1 _09748_/B _09736_/Y VPWR VGND sg13cmos5l_a21oi_1
XFILLER_39_181 VPWR VGND sg13cmos5l_fill_2
Xclkbuf_leaf_66_clk _14064_/CLK clkbuf_4_14_0_clk/X VPWR VGND sg13cmos5l_buf_8
XFILLER_15_516 VPWR VGND sg13cmos5l_decap_8
XFILLER_55_696 VPWR VGND sg13cmos5l_fill_1
XFILLER_83_972 VPWR VGND sg13cmos5l_fill_2
X_09668_ _11561_/B _14434_/Q _14653_/Q _09689_/S VPWR VGND sg13cmos5l_mux2_1
XFILLER_43_858 VPWR VGND sg13cmos5l_fill_1
X_08619_ _08621_/B _08619_/A _08619_/B _08619_/C VPWR VGND sg13cmos5l_nor3_1
X_09599_ _09599_/Y _09617_/A _11395_/B _09598_/Y VPWR VGND sg13cmos5l_o21ai_1
X_14641__2184 _14641_/RESET_B VPWR VGND sg13cmos5l_tiehi
X_11630_ _11630_/X _14214_/Q _14212_/Q _14213_/Q _14215_/Q VPWR VGND sg13cmos5l_or4_1
XFILLER_23_593 VPWR VGND sg13cmos5l_fill_1
X_11561_ _11562_/B _11605_/A _11561_/B VPWR VGND sg13cmos5l_nand2_1
XFILLER_10_221 VPWR VGND sg13cmos5l_fill_1
XFILLER_24_86 VPWR VGND sg13cmos5l_fill_2
X_10512_ _14016_/D _10577_/A1 _10531_/B _10511_/Y VPWR VGND sg13cmos5l_o21ai_1
X_13300_ _13300_/Q clkload20/A _13300_/D _13300_/RESET_B VPWR VGND sg13cmos5l_dfrbpq_1
X_11492_ _11492_/Y _11492_/A _11504_/B VPWR VGND sg13cmos5l_xnor2_1
X_14280_ _14280_/Q _14292_/CLK _14280_/D _14280_/RESET_B VPWR VGND sg13cmos5l_dfrbpq_1
X_10443_ _13982_/D _10573_/A1 _10480_/B _10442_/Y VPWR VGND sg13cmos5l_a21oi_1
X_13231_ _13231_/Q clkload38/A _13231_/D _13231_/RESET_B VPWR VGND sg13cmos5l_dfrbpq_1
XFILLER_40_96 VPWR VGND sg13cmos5l_fill_2
X_10374_ _10374_/Y _10374_/A _10374_/B VPWR VGND sg13cmos5l_nor2_1
X_13162_ _13162_/Y _13162_/A _13162_/B VPWR VGND sg13cmos5l_nand2_1
XFILLER_3_965 VPWR VGND sg13cmos5l_fill_2
X_12113_ _12113_/Y _13766_/Q _12346_/A2 _12345_/B1 _13830_/Q VPWR VGND sg13cmos5l_a22oi_1
X_14233__1244 _14233_/RESET_B VPWR VGND sg13cmos5l_tiehi
X_13093_ _13095_/B _14531_/Q _13099_/D VPWR VGND sg13cmos5l_nand2_1
X_12044_ _12077_/A _12093_/A _13245_/Q VPWR VGND sg13cmos5l_nand2_1
XFILLER_49_94 VPWR VGND sg13cmos5l_fill_2
Xfanout790 _08301_/S _08375_/S VPWR VGND sg13cmos5l_buf_1
XFILLER_58_490 VPWR VGND sg13cmos5l_decap_8
XFILLER_81_909 VPWR VGND sg13cmos5l_fill_1
Xclkbuf_leaf_57_clk _14453_/CLK clkload7/A VPWR VGND sg13cmos5l_buf_8
X_13995_ _13995_/Q clkload62/A _13995_/D _13995_/RESET_B VPWR VGND sg13cmos5l_dfrbpq_1
XFILLER_18_376 VPWR VGND sg13cmos5l_fill_1
XFILLER_92_268 VPWR VGND sg13cmos5l_fill_2
X_12946_ _14460_/D _12946_/A VPWR VGND sg13cmos5l_inv_1
X_13492__1930 _13492_/RESET_B VPWR VGND sg13cmos5l_tiehi
X_12877_ _12877_/Y _12884_/B _12876_/Y _12897_/A VPWR VGND sg13cmos5l_o21ai_1
X_11828_ _11828_/Y _13980_/Q _11971_/A2 _11966_/B _13788_/Q _12010_/C1 VPWR VGND sg13cmos5l_a221oi_1
X_14616_ _14616_/Q clkload73/A _14616_/D _14616_/RESET_B VPWR VGND sg13cmos5l_dfrbpq_1
X_14547_ _14547_/Q clkload12/A _14547_/D fanout957/X VPWR VGND sg13cmos5l_dfrbpq_1
X_11759_ _12634_/B _11759_/A _11867_/B VPWR VGND sg13cmos5l_nand2_1
X_14478_ _14478_/Q clkload10/A _14478_/D fanout975/X VPWR VGND sg13cmos5l_dfrbpq_1
X_13429_ _13429_/Q clkload15/A _13429_/D _13429_/RESET_B VPWR VGND sg13cmos5l_dfrbpq_1
XFILLER_6_781 VPWR VGND sg13cmos5l_fill_2
X_08970_ _08971_/B _08970_/A _12963_/C VPWR VGND sg13cmos5l_xnor2_1
Xhold3329 hold3329/X _13356_/Q VPWR VGND sg13cmos5l_dlygate4sd3_1
Xhold3318 hold3318/X _13471_/Q VPWR VGND sg13cmos5l_dlygate4sd3_1
Xhold3307 _13535_/D _09424_/X VPWR VGND sg13cmos5l_dlygate4sd3_1
XFILLER_69_733 VPWR VGND sg13cmos5l_fill_1
X_07921_ _07921_/Y _10978_/B _11618_/C _11019_/A VPWR VGND sg13cmos5l_nand3_1
Xhold2606 _10161_/A _13844_/Q VPWR VGND sg13cmos5l_dlygate4sd3_1
Xhold2617 _10222_/A _13874_/Q VPWR VGND sg13cmos5l_dlygate4sd3_1
Xhold2628 _11095_/A _14291_/Q VPWR VGND sg13cmos5l_dlygate4sd3_1
XFILLER_68_254 VPWR VGND sg13cmos5l_fill_2
X_07852_ _11014_/B _10653_/A _08431_/C _07851_/Y VPWR VGND sg13cmos5l_a21o_1
Xhold2639 _13090_/A _14529_/Q VPWR VGND sg13cmos5l_dlygate4sd3_1
XFILLER_56_438 VPWR VGND sg13cmos5l_decap_4
XFILLER_96_585 VPWR VGND sg13cmos5l_fill_2
Xinput1 input1/X rst_n VPWR VGND sg13cmos5l_buf_1
XFILLER_72_909 VPWR VGND sg13cmos5l_fill_2
X_07783_ _07784_/A _07842_/A _07775_/A _07782_/Y VPWR VGND sg13cmos5l_o21ai_1
X_09522_ _09522_/Y _09535_/A _09522_/B VPWR VGND sg13cmos5l_nor2_1
Xclkbuf_leaf_48_clk clkload74/A clkload6/A VPWR VGND sg13cmos5l_buf_8
XFILLER_64_471 VPWR VGND sg13cmos5l_fill_1
XFILLER_65_994 VPWR VGND sg13cmos5l_fill_2
X_13360__2062 _13360_/RESET_B VPWR VGND sg13cmos5l_tiehi
XFILLER_92_791 VPWR VGND sg13cmos5l_fill_1
X_09453_ _09453_/X _14108_/Q hold3187/X _09453_/S VPWR VGND sg13cmos5l_mux2_1
XFILLER_101_58 VPWR VGND sg13cmos5l_fill_1
XFILLER_80_975 VPWR VGND sg13cmos5l_fill_2
X_08404_ _08404_/Y _08403_/S _07322_/Y _08404_/B1 VPWR VGND sg13cmos5l_a21oi_1
X_09384_ _09384_/X _14105_/Q hold3209/X _09401_/S VPWR VGND sg13cmos5l_mux2_1
X_08335_ _08335_/Y _08338_/S _13387_/Q _08334_/Y VPWR VGND sg13cmos5l_o21ai_1
X_08266_ _08266_/X _08260_/Y _08261_/Y _08379_/C1 VPWR VGND sg13cmos5l_a21o_1
Xheichips26_loopcache_rv_2213 uio_oe[1] VPWR VGND sg13cmos5l_tiehi
Xheichips26_loopcache_rv_2224 uio_oe[12] VPWR VGND sg13cmos5l_tiehi
X_13667__1724 _13667_/RESET_B VPWR VGND sg13cmos5l_tiehi
XFILLER_4_707 VPWR VGND sg13cmos5l_fill_2
X_07217_ _12248_/A _14367_/Q VPWR VGND sg13cmos5l_inv_1
X_08197_ _08198_/C _13220_/Q _08207_/B1 _11039_/A2 _14533_/Q VPWR VGND sg13cmos5l_a22oi_1
XFILLER_10_66 VPWR VGND sg13cmos5l_fill_1
X_14047__1344 _14047_/RESET_B VPWR VGND sg13cmos5l_tiehi
XFILLER_0_935 VPWR VGND sg13cmos5l_decap_8
XFILLER_59_210 VPWR VGND sg13cmos5l_fill_2
X_10090_ _10090_/Y _10416_/B _10090_/B VPWR VGND sg13cmos5l_nand2_1
X_13570__1852 _13570_/RESET_B VPWR VGND sg13cmos5l_tiehi
XFILLER_102_874 VPWR VGND sg13cmos5l_decap_4
XFILLER_19_86 VPWR VGND sg13cmos5l_fill_1
XFILLER_74_224 VPWR VGND sg13cmos5l_fill_2
Xclkbuf_leaf_39_clk clkload40/A clkbuf_4_6_0_clk/X VPWR VGND sg13cmos5l_buf_8
X_12800_ _12800_/X _12891_/A1 _12611_/Y _12739_/A VPWR VGND sg13cmos5l_a21o_1
XFILLER_71_920 VPWR VGND sg13cmos5l_fill_1
X_10992_ _14230_/D _10989_/Y _10990_/Y _10991_/Y VPWR VGND sg13cmos5l_a21oi_1
X_13780_ _13780_/Q clkload17/A _13780_/D _13780_/RESET_B VPWR VGND sg13cmos5l_dfrbpq_1
XFILLER_16_836 VPWR VGND sg13cmos5l_fill_1
X_12731_ _12731_/Y _12731_/A _12730_/Y VPWR VGND sg13cmos5l_nor2b_1
XFILLER_70_441 VPWR VGND sg13cmos5l_fill_2
X_12662_ _12663_/D _12658_/Y _12677_/A _12661_/Y VPWR VGND sg13cmos5l_o21ai_1
XFILLER_43_688 VPWR VGND sg13cmos5l_fill_2
XFILLER_70_485 VPWR VGND sg13cmos5l_decap_8
XFILLER_71_997 VPWR VGND sg13cmos5l_fill_1
X_11613_ _11614_/B _11613_/A _11613_/B _11613_/C VPWR VGND sg13cmos5l_nor3_1
X_14401_ _14401_/Q _14650_/CLK _14401_/D _14401_/RESET_B VPWR VGND sg13cmos5l_dfrbpq_1
X_12593_ _12594_/B _12601_/A _12587_/Y _12591_/X _12592_/Y _11672_/B VPWR VGND sg13cmos5l_a221oi_1
X_11544_ _11564_/A _11563_/A _11553_/B VPWR VGND sg13cmos5l_nand2_1
X_14332_ _14332_/Q clkload79/A _14332_/D _14332_/RESET_B VPWR VGND sg13cmos5l_dfrbpq_1
XFILLER_100_1000 VPWR VGND sg13cmos5l_decap_8
X_11475_ _11477_/B _11493_/A _11493_/B VPWR VGND sg13cmos5l_nor2_1
X_14263_ _14263_/Q clkload39/A _14263_/D _14263_/RESET_B VPWR VGND sg13cmos5l_dfrbpq_1
X_10426_ _10426_/Y _10426_/A _10432_/B VPWR VGND sg13cmos5l_nor2_1
X_13214_ _13214_/Q _14532_/CLK _13214_/D fanout974/X VPWR VGND sg13cmos5l_dfrbpq_1
X_14194_ _14194_/Q clkload44/A _14194_/D _14194_/RESET_B VPWR VGND sg13cmos5l_dfrbpq_1
X_10357_ _13940_/D _10357_/A1 _10366_/B _10356_/Y VPWR VGND sg13cmos5l_a21oi_1
X_13145_ _13146_/B _09344_/A _13138_/B _13138_/Y hold3484/X VPWR VGND sg13cmos5l_a22oi_1
XFILLER_3_784 VPWR VGND sg13cmos5l_fill_2
X_10288_ _13906_/D _10549_/A1 _10299_/B _10287_/Y VPWR VGND sg13cmos5l_a21oi_1
X_13076_ _13078_/B _13076_/A _13040_/D VPWR VGND sg13cmos5l_nor2b_1
X_12027_ _12027_/Y _14019_/Q _12030_/B _12345_/B1 _13827_/Q VPWR VGND sg13cmos5l_a22oi_1
XFILLER_20_1001 VPWR VGND sg13cmos5l_fill_1
XFILLER_65_235 VPWR VGND sg13cmos5l_fill_2
XFILLER_66_758 VPWR VGND sg13cmos5l_decap_8
X_13978_ _13978_/Q _14042_/CLK _13978_/D _13978_/RESET_B VPWR VGND sg13cmos5l_dfrbpq_1
X_13745__1646 _13745_/RESET_B VPWR VGND sg13cmos5l_tiehi
XFILLER_46_471 VPWR VGND sg13cmos5l_fill_2
XFILLER_46_482 VPWR VGND sg13cmos5l_fill_1
XFILLER_62_920 VPWR VGND sg13cmos5l_fill_1
X_13433__1989 _13433_/RESET_B VPWR VGND sg13cmos5l_tiehi
X_12929_ _12930_/A hold3519/X _11358_/B _11401_/B _12933_/B2 VPWR VGND sg13cmos5l_a22oi_1
XFILLER_61_452 VPWR VGND sg13cmos5l_fill_1
XFILLER_61_463 VPWR VGND sg13cmos5l_decap_8
XFILLER_21_327 VPWR VGND sg13cmos5l_fill_2
XFILLER_61_485 VPWR VGND sg13cmos5l_decap_8
X_13960__1431 _13960_/RESET_B VPWR VGND sg13cmos5l_tiehi
X_08120_ _08123_/B _13211_/Q _13210_/Q _13212_/Q _08143_/B VPWR VGND sg13cmos5l_nand4_1
X_08051_ _08051_/Y _09199_/B _08050_/Y _08005_/Y VPWR VGND sg13cmos5l_a21oi_1
Xhold3104 _07264_/A _14250_/Q VPWR VGND sg13cmos5l_dlygate4sd3_1
Xhold3115 _13537_/D _09426_/X VPWR VGND sg13cmos5l_dlygate4sd3_1
X_14640__2183 _14640_/RESET_B VPWR VGND sg13cmos5l_tiehi
X_13993__1398 _13993_/RESET_B VPWR VGND sg13cmos5l_tiehi
X_13378__2044 _13378_/RESET_B VPWR VGND sg13cmos5l_tiehi
XFILLER_102_126 VPWR VGND sg13cmos5l_fill_2
X_08953_ _13267_/D _08042_/B hold3445/X _10778_/B VPWR VGND sg13cmos5l_mux2_1
Xhold2403 _10531_/A _14026_/Q VPWR VGND sg13cmos5l_dlygate4sd3_1
Xhold3126 hold3126/X _14110_/Q VPWR VGND sg13cmos5l_dlygate4sd3_1
Xhold3137 hold3137/X _13501_/Q VPWR VGND sg13cmos5l_dlygate4sd3_1
Xhold3148 hold3148/X _13507_/Q VPWR VGND sg13cmos5l_dlygate4sd3_1
XFILLER_97_872 VPWR VGND sg13cmos5l_decap_8
X_07904_ _07911_/A _10848_/A _07944_/B VPWR VGND sg13cmos5l_nand2_1
Xhold2414 _10556_/A _14038_/Q VPWR VGND sg13cmos5l_dlygate4sd3_1
Xhold2425 _10736_/A _14139_/Q VPWR VGND sg13cmos5l_dlygate4sd3_1
Xhold2436 _08987_/A _13276_/Q VPWR VGND sg13cmos5l_dlygate4sd3_1
Xhold3159 hold3159/X _13543_/Q VPWR VGND sg13cmos5l_dlygate4sd3_1
XFILLER_97_883 VPWR VGND sg13cmos5l_fill_1
XFILLER_99_1002 VPWR VGND sg13cmos5l_decap_8
X_08884_ _14649_/D hold2354/X _08900_/A2 _08883_/Y VPWR VGND sg13cmos5l_a21o_1
Xhold2447 _10523_/A _14022_/Q VPWR VGND sg13cmos5l_dlygate4sd3_1
Xhold2458 _10489_/A _14005_/Q VPWR VGND sg13cmos5l_dlygate4sd3_1
Xhold2469 _10636_/A _14074_/Q VPWR VGND sg13cmos5l_dlygate4sd3_1
XFILLER_57_769 VPWR VGND sg13cmos5l_fill_2
X_07835_ _08808_/A _14379_/Q _14347_/Q VPWR VGND sg13cmos5l_and2_1
XFILLER_72_739 VPWR VGND sg13cmos5l_fill_2
X_07766_ _08540_/B _07767_/A _07767_/B VPWR VGND sg13cmos5l_and2_1
X_09505_ _13589_/D _09511_/B _10555_/A1 _09504_/Y VPWR VGND sg13cmos5l_a21oi_1
XFILLER_13_806 VPWR VGND sg13cmos5l_fill_1
XFILLER_13_817 VPWR VGND sg13cmos5l_fill_2
XFILLER_53_964 VPWR VGND sg13cmos5l_decap_4
X_07697_ _08497_/A _14384_/Q _11821_/A VPWR VGND sg13cmos5l_or2_1
X_09436_ _13547_/D _08332_/A hold3352/X _09442_/S VPWR VGND sg13cmos5l_mux2_1
XFILLER_40_614 VPWR VGND sg13cmos5l_fill_2
XFILLER_80_772 VPWR VGND sg13cmos5l_fill_2
X_09367_ _09367_/X _14121_/Q hold3093/X _09373_/S VPWR VGND sg13cmos5l_mux2_1
X_08318_ _12640_/B _08311_/Y _08317_/Y _08307_/Y VPWR VGND sg13cmos5l_o21ai_1
X_09298_ _13418_/D _08320_/A hold3132/X _09306_/S VPWR VGND sg13cmos5l_mux2_1
X_13588__1834 _13588_/RESET_B VPWR VGND sg13cmos5l_tiehi
X_08249_ _08249_/Y _13412_/Q _08309_/A VPWR VGND sg13cmos5l_nand2b_1
XFILLER_4_537 VPWR VGND sg13cmos5l_fill_2
X_11260_ _11260_/Y _11243_/A _11256_/D _12923_/B2 VPWR VGND sg13cmos5l_o21ai_1
X_10211_ _10211_/Y _10211_/A _10211_/B VPWR VGND sg13cmos5l_nor2_1
X_11191_ _11203_/A _11214_/A _11214_/B VPWR VGND sg13cmos5l_and2_1
X_13823__1568 _13823_/RESET_B VPWR VGND sg13cmos5l_tiehi
XFILLER_0_732 VPWR VGND sg13cmos5l_fill_2
X_10142_ _13835_/D _10599_/A1 _10143_/B _10141_/Y VPWR VGND sg13cmos5l_o21ai_1
X_14454__1048 _14454_/RESET_B VPWR VGND sg13cmos5l_tiehi
X_10073_ _13801_/D _10595_/A1 _10072_/B _10072_/Y VPWR VGND sg13cmos5l_o21ai_1
Xhold2970 _09714_/A _13626_/Q VPWR VGND sg13cmos5l_dlygate4sd3_1
Xhold2981 _11065_/A _14284_/Q VPWR VGND sg13cmos5l_dlygate4sd3_1
Xhold2992 _10345_/A _13935_/Q VPWR VGND sg13cmos5l_dlygate4sd3_1
X_13901_ _13901_/Q _14053_/CLK _13901_/D _13901_/RESET_B VPWR VGND sg13cmos5l_dfrbpq_1
X_13832_ _13832_/Q _14640_/CLK _13832_/D _13832_/RESET_B VPWR VGND sg13cmos5l_dfrbpq_1
X_14183__1294 _14183_/RESET_B VPWR VGND sg13cmos5l_tiehi
X_13763_ _13763_/Q clkload56/A _13763_/D _13763_/RESET_B VPWR VGND sg13cmos5l_dfrbpq_1
XFILLER_90_558 VPWR VGND sg13cmos5l_fill_1
X_10975_ _14227_/D _10851_/A _10973_/Y _10974_/Y VPWR VGND sg13cmos5l_o21ai_1
X_12714_ _12715_/B _11150_/X _12608_/Y _12609_/X _11157_/A VPWR VGND sg13cmos5l_a22oi_1
Xheichips26_loopcache_rv uio_oe[0] VPWR VGND sg13cmos5l_tiehi
X_13694_ _13694_/Q clkload51/A _13694_/D _13694_/RESET_B VPWR VGND sg13cmos5l_dfrbpq_1
X_12645_ _12646_/C _14444_/Q _13234_/Q VPWR VGND sg13cmos5l_xnor2_1
X_12576_ _12576_/X _12577_/A _13229_/Q VPWR VGND sg13cmos5l_and2_1
X_11527_ _11527_/Y _11466_/A _11555_/C _11558_/B1 VPWR VGND sg13cmos5l_o21ai_1
X_14315_ _14315_/Q _14630_/CLK _14315_/D _14315_/RESET_B VPWR VGND sg13cmos5l_dfrbpq_1
X_14387__1121 _14387_/RESET_B VPWR VGND sg13cmos5l_tiehi
X_11458_ _11459_/B _11393_/B _11392_/B _11393_/X _11334_/A _11457_/Y VPWR VGND sg13cmos5l_a221oi_1
X_14246_ _14246_/Q clkload43/A _14246_/D _14246_/RESET_B VPWR VGND sg13cmos5l_dfrbpq_1
X_10409_ _13966_/D fanout73/X _10408_/B _10408_/Y VPWR VGND sg13cmos5l_a21oi_1
X_11389_ _11389_/Y _11389_/A _11389_/B VPWR VGND sg13cmos5l_nor2_1
X_14177_ _14177_/Q clkload45/A _14177_/D _14177_/RESET_B VPWR VGND sg13cmos5l_dfrbpq_1
X_13128_ _13136_/S _13140_/A _13128_/B _13128_/C VPWR VGND sg13cmos5l_nor3_1
XFILLER_97_179 VPWR VGND sg13cmos5l_fill_2
X_14310__1198 _14310_/RESET_B VPWR VGND sg13cmos5l_tiehi
X_13059_ _14515_/D _13059_/A _13061_/C VPWR VGND sg13cmos5l_xor2_1
X_13978__1413 _13978_/RESET_B VPWR VGND sg13cmos5l_tiehi
XFILLER_81_503 VPWR VGND sg13cmos5l_fill_1
X_07620_ _07622_/B _14242_/Q _12963_/B _08157_/B VPWR VGND sg13cmos5l_nand3_1
XFILLER_81_536 VPWR VGND sg13cmos5l_decap_4
X_07551_ _07552_/D _14554_/Q _13295_/Q VPWR VGND sg13cmos5l_xor2_1
X_07482_ _07486_/A _14487_/Q _07528_/B1 _07467_/Y input20/X VPWR VGND sg13cmos5l_a22oi_1
X_13227__1053 _13227_/RESET_B VPWR VGND sg13cmos5l_tiehi
XFILLER_22_669 VPWR VGND sg13cmos5l_fill_2
X_09221_ _13349_/D _08257_/A hold3145/X _09230_/B VPWR VGND sg13cmos5l_mux2_1
X_09152_ _09152_/Y _14430_/Q _11530_/A VPWR VGND sg13cmos5l_nand2_1
X_08103_ _08104_/C _09410_/A _08095_/Y _08111_/B _08961_/A VPWR VGND sg13cmos5l_a22oi_1
X_09083_ _09083_/Y _09083_/A _09095_/B VPWR VGND sg13cmos5l_nor2_1
X_08034_ _09342_/B _14548_/Q _14547_/Q _14550_/Q _14549_/Q VPWR VGND sg13cmos5l_or4_1
XFILLER_103_402 VPWR VGND sg13cmos5l_fill_1
X_09985_ _09985_/Y _09985_/A _10023_/B VPWR VGND sg13cmos5l_nand2_1
XFILLER_57_500 VPWR VGND sg13cmos5l_decap_8
XFILLER_57_511 VPWR VGND sg13cmos5l_fill_2
X_08936_ _08936_/Y hold3541/X _13191_/B1 _08938_/B1 VPWR VGND sg13cmos5l_a21oi_1
Xhold2233 _10649_/A _14081_/Q VPWR VGND sg13cmos5l_dlygate4sd3_1
Xhold2244 _14152_/D _10776_/Y VPWR VGND sg13cmos5l_dlygate4sd3_1
Xhold2255 _10145_/A _13837_/Q VPWR VGND sg13cmos5l_dlygate4sd3_1
XFILLER_29_235 VPWR VGND sg13cmos5l_fill_1
XFILLER_57_544 VPWR VGND sg13cmos5l_decap_4
XFILLER_69_393 VPWR VGND sg13cmos5l_decap_4
X_08867_ _08870_/A _08867_/A _08867_/B VPWR VGND sg13cmos5l_nand2_1
Xhold2266 _10570_/A _14045_/Q VPWR VGND sg13cmos5l_dlygate4sd3_1
Xhold2277 _10760_/A _14147_/Q VPWR VGND sg13cmos5l_dlygate4sd3_1
Xhold2288 _10005_/A _13768_/Q VPWR VGND sg13cmos5l_dlygate4sd3_1
XFILLER_29_279 VPWR VGND sg13cmos5l_fill_2
X_07818_ _08623_/A _08904_/A VPWR VGND sg13cmos5l_inv_1
Xhold2299 _11420_/A _14329_/Q VPWR VGND sg13cmos5l_dlygate4sd3_1
X_08798_ _08798_/Y _07720_/Y _08808_/B _08831_/B1 _07724_/B VPWR VGND sg13cmos5l_a22oi_1
X_07749_ _07749_/Y _08500_/A _07748_/Y _07743_/Y VPWR VGND sg13cmos5l_a21oi_1
XFILLER_12_102 VPWR VGND sg13cmos5l_fill_2
XFILLER_41_912 VPWR VGND sg13cmos5l_fill_1
XFILLER_53_772 VPWR VGND sg13cmos5l_decap_8
X_10760_ _10760_/Y _10760_/A _10766_/B VPWR VGND sg13cmos5l_nand2_1
XFILLER_12_113 VPWR VGND sg13cmos5l_fill_1
XFILLER_9_607 VPWR VGND sg13cmos5l_decap_4
X_09419_ _13530_/D _08170_/A hold3074/X _09421_/S VPWR VGND sg13cmos5l_mux2_1
X_10691_ _14111_/D input5/X _07961_/A _10692_/S VPWR VGND sg13cmos5l_mux2_1
X_12430_ _12545_/B _12430_/A1 _12423_/Y _12429_/Y VPWR VGND sg13cmos5l_a21o_1
XFILLER_5_813 VPWR VGND sg13cmos5l_fill_1
X_14100_ _14100_/Q _14117_/CLK _14100_/D fanout996/X VPWR VGND sg13cmos5l_dfrbpq_1
X_12361_ _12364_/C _12362_/A _12361_/B _12362_/B VPWR VGND sg13cmos5l_nor3_1
X_11312_ _11313_/B _11312_/A _11312_/B VPWR VGND sg13cmos5l_nand2_1
X_12292_ _12295_/A _13644_/Q _12292_/B VPWR VGND sg13cmos5l_nand2_1
XFILLER_106_0 VPWR VGND sg13cmos5l_fill_2
X_11243_ _11243_/Y _11243_/A _11243_/B VPWR VGND sg13cmos5l_nand2_1
X_14031_ _14031_/Q _14065_/CLK _14031_/D _14031_/RESET_B VPWR VGND sg13cmos5l_dfrbpq_1
X_11174_ _11214_/A _14312_/Q _09495_/X _11197_/S VPWR VGND sg13cmos5l_mux2_1
XFILLER_48_511 VPWR VGND sg13cmos5l_fill_1
X_10125_ _10125_/Y _10125_/A _10147_/B VPWR VGND sg13cmos5l_nand2_1
X_10056_ _10056_/Y _10056_/A _10072_/B VPWR VGND sg13cmos5l_nand2_1
Xhold3490 _12460_/A _14383_/Q VPWR VGND sg13cmos5l_dlygate4sd3_1
XFILLER_48_555 VPWR VGND sg13cmos5l_fill_1
XFILLER_75_352 VPWR VGND sg13cmos5l_fill_1
XFILLER_35_227 VPWR VGND sg13cmos5l_fill_1
XFILLER_17_953 VPWR VGND sg13cmos5l_fill_2
X_13815_ _13815_/Q _14299_/CLK _13815_/D _13815_/RESET_B VPWR VGND sg13cmos5l_dfrbpq_1
XFILLER_44_794 VPWR VGND sg13cmos5l_fill_2
X_10958_ _10959_/A _10843_/B _10960_/B _10906_/Y _10971_/C VPWR VGND sg13cmos5l_a22oi_1
X_13746_ _13746_/Q clkload54/A _13746_/D _13746_/RESET_B VPWR VGND sg13cmos5l_dfrbpq_1
XFILLER_43_293 VPWR VGND sg13cmos5l_fill_1
XFILLER_71_591 VPWR VGND sg13cmos5l_fill_1
X_13677_ _13677_/Q _14053_/CLK _13677_/D _13677_/RESET_B VPWR VGND sg13cmos5l_dfrbpq_1
X_10889_ _10971_/B _14247_/D _14248_/D VPWR VGND sg13cmos5l_nor2b_1
X_12628_ _12646_/A _14443_/Q _13233_/Q VPWR VGND sg13cmos5l_nand2_1
XFILLER_89_1001 VPWR VGND sg13cmos5l_fill_1
X_13695__1696 _13695_/RESET_B VPWR VGND sg13cmos5l_tiehi
X_12559_ _12559_/X _12735_/A _12559_/B VPWR VGND sg13cmos5l_and2_1
X_14229_ _14229_/Q clkload45/A _14229_/D _14229_/RESET_B VPWR VGND sg13cmos5l_dfrbpq_1
XFILLER_59_809 VPWR VGND sg13cmos5l_decap_8
Xfanout619 _07528_/B1 _07436_/Y VPWR VGND sg13cmos5l_buf_1
Xfanout608 _12923_/B2 _11318_/B1 VPWR VGND sg13cmos5l_buf_1
XFILLER_21_0 VPWR VGND sg13cmos5l_fill_2
XFILLER_39_500 VPWR VGND sg13cmos5l_fill_2
X_09770_ _13652_/D _10357_/A1 _09773_/B _09769_/Y VPWR VGND sg13cmos5l_a21oi_1
X_08721_ _08721_/Y _13749_/Q _11809_/A2 _11788_/C1 VPWR VGND sg13cmos5l_a21oi_1
X_08652_ _08652_/Y _08652_/A _08655_/A VPWR VGND sg13cmos5l_nor2b_1
XFILLER_67_897 VPWR VGND sg13cmos5l_fill_1
XFILLER_82_834 VPWR VGND sg13cmos5l_decap_8
X_07603_ _07628_/B _13287_/Q _07603_/B VPWR VGND sg13cmos5l_xnor2_1
XFILLER_82_878 VPWR VGND sg13cmos5l_fill_2
XFILLER_93_193 VPWR VGND sg13cmos5l_fill_2
X_08583_ _08583_/Y _08583_/A _08583_/B VPWR VGND sg13cmos5l_nand2_1
XFILLER_81_366 VPWR VGND sg13cmos5l_fill_1
X_07534_ _07535_/C _13146_/A _14470_/Q VPWR VGND sg13cmos5l_nor2_1
XFILLER_50_731 VPWR VGND sg13cmos5l_decap_8
XFILLER_50_742 VPWR VGND sg13cmos5l_fill_2
XFILLER_50_753 VPWR VGND sg13cmos5l_fill_1
XFILLER_62_580 VPWR VGND sg13cmos5l_decap_8
X_07465_ _07470_/A _14067_/Q _07465_/B VPWR VGND sg13cmos5l_nand2_1
X_09204_ _13333_/D _09414_/A0 hold3091/X _09208_/S VPWR VGND sg13cmos5l_mux2_1
XFILLER_10_639 VPWR VGND sg13cmos5l_decap_4
X_07396_ _07397_/C _07396_/A _07571_/A _07414_/A _07570_/A VPWR VGND sg13cmos5l_nor4_1
X_09135_ _09135_/Y _11451_/A _09134_/Y _09135_/B1 VPWR VGND sg13cmos5l_a21oi_1
X_09066_ _13307_/D _08989_/A _13197_/A2 _09064_/X _09065_/Y VPWR VGND sg13cmos5l_a22oi_1
X_08017_ _08031_/A _14551_/Q _08039_/B VPWR VGND sg13cmos5l_xnor2_1
XFILLER_104_700 VPWR VGND sg13cmos5l_decap_8
XFILLER_89_400 VPWR VGND sg13cmos5l_fill_1
XFILLER_77_606 VPWR VGND sg13cmos5l_fill_1
XFILLER_89_444 VPWR VGND sg13cmos5l_fill_2
X_13740__1651 _13740_/RESET_B VPWR VGND sg13cmos5l_tiehi
XFILLER_77_617 VPWR VGND sg13cmos5l_fill_1
X_09968_ _13749_/D _10555_/A1 _09969_/B _09967_/Y VPWR VGND sg13cmos5l_o21ai_1
X_08919_ _08919_/Y _11316_/A _14095_/Q _13195_/B1 hold3423/X VPWR VGND sg13cmos5l_a22oi_1
XFILLER_57_341 VPWR VGND sg13cmos5l_fill_1
X_09899_ _13715_/D _10551_/A1 _09910_/B _09898_/Y VPWR VGND sg13cmos5l_a21oi_1
X_11930_ _11930_/Y _11930_/A _11930_/B VPWR VGND sg13cmos5l_nand2_1
XFILLER_45_536 VPWR VGND sg13cmos5l_fill_2
X_11861_ _11864_/A _13629_/Q _11944_/A1 _11783_/B VPWR VGND sg13cmos5l_a21oi_1
XFILLER_26_761 VPWR VGND sg13cmos5l_fill_2
XFILLER_60_517 VPWR VGND sg13cmos5l_fill_2
X_10812_ _10812_/Y _07328_/Y _10763_/B _10811_/Y VPWR VGND sg13cmos5l_a21oi_1
X_11792_ _11792_/Y _14445_/Q _11686_/B _11791_/Y VPWR VGND sg13cmos5l_a21oi_1
X_14580_ _14580_/Q clkload73/A _14580_/D _14580_/RESET_B VPWR VGND sg13cmos5l_dfrbpq_1
X_13600_ _13600_/Q clkload47/A _13600_/D _13600_/RESET_B VPWR VGND sg13cmos5l_dfrbpq_1
XFILLER_41_731 VPWR VGND sg13cmos5l_fill_2
XFILLER_72_399 VPWR VGND sg13cmos5l_fill_2
X_10743_ _10743_/Y _10793_/B _10741_/Y _10742_/Y VPWR VGND sg13cmos5l_o21ai_1
X_13531_ _13531_/Q _14109_/CLK _13531_/D _13531_/RESET_B VPWR VGND sg13cmos5l_dfrbpq_1
XFILLER_13_477 VPWR VGND sg13cmos5l_fill_1
XFILLER_13_499 VPWR VGND sg13cmos5l_decap_8
X_10674_ _14096_/D _14261_/D hold3506/X _10826_/S VPWR VGND sg13cmos5l_mux2_1
X_13462_ _13462_/Q clkload27/A _13462_/D _13462_/RESET_B VPWR VGND sg13cmos5l_dfrbpq_1
X_13393_ _13393_/Q clkload30/A _13393_/D _13393_/RESET_B VPWR VGND sg13cmos5l_dfrbpq_1
X_12413_ _12413_/Y _12432_/B _12415_/A VPWR VGND sg13cmos5l_nand2b_1
X_12344_ _12347_/A _13902_/Q _12344_/B VPWR VGND sg13cmos5l_nand2_1
X_12275_ _12275_/Y _12382_/A _12275_/B VPWR VGND sg13cmos5l_nand2_1
X_14014_ _14014_/Q clkload63/A _14014_/D _14014_/RESET_B VPWR VGND sg13cmos5l_dfrbpq_1
X_11226_ _11226_/Y _11226_/A _11226_/B VPWR VGND sg13cmos5l_xnor2_1
XFILLER_68_639 VPWR VGND sg13cmos5l_fill_1
XFILLER_96_926 VPWR VGND sg13cmos5l_fill_2
X_11157_ _11157_/X _11157_/A _12637_/C VPWR VGND sg13cmos5l_or2_1
X_10108_ _13818_/D _10369_/A1 _10107_/B _10107_/Y VPWR VGND sg13cmos5l_o21ai_1
X_11088_ _11088_/Y _14389_/Q _11088_/A2 _11087_/X VPWR VGND sg13cmos5l_a21oi_1
XFILLER_91_620 VPWR VGND sg13cmos5l_fill_2
X_10039_ _13784_/D _10561_/A1 _10042_/B _10038_/Y VPWR VGND sg13cmos5l_o21ai_1
XFILLER_56_1000 VPWR VGND sg13cmos5l_fill_2
X_13782__1609 _13782_/RESET_B VPWR VGND sg13cmos5l_tiehi
X_13729_ _13729_/Q clkload57/A _13729_/D _13729_/RESET_B VPWR VGND sg13cmos5l_dfrbpq_1
X_07250_ _11093_/A _14374_/Q VPWR VGND sg13cmos5l_inv_1
X_07181_ _10871_/A _14222_/Q VPWR VGND sg13cmos5l_inv_1
XFILLER_69_0 VPWR VGND sg13cmos5l_fill_2
XFILLER_8_492 VPWR VGND sg13cmos5l_decap_4
XFILLER_99_742 VPWR VGND sg13cmos5l_fill_1
Xfanout405 _11141_/B fanout414/X VPWR VGND sg13cmos5l_buf_1
XFILLER_48_19 VPWR VGND sg13cmos5l_fill_2
XFILLER_99_775 VPWR VGND sg13cmos5l_fill_1
X_09822_ _13678_/D fanout73/X _09821_/B _09821_/Y VPWR VGND sg13cmos5l_a21oi_1
Xfanout438 _10446_/B _10467_/A2 VPWR VGND sg13cmos5l_buf_1
Xfanout427 _10501_/B _10511_/B VPWR VGND sg13cmos5l_buf_1
Xfanout416 _10576_/B _10577_/A2 VPWR VGND sg13cmos5l_buf_1
XFILLER_101_736 VPWR VGND sg13cmos5l_fill_2
X_09753_ _13645_/D fanout76/X _09730_/B _09752_/Y VPWR VGND sg13cmos5l_a21oi_1
Xfanout449 _08747_/B _08725_/B VPWR VGND sg13cmos5l_buf_1
X_08704_ _08704_/Y _08700_/Y _08701_/Y _08702_/Y _08703_/Y VPWR VGND sg13cmos5l_a22oi_1
XFILLER_55_812 VPWR VGND sg13cmos5l_fill_1
X_09684_ _09686_/B _14467_/Q _09685_/B VPWR VGND sg13cmos5l_nor2_1
X_08635_ _08637_/B _14615_/Q _14189_/Q VPWR VGND sg13cmos5l_nand2b_1
XFILLER_70_837 VPWR VGND sg13cmos5l_decap_4
XFILLER_82_697 VPWR VGND sg13cmos5l_fill_2
X_08566_ _08567_/B _07665_/C _08554_/B _07779_/B VPWR VGND sg13cmos5l_a21oi_1
XFILLER_23_731 VPWR VGND sg13cmos5l_fill_2
X_07517_ _13033_/A _07532_/A _07517_/B VPWR VGND sg13cmos5l_nand2_1
XFILLER_50_550 VPWR VGND sg13cmos5l_decap_8
X_08497_ _08497_/Y _08497_/A _08497_/B VPWR VGND sg13cmos5l_nand2_1
Xfanout56 fanout56/X _09692_/Y VPWR VGND sg13cmos5l_buf_1
XFILLER_22_263 VPWR VGND sg13cmos5l_fill_1
X_07448_ _07448_/Y _08227_/A2 _07446_/Y _07526_/A1 VPWR VGND sg13cmos5l_o21ai_1
Xfanout89 _09306_/S _09295_/B VPWR VGND sg13cmos5l_buf_1
Xfanout78 fanout78/X _09660_/Y VPWR VGND sg13cmos5l_buf_1
Xfanout67 _12127_/A _12154_/A VPWR VGND sg13cmos5l_buf_1
X_13758__1633 _13758_/RESET_B VPWR VGND sg13cmos5l_tiehi
XFILLER_10_458 VPWR VGND sg13cmos5l_fill_1
XFILLER_6_407 VPWR VGND sg13cmos5l_fill_2
X_07379_ _07587_/A _12963_/A _14540_/Q VPWR VGND sg13cmos5l_xnor2_1
X_13446__1976 _13446_/RESET_B VPWR VGND sg13cmos5l_tiehi
X_09118_ _09118_/Y _12093_/A _09135_/B1 _09117_/Y VPWR VGND sg13cmos5l_a21oi_1
X_10390_ _10390_/Y _10390_/A _10402_/B VPWR VGND sg13cmos5l_nor2_1
X_09049_ _13304_/D _09077_/B _09047_/Y _09048_/Y VPWR VGND sg13cmos5l_a21oi_1
X_12060_ _12060_/Y _13700_/Q _12060_/B VPWR VGND sg13cmos5l_nand2_1
X_11011_ _14237_/D _11011_/A _11011_/B VPWR VGND sg13cmos5l_nand2_1
Xfanout950 _12594_/A _07198_/Y VPWR VGND sg13cmos5l_buf_1
Xfanout961 fanout961/X fanout962/X VPWR VGND sg13cmos5l_buf_1
XFILLER_46_801 VPWR VGND sg13cmos5l_fill_2
Xfanout972 fanout972/X fanout973/X VPWR VGND sg13cmos5l_buf_1
Xfanout983 fanout983/X fanout988/X VPWR VGND sg13cmos5l_buf_1
Xfanout994 fanout994/X input1/X VPWR VGND sg13cmos5l_buf_1
XFILLER_64_108 VPWR VGND sg13cmos5l_fill_1
XFILLER_86_992 VPWR VGND sg13cmos5l_fill_2
XFILLER_92_417 VPWR VGND sg13cmos5l_fill_2
XFILLER_92_439 VPWR VGND sg13cmos5l_decap_4
X_12962_ _14468_/D _12962_/A VPWR VGND sg13cmos5l_inv_1
XFILLER_100_791 VPWR VGND sg13cmos5l_fill_2
X_11913_ _11913_/Y _13855_/Q _12203_/B1 _12005_/B _13663_/Q _12010_/C1 VPWR VGND sg13cmos5l_a221oi_1
X_12893_ _14436_/D _12890_/X _12892_/Y _12893_/B1 VPWR VGND sg13cmos5l_a21oi_1
XFILLER_45_355 VPWR VGND sg13cmos5l_fill_1
X_11844_ _11844_/Y _14447_/Q _12353_/B _11849_/B _11826_/Y _11843_/X VPWR VGND sg13cmos5l_a221oi_1
X_14632_ _14632_/Q clkload69/A _14632_/D _14632_/RESET_B VPWR VGND sg13cmos5l_dfrbpq_1
X_13229__1045 _13229_/RESET_B VPWR VGND sg13cmos5l_tiehi
XFILLER_60_369 VPWR VGND sg13cmos5l_decap_4
X_11775_ _11775_/Y _13978_/Q _11945_/S VPWR VGND sg13cmos5l_nand2_1
X_14563_ _14563_/Q clkload38/A _14563_/D _14563_/RESET_B VPWR VGND sg13cmos5l_dfrbpq_1
X_10726_ _10726_/Y _10774_/A _14280_/Q VPWR VGND sg13cmos5l_nand2_1
X_14494_ _14494_/Q clkload10/A _14494_/D fanout975/X VPWR VGND sg13cmos5l_dfrbpq_1
X_13514_ _13514_/Q clkload35/A _13514_/D _13514_/RESET_B VPWR VGND sg13cmos5l_dfrbpq_1
XFILLER_9_267 VPWR VGND sg13cmos5l_fill_1
X_10657_ _10657_/Y _10657_/A _11029_/C VPWR VGND sg13cmos5l_nor2_1
X_13445_ _13445_/Q clkload42/A _13445_/D _13445_/RESET_B VPWR VGND sg13cmos5l_dfrbpq_1
XFILLER_10_981 VPWR VGND sg13cmos5l_fill_1
Xclkload26 clkload26/Y clkload26/A VPWR VGND sg13cmos5l_inv_2
Xclkload15 clkload15/Y clkload15/A VPWR VGND sg13cmos5l_inv_1
XFILLER_86_1026 VPWR VGND sg13cmos5l_fill_2
X_10588_ _10588_/Y _10588_/A _10602_/B VPWR VGND sg13cmos5l_nand2_1
Xclkload59 clkload59/Y clkload59/A VPWR VGND sg13cmos5l_inv_1
Xclkload48 clkload48/Y clkload48/A VPWR VGND sg13cmos5l_inv_1
Xclkload37 clkload37/Y clkload37/A VPWR VGND sg13cmos5l_inv_1
X_13376_ _13376_/Q _13568_/CLK _13376_/D _13376_/RESET_B VPWR VGND sg13cmos5l_dfrbpq_1
X_12327_ _12327_/Y _12385_/A _12327_/B VPWR VGND sg13cmos5l_nor2_1
X_12258_ _12258_/Y _12284_/A _12257_/Y VPWR VGND sg13cmos5l_nor2b_1
X_11209_ _11225_/A _14086_/Q _11214_/D VPWR VGND sg13cmos5l_nand2_1
X_12189_ _12189_/Y _12216_/B _12189_/B VPWR VGND sg13cmos5l_xnor2_1
XFILLER_95_91 VPWR VGND sg13cmos5l_fill_1
X_13836__1555 _13836_/RESET_B VPWR VGND sg13cmos5l_tiehi
X_13524__1898 _13524_/RESET_B VPWR VGND sg13cmos5l_tiehi
XFILLER_91_461 VPWR VGND sg13cmos5l_decap_4
X_08420_ _12636_/B _08418_/Y _08419_/Y _08409_/Y VPWR VGND sg13cmos5l_o21ai_1
XFILLER_64_697 VPWR VGND sg13cmos5l_decap_4
X_08351_ _08351_/Y _08403_/S _07317_/Y _08404_/B1 VPWR VGND sg13cmos5l_a21oi_1
XFILLER_32_583 VPWR VGND sg13cmos5l_fill_2
X_07302_ _07302_/Y _13347_/Q VPWR VGND sg13cmos5l_inv_1
X_08282_ _08282_/X _09293_/A _08307_/B VPWR VGND sg13cmos5l_and2_1
XFILLER_20_745 VPWR VGND sg13cmos5l_fill_1
X_07233_ _07691_/A _14385_/Q VPWR VGND sg13cmos5l_inv_1
Xclkload9 clkload9/Y clkload9/A VPWR VGND sg13cmos5l_inv_4
X_14196__1281 _14196_/RESET_B VPWR VGND sg13cmos5l_tiehi
XFILLER_106_817 VPWR VGND sg13cmos5l_fill_2
X_07164_ _09676_/A _14466_/Q VPWR VGND sg13cmos5l_inv_1
Xfanout213 _10052_/B _10054_/B VPWR VGND sg13cmos5l_buf_1
Xfanout202 _10119_/B _10120_/A2 VPWR VGND sg13cmos5l_buf_1
XFILLER_8_1026 VPWR VGND sg13cmos5l_fill_2
Xfanout246 _08406_/B1 _08204_/A1 VPWR VGND sg13cmos5l_buf_1
Xfanout235 _10308_/A1 _09550_/Y VPWR VGND sg13cmos5l_buf_1
Xfanout224 _09969_/B _09989_/B VPWR VGND sg13cmos5l_buf_1
XFILLER_75_918 VPWR VGND sg13cmos5l_decap_4
XFILLER_87_778 VPWR VGND sg13cmos5l_fill_2
X_07997_ _07997_/X _10978_/B _14657_/Q _07997_/C _07997_/D VPWR VGND sg13cmos5l_and4_1
X_09805_ _09805_/Y _09805_/A _09821_/B VPWR VGND sg13cmos5l_nor2_1
Xfanout279 _10284_/B _10221_/Y VPWR VGND sg13cmos5l_buf_1
Xfanout268 _10349_/B _10341_/B VPWR VGND sg13cmos5l_buf_1
Xfanout257 _10414_/B _10406_/B VPWR VGND sg13cmos5l_buf_1
XFILLER_28_812 VPWR VGND sg13cmos5l_fill_2
X_09736_ _09736_/Y _09736_/A _09748_/B VPWR VGND sg13cmos5l_nor2_1
X_09667_ _13613_/D _09666_/B fanout75/X _09666_/Y VPWR VGND sg13cmos5l_a21oi_1
XFILLER_54_163 VPWR VGND sg13cmos5l_fill_1
XFILLER_70_601 VPWR VGND sg13cmos5l_fill_2
XFILLER_82_472 VPWR VGND sg13cmos5l_decap_4
X_08618_ _14611_/D _08619_/A _08618_/B VPWR VGND sg13cmos5l_xor2_1
X_09598_ _09598_/Y _09604_/B _09597_/Y _09617_/A VPWR VGND sg13cmos5l_o21ai_1
X_14323__1185 _14323_/RESET_B VPWR VGND sg13cmos5l_tiehi
X_08549_ _14601_/D _08582_/A _08549_/B VPWR VGND sg13cmos5l_xnor2_1
X_11560_ _11560_/Y _11560_/A _11560_/B VPWR VGND sg13cmos5l_nand2_1
XFILLER_50_380 VPWR VGND sg13cmos5l_decap_8
X_10511_ _10511_/Y _10511_/A _10511_/B VPWR VGND sg13cmos5l_nand2_1
X_11491_ _11491_/Y _11614_/A _11491_/B VPWR VGND sg13cmos5l_nor2_1
X_13230_ _13230_/Q _14622_/CLK _13230_/D _13230_/RESET_B VPWR VGND sg13cmos5l_dfrbpq_1
X_10442_ _10442_/Y _10442_/A _10480_/B VPWR VGND sg13cmos5l_nor2_1
XFILLER_3_911 VPWR VGND sg13cmos5l_fill_1
XFILLER_40_86 VPWR VGND sg13cmos5l_fill_2
X_10373_ _13948_/D _10569_/A1 _10374_/B _10372_/Y VPWR VGND sg13cmos5l_a21oi_1
X_13914__1477 _13914_/RESET_B VPWR VGND sg13cmos5l_tiehi
X_13161_ _13230_/D _11660_/B _13164_/A2 _13159_/Y _13160_/Y VPWR VGND sg13cmos5l_a22oi_1
X_12112_ _12112_/Y _14054_/Q _12348_/A2 _12345_/B1 _13798_/Q _12349_/C1 VPWR VGND
+ sg13cmos5l_a221oi_1
X_13092_ _14530_/D _13092_/A _13092_/B VPWR VGND sg13cmos5l_xor2_1
X_12043_ _14359_/D _07764_/B _12127_/A _12024_/Y _12042_/Y VPWR VGND sg13cmos5l_a22oi_1
XFILLER_2_487 VPWR VGND sg13cmos5l_decap_8
XFILLER_2_498 VPWR VGND sg13cmos5l_fill_1
XFILLER_78_756 VPWR VGND sg13cmos5l_decap_4
XFILLER_1_47 VPWR VGND sg13cmos5l_fill_1
Xfanout791 _08363_/S _08375_/S VPWR VGND sg13cmos5l_buf_1
Xfanout780 _08391_/B1 _08405_/C1 VPWR VGND sg13cmos5l_buf_1
X_13994_ _13994_/Q clkload51/A _13994_/D _13994_/RESET_B VPWR VGND sg13cmos5l_dfrbpq_1
XFILLER_33_303 VPWR VGND sg13cmos5l_fill_1
XFILLER_46_664 VPWR VGND sg13cmos5l_fill_2
XFILLER_61_601 VPWR VGND sg13cmos5l_decap_8
XFILLER_65_72 VPWR VGND sg13cmos5l_fill_1
XFILLER_65_83 VPWR VGND sg13cmos5l_fill_2
X_14609__2152 _14609_/RESET_B VPWR VGND sg13cmos5l_tiehi
X_12945_ _12946_/A hold3553/X _12945_/A2 _11504_/B _12945_/B2 VPWR VGND sg13cmos5l_a22oi_1
XFILLER_73_483 VPWR VGND sg13cmos5l_fill_2
X_12876_ _12876_/Y _12871_/A _12871_/B _12869_/Y VPWR VGND sg13cmos5l_o21ai_1
XFILLER_61_678 VPWR VGND sg13cmos5l_decap_8
X_11827_ _11827_/Y _14044_/Q _11969_/A2 _11944_/A1 _13724_/Q VPWR VGND sg13cmos5l_a22oi_1
X_14615_ _14615_/Q clkload73/A _14615_/D _14615_/RESET_B VPWR VGND sg13cmos5l_dfrbpq_1
X_11758_ _11758_/Y _11747_/Y _11751_/Y _11757_/Y _11837_/C1 VPWR VGND sg13cmos5l_a22oi_1
X_14546_ _14546_/Q clkload21/A _14546_/D fanout983/X VPWR VGND sg13cmos5l_dfrbpq_1
XFILLER_41_380 VPWR VGND sg13cmos5l_decap_4
X_10709_ _14129_/D input7/X _08397_/A _10709_/S VPWR VGND sg13cmos5l_mux2_1
X_13509__1913 _13509_/RESET_B VPWR VGND sg13cmos5l_tiehi
X_11689_ _11689_/Y _14039_/Q _11702_/B VPWR VGND sg13cmos5l_nand2_1
X_14477_ _14477_/Q clkload10/A _14477_/D fanout975/X VPWR VGND sg13cmos5l_dfrbpq_1
X_13428_ _13428_/Q clkload15/A _13428_/D _13428_/RESET_B VPWR VGND sg13cmos5l_dfrbpq_1
X_13359_ _13359_/Q clkload33/A _13359_/D _13359_/RESET_B VPWR VGND sg13cmos5l_dfrbpq_1
X_07920_ _11019_/A _14570_/Q _07997_/C VPWR VGND sg13cmos5l_and2_1
Xhold3319 hold3319/X _13358_/Q VPWR VGND sg13cmos5l_dlygate4sd3_1
Xhold3308 _13055_/A _15891_/A VPWR VGND sg13cmos5l_dlygate4sd3_1
Xhold2607 _09825_/A _13680_/Q VPWR VGND sg13cmos5l_dlygate4sd3_1
Xhold2618 _09942_/A _13737_/Q VPWR VGND sg13cmos5l_dlygate4sd3_1
Xhold2629 _07330_/A _14167_/Q VPWR VGND sg13cmos5l_dlygate4sd3_1
XFILLER_68_233 VPWR VGND sg13cmos5l_fill_2
X_07851_ _07851_/Y _08168_/A _11149_/B _07851_/C VPWR VGND sg13cmos5l_nor3_1
X_07782_ _07782_/Y _07656_/A _14365_/Q _07781_/Y VPWR VGND sg13cmos5l_a21oi_1
Xinput2 input2/X ui_in[0] VPWR VGND sg13cmos5l_buf_1
XFILLER_65_951 VPWR VGND sg13cmos5l_decap_4
X_09521_ _09522_/B _09534_/C _09534_/D VPWR VGND sg13cmos5l_nor2_1
XFILLER_25_826 VPWR VGND sg13cmos5l_fill_2
XFILLER_37_686 VPWR VGND sg13cmos5l_fill_1
XFILLER_64_461 VPWR VGND sg13cmos5l_decap_4
X_09452_ _09452_/X _14107_/Q hold3175/X _09453_/S VPWR VGND sg13cmos5l_mux2_1
X_08403_ _08403_/X _13584_/Q _13552_/Q _08403_/S VPWR VGND sg13cmos5l_mux2_1
X_09383_ _13495_/D _09416_/A0 hold3099/X _09396_/S VPWR VGND sg13cmos5l_mux2_1
XFILLER_51_177 VPWR VGND sg13cmos5l_fill_1
XFILLER_52_689 VPWR VGND sg13cmos5l_fill_1
X_08334_ _08334_/Y _08338_/S _07316_/Y _08339_/B1 VPWR VGND sg13cmos5l_a21oi_1
X_08265_ _08265_/Y _08405_/A1 _08263_/X _08264_/Y _08262_/X _08391_/B1 VPWR VGND sg13cmos5l_a221oi_1
Xheichips26_loopcache_rv_2214 uio_oe[2] VPWR VGND sg13cmos5l_tiehi
Xheichips26_loopcache_rv_2225 uio_oe[13] VPWR VGND sg13cmos5l_tiehi
X_07216_ _07216_/Y _12282_/A VPWR VGND sg13cmos5l_inv_1
X_08196_ _08198_/B _14481_/Q _08209_/B1 _11039_/B1 _14497_/Q VPWR VGND sg13cmos5l_a22oi_1
X_14308__1200 _14308_/RESET_B VPWR VGND sg13cmos5l_tiehi
XFILLER_106_603 VPWR VGND sg13cmos5l_fill_2
XFILLER_106_614 VPWR VGND sg13cmos5l_fill_1
XFILLER_106_636 VPWR VGND sg13cmos5l_decap_4
XFILLER_0_914 VPWR VGND sg13cmos5l_decap_8
XFILLER_102_853 VPWR VGND sg13cmos5l_fill_2
XFILLER_19_108 VPWR VGND sg13cmos5l_fill_2
XFILLER_16_804 VPWR VGND sg13cmos5l_fill_1
X_09719_ _13628_/D _10308_/A1 _09730_/B _09718_/Y VPWR VGND sg13cmos5l_a21oi_1
X_10991_ _10991_/Y _14230_/Q _10989_/Y _10848_/A VPWR VGND sg13cmos5l_o21ai_1
XFILLER_43_623 VPWR VGND sg13cmos5l_fill_1
XFILLER_55_483 VPWR VGND sg13cmos5l_decap_8
X_12730_ _12730_/Y _14452_/Q _13242_/Q VPWR VGND sg13cmos5l_nand2_1
XFILLER_37_1009 VPWR VGND sg13cmos5l_fill_2
X_12661_ _12661_/Y _12658_/Y _12677_/A _12792_/A VPWR VGND sg13cmos5l_a21oi_1
X_11612_ _11612_/Y _11613_/A _11613_/B _11613_/C VPWR VGND sg13cmos5l_o21ai_1
X_14400_ _14400_/Q _14650_/CLK _14400_/D _14400_/RESET_B VPWR VGND sg13cmos5l_dfrbpq_1
X_12592_ _12592_/Y _12591_/A _12591_/B _12792_/A VPWR VGND sg13cmos5l_a21oi_1
X_11543_ _11553_/B _11543_/A _11543_/B VPWR VGND sg13cmos5l_nand2_1
X_14331_ _14331_/Q clkload79/A _14331_/D _14331_/RESET_B VPWR VGND sg13cmos5l_dfrbpq_1
X_11474_ _11474_/Y _11486_/B _11474_/B VPWR VGND sg13cmos5l_xnor2_1
X_14262_ _14262_/Q clkload38/A _14262_/D _14262_/RESET_B VPWR VGND sg13cmos5l_dfrbpq_1
X_10425_ _13973_/D _10425_/A1 _10436_/B _10424_/Y VPWR VGND sg13cmos5l_a21oi_1
X_14193_ _14193_/Q _14217_/CLK _14193_/D _14193_/RESET_B VPWR VGND sg13cmos5l_dfrbpq_1
X_13213_ _13213_/Q _14577_/CLK _13213_/D fanout965/X VPWR VGND sg13cmos5l_dfrbpq_1
X_13144_ _14561_/D _13146_/A _13144_/B VPWR VGND sg13cmos5l_nor2_1
X_10356_ _10356_/Y _10356_/A _10366_/B VPWR VGND sg13cmos5l_nor2_1
X_10287_ _10287_/Y _10287_/A _10299_/B VPWR VGND sg13cmos5l_nor2_1
X_13075_ _14522_/D _13075_/A _13075_/B VPWR VGND sg13cmos5l_nor2_1
XFILLER_66_704 VPWR VGND sg13cmos5l_fill_1
X_12026_ _12026_/Y _13731_/Q _12346_/A2 _12030_/B _13987_/Q _12349_/C1 VPWR VGND sg13cmos5l_a221oi_1
XFILLER_66_715 VPWR VGND sg13cmos5l_fill_1
XFILLER_65_247 VPWR VGND sg13cmos5l_fill_1
XFILLER_46_450 VPWR VGND sg13cmos5l_decap_8
XFILLER_46_461 VPWR VGND sg13cmos5l_fill_2
X_13977_ _13977_/Q clkload50/A _13977_/D _13977_/RESET_B VPWR VGND sg13cmos5l_dfrbpq_1
X_12928_ _14451_/D _12928_/A VPWR VGND sg13cmos5l_inv_1
XFILLER_73_291 VPWR VGND sg13cmos5l_fill_2
X_13441__1981 _13441_/RESET_B VPWR VGND sg13cmos5l_tiehi
X_13304__2208 _13304_/RESET_B VPWR VGND sg13cmos5l_tiehi
XFILLER_22_829 VPWR VGND sg13cmos5l_fill_2
X_12859_ _12859_/Y _12859_/A _12859_/B _12859_/C VPWR VGND sg13cmos5l_nand3_1
XFILLER_14_391 VPWR VGND sg13cmos5l_fill_2
X_14529_ _14529_/Q _14532_/CLK _14529_/D fanout969/X VPWR VGND sg13cmos5l_dfrbpq_1
X_14419__1089 _14419_/RESET_B VPWR VGND sg13cmos5l_tiehi
X_08050_ _08050_/Y _08050_/A _13128_/C VPWR VGND sg13cmos5l_nand2_1
XFILLER_51_0 VPWR VGND sg13cmos5l_fill_1
Xhold3105 hold3105/X _13440_/Q VPWR VGND sg13cmos5l_dlygate4sd3_1
X_08952_ _13266_/D _08037_/B hold3414/X _10778_/B VPWR VGND sg13cmos5l_mux2_1
Xhold2404 _10082_/A _13806_/Q VPWR VGND sg13cmos5l_dlygate4sd3_1
Xhold3116 hold3116/X _13462_/Q VPWR VGND sg13cmos5l_dlygate4sd3_1
Xhold3127 _13565_/D _09455_/X VPWR VGND sg13cmos5l_dlygate4sd3_1
Xhold3138 hold3138/X _13427_/Q VPWR VGND sg13cmos5l_dlygate4sd3_1
X_07903_ _07944_/B _14438_/Q _10653_/A _07902_/Y VPWR VGND sg13cmos5l_a21oi_1
X_08883_ _08883_/Y _08593_/A _08902_/A2 _08882_/Y VPWR VGND sg13cmos5l_o21ai_1
Xhold2415 _11320_/A _14323_/Q VPWR VGND sg13cmos5l_dlygate4sd3_1
Xhold2426 _14139_/D _10737_/Y VPWR VGND sg13cmos5l_dlygate4sd3_1
Xhold2437 _10017_/A _13774_/Q VPWR VGND sg13cmos5l_dlygate4sd3_1
Xhold3149 _13507_/D _09395_/X VPWR VGND sg13cmos5l_dlygate4sd3_1
XFILLER_84_501 VPWR VGND sg13cmos5l_fill_2
X_07834_ _07836_/A _14379_/Q _14347_/Q VPWR VGND sg13cmos5l_nor2_1
Xhold2448 _10135_/A _13832_/Q VPWR VGND sg13cmos5l_dlygate4sd3_1
Xhold2459 _12989_/A _14482_/Q VPWR VGND sg13cmos5l_dlygate4sd3_1
XFILLER_57_759 VPWR VGND sg13cmos5l_decap_4
X_07765_ _07767_/B _14391_/Q _14359_/Q VPWR VGND sg13cmos5l_nand2_1
XFILLER_53_932 VPWR VGND sg13cmos5l_fill_2
X_07696_ _07698_/B _14384_/Q _11821_/A VPWR VGND sg13cmos5l_nor2_1
X_09504_ _09504_/Y _09504_/A _09511_/B VPWR VGND sg13cmos5l_nor2_1
X_09435_ _09435_/X _14123_/Q hold3264/X _09442_/S VPWR VGND sg13cmos5l_mux2_1
XFILLER_52_486 VPWR VGND sg13cmos5l_decap_4
X_09366_ _09366_/X _14120_/Q hold3033/X _09366_/S VPWR VGND sg13cmos5l_mux2_1
X_08317_ _08317_/Y _08317_/A1 _08316_/Y _13040_/C VPWR VGND sg13cmos5l_o21ai_1
X_09297_ _13417_/D _09225_/A hold3237/X _09297_/S VPWR VGND sg13cmos5l_mux2_1
X_13616__1775 _13616_/RESET_B VPWR VGND sg13cmos5l_tiehi
X_08248_ _08248_/Y _08252_/A _08245_/X _08246_/X _08247_/Y _08311_/C1 VPWR VGND sg13cmos5l_a221oi_1
XFILLER_106_400 VPWR VGND sg13cmos5l_fill_1
X_08179_ _08179_/Y _08202_/A _08176_/X _08178_/Y VPWR VGND sg13cmos5l_a21oi_1
X_10210_ _13868_/D fanout78/X _10217_/B _10209_/Y VPWR VGND sg13cmos5l_a21oi_1
X_14608__2151 _14608_/RESET_B VPWR VGND sg13cmos5l_tiehi
XFILLER_106_455 VPWR VGND sg13cmos5l_decap_4
X_11190_ _11190_/Y _11176_/Y _11214_/B _12907_/B2 VPWR VGND sg13cmos5l_o21ai_1
X_13831__1560 _13831_/RESET_B VPWR VGND sg13cmos5l_tiehi
X_10141_ _10141_/Y _10141_/A _10143_/B VPWR VGND sg13cmos5l_nand2_1
X_13483__1939 _13483_/RESET_B VPWR VGND sg13cmos5l_tiehi
XFILLER_0_755 VPWR VGND sg13cmos5l_decap_8
X_10072_ _10072_/Y _10072_/A _10072_/B VPWR VGND sg13cmos5l_nand2_1
XFILLER_102_672 VPWR VGND sg13cmos5l_fill_1
X_13900_ _13900_/Q clkload61/A _13900_/D _13900_/RESET_B VPWR VGND sg13cmos5l_dfrbpq_1
Xhold2960 _09653_/A _13611_/Q VPWR VGND sg13cmos5l_dlygate4sd3_1
Xhold2971 _09934_/A _13733_/Q VPWR VGND sg13cmos5l_dlygate4sd3_1
Xhold2982 hold2982/X _13481_/Q VPWR VGND sg13cmos5l_dlygate4sd3_1
Xhold2993 _09896_/A _13714_/Q VPWR VGND sg13cmos5l_dlygate4sd3_1
XFILLER_75_578 VPWR VGND sg13cmos5l_fill_1
X_13831_ _13831_/Q _14064_/CLK _13831_/D _13831_/RESET_B VPWR VGND sg13cmos5l_dfrbpq_1
XFILLER_44_921 VPWR VGND sg13cmos5l_fill_2
XFILLER_46_74 VPWR VGND sg13cmos5l_fill_2
XFILLER_56_781 VPWR VGND sg13cmos5l_decap_8
XFILLER_56_792 VPWR VGND sg13cmos5l_fill_2
XFILLER_90_526 VPWR VGND sg13cmos5l_decap_8
XFILLER_90_537 VPWR VGND sg13cmos5l_fill_2
X_10974_ _10974_/Y _10974_/A _10976_/B VPWR VGND sg13cmos5l_nand2_1
X_13762_ _13762_/Q clkload46/A _13762_/D _13762_/RESET_B VPWR VGND sg13cmos5l_dfrbpq_1
X_12713_ _12713_/Y _12744_/A _12713_/B VPWR VGND sg13cmos5l_xnor2_1
X_13693_ _13693_/Q clkload48/A _13693_/D _13693_/RESET_B VPWR VGND sg13cmos5l_dfrbpq_1
X_12644_ _12658_/A _14444_/Q _13234_/Q VPWR VGND sg13cmos5l_and2_1
X_12575_ _12575_/Y _12548_/Y _12572_/Y _12574_/Y VPWR VGND sg13cmos5l_o21ai_1
X_11526_ _11526_/Y _11614_/A _11513_/Y _11534_/B _11525_/Y _11557_/A VPWR VGND sg13cmos5l_a221oi_1
X_14314_ _14314_/Q clkload40/A _14314_/D _14314_/RESET_B VPWR VGND sg13cmos5l_dfrbpq_1
X_11457_ _11457_/Y _11515_/A VPWR VGND sg13cmos5l_inv_1
X_14245_ _14245_/Q clkload43/A _14245_/D _14245_/RESET_B VPWR VGND sg13cmos5l_dfrbpq_1
X_10408_ _10408_/Y _10408_/A _10408_/B VPWR VGND sg13cmos5l_nor2_1
X_11388_ _11388_/Y _11388_/A _11388_/B VPWR VGND sg13cmos5l_nor2_1
X_14176_ _14176_/Q clkload65/A _14176_/D _14176_/RESET_B VPWR VGND sg13cmos5l_dfrbpq_1
X_10339_ _10339_/Y _10339_/A _10339_/B VPWR VGND sg13cmos5l_nor2_1
X_13459__1963 _13459_/RESET_B VPWR VGND sg13cmos5l_tiehi
X_13127_ _14550_/D _13127_/A _13127_/B VPWR VGND sg13cmos5l_nor2_1
XFILLER_97_136 VPWR VGND sg13cmos5l_fill_1
X_13058_ _14514_/D _13058_/A _13058_/B VPWR VGND sg13cmos5l_xnor2_1
XFILLER_39_726 VPWR VGND sg13cmos5l_fill_2
XFILLER_94_821 VPWR VGND sg13cmos5l_fill_2
X_12009_ _12009_/Y _13602_/Q _11884_/B _12005_/B _13666_/Q VPWR VGND sg13cmos5l_a22oi_1
X_14282__1226 _14282_/RESET_B VPWR VGND sg13cmos5l_tiehi
XFILLER_94_843 VPWR VGND sg13cmos5l_fill_2
XFILLER_94_854 VPWR VGND sg13cmos5l_fill_2
XFILLER_54_729 VPWR VGND sg13cmos5l_decap_4
XFILLER_94_887 VPWR VGND sg13cmos5l_decap_8
X_07550_ _07552_/C _14557_/Q _13298_/Q VPWR VGND sg13cmos5l_xor2_1
XFILLER_62_784 VPWR VGND sg13cmos5l_decap_8
X_07481_ _07481_/Y _12963_/A _12963_/C VPWR VGND sg13cmos5l_nor2_1
X_09220_ _13348_/D _07303_/Y _09225_/B _09219_/Y VPWR VGND sg13cmos5l_a21oi_1
X_13873__1518 _13873_/RESET_B VPWR VGND sg13cmos5l_tiehi
XFILLER_99_0 VPWR VGND sg13cmos5l_fill_2
X_09151_ _11499_/A _14334_/Q _09163_/B VPWR VGND sg13cmos5l_nand2_1
X_08102_ _08102_/Y _08113_/A _09410_/A _08102_/C VPWR VGND sg13cmos5l_nand3_1
X_09082_ _09082_/Y _14354_/Q _09106_/A2 _09081_/Y VPWR VGND sg13cmos5l_a21oi_1
X_08033_ _08053_/A _08033_/A _08032_/Y VPWR VGND sg13cmos5l_nor2b_1
X_13327__2095 _13327_/RESET_B VPWR VGND sg13cmos5l_tiehi
XFILLER_103_458 VPWR VGND sg13cmos5l_fill_2
XFILLER_88_158 VPWR VGND sg13cmos5l_fill_2
X_09984_ _13757_/D _10571_/A1 _09989_/B _09983_/Y VPWR VGND sg13cmos5l_o21ai_1
X_08935_ _13252_/D _07291_/Y _13188_/A2 _13192_/B1 _08934_/Y VPWR VGND sg13cmos5l_a22oi_1
Xhold2234 _14081_/D _10649_/Y VPWR VGND sg13cmos5l_dlygate4sd3_1
Xhold2245 _10137_/A _13833_/Q VPWR VGND sg13cmos5l_dlygate4sd3_1
XFILLER_96_180 VPWR VGND sg13cmos5l_fill_1
X_08866_ _14644_/D hold2429/X _08869_/B _08865_/Y VPWR VGND sg13cmos5l_a21o_1
Xhold2256 _12991_/A _14483_/Q VPWR VGND sg13cmos5l_dlygate4sd3_1
Xhold2267 hold2267/X _14599_/Q VPWR VGND sg13cmos5l_dlygate4sd3_1
Xhold2278 _14147_/D _10761_/Y VPWR VGND sg13cmos5l_dlygate4sd3_1
X_07817_ _08904_/A _08625_/B _07816_/X VPWR VGND sg13cmos5l_nor2b_1
X_08797_ _14626_/D _08797_/A VPWR VGND sg13cmos5l_inv_1
Xhold2289 _11279_/A _14320_/Q VPWR VGND sg13cmos5l_dlygate4sd3_1
X_07748_ _07748_/Y _07705_/A _07746_/Y _07747_/Y VPWR VGND sg13cmos5l_o21ai_1
XFILLER_72_548 VPWR VGND sg13cmos5l_fill_2
XFILLER_52_261 VPWR VGND sg13cmos5l_fill_2
X_07679_ _08517_/B _07679_/A _08834_/A VPWR VGND sg13cmos5l_nor2_1
XFILLER_80_581 VPWR VGND sg13cmos5l_fill_1
X_09418_ _09418_/X _14106_/Q hold3190/X _09434_/S VPWR VGND sg13cmos5l_mux2_1
X_10690_ _14110_/D input4/X _10690_/A1 _10692_/S VPWR VGND sg13cmos5l_mux2_1
X_13849__1542 _13849_/RESET_B VPWR VGND sg13cmos5l_tiehi
X_09349_ _09349_/X _14103_/Q hold3116/X _09368_/S VPWR VGND sg13cmos5l_mux2_1
X_13537__1885 _13537_/RESET_B VPWR VGND sg13cmos5l_tiehi
XFILLER_21_692 VPWR VGND sg13cmos5l_fill_1
X_12360_ _12364_/B _12360_/A _12360_/B VPWR VGND sg13cmos5l_and2_1
X_11311_ _11327_/B _14092_/Q _11311_/B VPWR VGND sg13cmos5l_xnor2_1
X_14360__1148 _14360_/RESET_B VPWR VGND sg13cmos5l_tiehi
XFILLER_4_324 VPWR VGND sg13cmos5l_fill_1
X_12291_ _12291_/Y _12287_/Y _12288_/Y _12289_/Y _12290_/Y VPWR VGND sg13cmos5l_a22oi_1
X_11242_ _11243_/B _11242_/A _11256_/C VPWR VGND sg13cmos5l_xnor2_1
X_14030_ _14030_/Q clkload56/A _14030_/D _14030_/RESET_B VPWR VGND sg13cmos5l_dfrbpq_1
X_11173_ _11173_/Y _11173_/A _11196_/B VPWR VGND sg13cmos5l_nand2_1
X_10124_ _13826_/D _10581_/A1 _10137_/B _10123_/Y VPWR VGND sg13cmos5l_o21ai_1
XFILLER_95_618 VPWR VGND sg13cmos5l_fill_1
X_10055_ _13792_/D _10577_/A1 _10054_/B _10054_/Y VPWR VGND sg13cmos5l_o21ai_1
Xhold3491 hold3491/X _14549_/Q VPWR VGND sg13cmos5l_dlygate4sd3_1
Xhold3480 hold3480/X _14091_/Q VPWR VGND sg13cmos5l_dlygate4sd3_1
XFILLER_91_802 VPWR VGND sg13cmos5l_decap_8
Xhold2790 _10293_/A _13909_/Q VPWR VGND sg13cmos5l_dlygate4sd3_1
X_13814_ _13814_/Q clkload49/A _13814_/D _13814_/RESET_B VPWR VGND sg13cmos5l_dfrbpq_1
XFILLER_17_987 VPWR VGND sg13cmos5l_fill_2
X_10957_ _14220_/D _10957_/A VPWR VGND sg13cmos5l_inv_1
X_13745_ _13745_/Q _14640_/CLK _13745_/D _13745_/RESET_B VPWR VGND sg13cmos5l_dfrbpq_1
X_13676_ _13676_/Q clkload61/A _13676_/D _13676_/RESET_B VPWR VGND sg13cmos5l_dfrbpq_1
X_10888_ _10888_/Y _10946_/A _10887_/Y _10883_/Y VPWR VGND sg13cmos5l_o21ai_1
X_12627_ _12634_/C _12643_/A _12627_/B VPWR VGND sg13cmos5l_nand2_1
X_14336__1172 _14336_/RESET_B VPWR VGND sg13cmos5l_tiehi
X_12558_ _12558_/Y _12556_/Y _12557_/Y _10998_/A VPWR VGND sg13cmos5l_a21oi_1
X_11509_ _11509_/Y _11509_/A _11541_/B VPWR VGND sg13cmos5l_nand2_1
X_12489_ _12490_/B _12489_/A1 _13243_/Q _12488_/Y VPWR VGND sg13cmos5l_o21ai_1
X_14228_ _14228_/Q clkload44/A _14228_/D _14228_/RESET_B VPWR VGND sg13cmos5l_dfrbpq_1
XFILLER_98_412 VPWR VGND sg13cmos5l_fill_1
Xfanout609 _11318_/B1 _07933_/A VPWR VGND sg13cmos5l_buf_1
X_14159_ _14159_/Q clkload25/A _14159_/D fanout992/X VPWR VGND sg13cmos5l_dfrbpq_1
XFILLER_101_929 VPWR VGND sg13cmos5l_fill_2
XFILLER_58_309 VPWR VGND sg13cmos5l_fill_2
XFILLER_79_670 VPWR VGND sg13cmos5l_decap_4
XFILLER_86_629 VPWR VGND sg13cmos5l_fill_1
XFILLER_67_832 VPWR VGND sg13cmos5l_decap_8
X_08720_ _08720_/Y _08720_/A _08720_/B _08720_/C VPWR VGND sg13cmos5l_nand3_1
X_13927__1464 _13927_/RESET_B VPWR VGND sg13cmos5l_tiehi
XFILLER_39_545 VPWR VGND sg13cmos5l_fill_2
X_08651_ _08651_/Y _08653_/B _11719_/S VPWR VGND sg13cmos5l_nand2_1
XFILLER_94_684 VPWR VGND sg13cmos5l_fill_2
X_07602_ _07625_/B _07602_/A _07603_/B VPWR VGND sg13cmos5l_nor2_1
XFILLER_19_291 VPWR VGND sg13cmos5l_fill_1
X_08582_ _08583_/B _08582_/A _08582_/B _08582_/C _08582_/D VPWR VGND sg13cmos5l_nor4_1
XFILLER_35_784 VPWR VGND sg13cmos5l_fill_2
X_07533_ _14246_/D hold3500/X _13033_/B _07533_/S VPWR VGND sg13cmos5l_mux2_1
X_14607__2150 _14607_/RESET_B VPWR VGND sg13cmos5l_tiehi
X_07464_ _07464_/Y _07403_/A _07462_/X _07463_/Y VPWR VGND sg13cmos5l_o21ai_1
X_14259__1806 _14259_/RESET_B VPWR VGND sg13cmos5l_tiehi
XFILLER_10_607 VPWR VGND sg13cmos5l_decap_4
X_09203_ _13332_/D _10681_/A1 hold3228/X _09208_/S VPWR VGND sg13cmos5l_mux2_1
XFILLER_22_478 VPWR VGND sg13cmos5l_fill_1
X_07395_ _07407_/B _07395_/A _07395_/B _07395_/C _07395_/D VPWR VGND sg13cmos5l_nor4_1
X_09134_ _09134_/Y _14427_/Q _11450_/A VPWR VGND sg13cmos5l_nand2_1
X_13414__2008 _13414_/RESET_B VPWR VGND sg13cmos5l_tiehi
X_09065_ _09065_/Y _14351_/Q _09065_/A2 _13197_/A2 VPWR VGND sg13cmos5l_a21oi_1
X_08016_ _08039_/B _08964_/A _13272_/Q _08050_/A VPWR VGND sg13cmos5l_mux2_1
XFILLER_78_39 VPWR VGND sg13cmos5l_fill_2
XFILLER_104_756 VPWR VGND sg13cmos5l_fill_1
XFILLER_77_629 VPWR VGND sg13cmos5l_fill_1
X_09967_ _09967_/Y _09967_/A _09969_/B VPWR VGND sg13cmos5l_nand2_1
XFILLER_58_843 VPWR VGND sg13cmos5l_decap_8
XFILLER_94_16 VPWR VGND sg13cmos5l_fill_1
XFILLER_98_990 VPWR VGND sg13cmos5l_fill_2
X_08918_ _08918_/Y _14273_/Q _08917_/X _13188_/A2 VPWR VGND sg13cmos5l_a21oi_1
XFILLER_100_951 VPWR VGND sg13cmos5l_fill_2
XFILLER_69_191 VPWR VGND sg13cmos5l_fill_1
XFILLER_85_651 VPWR VGND sg13cmos5l_decap_4
X_09898_ _09898_/Y _09898_/A _09910_/B VPWR VGND sg13cmos5l_nor2_1
XFILLER_84_150 VPWR VGND sg13cmos5l_fill_1
X_08849_ _08851_/C _07682_/Y _08861_/C VPWR VGND sg13cmos5l_nand2b_1
XFILLER_72_345 VPWR VGND sg13cmos5l_fill_1
XFILLER_73_879 VPWR VGND sg13cmos5l_decap_4
X_11860_ _11865_/B _11860_/A _11860_/B _11860_/C VPWR VGND sg13cmos5l_nand3_1
X_14414__1094 _14414_/RESET_B VPWR VGND sg13cmos5l_tiehi
X_10811_ _10811_/Y _14308_/Q _10759_/A _10763_/B VPWR VGND sg13cmos5l_a21oi_1
X_11791_ _11791_/Y _07237_/Y _11868_/A2 _11816_/B1 _12649_/B VPWR VGND sg13cmos5l_a22oi_1
X_10742_ _10742_/Y _10742_/A _10793_/B VPWR VGND sg13cmos5l_nand2_1
X_13530_ _13530_/Q clkload27/A _13530_/D _13530_/RESET_B VPWR VGND sg13cmos5l_dfrbpq_1
X_10673_ _14095_/D _07266_/Y _10826_/S _10672_/Y VPWR VGND sg13cmos5l_a21oi_1
X_13461_ _13461_/Q _14292_/CLK _13461_/D _13461_/RESET_B VPWR VGND sg13cmos5l_dfrbpq_1
X_13392_ _13392_/Q clkload34/A _13392_/D _13392_/RESET_B VPWR VGND sg13cmos5l_dfrbpq_1
X_12412_ _12432_/B _12412_/A _12411_/Y VPWR VGND sg13cmos5l_nor2b_1
X_12343_ _12343_/Y _12339_/Y _12340_/Y _12341_/Y _12342_/Y VPWR VGND sg13cmos5l_a22oi_1
XFILLER_5_655 VPWR VGND sg13cmos5l_fill_2
X_12274_ _12523_/B _12263_/Y _12266_/Y _12270_/Y _12273_/Y VPWR VGND sg13cmos5l_a22oi_1
X_11225_ _11226_/B _11225_/A _11239_/A VPWR VGND sg13cmos5l_nand2_1
X_14013_ _14013_/Q _14045_/CLK _14013_/D _14013_/RESET_B VPWR VGND sg13cmos5l_dfrbpq_1
X_11156_ _11156_/Y _11628_/A _11164_/B VPWR VGND sg13cmos5l_nor2b_1
X_10107_ _10107_/Y _10107_/A _10107_/B VPWR VGND sg13cmos5l_nand2_1
X_11087_ _11087_/X _14381_/Q _11091_/B VPWR VGND sg13cmos5l_and2_1
X_10038_ _10038_/Y _10038_/A _10042_/B VPWR VGND sg13cmos5l_nand2_1
XFILLER_36_526 VPWR VGND sg13cmos5l_fill_2
XFILLER_75_172 VPWR VGND sg13cmos5l_fill_1
X_15895_ _15895_/X _15895_/A VPWR VGND sg13cmos5l_buf_1
XFILLER_1_1010 VPWR VGND sg13cmos5l_decap_8
XFILLER_48_397 VPWR VGND sg13cmos5l_fill_2
X_13611__1780 _13611_/RESET_B VPWR VGND sg13cmos5l_tiehi
XFILLER_63_389 VPWR VGND sg13cmos5l_fill_2
XFILLER_72_890 VPWR VGND sg13cmos5l_fill_2
X_11989_ _11989_/Y _11957_/A _11988_/Y _11987_/Y VPWR VGND sg13cmos5l_o21ai_1
X_13728_ _13728_/Q _14048_/CLK _13728_/D _13728_/RESET_B VPWR VGND sg13cmos5l_dfrbpq_1
X_13790__1601 _13790_/RESET_B VPWR VGND sg13cmos5l_tiehi
X_13659_ _13659_/Q _14042_/CLK _13659_/D _13659_/RESET_B VPWR VGND sg13cmos5l_dfrbpq_1
X_07180_ _09485_/B _07180_/A VPWR VGND sg13cmos5l_inv_1
XFILLER_99_787 VPWR VGND sg13cmos5l_fill_2
X_09821_ _09821_/Y _09821_/A _09821_/B VPWR VGND sg13cmos5l_nor2_1
Xfanout439 _10466_/B _10467_/A2 VPWR VGND sg13cmos5l_buf_1
Xfanout428 _10511_/B _10531_/B VPWR VGND sg13cmos5l_buf_1
Xfanout417 _10564_/B _10596_/B VPWR VGND sg13cmos5l_buf_1
Xfanout406 _11132_/B _11135_/B VPWR VGND sg13cmos5l_buf_1
X_09752_ _09752_/Y _09752_/A _09752_/B VPWR VGND sg13cmos5l_nor2_1
XFILLER_67_662 VPWR VGND sg13cmos5l_fill_2
X_08703_ _08703_/Y _13620_/Q _08738_/A2 _08747_/B _13684_/Q _11752_/S VPWR VGND sg13cmos5l_a221oi_1
XFILLER_67_684 VPWR VGND sg13cmos5l_fill_1
XFILLER_67_695 VPWR VGND sg13cmos5l_decap_4
XFILLER_95_993 VPWR VGND sg13cmos5l_fill_1
X_09683_ _11591_/B _14436_/Q _14655_/Q _09689_/S VPWR VGND sg13cmos5l_mux2_1
X_08634_ _08637_/A _08630_/Y _08633_/Y _07893_/B VPWR VGND sg13cmos5l_o21ai_1
XFILLER_42_507 VPWR VGND sg13cmos5l_fill_1
XFILLER_55_879 VPWR VGND sg13cmos5l_decap_8
X_08565_ _08571_/B _08559_/B _07661_/X _08558_/B _08563_/Y _07662_/X VPWR VGND sg13cmos5l_a221oi_1
X_07516_ _07517_/B _07505_/Y _07510_/Y _07515_/X _11040_/A VPWR VGND sg13cmos5l_a22oi_1
X_08496_ _08496_/Y _07705_/A _08489_/Y _07747_/Y VPWR VGND sg13cmos5l_o21ai_1
XFILLER_50_595 VPWR VGND sg13cmos5l_decap_8
X_07447_ _07447_/X _13430_/Q _13398_/Q _13366_/Q _13334_/Q _07522_/S0 _07522_/S1 VPWR
+ VGND sg13cmos5l_mux4_1
Xfanout79 fanout79/X fanout80/X VPWR VGND sg13cmos5l_buf_1
Xfanout68 _12154_/A _12412_/A VPWR VGND sg13cmos5l_buf_1
Xfanout57 fanout57/X _09687_/Y VPWR VGND sg13cmos5l_buf_1
X_07378_ _07591_/A _07378_/A VPWR VGND sg13cmos5l_inv_1
XFILLER_89_16 VPWR VGND sg13cmos5l_fill_1
X_09117_ _09117_/Y _11409_/A _09116_/Y _09135_/B1 VPWR VGND sg13cmos5l_a21oi_1
X_09048_ _09048_/Y _09048_/A _09077_/B VPWR VGND sg13cmos5l_nor2_1
X_13653__1738 _13653_/RESET_B VPWR VGND sg13cmos5l_tiehi
X_13799__1592 _13799_/RESET_B VPWR VGND sg13cmos5l_tiehi
XFILLER_1_146 VPWR VGND sg13cmos5l_fill_1
XFILLER_78_916 VPWR VGND sg13cmos5l_fill_2
X_11010_ _11011_/B _11019_/A _10980_/B _10983_/Y _11009_/Y VPWR VGND sg13cmos5l_a22oi_1
Xfanout940 _07369_/B _08956_/A VPWR VGND sg13cmos5l_buf_1
Xfanout951 _12755_/A _12802_/A VPWR VGND sg13cmos5l_buf_1
XFILLER_77_459 VPWR VGND sg13cmos5l_fill_1
Xfanout962 fanout962/X fanout967/X VPWR VGND sg13cmos5l_buf_1
Xfanout973 fanout973/X fanout980/X VPWR VGND sg13cmos5l_buf_1
Xfanout984 fanout984/X fanout985/X VPWR VGND sg13cmos5l_buf_1
Xfanout995 fanout995/X fanout998/A VPWR VGND sg13cmos5l_buf_1
X_14033__1358 _14033_/RESET_B VPWR VGND sg13cmos5l_tiehi
XFILLER_58_673 VPWR VGND sg13cmos5l_fill_1
X_12961_ _12962_/A hold3557/X _11604_/B _11611_/B _12961_/B2 VPWR VGND sg13cmos5l_a22oi_1
XFILLER_85_492 VPWR VGND sg13cmos5l_fill_2
X_11912_ _11912_/Y _13919_/Q _11969_/A2 _11914_/A2 _13599_/Q VPWR VGND sg13cmos5l_a22oi_1
X_12892_ _12892_/Y fanout60/X _12891_/X _12417_/Y VPWR VGND sg13cmos5l_a21oi_1
XFILLER_33_507 VPWR VGND sg13cmos5l_fill_2
X_11843_ _11843_/X _11870_/A _11843_/B VPWR VGND sg13cmos5l_or2_1
X_14631_ _14631_/Q _14631_/CLK _14631_/D _14631_/RESET_B VPWR VGND sg13cmos5l_dfrbpq_1
XFILLER_54_890 VPWR VGND sg13cmos5l_decap_4
X_11774_ _11774_/Y _11770_/Y _11771_/Y _11772_/Y _11773_/Y VPWR VGND sg13cmos5l_a22oi_1
X_14562_ _14562_/Q clkload12/A _14562_/D fanout958/X VPWR VGND sg13cmos5l_dfrbpq_1
XFILLER_13_253 VPWR VGND sg13cmos5l_fill_2
X_10725_ _10725_/Y _10772_/B _10723_/Y _10724_/Y VPWR VGND sg13cmos5l_o21ai_1
X_14493_ _14493_/Q clkload10/A _14493_/D fanout975/X VPWR VGND sg13cmos5l_dfrbpq_1
X_13513_ _13513_/Q clkload37/A _13513_/D _13513_/RESET_B VPWR VGND sg13cmos5l_dfrbpq_1
X_10656_ _14083_/D _10655_/Y hold3459/X _10659_/S VPWR VGND sg13cmos5l_mux2_1
X_13444_ _13444_/Q _14622_/CLK _13444_/D _13444_/RESET_B VPWR VGND sg13cmos5l_dfrbpq_1
XFILLER_103_1021 VPWR VGND sg13cmos5l_decap_8
XFILLER_70_95 VPWR VGND sg13cmos5l_fill_2
Xclkload16 clkload16/Y clkload16/A VPWR VGND sg13cmos5l_inv_1
X_10587_ _14053_/D _10587_/A1 _10602_/B _10586_/Y VPWR VGND sg13cmos5l_o21ai_1
Xclkload49 clkload49/Y clkload49/A VPWR VGND sg13cmos5l_inv_1
Xclkload38 clkload38/Y clkload38/A VPWR VGND sg13cmos5l_inv_1
Xclkload27 clkload27/Y clkload27/A VPWR VGND sg13cmos5l_inv_2
X_13375_ _13375_/Q _13568_/CLK _13375_/D _13375_/RESET_B VPWR VGND sg13cmos5l_dfrbpq_1
X_12326_ _12327_/B _12352_/A _12531_/B _12325_/Y VPWR VGND sg13cmos5l_o21ai_1
X_12257_ _12257_/Y _14366_/Q _13251_/Q _12330_/B VPWR VGND sg13cmos5l_nand3_1
X_13629__1762 _13629_/RESET_B VPWR VGND sg13cmos5l_tiehi
XFILLER_69_927 VPWR VGND sg13cmos5l_decap_8
X_11208_ _11214_/D _14315_/Q _09513_/X _11234_/A VPWR VGND sg13cmos5l_mux2_1
X_12188_ _12189_/B _12192_/A _07287_/Y _12161_/C VPWR VGND sg13cmos5l_o21ai_1
X_14258__1805 _14258_/RESET_B VPWR VGND sg13cmos5l_tiehi
XFILLER_23_1000 VPWR VGND sg13cmos5l_fill_2
XFILLER_96_779 VPWR VGND sg13cmos5l_decap_4
X_11139_ _14303_/D _11144_/B _11137_/Y _11138_/Y VPWR VGND sg13cmos5l_a21oi_1
XFILLER_77_982 VPWR VGND sg13cmos5l_decap_8
XFILLER_95_267 VPWR VGND sg13cmos5l_fill_1
X_14009__1382 _14009_/RESET_B VPWR VGND sg13cmos5l_tiehi
XFILLER_36_345 VPWR VGND sg13cmos5l_fill_1
XFILLER_92_930 VPWR VGND sg13cmos5l_fill_1
XFILLER_92_963 VPWR VGND sg13cmos5l_decap_8
X_13496__1926 _13496_/RESET_B VPWR VGND sg13cmos5l_tiehi
X_13532__1890 _13532_/RESET_B VPWR VGND sg13cmos5l_tiehi
XFILLER_17_581 VPWR VGND sg13cmos5l_fill_2
XFILLER_63_186 VPWR VGND sg13cmos5l_fill_2
X_08350_ _08350_/X _13580_/Q _13548_/Q _08398_/S VPWR VGND sg13cmos5l_mux2_1
XFILLER_32_540 VPWR VGND sg13cmos5l_fill_2
XFILLER_32_551 VPWR VGND sg13cmos5l_fill_1
XFILLER_60_860 VPWR VGND sg13cmos5l_fill_2
X_07301_ _07301_/Y _07301_/A VPWR VGND sg13cmos5l_inv_1
X_08281_ _08281_/Y _13153_/A _08281_/B VPWR VGND sg13cmos5l_nand2_1
XFILLER_81_0 VPWR VGND sg13cmos5l_fill_2
X_07232_ _11901_/A _14354_/Q VPWR VGND sg13cmos5l_inv_1
XFILLER_9_780 VPWR VGND sg13cmos5l_fill_1
X_07163_ _10981_/A _14567_/Q VPWR VGND sg13cmos5l_inv_1
XFILLER_87_702 VPWR VGND sg13cmos5l_fill_1
Xfanout214 _10042_/B _10054_/B VPWR VGND sg13cmos5l_buf_1
Xfanout203 _10107_/B _10120_/A2 VPWR VGND sg13cmos5l_buf_1
XFILLER_59_426 VPWR VGND sg13cmos5l_decap_4
X_09804_ _13669_/D _10326_/A1 _09817_/B _09803_/Y VPWR VGND sg13cmos5l_a21oi_1
Xfanout247 _08204_/A1 _07420_/B VPWR VGND sg13cmos5l_buf_1
Xfanout236 _10567_/A1 _09543_/Y VPWR VGND sg13cmos5l_buf_1
Xfanout225 _09989_/B fanout233/X VPWR VGND sg13cmos5l_buf_1
XFILLER_59_459 VPWR VGND sg13cmos5l_decap_8
X_07996_ _14256_/D _10877_/A _12622_/B _08368_/S VPWR VGND sg13cmos5l_mux2_1
Xfanout269 _10341_/B _10286_/Y VPWR VGND sg13cmos5l_buf_1
Xfanout258 _10406_/B _10368_/B VPWR VGND sg13cmos5l_buf_1
X_13364__2058 _13364_/RESET_B VPWR VGND sg13cmos5l_tiehi
XFILLER_39_161 VPWR VGND sg13cmos5l_fill_2
X_09735_ _13636_/D _10128_/A1 _09746_/B _09734_/Y VPWR VGND sg13cmos5l_a21oi_1
XFILLER_55_643 VPWR VGND sg13cmos5l_decap_8
XFILLER_95_790 VPWR VGND sg13cmos5l_fill_1
X_09666_ _09666_/Y _09666_/A _09666_/B VPWR VGND sg13cmos5l_nor2_1
XFILLER_83_985 VPWR VGND sg13cmos5l_fill_1
X_08617_ _08618_/B _08625_/A _08614_/Y _08615_/Y _08616_/X VPWR VGND sg13cmos5l_a22oi_1
XFILLER_36_890 VPWR VGND sg13cmos5l_fill_1
X_09597_ _09597_/Y _14454_/Q _09625_/C VPWR VGND sg13cmos5l_nor2_1
X_14295__1213 _14295_/RESET_B VPWR VGND sg13cmos5l_tiehi
X_08548_ _08549_/B _08545_/Y _08546_/Y _08547_/X _08559_/A VPWR VGND sg13cmos5l_a22oi_1
XFILLER_24_55 VPWR VGND sg13cmos5l_fill_2
X_08479_ _08491_/D _08479_/A _08479_/B _08479_/C VPWR VGND sg13cmos5l_nand3_1
X_13707__1684 _13707_/RESET_B VPWR VGND sg13cmos5l_tiehi
XFILLER_24_88 VPWR VGND sg13cmos5l_fill_1
X_10510_ _14015_/D _10575_/A1 _10511_/B _10509_/Y VPWR VGND sg13cmos5l_o21ai_1
X_11490_ _11490_/Y _11514_/A _11519_/A _11490_/C VPWR VGND sg13cmos5l_nand3_1
XFILLER_10_256 VPWR VGND sg13cmos5l_fill_2
X_10441_ _13981_/D _10571_/A1 _10446_/B _10440_/Y VPWR VGND sg13cmos5l_a21oi_1
X_13886__1505 _13886_/RESET_B VPWR VGND sg13cmos5l_tiehi
X_10372_ _10372_/Y _10372_/A _10384_/B VPWR VGND sg13cmos5l_nor2_1
X_13160_ _13160_/Y _11192_/A _14180_/Q _13162_/B _14265_/Q _13164_/A2 VPWR VGND sg13cmos5l_a221oi_1
X_12111_ _12111_/Y _13734_/Q _12346_/A2 _12030_/B _13990_/Q VPWR VGND sg13cmos5l_a22oi_1
X_13574__1848 _13574_/RESET_B VPWR VGND sg13cmos5l_tiehi
X_13091_ _13099_/D _14530_/Q _13092_/B VPWR VGND sg13cmos5l_and2_1
XFILLER_3_967 VPWR VGND sg13cmos5l_fill_1
X_12042_ _12042_/Y _12127_/A _12042_/B VPWR VGND sg13cmos5l_nor2_1
XFILLER_104_361 VPWR VGND sg13cmos5l_fill_1
XFILLER_77_223 VPWR VGND sg13cmos5l_fill_1
XFILLER_19_824 VPWR VGND sg13cmos5l_fill_1
Xfanout792 _08416_/S _08378_/A1 VPWR VGND sg13cmos5l_buf_1
Xfanout781 _08405_/C1 _14618_/Q VPWR VGND sg13cmos5l_buf_1
Xfanout770 _11587_/A _14624_/Q VPWR VGND sg13cmos5l_buf_1
X_13993_ _13993_/Q clkload63/A _13993_/D _13993_/RESET_B VPWR VGND sg13cmos5l_dfrbpq_1
XFILLER_19_857 VPWR VGND sg13cmos5l_fill_2
XFILLER_46_621 VPWR VGND sg13cmos5l_fill_2
X_12944_ _14459_/D _12944_/A VPWR VGND sg13cmos5l_inv_1
XFILLER_45_131 VPWR VGND sg13cmos5l_fill_2
XFILLER_46_654 VPWR VGND sg13cmos5l_decap_4
XFILLER_46_698 VPWR VGND sg13cmos5l_fill_1
XFILLER_61_624 VPWR VGND sg13cmos5l_decap_8
X_12875_ _12884_/B _14466_/Q _13256_/Q VPWR VGND sg13cmos5l_xor2_1
X_11826_ _11826_/Y _11982_/A _11825_/B _11715_/A VPWR VGND sg13cmos5l_a21oi_1
X_14614_ _14614_/Q _14614_/CLK _14614_/D _14614_/RESET_B VPWR VGND sg13cmos5l_dfrbpq_1
X_14463__1031 _14463_/RESET_B VPWR VGND sg13cmos5l_tiehi
XFILLER_14_584 VPWR VGND sg13cmos5l_fill_1
X_11757_ _11757_/Y _11757_/A _11757_/B VPWR VGND sg13cmos5l_nand2_1
X_14545_ _14545_/Q clkload11/A _14545_/D fanout966/X VPWR VGND sg13cmos5l_dfrbpq_1
X_10708_ _14128_/D input6/X _09304_/A _10710_/S VPWR VGND sg13cmos5l_mux2_1
X_11688_ _11688_/Y _14007_/Q _11697_/B _11725_/B VPWR VGND sg13cmos5l_a21oi_1
X_14476_ _14476_/Q _14532_/CLK _14476_/D fanout970/X VPWR VGND sg13cmos5l_dfrbpq_1
X_10639_ _10640_/B _14075_/Q _10638_/C hold3514/X VPWR VGND sg13cmos5l_a21o_1
X_13427_ _13427_/Q _14292_/CLK _13427_/D _13427_/RESET_B VPWR VGND sg13cmos5l_dfrbpq_1
X_13358_ _13358_/Q _13568_/CLK _13358_/D _13358_/RESET_B VPWR VGND sg13cmos5l_dfrbpq_1
X_12309_ _12309_/Y _12329_/B _12307_/Y _12308_/Y VPWR VGND sg13cmos5l_o21ai_1
Xhold3309 hold3309/X _13539_/Q VPWR VGND sg13cmos5l_dlygate4sd3_1
X_13289_ _13289_/Q clkload21/A _13289_/D fanout984/X VPWR VGND sg13cmos5l_dfrbpq_1
Xhold2608 _10207_/A _13867_/Q VPWR VGND sg13cmos5l_dlygate4sd3_1
Xhold2619 _09860_/A _13697_/Q VPWR VGND sg13cmos5l_dlygate4sd3_1
X_14373__1135 _14373_/RESET_B VPWR VGND sg13cmos5l_tiehi
XFILLER_68_256 VPWR VGND sg13cmos5l_fill_1
X_07850_ _07851_/C _14241_/Q _10653_/A _14239_/Q VPWR VGND sg13cmos5l_nor3_1
XFILLER_84_738 VPWR VGND sg13cmos5l_decap_8
XFILLER_96_587 VPWR VGND sg13cmos5l_fill_1
X_07781_ _07781_/Y _07657_/A _07657_/B _07779_/Y _07780_/Y VPWR VGND sg13cmos5l_a22oi_1
X_14094__1313 _14094_/RESET_B VPWR VGND sg13cmos5l_tiehi
X_09520_ _09520_/Y _09534_/C _09534_/D VPWR VGND sg13cmos5l_nand2_1
Xinput3 input3/X ui_in[10] VPWR VGND sg13cmos5l_buf_1
XFILLER_25_816 VPWR VGND sg13cmos5l_fill_1
XFILLER_64_440 VPWR VGND sg13cmos5l_decap_4
XFILLER_92_760 VPWR VGND sg13cmos5l_fill_2
XFILLER_65_996 VPWR VGND sg13cmos5l_fill_1
X_09451_ _13561_/D _08157_/A hold3287/X _09467_/S VPWR VGND sg13cmos5l_mux2_1
X_13964__1427 _13964_/RESET_B VPWR VGND sg13cmos5l_tiehi
X_08402_ _08402_/X _08403_/S _13456_/Q VPWR VGND sg13cmos5l_or2_1
X_09382_ _09382_/X _14103_/Q hold3111/X _09396_/S VPWR VGND sg13cmos5l_mux2_1
X_08333_ _08333_/X _13515_/Q _13483_/Q _08390_/S VPWR VGND sg13cmos5l_mux2_1
XFILLER_60_690 VPWR VGND sg13cmos5l_fill_1
X_08264_ _08264_/Y _08263_/S _07304_/Y _08339_/B1 VPWR VGND sg13cmos5l_a21oi_1
Xheichips26_loopcache_rv_2215 uio_oe[3] VPWR VGND sg13cmos5l_tiehi
Xheichips26_loopcache_rv_2226 uio_oe[14] VPWR VGND sg13cmos5l_tiehi
X_07215_ _12301_/A _14369_/Q VPWR VGND sg13cmos5l_inv_1
X_08195_ _08198_/A _14076_/Q _08207_/A2 _08208_/A2 _15894_/A VPWR VGND sg13cmos5l_a22oi_1
XFILLER_106_626 VPWR VGND sg13cmos5l_fill_2
XFILLER_99_381 VPWR VGND sg13cmos5l_fill_1
XFILLER_102_887 VPWR VGND sg13cmos5l_fill_2
XFILLER_75_716 VPWR VGND sg13cmos5l_decap_4
XFILLER_101_386 VPWR VGND sg13cmos5l_fill_1
XFILLER_74_226 VPWR VGND sg13cmos5l_fill_1
X_07979_ _07979_/X _13567_/Q _13535_/Q _13503_/Q _13471_/Q _08378_/A1 _07194_/A VPWR
+ VGND sg13cmos5l_mux4_1
X_09718_ _09718_/Y _09718_/A _09730_/B VPWR VGND sg13cmos5l_nor2_1
X_10990_ _10990_/Y _10990_/A _11007_/A VPWR VGND sg13cmos5l_nand2_1
XFILLER_56_996 VPWR VGND sg13cmos5l_decap_4
X_09649_ _11510_/B _14431_/Q _14650_/Q _09662_/S VPWR VGND sg13cmos5l_mux2_1
XFILLER_15_348 VPWR VGND sg13cmos5l_fill_2
X_12660_ _12677_/A _14445_/Q _13235_/Q VPWR VGND sg13cmos5l_xnor2_1
XFILLER_71_988 VPWR VGND sg13cmos5l_decap_8
X_11611_ _11613_/C _11611_/A _11611_/B VPWR VGND sg13cmos5l_xor2_1
XFILLER_11_510 VPWR VGND sg13cmos5l_fill_1
XFILLER_11_521 VPWR VGND sg13cmos5l_fill_2
X_14330_ _14330_/Q clkload81/A _14330_/D _14330_/RESET_B VPWR VGND sg13cmos5l_dfrbpq_1
X_14257__1804 _14257_/RESET_B VPWR VGND sg13cmos5l_tiehi
X_12591_ _12591_/X _12591_/A _12591_/B VPWR VGND sg13cmos5l_or2_1
XFILLER_7_503 VPWR VGND sg13cmos5l_fill_2
X_11542_ _11543_/B _11542_/A _11542_/B VPWR VGND sg13cmos5l_nand2_1
X_11473_ _11474_/B _11484_/A _11476_/C _11460_/Y VPWR VGND sg13cmos5l_a21oi_1
X_14261_ _14261_/Q clkload66/A _14261_/D _14261_/RESET_B VPWR VGND sg13cmos5l_dfrbpq_1
X_10424_ _10424_/Y _10424_/A _10436_/B VPWR VGND sg13cmos5l_nor2_1
X_14192_ _14192_/Q _14614_/CLK _14192_/D _14192_/RESET_B VPWR VGND sg13cmos5l_dfrbpq_1
X_13212_ _13212_/Q clkload9/A _13212_/D fanout965/X VPWR VGND sg13cmos5l_dfrbpq_1
X_13143_ _13144_/B _09377_/A _13138_/B _13138_/Y hold3476/X VPWR VGND sg13cmos5l_a22oi_1
X_10355_ _13939_/D _10355_/A1 _10366_/B _10354_/Y VPWR VGND sg13cmos5l_a21oi_1
X_10286_ _10286_/Y _10286_/A _10351_/C VPWR VGND sg13cmos5l_nor2_1
X_13074_ _13074_/Y _14521_/Q _13071_/C hold2854/X VPWR VGND sg13cmos5l_a21oi_1
X_12025_ _12025_/Y _14051_/Q _12348_/A2 _12345_/B1 _13795_/Q VPWR VGND sg13cmos5l_a22oi_1
XFILLER_66_738 VPWR VGND sg13cmos5l_fill_1
XFILLER_19_643 VPWR VGND sg13cmos5l_decap_8
X_13976_ _13976_/Q _14631_/CLK _13976_/D _13976_/RESET_B VPWR VGND sg13cmos5l_dfrbpq_1
XFILLER_34_635 VPWR VGND sg13cmos5l_fill_1
XFILLER_46_473 VPWR VGND sg13cmos5l_fill_1
X_12927_ _12928_/A hold3511/X _11358_/B _11347_/B _12933_/B2 VPWR VGND sg13cmos5l_a22oi_1
XFILLER_62_966 VPWR VGND sg13cmos5l_fill_1
XFILLER_92_60 VPWR VGND sg13cmos5l_fill_1
XFILLER_92_71 VPWR VGND sg13cmos5l_fill_1
X_12858_ _12859_/C _12857_/A _12857_/B _12863_/B VPWR VGND sg13cmos5l_a21o_1
XFILLER_22_819 VPWR VGND sg13cmos5l_fill_1
X_11809_ _11810_/C _13627_/Q _11809_/A2 _11916_/A2 _13883_/Q VPWR VGND sg13cmos5l_a22oi_1
XFILLER_61_498 VPWR VGND sg13cmos5l_fill_2
X_12789_ _12790_/C _12789_/A _12828_/A VPWR VGND sg13cmos5l_nor2_1
X_14528_ _14528_/Q _14532_/CLK _14528_/D fanout968/X VPWR VGND sg13cmos5l_dfrbpq_1
X_14459_ _14459_/Q clkload81/A _14459_/D _14459_/RESET_B VPWR VGND sg13cmos5l_dfrbpq_1
X_14427__1081 _14427_/RESET_B VPWR VGND sg13cmos5l_tiehi
Xhold3106 hold3106/X _13544_/Q VPWR VGND sg13cmos5l_dlygate4sd3_1
XFILLER_88_318 VPWR VGND sg13cmos5l_fill_1
X_08951_ _13265_/D _08036_/B hold3431/X _10778_/B VPWR VGND sg13cmos5l_mux2_1
Xhold3117 _13462_/D _09349_/X VPWR VGND sg13cmos5l_dlygate4sd3_1
Xhold3128 hold3128/X _13346_/Q VPWR VGND sg13cmos5l_dlygate4sd3_1
Xhold3139 hold3139/X _13395_/Q VPWR VGND sg13cmos5l_dlygate4sd3_1
X_07902_ _07902_/Y _07947_/A VPWR VGND sg13cmos5l_inv_1
X_08882_ _08882_/Y _08594_/A _08894_/B _08881_/Y VPWR VGND sg13cmos5l_a21oi_1
Xhold2405 _10576_/A _14048_/Q VPWR VGND sg13cmos5l_dlygate4sd3_1
Xhold2416 _10030_/A _13780_/Q VPWR VGND sg13cmos5l_dlygate4sd3_1
Xhold2427 _10088_/A _13809_/Q VPWR VGND sg13cmos5l_dlygate4sd3_1
XFILLER_29_407 VPWR VGND sg13cmos5l_fill_2
X_07833_ _08460_/A _07833_/A _08801_/A VPWR VGND sg13cmos5l_nor2_1
Xhold2438 hold2438/X _14525_/Q VPWR VGND sg13cmos5l_dlygate4sd3_1
Xhold2449 _10505_/A _14013_/Q VPWR VGND sg13cmos5l_dlygate4sd3_1
X_07764_ _07764_/Y _07764_/A _07764_/B VPWR VGND sg13cmos5l_nor2_1
X_07695_ _07699_/A _14384_/Q _11821_/A VPWR VGND sg13cmos5l_nand2_1
X_09503_ _09503_/Y _09509_/A _09500_/X _09502_/Y VPWR VGND sg13cmos5l_a21oi_1
XFILLER_53_955 VPWR VGND sg13cmos5l_fill_1
XFILLER_64_281 VPWR VGND sg13cmos5l_fill_1
XFILLER_80_730 VPWR VGND sg13cmos5l_fill_2
X_09434_ _09434_/X _14122_/Q hold3301/X _09434_/S VPWR VGND sg13cmos5l_mux2_1
XFILLER_40_616 VPWR VGND sg13cmos5l_fill_1
XFILLER_80_774 VPWR VGND sg13cmos5l_fill_1
X_14232__1245 _14232_/RESET_B VPWR VGND sg13cmos5l_tiehi
XFILLER_21_830 VPWR VGND sg13cmos5l_fill_1
X_09365_ _13478_/D _08269_/A hold3008/X _09376_/S VPWR VGND sg13cmos5l_mux2_1
X_08316_ _08316_/Y _08315_/A _08313_/Y _08315_/Y VPWR VGND sg13cmos5l_o21ai_1
X_09296_ _13416_/D _07310_/Y _09295_/B _09295_/Y VPWR VGND sg13cmos5l_a21oi_1
X_08247_ _08247_/Y _08309_/A _07303_/Y _08310_/B1 VPWR VGND sg13cmos5l_a21oi_1
X_08178_ _08178_/Y _08202_/A _08177_/X VPWR VGND sg13cmos5l_nor2b_1
X_10140_ _13834_/D _10532_/A1 _10139_/B _10139_/Y VPWR VGND sg13cmos5l_o21ai_1
X_13491__1931 _13491_/RESET_B VPWR VGND sg13cmos5l_tiehi
XFILLER_0_734 VPWR VGND sg13cmos5l_fill_1
X_10071_ _13800_/D _10593_/A1 _10086_/B _10070_/Y VPWR VGND sg13cmos5l_o21ai_1
XFILLER_0_767 VPWR VGND sg13cmos5l_fill_2
Xhold2950 _10335_/A _13930_/Q VPWR VGND sg13cmos5l_dlygate4sd3_1
Xhold2961 _10177_/A _13852_/Q VPWR VGND sg13cmos5l_dlygate4sd3_1
Xhold2972 hold2972/X _13219_/Q VPWR VGND sg13cmos5l_dlygate4sd3_1
Xhold2983 _09744_/A _13641_/Q VPWR VGND sg13cmos5l_dlygate4sd3_1
XFILLER_28_440 VPWR VGND sg13cmos5l_fill_1
Xhold2994 _10299_/A _13912_/Q VPWR VGND sg13cmos5l_dlygate4sd3_1
X_13830_ _13830_/Q clkload55/A _13830_/D _13830_/RESET_B VPWR VGND sg13cmos5l_dfrbpq_1
XFILLER_46_64 VPWR VGND sg13cmos5l_fill_1
XFILLER_90_516 VPWR VGND sg13cmos5l_fill_2
X_10973_ _10973_/Y _10844_/D _10880_/B _10937_/Y VPWR VGND sg13cmos5l_a21oi_1
X_13761_ _13761_/Q clkload57/A _13761_/D _13761_/RESET_B VPWR VGND sg13cmos5l_dfrbpq_1
XFILLER_16_657 VPWR VGND sg13cmos5l_fill_2
X_12712_ _12713_/B _09575_/C _11901_/B _12703_/Y VPWR VGND sg13cmos5l_o21ai_1
XFILLER_43_454 VPWR VGND sg13cmos5l_fill_2
X_13692_ _13692_/Q clkload46/A _13692_/D _13692_/RESET_B VPWR VGND sg13cmos5l_dfrbpq_1
X_12643_ _12649_/C _12643_/A _12651_/B VPWR VGND sg13cmos5l_nand2_1
XFILLER_12_841 VPWR VGND sg13cmos5l_fill_1
X_12574_ _12574_/Y _07518_/Y _12639_/C _12641_/A _12573_/X VPWR VGND sg13cmos5l_a22oi_1
XFILLER_7_311 VPWR VGND sg13cmos5l_fill_1
XFILLER_7_322 VPWR VGND sg13cmos5l_fill_1
X_11525_ _11525_/Y _11614_/A _11525_/B VPWR VGND sg13cmos5l_nor2_1
X_14313_ _14313_/Q clkload40/A _14313_/D _14313_/RESET_B VPWR VGND sg13cmos5l_dfrbpq_1
X_14244_ _14244_/Q clkload43/A _14244_/D _14244_/RESET_B VPWR VGND sg13cmos5l_dfrbpq_1
X_11456_ _11515_/A _11456_/A _11456_/B _11456_/C _11456_/D VPWR VGND sg13cmos5l_nor4_1
X_10407_ _13965_/D fanout76/X _10406_/B _10406_/Y VPWR VGND sg13cmos5l_a21oi_1
X_11387_ _11391_/C _11387_/A _11387_/B VPWR VGND sg13cmos5l_nor2_1
X_14175_ _14175_/Q clkload71/A _14175_/D _14175_/RESET_B VPWR VGND sg13cmos5l_dfrbpq_1
X_10338_ _13931_/D _10599_/A1 _10339_/B _10337_/Y VPWR VGND sg13cmos5l_a21oi_1
X_13126_ _13127_/B _09344_/A _13119_/B _13119_/Y _14550_/Q VPWR VGND sg13cmos5l_a22oi_1
XFILLER_79_830 VPWR VGND sg13cmos5l_fill_2
XFILLER_79_841 VPWR VGND sg13cmos5l_decap_8
X_13057_ _13061_/C _13057_/A _13058_/B VPWR VGND sg13cmos5l_nor2_1
XFILLER_79_863 VPWR VGND sg13cmos5l_decap_8
X_10269_ _13897_/D _10399_/A1 _10278_/B _10268_/Y VPWR VGND sg13cmos5l_a21oi_1
X_12008_ _12008_/Y _12008_/A _12008_/B _12008_/C VPWR VGND sg13cmos5l_nand3_1
X_13666__1725 _13666_/RESET_B VPWR VGND sg13cmos5l_tiehi
X_13959_ _13959_/Q _14064_/CLK _13959_/D _13959_/RESET_B VPWR VGND sg13cmos5l_dfrbpq_1
X_07480_ _12963_/C _07614_/A _07619_/A _08956_/A VPWR VGND sg13cmos5l_nand3_1
X_14046__1345 _14046_/RESET_B VPWR VGND sg13cmos5l_tiehi
XFILLER_21_104 VPWR VGND sg13cmos5l_fill_2
X_13881__1510 _13881_/RESET_B VPWR VGND sg13cmos5l_tiehi
XFILLER_21_148 VPWR VGND sg13cmos5l_fill_2
X_09150_ _09150_/Y _09161_/B _09148_/Y _09149_/Y VPWR VGND sg13cmos5l_a21oi_1
X_08101_ _13199_/D _08097_/Y _08100_/Y _13127_/A VPWR VGND sg13cmos5l_a21oi_1
X_09081_ _09081_/Y _11309_/A _09080_/Y _09106_/A2 VPWR VGND sg13cmos5l_a21oi_1
X_08032_ _08032_/Y _08032_/A _08032_/B _08032_/C VPWR VGND sg13cmos5l_nor3_1
X_14571__2117 _14571_/RESET_B VPWR VGND sg13cmos5l_tiehi
X_09983_ _09983_/Y _09983_/A _09989_/B VPWR VGND sg13cmos5l_nand2_1
X_08934_ _08934_/Y _14267_/Q _13191_/B1 _08938_/B1 VPWR VGND sg13cmos5l_a21oi_1
XFILLER_97_671 VPWR VGND sg13cmos5l_decap_8
Xhold2235 _11056_/A _14282_/Q VPWR VGND sg13cmos5l_dlygate4sd3_1
Xhold2246 _10552_/A _14036_/Q VPWR VGND sg13cmos5l_dlygate4sd3_1
X_14256__1803 _14256_/RESET_B VPWR VGND sg13cmos5l_tiehi
XFILLER_97_682 VPWR VGND sg13cmos5l_fill_1
X_08865_ _08865_/Y _08582_/A _08879_/A2 _08864_/Y VPWR VGND sg13cmos5l_o21ai_1
Xhold2257 _14483_/D _12991_/X VPWR VGND sg13cmos5l_dlygate4sd3_1
Xhold2268 _10594_/A _14057_/Q VPWR VGND sg13cmos5l_dlygate4sd3_1
Xhold2279 _10927_/A _14209_/Q VPWR VGND sg13cmos5l_dlygate4sd3_1
X_14450__1056 _14450_/RESET_B VPWR VGND sg13cmos5l_tiehi
XFILLER_85_877 VPWR VGND sg13cmos5l_fill_2
X_07816_ _07816_/X _14404_/Q _14372_/Q VPWR VGND sg13cmos5l_or2_1
X_08796_ _08797_/A _08450_/A _08819_/B _08822_/B hold3449/X _08795_/Y VPWR VGND sg13cmos5l_a221oi_1
XFILLER_26_922 VPWR VGND sg13cmos5l_fill_2
X_07747_ _07747_/Y _14384_/Q _11821_/A VPWR VGND sg13cmos5l_nand2b_1
XFILLER_53_752 VPWR VGND sg13cmos5l_fill_1
XFILLER_25_454 VPWR VGND sg13cmos5l_fill_2
XFILLER_40_402 VPWR VGND sg13cmos5l_decap_4
X_07678_ _07678_/Y _14386_/Q _14354_/Q VPWR VGND sg13cmos5l_nand2_1
XFILLER_13_649 VPWR VGND sg13cmos5l_fill_2
XFILLER_80_593 VPWR VGND sg13cmos5l_decap_8
X_09417_ _13528_/D _10685_/A1 hold3118/X _09421_/S VPWR VGND sg13cmos5l_mux2_1
X_09348_ _13461_/D _09414_/A0 hold3177/X _09366_/S VPWR VGND sg13cmos5l_mux2_1
X_09279_ _13403_/D _08182_/A hold3170/X _09280_/S VPWR VGND sg13cmos5l_mux2_1
X_11310_ _11352_/B _11311_/B VPWR VGND sg13cmos5l_inv_1
X_12290_ _12290_/Y _14028_/Q _12290_/A2 _12293_/B1 VPWR VGND sg13cmos5l_a21oi_1
XFILLER_106_2 VPWR VGND sg13cmos5l_fill_1
XFILLER_106_242 VPWR VGND sg13cmos5l_fill_2
X_11241_ _11241_/X _11268_/A _11241_/B VPWR VGND sg13cmos5l_xor2_1
X_13744__1647 _13744_/RESET_B VPWR VGND sg13cmos5l_tiehi
XFILLER_79_104 VPWR VGND sg13cmos5l_fill_1
X_11172_ _14311_/D _11172_/A VPWR VGND sg13cmos5l_inv_1
X_10123_ _10123_/Y _10123_/A _10137_/B VPWR VGND sg13cmos5l_nand2_1
XFILLER_0_542 VPWR VGND sg13cmos5l_fill_2
XFILLER_0_553 VPWR VGND sg13cmos5l_fill_2
Xhold3470 hold3470/X _13268_/Q VPWR VGND sg13cmos5l_dlygate4sd3_1
XFILLER_102_481 VPWR VGND sg13cmos5l_fill_1
XFILLER_103_993 VPWR VGND sg13cmos5l_decap_8
XFILLER_76_844 VPWR VGND sg13cmos5l_decap_8
X_10054_ _10054_/Y _10054_/A _10054_/B VPWR VGND sg13cmos5l_nand2_1
Xhold3492 _09020_/A _13292_/Q VPWR VGND sg13cmos5l_dlygate4sd3_1
Xhold3481 hold3481/X _13281_/Q VPWR VGND sg13cmos5l_dlygate4sd3_1
Xhold2780 _09815_/A _13675_/Q VPWR VGND sg13cmos5l_dlygate4sd3_1
Xhold2791 _10452_/A _13987_/Q VPWR VGND sg13cmos5l_dlygate4sd3_1
XFILLER_35_218 VPWR VGND sg13cmos5l_fill_2
XFILLER_91_825 VPWR VGND sg13cmos5l_fill_2
XFILLER_91_836 VPWR VGND sg13cmos5l_fill_2
X_13813_ _13813_/Q clkload49/A _13813_/D _13813_/RESET_B VPWR VGND sg13cmos5l_dfrbpq_1
X_10956_ _10957_/A hold3465/X _10960_/B _10857_/Y _10971_/C VPWR VGND sg13cmos5l_a22oi_1
X_13992__1399 _13992_/RESET_B VPWR VGND sg13cmos5l_tiehi
X_13744_ _13744_/Q clkload78/A _13744_/D _13744_/RESET_B VPWR VGND sg13cmos5l_dfrbpq_1
X_13377__2045 _13377_/RESET_B VPWR VGND sg13cmos5l_tiehi
XFILLER_16_498 VPWR VGND sg13cmos5l_fill_2
XFILLER_44_796 VPWR VGND sg13cmos5l_fill_1
X_10887_ _10887_/Y _14245_/Q _11011_/A _10887_/C _10887_/D VPWR VGND sg13cmos5l_nand4_1
X_13675_ _13675_/Q _14028_/CLK _13675_/D _13675_/RESET_B VPWR VGND sg13cmos5l_dfrbpq_1
X_12626_ _12627_/B _12548_/Y _12623_/Y _12625_/Y VPWR VGND sg13cmos5l_o21ai_1
XFILLER_8_620 VPWR VGND sg13cmos5l_fill_1
X_12557_ _12557_/Y _14342_/Q _14571_/Q _12555_/Y _10987_/B VPWR VGND sg13cmos5l_a22oi_1
X_11508_ _14334_/D _11506_/Y _11507_/Y _11497_/Y VPWR VGND sg13cmos5l_o21ai_1
X_12488_ _12488_/Y _12489_/A1 _12012_/Y _12487_/B VPWR VGND sg13cmos5l_a21oi_1
XFILLER_7_196 VPWR VGND sg13cmos5l_decap_4
X_11439_ _11439_/Y _11440_/A _11463_/B VPWR VGND sg13cmos5l_nor2_1
X_14227_ _14227_/Q clkload44/A _14227_/D _14227_/RESET_B VPWR VGND sg13cmos5l_dfrbpq_1
X_14158_ _14158_/Q clkload26/A _14158_/D fanout987/X VPWR VGND sg13cmos5l_dfrbpq_1
X_13109_ _13109_/Y _13109_/A _13109_/B VPWR VGND sg13cmos5l_xnor2_1
XFILLER_101_908 VPWR VGND sg13cmos5l_decap_8
X_14089_ _14089_/Q clkload72/A _14089_/D _14089_/RESET_B VPWR VGND sg13cmos5l_dfrbpq_1
XFILLER_67_844 VPWR VGND sg13cmos5l_decap_8
XFILLER_39_557 VPWR VGND sg13cmos5l_fill_2
XFILLER_67_877 VPWR VGND sg13cmos5l_decap_4
X_08650_ _08650_/X _08653_/B _11719_/S VPWR VGND sg13cmos5l_and2_1
X_13587__1835 _13587_/RESET_B VPWR VGND sg13cmos5l_tiehi
XFILLER_54_505 VPWR VGND sg13cmos5l_decap_8
X_07601_ _07603_/B _13286_/Q _13285_/Q _13284_/Q _07606_/B VPWR VGND sg13cmos5l_nand4_1
XFILLER_93_195 VPWR VGND sg13cmos5l_fill_1
X_08581_ _08581_/Y _08583_/A _08578_/Y _08580_/Y _07657_/B VPWR VGND sg13cmos5l_a22oi_1
XFILLER_50_700 VPWR VGND sg13cmos5l_decap_8
XFILLER_62_560 VPWR VGND sg13cmos5l_fill_2
X_07532_ _13033_/B _07532_/A _07532_/B VPWR VGND sg13cmos5l_and2_1
XFILLER_62_571 VPWR VGND sg13cmos5l_fill_1
XFILLER_90_880 VPWR VGND sg13cmos5l_decap_4
X_07463_ _07463_/Y _08227_/A2 _07461_/Y _07403_/A VPWR VGND sg13cmos5l_o21ai_1
X_13822__1569 _13822_/RESET_B VPWR VGND sg13cmos5l_tiehi
X_09202_ _13331_/D _09445_/A0 hold3326/X _09208_/S VPWR VGND sg13cmos5l_mux2_1
X_07394_ _07395_/D _14561_/Q _07436_/C _07372_/Y VPWR VGND sg13cmos5l_o21ai_1
X_09133_ _11451_/A _14331_/Q _09163_/B VPWR VGND sg13cmos5l_nand2_1
X_09064_ _09064_/X _11264_/A _09063_/Y _09075_/B1 VPWR VGND sg13cmos5l_a21o_1
X_13422__2000 _13422_/RESET_B VPWR VGND sg13cmos5l_tiehi
X_08015_ _08030_/B _14558_/Q _08038_/B VPWR VGND sg13cmos5l_xnor2_1
X_14182__1295 _14182_/RESET_B VPWR VGND sg13cmos5l_tiehi
XFILLER_104_746 VPWR VGND sg13cmos5l_fill_1
X_09966_ _13748_/D _10553_/A1 _09979_/B _09965_/Y VPWR VGND sg13cmos5l_o21ai_1
XFILLER_58_811 VPWR VGND sg13cmos5l_fill_1
X_08917_ _08917_/X _13162_/B _13159_/B VPWR VGND sg13cmos5l_or2_1
X_09897_ _13714_/D _10419_/A1 _09912_/B _09896_/Y VPWR VGND sg13cmos5l_a21oi_1
XFILLER_100_941 VPWR VGND sg13cmos5l_fill_2
XFILLER_57_332 VPWR VGND sg13cmos5l_decap_8
X_08848_ _08851_/B _07683_/A _08848_/B VPWR VGND sg13cmos5l_nand2b_1
Xclkbuf_leaf_96_clk clkload17/A clkbuf_4_2_0_clk/X VPWR VGND sg13cmos5l_buf_8
XFILLER_45_538 VPWR VGND sg13cmos5l_fill_1
XFILLER_57_398 VPWR VGND sg13cmos5l_decap_8
X_08779_ _08779_/Y _08785_/B2 _14159_/Q _13268_/Q _07959_/B VPWR VGND sg13cmos5l_a22oi_1
X_14386__1122 _14386_/RESET_B VPWR VGND sg13cmos5l_tiehi
XFILLER_26_763 VPWR VGND sg13cmos5l_fill_1
X_10810_ _10810_/Y _07327_/Y _10766_/B _10809_/Y VPWR VGND sg13cmos5l_a21oi_1
X_11790_ _12649_/B _11790_/A _11867_/B VPWR VGND sg13cmos5l_nand2_1
XFILLER_41_733 VPWR VGND sg13cmos5l_fill_1
X_10741_ _10741_/Y _10798_/A _14285_/Q VPWR VGND sg13cmos5l_nand2_1
X_13460_ _13460_/Q clkload15/A _13460_/D _13460_/RESET_B VPWR VGND sg13cmos5l_dfrbpq_1
XFILLER_9_428 VPWR VGND sg13cmos5l_fill_2
X_10672_ _10672_/Y _10826_/S _14260_/D VPWR VGND sg13cmos5l_nor2_1
X_12411_ _12411_/Y _14212_/Q _14213_/Q _11635_/A VPWR VGND sg13cmos5l_o21ai_1
Xclkbuf_leaf_20_clk _14105_/CLK clkbuf_4_4_0_clk/X VPWR VGND sg13cmos5l_buf_8
X_13391_ _13391_/Q clkload33/A _13391_/D _13391_/RESET_B VPWR VGND sg13cmos5l_dfrbpq_1
X_13977__1414 _13977_/RESET_B VPWR VGND sg13cmos5l_tiehi
X_12342_ _12342_/Y _13774_/Q _12346_/A2 _12346_/B1 VPWR VGND sg13cmos5l_a21oi_1
X_12273_ _12273_/Y _12271_/Y _12272_/Y _12378_/B1 VPWR VGND sg13cmos5l_a21oi_1
XFILLER_4_144 VPWR VGND sg13cmos5l_fill_2
X_11224_ _11226_/A _14087_/Q _11228_/B VPWR VGND sg13cmos5l_xnor2_1
X_14012_ _14012_/Q clkload47/A _14012_/D _14012_/RESET_B VPWR VGND sg13cmos5l_dfrbpq_1
XFILLER_96_939 VPWR VGND sg13cmos5l_decap_8
X_11155_ _14307_/D _07184_/Y _11166_/A2 _11154_/Y _10654_/B VPWR VGND sg13cmos5l_a22oi_1
XFILLER_95_438 VPWR VGND sg13cmos5l_fill_2
X_10106_ _13817_/D _10563_/A1 _10109_/B _10105_/Y VPWR VGND sg13cmos5l_o21ai_1
X_11086_ _14289_/D _11147_/B _11084_/Y _11085_/Y VPWR VGND sg13cmos5l_a21oi_1
XFILLER_76_630 VPWR VGND sg13cmos5l_fill_2
XFILLER_76_641 VPWR VGND sg13cmos5l_fill_2
X_10037_ _13783_/D _10559_/A1 _10042_/B _10036_/Y VPWR VGND sg13cmos5l_o21ai_1
Xclkbuf_leaf_87_clk clkload53/A clkload4/A VPWR VGND sg13cmos5l_buf_8
XFILLER_48_354 VPWR VGND sg13cmos5l_fill_2
XFILLER_48_376 VPWR VGND sg13cmos5l_fill_2
XFILLER_76_663 VPWR VGND sg13cmos5l_fill_1
XFILLER_76_685 VPWR VGND sg13cmos5l_decap_8
XFILLER_76_696 VPWR VGND sg13cmos5l_fill_2
XFILLER_91_622 VPWR VGND sg13cmos5l_fill_1
X_15894_ _15894_/X _15894_/A VPWR VGND sg13cmos5l_buf_1
X_14570__2116 _14570_/RESET_B VPWR VGND sg13cmos5l_tiehi
XFILLER_63_346 VPWR VGND sg13cmos5l_fill_1
XFILLER_64_847 VPWR VGND sg13cmos5l_fill_1
XFILLER_32_700 VPWR VGND sg13cmos5l_fill_2
XFILLER_63_368 VPWR VGND sg13cmos5l_fill_1
X_11988_ _11988_/Y _11988_/A _11956_/Y VPWR VGND sg13cmos5l_nor2b_1
X_10939_ _10939_/Y _10939_/A _10939_/B VPWR VGND sg13cmos5l_nand2_1
X_13727_ _13727_/Q clkload46/A _13727_/D _13727_/RESET_B VPWR VGND sg13cmos5l_dfrbpq_1
XFILLER_20_917 VPWR VGND sg13cmos5l_fill_2
XFILLER_32_755 VPWR VGND sg13cmos5l_fill_1
X_14255__1802 _14255_/RESET_B VPWR VGND sg13cmos5l_tiehi
X_13658_ _13658_/Q clkload53/A _13658_/D _13658_/RESET_B VPWR VGND sg13cmos5l_dfrbpq_1
Xclkbuf_leaf_11_clk clkload23/A clkload1/A VPWR VGND sg13cmos5l_buf_8
X_13589_ _13589_/Q clkload49/A _13589_/D _13589_/RESET_B VPWR VGND sg13cmos5l_dfrbpq_1
X_12609_ _12609_/X _12640_/A _12609_/B VPWR VGND sg13cmos5l_and2_1
XFILLER_87_928 VPWR VGND sg13cmos5l_decap_4
X_09820_ _13677_/D fanout75/X _09821_/B _09819_/Y VPWR VGND sg13cmos5l_a21oi_1
Xfanout429 _10519_/B _10531_/B VPWR VGND sg13cmos5l_buf_1
Xfanout418 _10596_/B _10577_/A2 VPWR VGND sg13cmos5l_buf_1
Xfanout407 _11135_/B _11145_/A1 VPWR VGND sg13cmos5l_buf_1
X_09751_ _13644_/D fanout78/X _09758_/B _09750_/Y VPWR VGND sg13cmos5l_a21oi_1
XFILLER_79_490 VPWR VGND sg13cmos5l_decap_4
X_08702_ _08702_/Y _13940_/Q _11749_/B _08748_/B1 _13876_/Q VPWR VGND sg13cmos5l_a22oi_1
Xclkbuf_leaf_78_clk clkload60/A clkbuf_4_10_0_clk/X VPWR VGND sg13cmos5l_buf_8
XFILLER_55_825 VPWR VGND sg13cmos5l_decap_8
XFILLER_94_460 VPWR VGND sg13cmos5l_fill_2
X_09682_ _09682_/Y _09682_/A _09682_/B VPWR VGND sg13cmos5l_nor2_1
XFILLER_55_847 VPWR VGND sg13cmos5l_fill_2
X_08633_ _08633_/Y _14192_/Q _08633_/B _08633_/C VPWR VGND sg13cmos5l_nor3_1
XFILLER_54_379 VPWR VGND sg13cmos5l_fill_1
X_08564_ _08564_/Y _08559_/B _07661_/X _07662_/X VPWR VGND sg13cmos5l_a21oi_1
XFILLER_82_699 VPWR VGND sg13cmos5l_fill_1
X_07515_ _07515_/X _07515_/A _07515_/B _07515_/C _07515_/D VPWR VGND sg13cmos5l_and4_1
XFILLER_50_541 VPWR VGND sg13cmos5l_decap_4
X_08495_ _14592_/D _08495_/A _08495_/B VPWR VGND sg13cmos5l_xnor2_1
X_07446_ _07446_/Y _07446_/A VPWR VGND sg13cmos5l_inv_1
Xfanout69 _12385_/A _12251_/A VPWR VGND sg13cmos5l_buf_1
Xfanout58 fanout58/X _09687_/Y VPWR VGND sg13cmos5l_buf_1
X_07377_ _07378_/A _08984_/A _14543_/Q VPWR VGND sg13cmos5l_xnor2_1
XFILLER_6_409 VPWR VGND sg13cmos5l_fill_1
X_09116_ _09116_/Y _14424_/Q _11374_/A VPWR VGND sg13cmos5l_nand2_1
X_09047_ _09047_/Y _11711_/A _09076_/A2 _09046_/Y VPWR VGND sg13cmos5l_a21oi_1
X_13661__1730 _13661_/RESET_B VPWR VGND sg13cmos5l_tiehi
X_09949_ _13740_/D fanout77/X _09948_/B _09948_/Y VPWR VGND sg13cmos5l_a21oi_1
Xfanout930 _08984_/A _13306_/Q VPWR VGND sg13cmos5l_buf_1
Xfanout941 _08956_/A _13300_/Q VPWR VGND sg13cmos5l_buf_1
Xfanout952 _12893_/B1 _12802_/A VPWR VGND sg13cmos5l_buf_1
Xfanout963 fanout963/X fanout966/X VPWR VGND sg13cmos5l_buf_1
Xfanout974 fanout974/X fanout977/X VPWR VGND sg13cmos5l_buf_1
Xfanout985 fanout985/X fanout988/X VPWR VGND sg13cmos5l_buf_1
Xclkbuf_leaf_69_clk clkload62/A clkload5/A VPWR VGND sg13cmos5l_buf_8
Xfanout996 fanout996/X fanout998/A VPWR VGND sg13cmos5l_buf_1
X_14041__1350 _14041_/RESET_B VPWR VGND sg13cmos5l_tiehi
X_13694__1697 _13694_/RESET_B VPWR VGND sg13cmos5l_tiehi
X_12960_ _14467_/D _12960_/A VPWR VGND sg13cmos5l_inv_1
XFILLER_100_793 VPWR VGND sg13cmos5l_fill_1
X_11911_ _11911_/Y _11907_/Y _11908_/Y _11909_/Y _11910_/Y VPWR VGND sg13cmos5l_a22oi_1
X_12891_ _12891_/X _12891_/A1 _12621_/X _12653_/X VPWR VGND sg13cmos5l_a21o_1
XFILLER_54_20 VPWR VGND sg13cmos5l_fill_1
X_11842_ _11843_/B _12408_/A1 _11838_/Y _11841_/Y VPWR VGND sg13cmos5l_o21ai_1
X_14630_ _14630_/Q _14630_/CLK _14630_/D _14630_/RESET_B VPWR VGND sg13cmos5l_dfrbpq_1
X_14561_ _14561_/Q clkload12/A _14561_/D fanout958/X VPWR VGND sg13cmos5l_dfrbpq_1
XFILLER_13_210 VPWR VGND sg13cmos5l_fill_2
X_11773_ _11773_/Y _13786_/Q _11785_/B _12238_/B1 VPWR VGND sg13cmos5l_a21oi_1
X_13512_ _13512_/Q clkload30/A _13512_/D _13512_/RESET_B VPWR VGND sg13cmos5l_dfrbpq_1
X_10724_ _10724_/Y _10724_/A _10781_/B VPWR VGND sg13cmos5l_nand2_1
X_14492_ _14492_/Q clkload10/A _14492_/D fanout975/X VPWR VGND sg13cmos5l_dfrbpq_1
XFILLER_103_1000 VPWR VGND sg13cmos5l_decap_8
X_10655_ _10655_/Y _14241_/Q _11029_/C _10654_/Y VPWR VGND sg13cmos5l_o21ai_1
X_13443_ _13443_/Q _14117_/CLK _13443_/D _13443_/RESET_B VPWR VGND sg13cmos5l_dfrbpq_1
XFILLER_70_63 VPWR VGND sg13cmos5l_fill_1
XFILLER_70_74 VPWR VGND sg13cmos5l_fill_2
Xclkload17 clkload17/Y clkload17/A VPWR VGND sg13cmos5l_inv_2
X_13374_ _13374_/Q clkload32/A _13374_/D _13374_/RESET_B VPWR VGND sg13cmos5l_dfrbpq_1
XFILLER_10_994 VPWR VGND sg13cmos5l_fill_1
X_10586_ _10586_/Y _10586_/A _10602_/B VPWR VGND sg13cmos5l_nand2_1
Xclkload39 clkload39/Y clkload39/A VPWR VGND sg13cmos5l_inv_4
Xclkload28 clkload28/Y clkload28/A VPWR VGND sg13cmos5l_inv_2
X_12325_ _12325_/Y _12856_/A _12353_/B _12324_/Y VPWR VGND sg13cmos5l_a21oi_1
XFILLER_86_1028 VPWR VGND sg13cmos5l_fill_1
XFILLER_5_475 VPWR VGND sg13cmos5l_fill_1
X_12256_ _12284_/A _12256_/A _12256_/B _12256_/C VPWR VGND sg13cmos5l_nor3_1
X_11207_ _11207_/Y _11207_/A _11220_/B VPWR VGND sg13cmos5l_nand2_1
X_12187_ _12216_/B _12187_/A _13250_/Q VPWR VGND sg13cmos5l_xnor2_1
X_11138_ _11138_/Y _11138_/A _11144_/B VPWR VGND sg13cmos5l_nor2_1
XFILLER_49_641 VPWR VGND sg13cmos5l_decap_4
XFILLER_84_909 VPWR VGND sg13cmos5l_fill_2
X_11069_ _11069_/Y _11069_/A _11132_/B VPWR VGND sg13cmos5l_nor2_1
Xclkbuf_leaf_0_clk clkload8/A clkbuf_4_0_0_clk/X VPWR VGND sg13cmos5l_buf_8
XFILLER_76_482 VPWR VGND sg13cmos5l_decap_4
XFILLER_92_942 VPWR VGND sg13cmos5l_decap_8
XFILLER_52_828 VPWR VGND sg13cmos5l_fill_2
XFILLER_52_839 VPWR VGND sg13cmos5l_fill_1
X_07300_ _07300_/Y _13346_/Q VPWR VGND sg13cmos5l_inv_1
XFILLER_32_563 VPWR VGND sg13cmos5l_fill_2
XFILLER_32_585 VPWR VGND sg13cmos5l_fill_1
XFILLER_60_894 VPWR VGND sg13cmos5l_decap_4
X_08280_ _14262_/D _14262_/Q _12598_/B _11042_/S VPWR VGND sg13cmos5l_mux2_1
X_07231_ _07751_/B _14355_/Q VPWR VGND sg13cmos5l_inv_1
XFILLER_105_307 VPWR VGND sg13cmos5l_fill_1
Xfanout204 _10139_/B _10120_/A2 VPWR VGND sg13cmos5l_buf_1
XFILLER_59_416 VPWR VGND sg13cmos5l_decap_4
XFILLER_8_1028 VPWR VGND sg13cmos5l_fill_1
X_09803_ _09803_/Y _09803_/A _09817_/B VPWR VGND sg13cmos5l_nor2_1
Xfanout237 _10371_/A1 _09543_/Y VPWR VGND sg13cmos5l_buf_1
Xfanout226 _09977_/B fanout233/X VPWR VGND sg13cmos5l_buf_1
Xfanout215 _10074_/B _10054_/B VPWR VGND sg13cmos5l_buf_1
X_07995_ _12622_/B _08379_/C1 _07994_/Y _07990_/Y VPWR VGND sg13cmos5l_o21ai_1
Xfanout259 _10368_/B _10351_/Y VPWR VGND sg13cmos5l_buf_1
Xfanout248 _07420_/B _07403_/X VPWR VGND sg13cmos5l_buf_1
XFILLER_68_972 VPWR VGND sg13cmos5l_fill_2
X_09734_ _09734_/Y _09734_/A _09746_/B VPWR VGND sg13cmos5l_nor2_1
X_13372__2050 _13372_/RESET_B VPWR VGND sg13cmos5l_tiehi
XFILLER_67_493 VPWR VGND sg13cmos5l_decap_8
X_09665_ _09665_/Y _09671_/A _11542_/B _09664_/Y VPWR VGND sg13cmos5l_a21oi_1
XFILLER_15_508 VPWR VGND sg13cmos5l_decap_4
XFILLER_83_964 VPWR VGND sg13cmos5l_fill_2
X_08616_ _08616_/X _08616_/A _08616_/B VPWR VGND sg13cmos5l_and2_1
X_09596_ _09604_/B _14454_/Q _09625_/C VPWR VGND sg13cmos5l_and2_1
XFILLER_70_658 VPWR VGND sg13cmos5l_fill_2
X_08547_ _08547_/X _08582_/B _08539_/B _07773_/Y VPWR VGND sg13cmos5l_a21o_1
X_08478_ _14589_/D _08815_/A _08478_/B VPWR VGND sg13cmos5l_xor2_1
X_13679__1712 _13679_/RESET_B VPWR VGND sg13cmos5l_tiehi
X_07429_ _07429_/Y _07403_/A _07427_/X _07428_/Y VPWR VGND sg13cmos5l_o21ai_1
X_10440_ _10440_/Y _10440_/A _10446_/B VPWR VGND sg13cmos5l_nor2_1
X_10371_ _13947_/D _10371_/A1 _10374_/B _10370_/Y VPWR VGND sg13cmos5l_a21oi_1
X_14059__1332 _14059_/RESET_B VPWR VGND sg13cmos5l_tiehi
X_12110_ _12110_/X _12110_/A _12132_/A VPWR VGND sg13cmos5l_xor2_1
X_13582__1840 _13582_/RESET_B VPWR VGND sg13cmos5l_tiehi
X_13090_ _14529_/D _13090_/A _13090_/B VPWR VGND sg13cmos5l_xor2_1
XFILLER_105_841 VPWR VGND sg13cmos5l_decap_8
X_12041_ _12042_/B _12097_/A1 _12492_/B _12040_/Y VPWR VGND sg13cmos5l_o21ai_1
XFILLER_105_885 VPWR VGND sg13cmos5l_decap_8
XFILLER_105_896 VPWR VGND sg13cmos5l_fill_1
Xfanout760 _10798_/A _10804_/A VPWR VGND sg13cmos5l_buf_1
XFILLER_19_803 VPWR VGND sg13cmos5l_fill_2
XFILLER_65_419 VPWR VGND sg13cmos5l_fill_1
Xfanout793 _08378_/A1 _08375_/S VPWR VGND sg13cmos5l_buf_1
Xfanout782 _07522_/S0 _07524_/S0 VPWR VGND sg13cmos5l_buf_1
Xfanout771 _11466_/A _11586_/A VPWR VGND sg13cmos5l_buf_1
X_14254__1801 _14254_/RESET_B VPWR VGND sg13cmos5l_tiehi
X_13992_ _13992_/Q _14640_/CLK _13992_/D _13992_/RESET_B VPWR VGND sg13cmos5l_dfrbpq_1
X_12943_ _12944_/A _14459_/Q _12945_/A2 _11493_/B _12945_/B2 VPWR VGND sg13cmos5l_a22oi_1
XFILLER_46_677 VPWR VGND sg13cmos5l_decap_4
XFILLER_65_85 VPWR VGND sg13cmos5l_fill_1
XFILLER_73_463 VPWR VGND sg13cmos5l_fill_1
X_12874_ _14434_/D _12382_/B _12873_/Y _12893_/B1 VPWR VGND sg13cmos5l_a21oi_1
X_11825_ _11849_/B _11982_/A _11825_/B VPWR VGND sg13cmos5l_or2_1
X_14613_ _14613_/Q clkload74/A _14613_/D _14613_/RESET_B VPWR VGND sg13cmos5l_dfrbpq_1
X_11756_ _11757_/B _14041_/Q _08687_/Y _11755_/X _11862_/B VPWR VGND sg13cmos5l_a22oi_1
X_14544_ _14544_/Q clkload19/A _14544_/D fanout983/X VPWR VGND sg13cmos5l_dfrbpq_1
XFILLER_81_73 VPWR VGND sg13cmos5l_fill_2
X_10707_ _14127_/D input5/X _09302_/A _10710_/S VPWR VGND sg13cmos5l_mux2_1
X_14475_ _14475_/Q _14532_/CLK _14475_/D fanout970/X VPWR VGND sg13cmos5l_dfrbpq_1
X_11687_ _11687_/Y _13975_/Q _11702_/B VPWR VGND sg13cmos5l_nand2_1
X_13426_ _13426_/Q _14102_/CLK _13426_/D _13426_/RESET_B VPWR VGND sg13cmos5l_dfrbpq_1
X_10638_ _10642_/B _14075_/Q _14076_/Q _10638_/C VPWR VGND sg13cmos5l_nand3_1
XFILLER_6_751 VPWR VGND sg13cmos5l_decap_8
X_10569_ _14044_/D _10569_/A1 _10576_/B _10568_/Y VPWR VGND sg13cmos5l_o21ai_1
X_13357_ _13357_/Q clkload41/A _13357_/D _13357_/RESET_B VPWR VGND sg13cmos5l_dfrbpq_1
X_13288_ _13288_/Q clkload21/A _13288_/D fanout984/X VPWR VGND sg13cmos5l_dfrbpq_1
X_12308_ _12308_/Y _12329_/B _12307_/Y _12364_/A VPWR VGND sg13cmos5l_a21oi_1
XFILLER_46_4 VPWR VGND sg13cmos5l_fill_2
X_12239_ _12239_/Y _12235_/Y _12236_/Y _12237_/Y _12238_/Y VPWR VGND sg13cmos5l_a22oi_1
Xhold2609 _09795_/A _13665_/Q VPWR VGND sg13cmos5l_dlygate4sd3_1
X_07780_ _07780_/Y _14396_/Q _14364_/Q VPWR VGND sg13cmos5l_nand2b_1
X_13757__1634 _13757_/RESET_B VPWR VGND sg13cmos5l_tiehi
XFILLER_37_633 VPWR VGND sg13cmos5l_fill_1
XFILLER_49_493 VPWR VGND sg13cmos5l_fill_2
XFILLER_77_791 VPWR VGND sg13cmos5l_fill_1
Xinput4 input4/X ui_in[11] VPWR VGND sg13cmos5l_buf_1
X_13445__1977 _13445_/RESET_B VPWR VGND sg13cmos5l_tiehi
X_09450_ _13560_/D _10685_/A1 hold3375/X _09453_/S VPWR VGND sg13cmos5l_mux2_1
XFILLER_25_828 VPWR VGND sg13cmos5l_fill_1
XFILLER_64_485 VPWR VGND sg13cmos5l_decap_8
X_08401_ _08401_/Y _08388_/A _08398_/X _08419_/A1 VPWR VGND sg13cmos5l_a21oi_1
X_09381_ _13493_/D _09414_/A0 hold3069/X _09396_/S VPWR VGND sg13cmos5l_mux2_1
XFILLER_51_157 VPWR VGND sg13cmos5l_fill_2
X_08332_ _08332_/Y _08332_/A _08397_/B _08344_/C VPWR VGND sg13cmos5l_nand3_1
XFILLER_20_522 VPWR VGND sg13cmos5l_fill_1
X_08263_ _08263_/X _13573_/Q _13541_/Q _08263_/S VPWR VGND sg13cmos5l_mux2_1
X_07214_ _12334_/A _14370_/Q VPWR VGND sg13cmos5l_inv_1
Xheichips26_loopcache_rv_2216 uio_oe[4] VPWR VGND sg13cmos5l_tiehi
Xheichips26_loopcache_rv_2227 uio_oe[15] VPWR VGND sg13cmos5l_tiehi
XFILLER_69_1001 VPWR VGND sg13cmos5l_fill_1
X_08194_ _08194_/X _08194_/A _08307_/B VPWR VGND sg13cmos5l_and2_1
XFILLER_106_605 VPWR VGND sg13cmos5l_fill_1
XFILLER_105_148 VPWR VGND sg13cmos5l_fill_2
XFILLER_0_949 VPWR VGND sg13cmos5l_decap_8
XFILLER_102_833 VPWR VGND sg13cmos5l_decap_8
XFILLER_47_419 VPWR VGND sg13cmos5l_decap_8
X_07978_ _07978_/Y _08356_/C _07973_/X _07977_/Y _11036_/C1 VPWR VGND sg13cmos5l_a22oi_1
X_14572__2119 _14572_/RESET_B VPWR VGND sg13cmos5l_tiehi
X_09717_ _13627_/D _10567_/A1 _09724_/B _09716_/Y VPWR VGND sg13cmos5l_a21oi_1
XFILLER_56_964 VPWR VGND sg13cmos5l_fill_2
XFILLER_76_1027 VPWR VGND sg13cmos5l_fill_2
X_09648_ _13610_/D _09642_/B _10532_/A1 _09642_/Y VPWR VGND sg13cmos5l_a21oi_1
XFILLER_71_956 VPWR VGND sg13cmos5l_fill_2
X_09579_ _13600_/D _09578_/B _10577_/A1 _09578_/Y VPWR VGND sg13cmos5l_a21oi_1
X_11610_ _11613_/B _11610_/A _11610_/B VPWR VGND sg13cmos5l_nand2_1
X_12590_ _12591_/B _12565_/X _12577_/X _12576_/X VPWR VGND sg13cmos5l_a21oi_1
X_11541_ _11541_/Y _11541_/A _11541_/B VPWR VGND sg13cmos5l_nand2_1
XFILLER_11_577 VPWR VGND sg13cmos5l_fill_2
X_11472_ _11486_/B _11484_/A _11493_/B VPWR VGND sg13cmos5l_xor2_1
X_14260_ _14260_/Q clkload65/A _14260_/D _14260_/RESET_B VPWR VGND sg13cmos5l_dfrbpq_1
XFILLER_100_1014 VPWR VGND sg13cmos5l_decap_8
X_10423_ _13972_/D _10553_/A1 _10432_/B _10422_/Y VPWR VGND sg13cmos5l_a21oi_1
X_14191_ _14191_/Q _14614_/CLK _14191_/D _14191_/RESET_B VPWR VGND sg13cmos5l_dfrbpq_1
X_13835__1556 _13835_/RESET_B VPWR VGND sg13cmos5l_tiehi
X_13211_ _13211_/Q _14577_/CLK _13211_/D fanout965/X VPWR VGND sg13cmos5l_dfrbpq_1
X_10354_ _10354_/Y _10354_/A _10366_/B VPWR VGND sg13cmos5l_nor2_1
X_14466__1025 _14466_/RESET_B VPWR VGND sg13cmos5l_tiehi
X_13523__1899 _13523_/RESET_B VPWR VGND sg13cmos5l_tiehi
X_13142_ _14560_/D _13146_/A _13142_/B VPWR VGND sg13cmos5l_nor2_1
XFILLER_2_220 VPWR VGND sg13cmos5l_decap_4
XFILLER_3_732 VPWR VGND sg13cmos5l_fill_2
XFILLER_105_682 VPWR VGND sg13cmos5l_decap_8
XFILLER_78_511 VPWR VGND sg13cmos5l_fill_2
X_10285_ _13905_/D fanout55/X _10284_/B _10284_/Y VPWR VGND sg13cmos5l_a21oi_1
X_13073_ _14521_/D _13075_/A _13073_/B VPWR VGND sg13cmos5l_nor2_1
XFILLER_78_533 VPWR VGND sg13cmos5l_decap_8
XFILLER_78_544 VPWR VGND sg13cmos5l_fill_2
X_12024_ _12024_/Y _12024_/A _12024_/B VPWR VGND sg13cmos5l_nand2_1
XFILLER_93_536 VPWR VGND sg13cmos5l_fill_1
Xfanout590 _12425_/C1 fanout593/X VPWR VGND sg13cmos5l_buf_1
X_14195__1282 _14195_/RESET_B VPWR VGND sg13cmos5l_tiehi
X_13975_ _13975_/Q _14299_/CLK _13975_/D _13975_/RESET_B VPWR VGND sg13cmos5l_dfrbpq_1
X_12926_ _14450_/D _12926_/A VPWR VGND sg13cmos5l_inv_1
XFILLER_62_978 VPWR VGND sg13cmos5l_decap_8
X_12857_ _12859_/B _12857_/A _12857_/B _12863_/B VPWR VGND sg13cmos5l_nand3_1
X_11808_ _11810_/B _13691_/Q _11858_/B _11783_/B VPWR VGND sg13cmos5l_a21oi_1
XFILLER_15_883 VPWR VGND sg13cmos5l_fill_1
X_12788_ _12828_/A _12788_/A _12788_/B _12788_/C VPWR VGND sg13cmos5l_or3_1
X_11739_ _11768_/A _11740_/A _13234_/Q VPWR VGND sg13cmos5l_nand2_1
X_14527_ _14527_/Q _14532_/CLK _14527_/D fanout968/X VPWR VGND sg13cmos5l_dfrbpq_1
XFILLER_30_886 VPWR VGND sg13cmos5l_fill_2
X_14458_ _14458_/Q clkload75/A _14458_/D _14458_/RESET_B VPWR VGND sg13cmos5l_dfrbpq_1
X_14389_ _14389_/Q clkload68/A _14389_/D _14389_/RESET_B VPWR VGND sg13cmos5l_dfrbpq_1
X_13409_ _13409_/Q clkload31/A _13409_/D _13409_/RESET_B VPWR VGND sg13cmos5l_dfrbpq_1
X_08950_ _13264_/D _08040_/B hold3388/X _10778_/B VPWR VGND sg13cmos5l_mux2_1
Xhold3107 hold3107/X _13503_/Q VPWR VGND sg13cmos5l_dlygate4sd3_1
Xhold3118 hold3118/X _13528_/Q VPWR VGND sg13cmos5l_dlygate4sd3_1
Xhold3129 _10307_/A _13916_/Q VPWR VGND sg13cmos5l_dlygate4sd3_1
X_14322__1186 _14322_/RESET_B VPWR VGND sg13cmos5l_tiehi
XFILLER_37_0 VPWR VGND sg13cmos5l_fill_2
X_07901_ _07947_/A _08424_/A _11153_/A _07901_/C VPWR VGND sg13cmos5l_or3_1
X_08881_ _08881_/Y _08881_/A _08895_/B VPWR VGND sg13cmos5l_nor2_1
Xhold2406 _10541_/A _14031_/Q VPWR VGND sg13cmos5l_dlygate4sd3_1
Xhold2417 _10076_/A _13803_/Q VPWR VGND sg13cmos5l_dlygate4sd3_1
Xhold2428 _09973_/A _13752_/Q VPWR VGND sg13cmos5l_dlygate4sd3_1
XFILLER_57_706 VPWR VGND sg13cmos5l_fill_1
X_07832_ _08801_/A _11105_/A _11671_/A VPWR VGND sg13cmos5l_nor2_1
Xhold2439 _13082_/B _13081_/Y VPWR VGND sg13cmos5l_dlygate4sd3_1
XFILLER_99_1016 VPWR VGND sg13cmos5l_decap_8
XFILLER_99_1027 VPWR VGND sg13cmos5l_fill_2
X_07763_ _07767_/A _07764_/A _07764_/B VPWR VGND sg13cmos5l_nand2_1
X_09502_ _09502_/Y _12589_/A _12577_/A _09501_/Y VPWR VGND sg13cmos5l_a21oi_1
XFILLER_65_783 VPWR VGND sg13cmos5l_fill_2
X_07694_ _08498_/B _14384_/Q _11821_/A VPWR VGND sg13cmos5l_and2_1
XFILLER_25_658 VPWR VGND sg13cmos5l_fill_2
XFILLER_52_422 VPWR VGND sg13cmos5l_fill_2
XFILLER_53_945 VPWR VGND sg13cmos5l_fill_1
X_09433_ _13544_/D _09295_/A hold3106/X _09438_/S VPWR VGND sg13cmos5l_mux2_1
X_13913__1478 _13913_/RESET_B VPWR VGND sg13cmos5l_tiehi
XFILLER_25_669 VPWR VGND sg13cmos5l_fill_2
XFILLER_52_466 VPWR VGND sg13cmos5l_decap_8
X_09364_ _13477_/D _08257_/A hold3158/X _09376_/S VPWR VGND sg13cmos5l_mux2_1
X_08315_ _08315_/Y _08315_/A _08315_/B VPWR VGND sg13cmos5l_nand2_1
X_09295_ _09295_/Y _09295_/A _09295_/B VPWR VGND sg13cmos5l_nor2_1
X_08246_ _08246_/X _08309_/A _13380_/Q VPWR VGND sg13cmos5l_or2_1
X_14253__1800 _14253_/RESET_B VPWR VGND sg13cmos5l_tiehi
X_08177_ _08177_/X _13434_/Q _13402_/Q _13370_/Q _13338_/Q _08283_/S _08200_/S1 VPWR
+ VGND sg13cmos5l_mux4_1
XFILLER_106_413 VPWR VGND sg13cmos5l_decap_8
XFILLER_106_435 VPWR VGND sg13cmos5l_fill_2
X_10070_ _10070_/Y _10070_/A _10086_/B VPWR VGND sg13cmos5l_nand2_1
Xhold2940 _11069_/A _14285_/Q VPWR VGND sg13cmos5l_dlygate4sd3_1
X_13508__1914 _13508_/RESET_B VPWR VGND sg13cmos5l_tiehi
XFILLER_75_514 VPWR VGND sg13cmos5l_decap_4
Xhold2951 _09864_/A _13699_/Q VPWR VGND sg13cmos5l_dlygate4sd3_1
Xhold2962 _09775_/A _13655_/Q VPWR VGND sg13cmos5l_dlygate4sd3_1
Xhold2973 _13004_/A _14490_/Q VPWR VGND sg13cmos5l_dlygate4sd3_1
Xhold2984 _09608_/A _13605_/Q VPWR VGND sg13cmos5l_dlygate4sd3_1
XFILLER_29_953 VPWR VGND sg13cmos5l_fill_1
Xhold2995 _09811_/A _13673_/Q VPWR VGND sg13cmos5l_dlygate4sd3_1
XFILLER_29_997 VPWR VGND sg13cmos5l_fill_2
XFILLER_44_923 VPWR VGND sg13cmos5l_fill_1
X_10972_ _14226_/D _08916_/B _10961_/A _10971_/Y VPWR VGND sg13cmos5l_o21ai_1
X_13760_ _13760_/Q _14048_/CLK _13760_/D _13760_/RESET_B VPWR VGND sg13cmos5l_dfrbpq_1
XFILLER_15_113 VPWR VGND sg13cmos5l_fill_1
X_13691_ _13691_/Q _14042_/CLK _13691_/D _13691_/RESET_B VPWR VGND sg13cmos5l_dfrbpq_1
X_12711_ _12744_/A _14450_/Q _13240_/Q VPWR VGND sg13cmos5l_xnor2_1
X_12642_ _12651_/B _12642_/A _12642_/B _12642_/C VPWR VGND sg13cmos5l_nand3_1
XFILLER_15_179 VPWR VGND sg13cmos5l_fill_1
XFILLER_8_813 VPWR VGND sg13cmos5l_fill_2
X_12573_ _12573_/X _12640_/A _12573_/B VPWR VGND sg13cmos5l_and2_1
X_11524_ _11534_/B _11523_/A _11523_/B _11523_/C VPWR VGND sg13cmos5l_o21ai_1
X_14312_ _14312_/Q clkload40/A _14312_/D _14312_/RESET_B VPWR VGND sg13cmos5l_dfrbpq_1
XFILLER_8_868 VPWR VGND sg13cmos5l_fill_2
X_11455_ _11517_/A _11439_/Y _11454_/Y _11453_/X VPWR VGND sg13cmos5l_o21ai_1
X_14243_ _14243_/Q clkload43/A _14243_/D _14243_/RESET_B VPWR VGND sg13cmos5l_dfrbpq_1
X_10406_ _10406_/Y _10406_/A _10406_/B VPWR VGND sg13cmos5l_nor2_1
X_11386_ _11386_/Y _11386_/A _11436_/B VPWR VGND sg13cmos5l_nand2_1
X_14174_ _14174_/Q clkload66/A _14174_/D _14174_/RESET_B VPWR VGND sg13cmos5l_dfrbpq_1
X_10337_ _10337_/Y _10337_/A _10339_/B VPWR VGND sg13cmos5l_nor2_1
X_13125_ _14549_/D _13127_/A _13125_/B VPWR VGND sg13cmos5l_nor2_1
XFILLER_79_820 VPWR VGND sg13cmos5l_decap_4
X_10268_ _10268_/Y _10268_/A _10278_/B VPWR VGND sg13cmos5l_nor2_1
X_13056_ _14513_/D _13056_/A _13058_/B VPWR VGND sg13cmos5l_nor2b_1
X_12007_ _12008_/C _13634_/Q _11884_/B _12203_/B1 _13890_/Q VPWR VGND sg13cmos5l_a22oi_1
XFILLER_39_728 VPWR VGND sg13cmos5l_fill_1
XFILLER_94_823 VPWR VGND sg13cmos5l_fill_1
X_10199_ _10199_/Y _10199_/A _10209_/B VPWR VGND sg13cmos5l_nor2_1
XFILLER_66_547 VPWR VGND sg13cmos5l_fill_1
XFILLER_94_856 VPWR VGND sg13cmos5l_fill_1
XFILLER_94_867 VPWR VGND sg13cmos5l_decap_8
X_14307__1201 _14307_/RESET_B VPWR VGND sg13cmos5l_tiehi
XFILLER_59_1022 VPWR VGND sg13cmos5l_decap_8
X_13958_ _13958_/Q clkload55/A _13958_/D _13958_/RESET_B VPWR VGND sg13cmos5l_dfrbpq_1
X_12909_ _12910_/A _14442_/Q _11220_/B _11214_/D _12913_/B2 VPWR VGND sg13cmos5l_a22oi_1
XFILLER_62_775 VPWR VGND sg13cmos5l_decap_4
X_13889_ _13889_/Q clkload58/A _13889_/D _13889_/RESET_B VPWR VGND sg13cmos5l_dfrbpq_1
X_08100_ _08100_/Y _08100_/A _13110_/B _08100_/C VPWR VGND sg13cmos5l_nand3_1
X_09080_ _09080_/Y _14418_/Q _11293_/A VPWR VGND sg13cmos5l_nand2_1
X_08031_ _08032_/C _08031_/A _08031_/B _08031_/C _08031_/D VPWR VGND sg13cmos5l_nand4_1
XFILLER_104_917 VPWR VGND sg13cmos5l_fill_1
X_09982_ _13756_/D _10569_/A1 _10007_/B _09981_/Y VPWR VGND sg13cmos5l_o21ai_1
X_08933_ _13251_/D _07290_/Y _13196_/A2 _13192_/B1 _08932_/Y VPWR VGND sg13cmos5l_a22oi_1
X_14586__2129 _14586_/RESET_B VPWR VGND sg13cmos5l_tiehi
Xhold2236 _14138_/D _10734_/Y VPWR VGND sg13cmos5l_dlygate4sd3_1
X_08864_ _08864_/Y _07666_/X _08861_/C _08848_/B _08551_/C VPWR VGND sg13cmos5l_a22oi_1
Xhold2247 _10503_/A _14012_/Q VPWR VGND sg13cmos5l_dlygate4sd3_1
Xhold2258 _10513_/A _14017_/Q VPWR VGND sg13cmos5l_dlygate4sd3_1
Xhold2269 _10582_/A _14051_/Q VPWR VGND sg13cmos5l_dlygate4sd3_1
X_07815_ _08625_/B _14404_/Q _14372_/Q VPWR VGND sg13cmos5l_and2_1
X_08795_ _08795_/Y _08456_/B _08875_/B _08794_/Y VPWR VGND sg13cmos5l_o21ai_1
X_07746_ _07746_/Y _07236_/Y _14351_/Q _07745_/Y VPWR VGND sg13cmos5l_a21oi_1
XFILLER_53_720 VPWR VGND sg13cmos5l_fill_1
XFILLER_65_580 VPWR VGND sg13cmos5l_decap_8
XFILLER_52_241 VPWR VGND sg13cmos5l_fill_1
X_07677_ _08834_/A _14386_/Q _14354_/Q VPWR VGND sg13cmos5l_and2_1
X_09416_ _13527_/D _09416_/A0 hold3202/X _09421_/S VPWR VGND sg13cmos5l_mux2_1
XFILLER_12_127 VPWR VGND sg13cmos5l_fill_2
X_09347_ _13460_/D _10681_/A1 hold3181/X _09368_/S VPWR VGND sg13cmos5l_mux2_1
X_09278_ _13402_/D _08170_/A hold3160/X _09280_/S VPWR VGND sg13cmos5l_mux2_1
X_08229_ _08229_/Y _08229_/A _08281_/B VPWR VGND sg13cmos5l_nand2_1
X_11240_ _11241_/B _14087_/Q _11228_/B _11239_/Y VPWR VGND sg13cmos5l_o21ai_1
X_11171_ _11172_/A hold3051/X _11196_/B _11170_/Y _12907_/B2 VPWR VGND sg13cmos5l_a22oi_1
X_13440__1982 _13440_/RESET_B VPWR VGND sg13cmos5l_tiehi
X_13303__2209 _13303_/RESET_B VPWR VGND sg13cmos5l_tiehi
X_10122_ _13825_/D _10579_/A1 _10137_/B _10121_/Y VPWR VGND sg13cmos5l_o21ai_1
XFILLER_76_801 VPWR VGND sg13cmos5l_decap_8
Xhold3460 _13153_/A _14263_/Q VPWR VGND sg13cmos5l_dlygate4sd3_1
XFILLER_0_587 VPWR VGND sg13cmos5l_fill_2
XFILLER_76_823 VPWR VGND sg13cmos5l_decap_4
XFILLER_87_171 VPWR VGND sg13cmos5l_fill_1
X_10053_ _13791_/D _10575_/A1 _10052_/B _10052_/Y VPWR VGND sg13cmos5l_o21ai_1
Xhold3493 _11759_/A _14348_/Q VPWR VGND sg13cmos5l_dlygate4sd3_1
Xhold3482 hold3482/X _14089_/Q VPWR VGND sg13cmos5l_dlygate4sd3_1
Xhold3471 _12556_/A _14169_/Q VPWR VGND sg13cmos5l_dlygate4sd3_1
XFILLER_48_569 VPWR VGND sg13cmos5l_decap_8
XFILLER_76_856 VPWR VGND sg13cmos5l_decap_4
Xhold2770 _09708_/A _13623_/Q VPWR VGND sg13cmos5l_dlygate4sd3_1
Xhold2781 _09938_/A _13735_/Q VPWR VGND sg13cmos5l_dlygate4sd3_1
Xhold2792 hold2792/X _13224_/Q VPWR VGND sg13cmos5l_dlygate4sd3_1
XFILLER_75_388 VPWR VGND sg13cmos5l_fill_2
X_13812_ _13812_/Q clkload17/A _13812_/D _13812_/RESET_B VPWR VGND sg13cmos5l_dfrbpq_1
XFILLER_90_347 VPWR VGND sg13cmos5l_fill_1
XFILLER_43_241 VPWR VGND sg13cmos5l_fill_2
X_10955_ _10971_/C _10961_/A _10961_/C VPWR VGND sg13cmos5l_and2_1
X_13743_ _13743_/Q _14065_/CLK _13743_/D _13743_/RESET_B VPWR VGND sg13cmos5l_dfrbpq_1
XFILLER_73_85 VPWR VGND sg13cmos5l_fill_2
X_10886_ _10887_/D _14249_/Q _14246_/Q VPWR VGND sg13cmos5l_nor2b_1
X_13674_ _13674_/Q _14045_/CLK _13674_/D _13674_/RESET_B VPWR VGND sg13cmos5l_dfrbpq_1
XFILLER_106_1020 VPWR VGND sg13cmos5l_decap_8
X_12625_ _12625_/Y _13032_/D _11153_/X _12641_/A _12624_/Y VPWR VGND sg13cmos5l_a22oi_1
X_12556_ _12556_/Y _12556_/A _12648_/B VPWR VGND sg13cmos5l_nand2_1
X_11507_ _11507_/Y _11466_/A _11555_/B _11558_/B1 VPWR VGND sg13cmos5l_o21ai_1
XFILLER_7_142 VPWR VGND sg13cmos5l_decap_4
X_12487_ _12490_/A _14390_/Q _12487_/B VPWR VGND sg13cmos5l_nand2_1
X_11438_ _11476_/B _11438_/A _11438_/B VPWR VGND sg13cmos5l_nand2_1
X_14226_ _14226_/Q clkload44/A _14226_/D _14226_/RESET_B VPWR VGND sg13cmos5l_dfrbpq_1
X_11369_ _11369_/Y _11380_/A _11368_/Y _11338_/A VPWR VGND sg13cmos5l_o21ai_1
X_14157_ _14157_/Q clkload16/A _14157_/D fanout987/X VPWR VGND sg13cmos5l_dfrbpq_1
X_13238__1040 _13238_/RESET_B VPWR VGND sg13cmos5l_tiehi
XFILLER_3_370 VPWR VGND sg13cmos5l_fill_1
X_13108_ _14537_/D _13108_/A _13109_/B VPWR VGND sg13cmos5l_nor2b_1
X_14088_ _14088_/Q clkload71/A _14088_/D _14088_/RESET_B VPWR VGND sg13cmos5l_dfrbpq_1
X_13039_ _13042_/A _13040_/B _10621_/D _13040_/A VPWR VGND sg13cmos5l_a21oi_1
XFILLER_39_547 VPWR VGND sg13cmos5l_fill_1
X_13615__1776 _13615_/RESET_B VPWR VGND sg13cmos5l_tiehi
XFILLER_66_388 VPWR VGND sg13cmos5l_decap_8
X_07600_ _07609_/B _13285_/Q _13284_/Q _07606_/B VPWR VGND sg13cmos5l_nand3_1
X_08580_ _08580_/Y _08580_/A VPWR VGND sg13cmos5l_inv_1
XFILLER_81_325 VPWR VGND sg13cmos5l_fill_1
XFILLER_82_848 VPWR VGND sg13cmos5l_decap_4
X_07531_ _07532_/B _07521_/Y _07526_/Y _07530_/Y _12964_/B VPWR VGND sg13cmos5l_a22oi_1
X_07462_ _07462_/X _13427_/Q _13395_/Q _13363_/Q _13331_/Q _08164_/S0 _08254_/A1 VPWR
+ VGND sg13cmos5l_mux4_1
X_13830__1561 _13830_/RESET_B VPWR VGND sg13cmos5l_tiehi
XFILLER_23_959 VPWR VGND sg13cmos5l_fill_2
X_07393_ _07395_/C _14559_/Q _07467_/C _07578_/A VPWR VGND sg13cmos5l_o21ai_1
X_09201_ _13330_/D _10679_/A1 hold3271/X _09208_/S VPWR VGND sg13cmos5l_mux2_1
X_09132_ _13318_/D _09137_/B _09130_/Y _09131_/Y VPWR VGND sg13cmos5l_a21oi_1
X_09063_ _09063_/Y _14415_/Q _11293_/A VPWR VGND sg13cmos5l_nand2_1
X_08014_ _08038_/B _08999_/A _13279_/Q _08062_/S VPWR VGND sg13cmos5l_mux2_1
XFILLER_104_714 VPWR VGND sg13cmos5l_decap_4
XFILLER_89_414 VPWR VGND sg13cmos5l_fill_1
XFILLER_104_769 VPWR VGND sg13cmos5l_fill_1
X_09965_ _09965_/Y _09965_/A _09979_/B VPWR VGND sg13cmos5l_nand2_1
XFILLER_103_279 VPWR VGND sg13cmos5l_fill_2
XFILLER_57_300 VPWR VGND sg13cmos5l_fill_1
X_08916_ _13159_/B _10871_/A _08916_/B VPWR VGND sg13cmos5l_nand2_1
X_09896_ _09896_/Y _09896_/A _09912_/B VPWR VGND sg13cmos5l_nor2_1
X_08847_ _08851_/A _08847_/A _08867_/B VPWR VGND sg13cmos5l_nand2_1
XFILLER_100_986 VPWR VGND sg13cmos5l_decap_8
XFILLER_57_355 VPWR VGND sg13cmos5l_decap_4
XFILLER_57_377 VPWR VGND sg13cmos5l_fill_2
X_08778_ _08778_/Y _08782_/A1 _07338_/Y _08777_/Y VPWR VGND sg13cmos5l_o21ai_1
X_07729_ _07729_/Y _08450_/A _08450_/B _07728_/Y VPWR VGND sg13cmos5l_o21ai_1
XFILLER_26_797 VPWR VGND sg13cmos5l_fill_2
XFILLER_53_561 VPWR VGND sg13cmos5l_decap_8
XFILLER_53_572 VPWR VGND sg13cmos5l_fill_2
XFILLER_53_594 VPWR VGND sg13cmos5l_fill_2
XFILLER_81_870 VPWR VGND sg13cmos5l_decap_4
X_10740_ _10740_/Y _10793_/B _10738_/Y _10739_/Y VPWR VGND sg13cmos5l_o21ai_1
XFILLER_80_380 VPWR VGND sg13cmos5l_fill_2
X_10671_ _14094_/D _14256_/D hold3458/X _10826_/S VPWR VGND sg13cmos5l_mux2_1
X_13458__1964 _13458_/RESET_B VPWR VGND sg13cmos5l_tiehi
XFILLER_22_970 VPWR VGND sg13cmos5l_fill_2
X_14281__1227 _14281_/RESET_B VPWR VGND sg13cmos5l_tiehi
X_12410_ _14372_/D _12417_/A _12409_/A _12391_/Y _12409_/Y VPWR VGND sg13cmos5l_a22oi_1
XFILLER_40_288 VPWR VGND sg13cmos5l_fill_2
X_13390_ _13390_/Q _13568_/CLK _13390_/D _13390_/RESET_B VPWR VGND sg13cmos5l_dfrbpq_1
X_12341_ _12341_/Y _14030_/Q _12030_/B _12349_/B1 _13838_/Q VPWR VGND sg13cmos5l_a22oi_1
X_12272_ _12272_/Y _13771_/Q _12292_/B _12290_/A2 _14027_/Q VPWR VGND sg13cmos5l_a22oi_1
XFILLER_4_156 VPWR VGND sg13cmos5l_fill_1
X_11223_ _11223_/Y _11228_/B VPWR VGND sg13cmos5l_inv_1
X_14011_ _14011_/Q clkload48/A _14011_/D _14011_/RESET_B VPWR VGND sg13cmos5l_dfrbpq_1
X_11154_ _11154_/Y _08435_/B _12639_/C _11149_/Y VPWR VGND sg13cmos5l_o21ai_1
X_13872__1519 _13872_/RESET_B VPWR VGND sg13cmos5l_tiehi
X_13226__1055 _13226_/RESET_B VPWR VGND sg13cmos5l_tiehi
XFILLER_0_373 VPWR VGND sg13cmos5l_fill_1
XFILLER_89_992 VPWR VGND sg13cmos5l_decap_8
X_10105_ _10105_/Y _10105_/A _10109_/B VPWR VGND sg13cmos5l_nand2_1
X_11085_ _11085_/Y _11085_/A _11144_/B VPWR VGND sg13cmos5l_nor2_1
XFILLER_48_333 VPWR VGND sg13cmos5l_decap_8
X_10036_ _10036_/Y _10036_/A _10042_/B VPWR VGND sg13cmos5l_nand2_1
Xhold3290 hold3290/X _13556_/Q VPWR VGND sg13cmos5l_dlygate4sd3_1
XFILLER_64_804 VPWR VGND sg13cmos5l_decap_8
X_15893_ _15893_/X _15893_/A VPWR VGND sg13cmos5l_buf_1
XFILLER_36_528 VPWR VGND sg13cmos5l_fill_1
XFILLER_75_196 VPWR VGND sg13cmos5l_fill_1
XFILLER_90_155 VPWR VGND sg13cmos5l_fill_2
X_11987_ _11987_/Y _11984_/B _11987_/B VPWR VGND sg13cmos5l_nand2b_1
X_10938_ _14212_/D _10946_/B _10937_/A _10934_/Y VPWR VGND sg13cmos5l_o21ai_1
X_13726_ _13726_/Q clkload59/A _13726_/D _13726_/RESET_B VPWR VGND sg13cmos5l_dfrbpq_1
X_13326__2096 _13326_/RESET_B VPWR VGND sg13cmos5l_tiehi
XFILLER_44_594 VPWR VGND sg13cmos5l_fill_1
X_14585__2128 _14585_/RESET_B VPWR VGND sg13cmos5l_tiehi
X_10869_ _10869_/Y _10869_/A _10932_/B VPWR VGND sg13cmos5l_nand2_1
X_13657_ _13657_/Q clkload50/A _13657_/D _13657_/RESET_B VPWR VGND sg13cmos5l_dfrbpq_1
X_13588_ _13588_/Q clkload17/A _13588_/D _13588_/RESET_B VPWR VGND sg13cmos5l_dfrbpq_1
X_12608_ _12608_/Y _12608_/A _12735_/A VPWR VGND sg13cmos5l_nor2b_1
XFILLER_76_4 VPWR VGND sg13cmos5l_fill_2
X_12539_ _12539_/Y _12546_/A1 _13256_/Q _12530_/B VPWR VGND sg13cmos5l_a21oi_1
X_14209_ _14209_/Q _14614_/CLK _14209_/D _14209_/RESET_B VPWR VGND sg13cmos5l_dfrbpq_1
XFILLER_98_233 VPWR VGND sg13cmos5l_fill_2
XFILLER_99_767 VPWR VGND sg13cmos5l_fill_1
Xfanout419 _10582_/B _10602_/B VPWR VGND sg13cmos5l_buf_1
Xfanout408 _11144_/B _11145_/A1 VPWR VGND sg13cmos5l_buf_1
X_09750_ _09750_/Y _09750_/A _09758_/B VPWR VGND sg13cmos5l_nor2_1
X_13848__1543 _13848_/RESET_B VPWR VGND sg13cmos5l_tiehi
XFILLER_67_653 VPWR VGND sg13cmos5l_fill_1
XFILLER_95_940 VPWR VGND sg13cmos5l_decap_4
X_08701_ _08701_/Y _13844_/Q _08748_/B1 _08747_/B _13652_/Q _08699_/X VPWR VGND sg13cmos5l_a221oi_1
X_09681_ _13615_/D _09693_/B fanout61/X _09680_/Y VPWR VGND sg13cmos5l_a21oi_1
X_13536__1886 _13536_/RESET_B VPWR VGND sg13cmos5l_tiehi
XFILLER_39_366 VPWR VGND sg13cmos5l_fill_1
XFILLER_66_152 VPWR VGND sg13cmos5l_fill_2
XFILLER_67_664 VPWR VGND sg13cmos5l_fill_1
X_08632_ _08633_/C _14187_/Q _08632_/B VPWR VGND sg13cmos5l_nor2_1
XFILLER_94_494 VPWR VGND sg13cmos5l_fill_2
XFILLER_54_369 VPWR VGND sg13cmos5l_fill_1
XFILLER_70_818 VPWR VGND sg13cmos5l_fill_2
X_08563_ _08563_/Y _08582_/D VPWR VGND sg13cmos5l_inv_1
XFILLER_35_572 VPWR VGND sg13cmos5l_fill_1
X_07514_ _07515_/D _13212_/Q _07530_/A2 _07467_/Y input22/X VPWR VGND sg13cmos5l_a22oi_1
X_08494_ _08495_/B _08489_/Y _08497_/B _08502_/A VPWR VGND sg13cmos5l_mux2_1
X_07445_ _07446_/A _13558_/Q _13526_/Q _13494_/Q _13462_/Q _07522_/S0 _07522_/S1 VPWR
+ VGND sg13cmos5l_mux4_1
Xfanout59 fanout59/X fanout60/X VPWR VGND sg13cmos5l_buf_1
XFILLER_22_299 VPWR VGND sg13cmos5l_fill_2
X_07376_ _07400_/A _14550_/Q _08964_/B VPWR VGND sg13cmos5l_nor2_1
X_09115_ _11409_/A _14328_/Q _09193_/B VPWR VGND sg13cmos5l_nand2_1
X_09046_ _09046_/Y _11222_/A _09045_/Y _09076_/A2 VPWR VGND sg13cmos5l_a21oi_1
XFILLER_2_616 VPWR VGND sg13cmos5l_fill_2
XFILLER_2_638 VPWR VGND sg13cmos5l_fill_2
XFILLER_78_918 VPWR VGND sg13cmos5l_fill_1
X_09948_ _09948_/Y _09948_/A _09948_/B VPWR VGND sg13cmos5l_nor2_1
Xfanout920 _11611_/A _14097_/Q VPWR VGND sg13cmos5l_buf_1
Xfanout931 _08979_/A _13305_/Q VPWR VGND sg13cmos5l_buf_1
Xfanout942 _08781_/A1 _08785_/B2 VPWR VGND sg13cmos5l_buf_1
Xfanout953 _12802_/A _07198_/Y VPWR VGND sg13cmos5l_buf_1
Xfanout964 fanout964/X fanout966/X VPWR VGND sg13cmos5l_buf_1
Xfanout975 fanout975/X fanout977/X VPWR VGND sg13cmos5l_buf_1
Xfanout986 fanout986/X fanout988/X VPWR VGND sg13cmos5l_buf_1
X_09879_ _13706_/D _10597_/A1 _09878_/B _09878_/Y VPWR VGND sg13cmos5l_a21oi_1
Xfanout997 _07198_/A fanout998/X VPWR VGND sg13cmos5l_buf_1
X_14299__1209 _14299_/RESET_B VPWR VGND sg13cmos5l_tiehi
XFILLER_45_336 VPWR VGND sg13cmos5l_fill_2
XFILLER_58_697 VPWR VGND sg13cmos5l_decap_4
XFILLER_85_494 VPWR VGND sg13cmos5l_fill_1
X_11910_ _11910_/Y _14015_/Q _12203_/B1 _12005_/B _13823_/Q VPWR VGND sg13cmos5l_a22oi_1
X_14335__1173 _14335_/RESET_B VPWR VGND sg13cmos5l_tiehi
X_12890_ _12890_/X _12895_/B _12890_/B VPWR VGND sg13cmos5l_or2_1
XFILLER_33_509 VPWR VGND sg13cmos5l_fill_1
X_11841_ _11841_/Y _14353_/Q _11672_/A _11840_/Y VPWR VGND sg13cmos5l_o21ai_1
XFILLER_54_881 VPWR VGND sg13cmos5l_decap_4
X_11772_ _11772_/Y _13818_/Q _12058_/B VPWR VGND sg13cmos5l_nand2_1
X_14560_ _14560_/Q clkload12/A _14560_/D fanout958/X VPWR VGND sg13cmos5l_dfrbpq_1
X_10723_ _10723_/Y _10759_/A _14279_/Q VPWR VGND sg13cmos5l_nand2_1
X_13511_ _13511_/Q clkload29/A _13511_/D _13511_/RESET_B VPWR VGND sg13cmos5l_dfrbpq_1
X_14491_ _14491_/Q _14577_/CLK _14491_/D fanout975/X VPWR VGND sg13cmos5l_dfrbpq_1
X_10654_ _10654_/Y _14083_/Q _10654_/B _10654_/C VPWR VGND sg13cmos5l_nand3_1
X_13442_ _13442_/Q clkload29/A _13442_/D _13442_/RESET_B VPWR VGND sg13cmos5l_dfrbpq_1
X_10585_ _14052_/D _10585_/A1 _10596_/B _10584_/Y VPWR VGND sg13cmos5l_o21ai_1
X_13926__1465 _13926_/RESET_B VPWR VGND sg13cmos5l_tiehi
X_13373_ _13373_/Q clkload31/A _13373_/D _13373_/RESET_B VPWR VGND sg13cmos5l_dfrbpq_1
Xclkload29 clkload29/X clkload29/A VPWR VGND sg13cmos5l_buf_8
Xclkload18 clkload18/Y clkload18/A VPWR VGND sg13cmos5l_inv_1
X_12324_ _12324_/Y _12334_/A _12301_/B _12382_/A _12323_/Y VPWR VGND sg13cmos5l_a22oi_1
X_12255_ _12255_/Y _14366_/Q _13251_/Q _12224_/Y VPWR VGND sg13cmos5l_a21oi_1
X_11206_ _14314_/D _11204_/Y _11205_/Y _11196_/Y VPWR VGND sg13cmos5l_o21ai_1
X_12186_ _12186_/Y _12187_/A _12251_/A VPWR VGND sg13cmos5l_nand2_1
X_11137_ _11137_/Y _14386_/Q _11143_/A2 _11093_/B _14402_/Q _11075_/X VPWR VGND sg13cmos5l_a221oi_1
XFILLER_49_653 VPWR VGND sg13cmos5l_fill_1
XFILLER_64_601 VPWR VGND sg13cmos5l_decap_8
XFILLER_76_461 VPWR VGND sg13cmos5l_decap_4
XFILLER_77_962 VPWR VGND sg13cmos5l_fill_2
X_11068_ _11068_/Y _14384_/Q _11088_/A2 _11067_/X VPWR VGND sg13cmos5l_a21oi_1
X_10019_ _10019_/Y _10019_/A _10023_/B VPWR VGND sg13cmos5l_nand2_1
X_13413__2009 _13413_/RESET_B VPWR VGND sg13cmos5l_tiehi
XFILLER_32_542 VPWR VGND sg13cmos5l_fill_1
XFILLER_44_391 VPWR VGND sg13cmos5l_fill_1
X_13709_ _13709_/Q _14053_/CLK _13709_/D _13709_/RESET_B VPWR VGND sg13cmos5l_dfrbpq_1
X_07230_ _11926_/A _14356_/Q VPWR VGND sg13cmos5l_inv_1
XFILLER_30_1028 VPWR VGND sg13cmos5l_fill_1
XFILLER_99_520 VPWR VGND sg13cmos5l_decap_8
X_14413__1095 _14413_/RESET_B VPWR VGND sg13cmos5l_tiehi
XFILLER_99_531 VPWR VGND sg13cmos5l_fill_2
Xfanout205 _10120_/A2 _10090_/Y VPWR VGND sg13cmos5l_buf_1
XFILLER_87_715 VPWR VGND sg13cmos5l_decap_4
X_09802_ _13668_/D _10128_/A1 _09801_/B _09801_/Y VPWR VGND sg13cmos5l_a21oi_1
Xfanout238 _10565_/A1 _10369_/A1 VPWR VGND sg13cmos5l_buf_1
Xfanout227 _10009_/B fanout233/X VPWR VGND sg13cmos5l_buf_1
Xfanout216 _10054_/B fanout222/X VPWR VGND sg13cmos5l_buf_1
XFILLER_87_748 VPWR VGND sg13cmos5l_decap_4
XFILLER_87_759 VPWR VGND sg13cmos5l_fill_2
X_07994_ _07994_/Y _07993_/A _07991_/X _07993_/Y VPWR VGND sg13cmos5l_a21oi_1
Xfanout249 _10366_/B _10374_/B VPWR VGND sg13cmos5l_buf_1
XFILLER_55_601 VPWR VGND sg13cmos5l_decap_4
X_09733_ _13635_/D _10453_/A1 _09754_/B _09732_/Y VPWR VGND sg13cmos5l_a21oi_1
XFILLER_95_781 VPWR VGND sg13cmos5l_decap_8
X_09664_ _09664_/Y _14464_/Q _09670_/C _09663_/Y VPWR VGND sg13cmos5l_a21oi_1
X_08615_ _08615_/Y _08615_/A _08619_/C VPWR VGND sg13cmos5l_nand2_1
X_09595_ _11395_/B _14423_/Q _14642_/Q _09615_/S VPWR VGND sg13cmos5l_mux2_1
XFILLER_55_689 VPWR VGND sg13cmos5l_decap_8
X_08546_ _08546_/Y _08861_/A _12093_/A _08559_/A VPWR VGND sg13cmos5l_a21oi_1
XFILLER_24_57 VPWR VGND sg13cmos5l_fill_1
X_08477_ _08478_/B _08476_/A _08475_/X _08476_/Y VPWR VGND sg13cmos5l_o21ai_1
X_07428_ _07428_/Y _08227_/A2 _07426_/Y _07526_/A1 VPWR VGND sg13cmos5l_o21ai_1
X_07359_ _07571_/A _08984_/A _14555_/Q VPWR VGND sg13cmos5l_xor2_1
X_14656__2199 _14656_/RESET_B VPWR VGND sg13cmos5l_tiehi
X_10370_ _10370_/Y _10370_/A _10374_/B VPWR VGND sg13cmos5l_nor2_1
X_09029_ _13296_/D _09030_/B _08985_/B _09028_/Y VPWR VGND sg13cmos5l_o21ai_1
X_13610__1781 _13610_/RESET_B VPWR VGND sg13cmos5l_tiehi
XFILLER_78_704 VPWR VGND sg13cmos5l_fill_1
X_12040_ _12040_/Y _14454_/Q _12302_/A2 _12038_/Y _12039_/Y VPWR VGND sg13cmos5l_a22oi_1
XFILLER_59_940 VPWR VGND sg13cmos5l_fill_2
Xfanout750 _11615_/C1 _07255_/Y VPWR VGND sg13cmos5l_buf_1
X_14584__2127 _14584_/RESET_B VPWR VGND sg13cmos5l_tiehi
XFILLER_59_962 VPWR VGND sg13cmos5l_decap_8
XFILLER_86_770 VPWR VGND sg13cmos5l_decap_8
XFILLER_93_718 VPWR VGND sg13cmos5l_fill_2
Xfanout794 _08375_/S fanout804/X VPWR VGND sg13cmos5l_buf_1
Xfanout783 _08283_/S _07524_/S0 VPWR VGND sg13cmos5l_buf_1
Xfanout772 _11586_/A _11447_/A1 VPWR VGND sg13cmos5l_buf_1
Xfanout761 _10792_/A _10804_/A VPWR VGND sg13cmos5l_buf_1
X_13991_ _13991_/Q clkload78/A _13991_/D _13991_/RESET_B VPWR VGND sg13cmos5l_dfrbpq_1
XFILLER_58_483 VPWR VGND sg13cmos5l_fill_2
X_12942_ _14458_/D _12942_/A VPWR VGND sg13cmos5l_inv_1
XFILLER_27_881 VPWR VGND sg13cmos5l_fill_1
XFILLER_33_328 VPWR VGND sg13cmos5l_fill_1
X_14612_ _14612_/Q clkload73/A _14612_/D _14612_/RESET_B VPWR VGND sg13cmos5l_dfrbpq_1
X_12873_ _12873_/Y _12897_/A _12871_/X _12872_/X fanout60/X VPWR VGND sg13cmos5l_a22oi_1
XFILLER_73_497 VPWR VGND sg13cmos5l_decap_8
X_11824_ _11825_/B _11799_/A _11983_/A _11823_/Y VPWR VGND sg13cmos5l_a21oi_1
XFILLER_42_873 VPWR VGND sg13cmos5l_fill_2
XFILLER_81_41 VPWR VGND sg13cmos5l_fill_1
X_11755_ _11755_/X _13817_/Q _13785_/Q _11945_/S VPWR VGND sg13cmos5l_mux2_1
X_14543_ _14543_/Q clkload19/A _14543_/D fanout982/X VPWR VGND sg13cmos5l_dfrbpq_1
XFILLER_41_372 VPWR VGND sg13cmos5l_decap_4
X_10706_ _14126_/D input4/X _09230_/A _10710_/S VPWR VGND sg13cmos5l_mux2_1
X_14474_ _14474_/Q clkload9/A _14474_/D fanout962/X VPWR VGND sg13cmos5l_dfrbpq_1
X_11686_ _11708_/C _14442_/Q _11686_/B VPWR VGND sg13cmos5l_and2_1
X_13425_ _13425_/Q clkload35/A _13425_/D _13425_/RESET_B VPWR VGND sg13cmos5l_dfrbpq_1
X_10637_ _14075_/D _10637_/A _10638_/C VPWR VGND sg13cmos5l_xor2_1
X_10568_ _10568_/Y _10568_/A _10576_/B VPWR VGND sg13cmos5l_nand2_1
X_13356_ _13356_/Q _14238_/CLK _13356_/D _13356_/RESET_B VPWR VGND sg13cmos5l_dfrbpq_1
X_10499_ _10499_/Y _10499_/A _10501_/B VPWR VGND sg13cmos5l_nand2_1
X_13287_ _13287_/Q clkload19/A _13287_/D fanout982/X VPWR VGND sg13cmos5l_dfrbpq_1
X_12307_ _12307_/Y _12307_/A _12307_/B VPWR VGND sg13cmos5l_nand2_1
X_12238_ _12238_/Y _13674_/Q _12234_/B _12238_/B1 VPWR VGND sg13cmos5l_a21oi_1
X_12169_ _12169_/Y _12169_/A _12169_/B _12169_/C VPWR VGND sg13cmos5l_nand3_1
XFILLER_49_450 VPWR VGND sg13cmos5l_decap_8
XFILLER_96_578 VPWR VGND sg13cmos5l_decap_8
Xinput5 input5/X ui_in[12] VPWR VGND sg13cmos5l_buf_1
XFILLER_25_807 VPWR VGND sg13cmos5l_fill_2
XFILLER_37_667 VPWR VGND sg13cmos5l_fill_2
XFILLER_80_902 VPWR VGND sg13cmos5l_fill_2
X_08400_ _08400_/Y _08398_/S _13392_/Q _08399_/Y VPWR VGND sg13cmos5l_o21ai_1
X_09380_ _13492_/D _10681_/A1 hold2999/X _09396_/S VPWR VGND sg13cmos5l_mux2_1
X_13652__1739 _13652_/RESET_B VPWR VGND sg13cmos5l_tiehi
X_08331_ _14266_/D _14266_/Q _12549_/B _11042_/S VPWR VGND sg13cmos5l_mux2_1
X_13798__1593 _13798_/RESET_B VPWR VGND sg13cmos5l_tiehi
X_08262_ _08262_/X _08263_/S _13445_/Q VPWR VGND sg13cmos5l_or2_1
X_07213_ _07810_/B _14371_/Q VPWR VGND sg13cmos5l_inv_1
Xheichips26_loopcache_rv_2217 uio_oe[5] VPWR VGND sg13cmos5l_tiehi
XFILLER_20_589 VPWR VGND sg13cmos5l_fill_2
X_08193_ _14252_/D hold3408/X _12560_/B _11042_/S VPWR VGND sg13cmos5l_mux2_1
X_14032__1359 _14032_/RESET_B VPWR VGND sg13cmos5l_tiehi
XFILLER_0_928 VPWR VGND sg13cmos5l_decap_8
XFILLER_102_801 VPWR VGND sg13cmos5l_fill_1
XFILLER_87_523 VPWR VGND sg13cmos5l_fill_1
XFILLER_102_867 VPWR VGND sg13cmos5l_decap_8
XFILLER_102_878 VPWR VGND sg13cmos5l_fill_1
XFILLER_102_889 VPWR VGND sg13cmos5l_fill_1
X_07977_ _07977_/Y _07977_/A _07977_/B _07977_/C VPWR VGND sg13cmos5l_nand3_1
XFILLER_28_623 VPWR VGND sg13cmos5l_fill_1
XFILLER_68_781 VPWR VGND sg13cmos5l_fill_2
X_09716_ _09716_/Y _09716_/A _09724_/B VPWR VGND sg13cmos5l_nor2_1
XFILLER_28_689 VPWR VGND sg13cmos5l_fill_1
XFILLER_83_795 VPWR VGND sg13cmos5l_decap_8
X_09647_ _09647_/Y _09671_/A _11498_/B _09645_/Y _09646_/Y VPWR VGND sg13cmos5l_a22oi_1
X_09578_ _09578_/Y _09578_/A _09578_/B VPWR VGND sg13cmos5l_nor2_1
X_08529_ _08529_/X _08847_/A _08529_/B VPWR VGND sg13cmos5l_and2_1
X_13628__1763 _13628_/RESET_B VPWR VGND sg13cmos5l_tiehi
XFILLER_11_523 VPWR VGND sg13cmos5l_fill_1
X_11540_ _14336_/D _11538_/Y _11539_/Y _11529_/Y VPWR VGND sg13cmos5l_o21ai_1
X_11471_ _11493_/B _11471_/A _11471_/B VPWR VGND sg13cmos5l_nand2_1
X_10422_ _10422_/Y _10422_/A _10432_/B VPWR VGND sg13cmos5l_nor2_1
X_14190_ _14190_/Q _14614_/CLK _14190_/D _14190_/RESET_B VPWR VGND sg13cmos5l_dfrbpq_1
X_14008__1383 _14008_/RESET_B VPWR VGND sg13cmos5l_tiehi
X_13495__1927 _13495_/RESET_B VPWR VGND sg13cmos5l_tiehi
X_13210_ _13210_/Q _14577_/CLK _13210_/D fanout965/X VPWR VGND sg13cmos5l_dfrbpq_1
X_10353_ _13938_/D _10419_/A1 _10380_/B _10352_/Y VPWR VGND sg13cmos5l_a21oi_1
X_13531__1891 _13531_/RESET_B VPWR VGND sg13cmos5l_tiehi
X_13141_ _13142_/B _09410_/A _13138_/B _13138_/Y hold3498/X VPWR VGND sg13cmos5l_a22oi_1
XFILLER_2_210 VPWR VGND sg13cmos5l_fill_1
X_13072_ _13072_/Y hold3447/X _13071_/C _13071_/Y VPWR VGND sg13cmos5l_o21ai_1
XFILLER_3_766 VPWR VGND sg13cmos5l_fill_1
X_10284_ _10284_/Y _10284_/A _10284_/B VPWR VGND sg13cmos5l_nor2_1
X_12023_ _12024_/B _12136_/A _12047_/A _12023_/C VPWR VGND sg13cmos5l_nor3_1
XFILLER_3_799 VPWR VGND sg13cmos5l_fill_2
XFILLER_19_601 VPWR VGND sg13cmos5l_fill_1
XFILLER_59_781 VPWR VGND sg13cmos5l_fill_1
Xfanout591 _12293_/B1 fanout593/X VPWR VGND sg13cmos5l_buf_1
Xfanout580 _11785_/B _12055_/B VPWR VGND sg13cmos5l_buf_1
X_13974_ _13974_/Q clkload50/A _13974_/D _13974_/RESET_B VPWR VGND sg13cmos5l_dfrbpq_1
XFILLER_18_166 VPWR VGND sg13cmos5l_fill_2
XFILLER_74_795 VPWR VGND sg13cmos5l_fill_1
X_12925_ _12926_/A _14450_/Q _11358_/B _11337_/B _12933_/B2 VPWR VGND sg13cmos5l_a22oi_1
XFILLER_61_445 VPWR VGND sg13cmos5l_decap_8
X_12856_ _12863_/B _12856_/A _13254_/Q VPWR VGND sg13cmos5l_xnor2_1
XFILLER_15_851 VPWR VGND sg13cmos5l_fill_1
X_11807_ _11810_/A _13947_/Q _11939_/B VPWR VGND sg13cmos5l_nand2_1
X_14526_ _14526_/Q _14532_/CLK _14526_/D fanout970/X VPWR VGND sg13cmos5l_dfrbpq_1
X_12787_ _12790_/B _12787_/A VPWR VGND sg13cmos5l_inv_1
X_11738_ _14348_/D _11737_/X _11711_/A _11738_/S VPWR VGND sg13cmos5l_mux2_1
X_11669_ _11682_/B _11661_/B _11663_/B _11659_/Y VPWR VGND sg13cmos5l_a21oi_1
X_14457_ _14457_/Q clkload75/A _14457_/D _14457_/RESET_B VPWR VGND sg13cmos5l_dfrbpq_1
X_13363__2059 _13363_/RESET_B VPWR VGND sg13cmos5l_tiehi
X_14388_ _14388_/Q clkload70/A _14388_/D _14388_/RESET_B VPWR VGND sg13cmos5l_dfrbpq_1
X_13408_ _13408_/Q _13568_/CLK _13408_/D _13408_/RESET_B VPWR VGND sg13cmos5l_dfrbpq_1
X_13339_ _13339_/Q _14109_/CLK _13339_/D _13339_/RESET_B VPWR VGND sg13cmos5l_dfrbpq_1
X_14294__1214 _14294_/RESET_B VPWR VGND sg13cmos5l_tiehi
Xhold3108 hold3108/X _13567_/Q VPWR VGND sg13cmos5l_dlygate4sd3_1
Xhold3119 hold3119/X _13457_/Q VPWR VGND sg13cmos5l_dlygate4sd3_1
XFILLER_69_534 VPWR VGND sg13cmos5l_fill_2
X_07900_ _07901_/C _11164_/B _11151_/B _14563_/Q VPWR VGND sg13cmos5l_a21oi_1
X_08880_ _14648_/D hold2693/X _08900_/A2 _08879_/Y VPWR VGND sg13cmos5l_a21o_1
Xhold2407 _10113_/A _13821_/Q VPWR VGND sg13cmos5l_dlygate4sd3_1
Xhold2418 _10537_/A _14029_/Q VPWR VGND sg13cmos5l_dlygate4sd3_1
XFILLER_97_865 VPWR VGND sg13cmos5l_fill_2
X_07831_ _07833_/A _14377_/Q _14345_/Q VPWR VGND sg13cmos5l_nor2_1
Xhold2429 hold2429/X _14601_/Q VPWR VGND sg13cmos5l_dlygate4sd3_1
X_13706__1685 _13706_/RESET_B VPWR VGND sg13cmos5l_tiehi
XFILLER_56_206 VPWR VGND sg13cmos5l_fill_2
X_07762_ _07762_/Y _08532_/B _08540_/A _07768_/A VPWR VGND sg13cmos5l_o21ai_1
X_09501_ _09501_/Y _12589_/A _12577_/A _09663_/B1 VPWR VGND sg13cmos5l_o21ai_1
X_14655__2198 _14655_/RESET_B VPWR VGND sg13cmos5l_tiehi
X_07693_ _08500_/A _07693_/A _07693_/B VPWR VGND sg13cmos5l_nand2_1
X_13885__1506 _13885_/RESET_B VPWR VGND sg13cmos5l_tiehi
XFILLER_53_968 VPWR VGND sg13cmos5l_fill_2
XFILLER_80_732 VPWR VGND sg13cmos5l_fill_1
X_09432_ _13543_/D _09293_/A hold3159/X _09434_/S VPWR VGND sg13cmos5l_mux2_1
X_13921__1470 _13921_/RESET_B VPWR VGND sg13cmos5l_tiehi
X_13573__1849 _13573_/RESET_B VPWR VGND sg13cmos5l_tiehi
XFILLER_80_765 VPWR VGND sg13cmos5l_decap_8
XFILLER_80_787 VPWR VGND sg13cmos5l_decap_8
X_09363_ _13476_/D _09219_/A hold3286/X _09366_/S VPWR VGND sg13cmos5l_mux2_1
X_08314_ _08315_/B _13577_/Q _13545_/Q _08314_/S VPWR VGND sg13cmos5l_mux2_1
XFILLER_20_342 VPWR VGND sg13cmos5l_fill_1
XFILLER_32_180 VPWR VGND sg13cmos5l_fill_2
X_09294_ _13415_/D _07308_/Y _09293_/B _09293_/Y VPWR VGND sg13cmos5l_a21oi_1
X_14583__2126 _14583_/RESET_B VPWR VGND sg13cmos5l_tiehi
X_08245_ _08245_/X _13508_/Q _13476_/Q _08309_/A VPWR VGND sg13cmos5l_mux2_1
X_08176_ _08176_/X _13562_/Q _13530_/Q _13498_/Q _13466_/Q _08283_/S _08200_/S1 VPWR
+ VGND sg13cmos5l_mux4_1
X_13339__2083 _13339_/RESET_B VPWR VGND sg13cmos5l_tiehi
XFILLER_88_821 VPWR VGND sg13cmos5l_fill_2
Xhold2930 _13052_/A _15890_/A VPWR VGND sg13cmos5l_dlygate4sd3_1
Xhold2941 _10321_/A _13923_/Q VPWR VGND sg13cmos5l_dlygate4sd3_1
Xhold2952 _10372_/A _13948_/Q VPWR VGND sg13cmos5l_dlygate4sd3_1
Xhold2963 _09167_/A _13324_/Q VPWR VGND sg13cmos5l_dlygate4sd3_1
Xhold2974 _13059_/A _15894_/A VPWR VGND sg13cmos5l_dlygate4sd3_1
X_14469__1019 _14469_/RESET_B VPWR VGND sg13cmos5l_tiehi
Xhold2985 _10462_/A _13992_/Q VPWR VGND sg13cmos5l_dlygate4sd3_1
Xhold2996 _10197_/A _13862_/Q VPWR VGND sg13cmos5l_dlygate4sd3_1
X_10971_ _10971_/Y _10971_/A _10971_/B _10971_/C VPWR VGND sg13cmos5l_nand3_1
XFILLER_16_659 VPWR VGND sg13cmos5l_fill_1
X_13690_ _13690_/Q clkload53/A _13690_/D _13690_/RESET_B VPWR VGND sg13cmos5l_dfrbpq_1
X_12710_ _12745_/A _14450_/Q _13240_/Q VPWR VGND sg13cmos5l_nor2_1
X_13549__1873 _13549_/RESET_B VPWR VGND sg13cmos5l_tiehi
X_12641_ _12642_/C _12641_/A _12641_/B VPWR VGND sg13cmos5l_nand2_1
XFILLER_52_990 VPWR VGND sg13cmos5l_fill_1
X_14372__1136 _14372_/RESET_B VPWR VGND sg13cmos5l_tiehi
X_12572_ _12572_/Y _12636_/C _12570_/X _12571_/X _12637_/C VPWR VGND sg13cmos5l_a22oi_1
XFILLER_7_27 VPWR VGND sg13cmos5l_fill_2
X_11523_ _11525_/B _11523_/A _11523_/B _11523_/C VPWR VGND sg13cmos5l_nor3_1
X_14311_ _14311_/Q clkload40/A _14311_/D _14311_/RESET_B VPWR VGND sg13cmos5l_dfrbpq_1
X_11454_ _11454_/Y _11440_/A _11463_/B _11443_/A VPWR VGND sg13cmos5l_a21oi_1
X_14242_ _14242_/Q clkload37/A _14242_/D _14242_/RESET_B VPWR VGND sg13cmos5l_dfrbpq_1
X_14093__1314 _14093_/RESET_B VPWR VGND sg13cmos5l_tiehi
X_10405_ _13964_/D fanout78/X _10412_/B _10404_/Y VPWR VGND sg13cmos5l_a21oi_1
X_11385_ _14326_/D _11383_/Y _11384_/Y _11373_/Y VPWR VGND sg13cmos5l_o21ai_1
X_14173_ _14173_/Q _14622_/CLK _14173_/D _14173_/RESET_B VPWR VGND sg13cmos5l_dfrbpq_1
X_10336_ _13930_/D _10597_/A1 _10345_/B _10335_/Y VPWR VGND sg13cmos5l_a21oi_1
X_13963__1428 _13963_/RESET_B VPWR VGND sg13cmos5l_tiehi
X_13124_ _13125_/B _09377_/A _13119_/B _13119_/Y hold3491/X VPWR VGND sg13cmos5l_a22oi_1
XFILLER_106_992 VPWR VGND sg13cmos5l_decap_8
XFILLER_79_832 VPWR VGND sg13cmos5l_fill_1
X_10267_ _13896_/D _10397_/A1 _10274_/B _10266_/Y VPWR VGND sg13cmos5l_a21oi_1
Xclkbuf_4_9_0_clk clkload4/A clkbuf_0_clk/X VPWR VGND sg13cmos5l_buf_8
X_13055_ _13058_/B _13055_/A _13055_/B _13055_/C VPWR VGND sg13cmos5l_nand3_1
X_12006_ _12008_/B _13954_/Q _12010_/A2 _12206_/B VPWR VGND sg13cmos5l_a21oi_1
XFILLER_78_364 VPWR VGND sg13cmos5l_fill_2
X_10198_ _13862_/D fanout80/X _10213_/B _10197_/Y VPWR VGND sg13cmos5l_a21oi_1
XFILLER_66_559 VPWR VGND sg13cmos5l_fill_2
XFILLER_35_902 VPWR VGND sg13cmos5l_fill_2
XFILLER_47_784 VPWR VGND sg13cmos5l_fill_1
XFILLER_81_518 VPWR VGND sg13cmos5l_fill_1
XFILLER_93_367 VPWR VGND sg13cmos5l_fill_2
X_13957_ _13957_/Q _14028_/CLK _13957_/D _13957_/RESET_B VPWR VGND sg13cmos5l_dfrbpq_1
X_12908_ _14441_/D _12908_/A VPWR VGND sg13cmos5l_inv_1
XFILLER_62_754 VPWR VGND sg13cmos5l_decap_4
X_13888_ _13888_/Q clkload48/A _13888_/D _13888_/RESET_B VPWR VGND sg13cmos5l_dfrbpq_1
X_12839_ _12839_/Y _12864_/B _12839_/B VPWR VGND sg13cmos5l_xnor2_1
X_14348__1160 _14348_/RESET_B VPWR VGND sg13cmos5l_tiehi
X_14509_ _15888_/A _14532_/CLK _14509_/D fanout968/X VPWR VGND sg13cmos5l_dfrbpq_1
X_08030_ _08032_/B _08030_/A _08030_/B _08030_/C VPWR VGND sg13cmos5l_nand3_1
X_09981_ _09981_/Y _09981_/A _10007_/B VPWR VGND sg13cmos5l_nand2_1
XFILLER_103_428 VPWR VGND sg13cmos5l_fill_1
X_08932_ _08932_/Y _14266_/Q _13191_/B1 _08938_/B1 VPWR VGND sg13cmos5l_a21oi_1
X_13939__1452 _13939_/RESET_B VPWR VGND sg13cmos5l_tiehi
Xhold2237 _13028_/A _14502_/Q VPWR VGND sg13cmos5l_dlygate4sd3_1
XFILLER_29_217 VPWR VGND sg13cmos5l_fill_1
XFILLER_69_386 VPWR VGND sg13cmos5l_decap_8
X_08863_ _14643_/D _08863_/A _08863_/B _08863_/C _08863_/D VPWR VGND sg13cmos5l_nand4_1
Xhold2248 _11141_/A _14304_/Q VPWR VGND sg13cmos5l_dlygate4sd3_1
Xhold2259 _10560_/A _14040_/Q VPWR VGND sg13cmos5l_dlygate4sd3_1
XFILLER_57_537 VPWR VGND sg13cmos5l_decap_8
X_07814_ _08628_/A _08908_/A VPWR VGND sg13cmos5l_inv_1
X_08794_ _08794_/Y _14375_/Q _11641_/A _08808_/B VPWR VGND sg13cmos5l_nand3_1
XFILLER_26_902 VPWR VGND sg13cmos5l_fill_2
X_07745_ _07745_/Y _08491_/A _07745_/B VPWR VGND sg13cmos5l_nor2_1
XFILLER_65_592 VPWR VGND sg13cmos5l_decap_8
XFILLER_53_765 VPWR VGND sg13cmos5l_decap_8
X_07676_ _07679_/A _14386_/Q _14354_/Q VPWR VGND sg13cmos5l_nor2_1
X_09415_ _13526_/D _10683_/A1 hold3092/X _09421_/S VPWR VGND sg13cmos5l_mux2_1
X_09346_ _13459_/D _09445_/A0 hold3421/X _09366_/S VPWR VGND sg13cmos5l_mux2_1
X_09277_ _13401_/D _08157_/A hold3311/X _09293_/B VPWR VGND sg13cmos5l_mux2_1
X_08228_ _12553_/A _08344_/C _08218_/X _08227_/Y VPWR VGND sg13cmos5l_a21oi_1
XFILLER_10_1026 VPWR VGND sg13cmos5l_fill_2
X_08159_ _08161_/B _14530_/Q _11039_/A2 _08209_/B1 _14478_/Q VPWR VGND sg13cmos5l_a22oi_1
XFILLER_106_266 VPWR VGND sg13cmos5l_fill_2
X_11170_ _11170_/Y _11170_/A _11170_/B VPWR VGND sg13cmos5l_xnor2_1
X_10121_ _10121_/Y _10121_/A _10137_/B VPWR VGND sg13cmos5l_nand2_1
X_13311__2201 _13311_/RESET_B VPWR VGND sg13cmos5l_tiehi
XFILLER_0_555 VPWR VGND sg13cmos5l_fill_1
XFILLER_103_951 VPWR VGND sg13cmos5l_decap_4
X_10052_ _10052_/Y _10052_/A _10052_/B VPWR VGND sg13cmos5l_nand2_1
Xhold3461 _13228_/D _13155_/Y VPWR VGND sg13cmos5l_dlygate4sd3_1
Xhold3450 _09030_/A _13297_/Q VPWR VGND sg13cmos5l_dlygate4sd3_1
XFILLER_48_526 VPWR VGND sg13cmos5l_fill_1
XFILLER_76_813 VPWR VGND sg13cmos5l_fill_1
Xhold3494 _07898_/B _14225_/Q VPWR VGND sg13cmos5l_dlygate4sd3_1
Xhold3483 hold3483/X _14130_/Q VPWR VGND sg13cmos5l_dlygate4sd3_1
Xhold3472 _14406_/D _12558_/Y VPWR VGND sg13cmos5l_dlygate4sd3_1
XFILLER_29_740 VPWR VGND sg13cmos5l_fill_1
Xhold2760 _10468_/A _13995_/Q VPWR VGND sg13cmos5l_dlygate4sd3_1
Xhold2771 _11089_/A _14290_/Q VPWR VGND sg13cmos5l_dlygate4sd3_1
Xhold2782 _09765_/A _13650_/Q VPWR VGND sg13cmos5l_dlygate4sd3_1
X_14426__1082 _14426_/RESET_B VPWR VGND sg13cmos5l_tiehi
Xhold2793 _08150_/A _08148_/Y VPWR VGND sg13cmos5l_dlygate4sd3_1
X_13811_ _13811_/Q clkload50/A _13811_/D _13811_/RESET_B VPWR VGND sg13cmos5l_dfrbpq_1
X_13742_ _13742_/Q clkload56/A _13742_/D _13742_/RESET_B VPWR VGND sg13cmos5l_dfrbpq_1
XFILLER_16_445 VPWR VGND sg13cmos5l_fill_2
XFILLER_16_456 VPWR VGND sg13cmos5l_decap_4
X_10954_ _10961_/C _14245_/D _14246_/D _10954_/C VPWR VGND sg13cmos5l_nor3_1
XFILLER_31_404 VPWR VGND sg13cmos5l_fill_2
XFILLER_32_927 VPWR VGND sg13cmos5l_fill_1
XFILLER_71_584 VPWR VGND sg13cmos5l_decap_8
X_10885_ _10887_/C _14248_/Q _14247_/Q _10885_/C _10885_/D VPWR VGND sg13cmos5l_nor4_1
X_13673_ _13673_/Q clkload63/A _13673_/D _13673_/RESET_B VPWR VGND sg13cmos5l_dfrbpq_1
X_12624_ _12624_/Y _12624_/A _12583_/A VPWR VGND sg13cmos5l_nor2b_1
XFILLER_11_150 VPWR VGND sg13cmos5l_fill_1
X_12555_ _12555_/Y _12548_/Y _12551_/Y _12554_/Y VPWR VGND sg13cmos5l_o21ai_1
X_11506_ _11506_/Y _11464_/A _11502_/X _11513_/A _11505_/Y _11557_/A VPWR VGND sg13cmos5l_a221oi_1
X_14654__2197 _14654_/RESET_B VPWR VGND sg13cmos5l_tiehi
X_12486_ _14389_/D _12486_/A _12486_/B VPWR VGND sg13cmos5l_nand2_1
X_11437_ _11438_/B _11450_/A _11437_/B VPWR VGND sg13cmos5l_nand2_1
X_14225_ _14225_/Q clkload44/A _14225_/D _14225_/RESET_B VPWR VGND sg13cmos5l_dfrbpq_1
X_11368_ _11368_/Y _11401_/A _11401_/B _11444_/A VPWR VGND sg13cmos5l_o21ai_1
X_14156_ _14156_/Q clkload26/A _14156_/D fanout987/X VPWR VGND sg13cmos5l_dfrbpq_1
X_10319_ _10319_/Y _10319_/A _10319_/B VPWR VGND sg13cmos5l_nor2_1
X_14231__1246 _14231_/RESET_B VPWR VGND sg13cmos5l_tiehi
X_13107_ _13109_/B _14536_/Q _14537_/Q _13107_/C VPWR VGND sg13cmos5l_nand3_1
X_11299_ _11301_/B _11331_/A _11300_/C _11327_/A VPWR VGND sg13cmos5l_o21ai_1
X_14087_ _14087_/Q clkload71/A _14087_/D _14087_/RESET_B VPWR VGND sg13cmos5l_dfrbpq_1
XFILLER_79_662 VPWR VGND sg13cmos5l_decap_4
X_14582__2125 _14582_/RESET_B VPWR VGND sg13cmos5l_tiehi
X_13038_ _14505_/D _13040_/B _13038_/B VPWR VGND sg13cmos5l_xnor2_1
XFILLER_39_537 VPWR VGND sg13cmos5l_fill_2
XFILLER_94_665 VPWR VGND sg13cmos5l_fill_2
XFILLER_47_581 VPWR VGND sg13cmos5l_decap_4
X_07530_ _07530_/Y _13213_/Q _07530_/A2 _07530_/B1 _14474_/Q _07529_/Y VPWR VGND sg13cmos5l_a221oi_1
XFILLER_50_724 VPWR VGND sg13cmos5l_decap_8
X_07461_ _07461_/Y _07461_/A VPWR VGND sg13cmos5l_inv_1
XFILLER_16_990 VPWR VGND sg13cmos5l_fill_2
XFILLER_97_0 VPWR VGND sg13cmos5l_fill_1
X_07392_ _07395_/B _07577_/A _07569_/A VPWR VGND sg13cmos5l_nand2b_1
X_09200_ _09200_/Y _09344_/A _09309_/B VPWR VGND sg13cmos5l_nand2_1
X_13490__1932 _13490_/RESET_B VPWR VGND sg13cmos5l_tiehi
X_09131_ _09131_/Y _09131_/A _09137_/B VPWR VGND sg13cmos5l_nor2_1
X_09062_ _11264_/A _14319_/Q _09073_/B VPWR VGND sg13cmos5l_nand2_1
X_08013_ _08030_/A _14555_/Q _08037_/B VPWR VGND sg13cmos5l_xnor2_1
XFILLER_89_437 VPWR VGND sg13cmos5l_decap_8
X_09964_ _13747_/D _10551_/A1 _09979_/B _09963_/Y VPWR VGND sg13cmos5l_o21ai_1
X_14207__1270 _14207_/RESET_B VPWR VGND sg13cmos5l_tiehi
XFILLER_103_269 VPWR VGND sg13cmos5l_fill_1
X_08915_ _13162_/B _14195_/Q _14225_/Q _14220_/Q VPWR VGND sg13cmos5l_or3_1
X_09895_ _09895_/Y _14234_/Q _09895_/B _10417_/A VPWR VGND sg13cmos5l_nor3_1
XFILLER_100_932 VPWR VGND sg13cmos5l_fill_1
XFILLER_58_857 VPWR VGND sg13cmos5l_decap_4
X_08846_ _14639_/D _08846_/A VPWR VGND sg13cmos5l_inv_1
XFILLER_73_805 VPWR VGND sg13cmos5l_decap_4
X_08777_ _08777_/Y _08785_/B2 _14158_/Q _13267_/Q _08781_/B2 VPWR VGND sg13cmos5l_a22oi_1
X_07728_ _07728_/Y _14375_/Q _11641_/A VPWR VGND sg13cmos5l_nand2b_1
XFILLER_25_253 VPWR VGND sg13cmos5l_fill_1
X_07659_ _08559_/B _14394_/Q _14362_/Q VPWR VGND sg13cmos5l_and2_1
X_10670_ _14093_/D _14255_/D _14093_/Q _10826_/S VPWR VGND sg13cmos5l_mux2_1
XFILLER_9_419 VPWR VGND sg13cmos5l_fill_2
X_09329_ _13445_/D _08257_/A hold2965/X _09338_/S VPWR VGND sg13cmos5l_mux2_1
X_13665__1726 _13665_/RESET_B VPWR VGND sg13cmos5l_tiehi
X_12340_ _12340_/Y _13998_/Q _12030_/B _12345_/B1 _13806_/Q _12349_/C1 VPWR VGND sg13cmos5l_a221oi_1
X_12271_ _12271_/Y _13835_/Q _12260_/B _12293_/B1 VPWR VGND sg13cmos5l_a21oi_1
X_13701__1690 _13701_/RESET_B VPWR VGND sg13cmos5l_tiehi
X_11222_ _11256_/B _11222_/A _11222_/B VPWR VGND sg13cmos5l_nand2_1
X_14010_ _14010_/Q _14042_/CLK _14010_/D _14010_/RESET_B VPWR VGND sg13cmos5l_dfrbpq_1
X_11153_ _11153_/X _11153_/A _11157_/A VPWR VGND sg13cmos5l_or2_1
X_14045__1346 _14045_/RESET_B VPWR VGND sg13cmos5l_tiehi
X_13880__1511 _13880_/RESET_B VPWR VGND sg13cmos5l_tiehi
X_10104_ _13816_/D _10496_/A1 _10107_/B _10103_/Y VPWR VGND sg13cmos5l_o21ai_1
X_11084_ _11084_/Y _14388_/Q _11088_/A2 _11083_/X VPWR VGND sg13cmos5l_a21oi_1
XFILLER_76_621 VPWR VGND sg13cmos5l_fill_1
XFILLER_76_632 VPWR VGND sg13cmos5l_fill_1
X_10035_ _13782_/D _10557_/A1 _10034_/B _10034_/Y VPWR VGND sg13cmos5l_o21ai_1
Xhold3291 hold3291/X _13553_/Q VPWR VGND sg13cmos5l_dlygate4sd3_1
Xhold3280 _13569_/D _09459_/X VPWR VGND sg13cmos5l_dlygate4sd3_1
X_15892_ _15892_/X _15892_/A VPWR VGND sg13cmos5l_buf_1
XFILLER_48_356 VPWR VGND sg13cmos5l_fill_1
XFILLER_48_367 VPWR VGND sg13cmos5l_decap_4
XFILLER_48_378 VPWR VGND sg13cmos5l_fill_1
XFILLER_75_131 VPWR VGND sg13cmos5l_fill_1
XFILLER_91_602 VPWR VGND sg13cmos5l_fill_2
Xhold2590 _10159_/A _13843_/Q VPWR VGND sg13cmos5l_dlygate4sd3_1
XFILLER_1_1024 VPWR VGND sg13cmos5l_decap_4
XFILLER_29_592 VPWR VGND sg13cmos5l_fill_2
XFILLER_72_860 VPWR VGND sg13cmos5l_fill_1
X_11986_ _11987_/B _11984_/A _11985_/Y _11930_/B VPWR VGND sg13cmos5l_o21ai_1
XFILLER_44_562 VPWR VGND sg13cmos5l_fill_1
X_10937_ _10937_/Y _10937_/A VPWR VGND sg13cmos5l_inv_1
X_13725_ _13725_/Q _14045_/CLK _13725_/D _13725_/RESET_B VPWR VGND sg13cmos5l_dfrbpq_1
X_13656_ _13656_/Q clkload53/A _13656_/D _13656_/RESET_B VPWR VGND sg13cmos5l_dfrbpq_1
X_10868_ _10943_/B _10877_/A _10880_/B VPWR VGND sg13cmos5l_nand2_1
X_12607_ _14410_/D _12686_/A _12607_/B _12607_/C _12607_/D VPWR VGND sg13cmos5l_nand4_1
X_10799_ _10799_/Y _14160_/Q _10799_/B VPWR VGND sg13cmos5l_nand2_1
X_13587_ _13587_/Q clkload18/A _13587_/D _13587_/RESET_B VPWR VGND sg13cmos5l_dfrbpq_1
X_12538_ _12538_/Y _12379_/Y _12538_/B VPWR VGND sg13cmos5l_nand2b_1
X_12469_ _12469_/Y _08646_/A _11866_/Y _12466_/B VPWR VGND sg13cmos5l_a21oi_1
X_14208_ _14208_/Q _14614_/CLK _14208_/D _14208_/RESET_B VPWR VGND sg13cmos5l_dfrbpq_1
XFILLER_101_707 VPWR VGND sg13cmos5l_decap_4
Xfanout409 _11145_/A1 fanout414/X VPWR VGND sg13cmos5l_buf_1
X_14139_ _14139_/Q clkload26/A _14139_/D fanout986/X VPWR VGND sg13cmos5l_dfrbpq_1
XFILLER_100_206 VPWR VGND sg13cmos5l_fill_2
X_08700_ _08700_/Y _13588_/Q _08738_/A2 _08687_/A VPWR VGND sg13cmos5l_a21oi_1
X_09680_ _09680_/Y _09680_/A _09693_/B VPWR VGND sg13cmos5l_nor2_1
XFILLER_55_805 VPWR VGND sg13cmos5l_decap_8
XFILLER_94_440 VPWR VGND sg13cmos5l_fill_2
XFILLER_94_462 VPWR VGND sg13cmos5l_fill_1
X_08631_ _08632_/B _14581_/Q _14580_/Q VPWR VGND sg13cmos5l_nor2_1
XFILLER_54_315 VPWR VGND sg13cmos5l_fill_2
XFILLER_54_348 VPWR VGND sg13cmos5l_fill_2
XFILLER_54_359 VPWR VGND sg13cmos5l_decap_4
X_08562_ _08582_/D _08867_/A _08562_/B VPWR VGND sg13cmos5l_nand2_1
X_13743__1648 _13743_/RESET_B VPWR VGND sg13cmos5l_tiehi
XFILLER_23_702 VPWR VGND sg13cmos5l_fill_2
XFILLER_63_871 VPWR VGND sg13cmos5l_decap_4
X_07513_ _07515_/C _14068_/Q _07465_/B _07527_/B1 _15886_/A VPWR VGND sg13cmos5l_a22oi_1
X_08493_ _08497_/B _08484_/Y _08492_/B _08492_/A VPWR VGND sg13cmos5l_a21oi_1
X_07444_ _07450_/A _10683_/A1 _08199_/A1 _08187_/B2 VPWR VGND sg13cmos5l_a21oi_1
X_07375_ _07399_/B _08974_/A _14541_/Q VPWR VGND sg13cmos5l_xor2_1
X_09114_ _13315_/D _09125_/B _09112_/Y _09113_/Y VPWR VGND sg13cmos5l_a21oi_1
X_09045_ _09045_/Y _14412_/Q _11234_/A VPWR VGND sg13cmos5l_nand2_1
X_13376__2046 _13376_/RESET_B VPWR VGND sg13cmos5l_tiehi
X_09947_ _13739_/D _10534_/A1 _09958_/B _09946_/Y VPWR VGND sg13cmos5l_a21oi_1
Xfanout910 _09416_/A0 _14104_/Q VPWR VGND sg13cmos5l_buf_1
Xfanout921 _12964_/A _07472_/A VPWR VGND sg13cmos5l_buf_1
Xfanout932 _08974_/A _09048_/A VPWR VGND sg13cmos5l_buf_1
Xfanout943 _13148_/A _08785_/B2 VPWR VGND sg13cmos5l_buf_1
Xfanout954 _13127_/A _13140_/A VPWR VGND sg13cmos5l_buf_1
Xfanout965 fanout965/X fanout966/X VPWR VGND sg13cmos5l_buf_1
Xfanout976 fanout976/X fanout977/X VPWR VGND sg13cmos5l_buf_1
X_09878_ _09878_/Y _09878_/A _09878_/B VPWR VGND sg13cmos5l_nor2_1
Xfanout987 fanout987/X fanout988/X VPWR VGND sg13cmos5l_buf_1
Xfanout998 fanout998/X fanout998/A VPWR VGND sg13cmos5l_buf_1
XFILLER_100_784 VPWR VGND sg13cmos5l_decap_8
XFILLER_18_518 VPWR VGND sg13cmos5l_fill_1
XFILLER_46_849 VPWR VGND sg13cmos5l_fill_2
XFILLER_79_1026 VPWR VGND sg13cmos5l_fill_2
X_08829_ _08829_/Y _08495_/A _08879_/A2 _08828_/Y VPWR VGND sg13cmos5l_o21ai_1
X_11840_ _11840_/Y _11840_/A _12673_/B VPWR VGND sg13cmos5l_nand2_1
X_14653__2196 _14653_/RESET_B VPWR VGND sg13cmos5l_tiehi
X_11771_ _11771_/Y _13754_/Q _12058_/B _11726_/B VPWR VGND sg13cmos5l_a21oi_1
X_13719__1672 _13719_/RESET_B VPWR VGND sg13cmos5l_tiehi
X_10722_ _10722_/Y _10802_/B _10720_/Y _10721_/Y VPWR VGND sg13cmos5l_o21ai_1
X_13510_ _13510_/Q clkload41/A _13510_/D _13510_/RESET_B VPWR VGND sg13cmos5l_dfrbpq_1
X_14490_ _14490_/Q _14577_/CLK _14490_/D fanout964/X VPWR VGND sg13cmos5l_dfrbpq_1
X_10653_ _10654_/C _10653_/A _14239_/Q _14084_/Q VPWR VGND sg13cmos5l_nor3_1
X_13441_ _13441_/Q clkload31/A _13441_/D _13441_/RESET_B VPWR VGND sg13cmos5l_dfrbpq_1
X_10584_ _10584_/Y _10584_/A _10596_/B VPWR VGND sg13cmos5l_nand2_1
X_14581__2124 _14581_/RESET_B VPWR VGND sg13cmos5l_tiehi
X_13372_ _13372_/Q _14109_/CLK _13372_/D _13372_/RESET_B VPWR VGND sg13cmos5l_dfrbpq_1
Xclkload19 clkload19/Y clkload19/A VPWR VGND sg13cmos5l_inv_1
X_13586__1836 _13586_/RESET_B VPWR VGND sg13cmos5l_tiehi
X_12323_ _12323_/Y _12323_/A _12405_/B VPWR VGND sg13cmos5l_nand2_1
XFILLER_6_967 VPWR VGND sg13cmos5l_fill_2
XFILLER_79_52 VPWR VGND sg13cmos5l_fill_2
X_12254_ _12256_/C _14367_/Q _13252_/Q VPWR VGND sg13cmos5l_xnor2_1
XFILLER_96_705 VPWR VGND sg13cmos5l_fill_2
X_11205_ _11205_/Y _11193_/A _11214_/C _12907_/B2 VPWR VGND sg13cmos5l_o21ai_1
X_12185_ _14364_/D _12185_/A VPWR VGND sg13cmos5l_inv_1
X_11136_ _14302_/D _11135_/B _11134_/Y _11135_/Y VPWR VGND sg13cmos5l_a21oi_1
XFILLER_49_621 VPWR VGND sg13cmos5l_fill_1
XFILLER_77_952 VPWR VGND sg13cmos5l_decap_4
XFILLER_37_816 VPWR VGND sg13cmos5l_fill_2
X_11067_ _11067_/X _14376_/Q _11083_/B VPWR VGND sg13cmos5l_and2_1
XFILLER_64_624 VPWR VGND sg13cmos5l_fill_1
XFILLER_76_473 VPWR VGND sg13cmos5l_fill_2
XFILLER_76_495 VPWR VGND sg13cmos5l_decap_8
XFILLER_77_996 VPWR VGND sg13cmos5l_fill_1
XFILLER_91_410 VPWR VGND sg13cmos5l_fill_1
X_10018_ _13774_/D fanout74/X _10017_/B _10017_/Y VPWR VGND sg13cmos5l_o21ai_1
X_13421__2001 _13421_/RESET_B VPWR VGND sg13cmos5l_tiehi
XFILLER_91_443 VPWR VGND sg13cmos5l_fill_1
XFILLER_17_562 VPWR VGND sg13cmos5l_fill_1
XFILLER_64_679 VPWR VGND sg13cmos5l_fill_2
XFILLER_91_465 VPWR VGND sg13cmos5l_fill_2
X_14181__1296 _14181_/RESET_B VPWR VGND sg13cmos5l_tiehi
XFILLER_44_381 VPWR VGND sg13cmos5l_fill_1
X_11969_ _11969_/Y _14049_/Q _11969_/A2 _11966_/B _13793_/Q VPWR VGND sg13cmos5l_a22oi_1
X_13708_ _13708_/Q _14064_/CLK _13708_/D _13708_/RESET_B VPWR VGND sg13cmos5l_dfrbpq_1
X_13639_ _13639_/Q _14064_/CLK _13639_/D _13639_/RESET_B VPWR VGND sg13cmos5l_dfrbpq_1
X_14385__1123 _14385_/RESET_B VPWR VGND sg13cmos5l_tiehi
XFILLER_99_554 VPWR VGND sg13cmos5l_fill_1
XFILLER_8_1019 VPWR VGND sg13cmos5l_decap_8
X_09801_ _09801_/Y _09801_/A _09801_/B VPWR VGND sg13cmos5l_nor2_1
Xfanout228 _10017_/B _10021_/B VPWR VGND sg13cmos5l_buf_1
Xfanout217 _10072_/B fanout222/X VPWR VGND sg13cmos5l_buf_1
Xfanout206 _10137_/B _10146_/A2 VPWR VGND sg13cmos5l_buf_1
XFILLER_68_930 VPWR VGND sg13cmos5l_decap_4
XFILLER_86_237 VPWR VGND sg13cmos5l_fill_1
X_07993_ _07993_/Y _07993_/A _07992_/X VPWR VGND sg13cmos5l_nor2b_1
X_09732_ _09732_/Y _09732_/A _09754_/B VPWR VGND sg13cmos5l_nor2_1
Xfanout239 _10369_/A1 _09536_/Y VPWR VGND sg13cmos5l_buf_1
XFILLER_68_974 VPWR VGND sg13cmos5l_fill_1
XFILLER_28_827 VPWR VGND sg13cmos5l_fill_2
XFILLER_68_996 VPWR VGND sg13cmos5l_decap_8
X_09663_ _09663_/Y _12856_/A _09670_/C _09663_/B1 VPWR VGND sg13cmos5l_o21ai_1
X_13976__1415 _13976_/RESET_B VPWR VGND sg13cmos5l_tiehi
XFILLER_55_657 VPWR VGND sg13cmos5l_fill_2
XFILLER_82_454 VPWR VGND sg13cmos5l_fill_2
XFILLER_83_955 VPWR VGND sg13cmos5l_decap_4
XFILLER_83_966 VPWR VGND sg13cmos5l_fill_1
X_08614_ _08614_/Y _08619_/B _07808_/Y _07809_/Y VPWR VGND sg13cmos5l_a21oi_1
X_09594_ _09594_/Y _09594_/A _09666_/B VPWR VGND sg13cmos5l_nor2_1
XFILLER_36_871 VPWR VGND sg13cmos5l_fill_2
XFILLER_43_819 VPWR VGND sg13cmos5l_fill_1
XFILLER_82_465 VPWR VGND sg13cmos5l_decap_8
XFILLER_82_476 VPWR VGND sg13cmos5l_fill_1
X_08545_ _08545_/Y _08861_/A _12093_/A _08542_/Y VPWR VGND sg13cmos5l_o21ai_1
XFILLER_35_392 VPWR VGND sg13cmos5l_fill_1
XFILLER_51_841 VPWR VGND sg13cmos5l_decap_4
XFILLER_70_649 VPWR VGND sg13cmos5l_fill_2
XFILLER_50_340 VPWR VGND sg13cmos5l_fill_2
XFILLER_51_874 VPWR VGND sg13cmos5l_fill_2
X_08476_ _08476_/Y _08476_/A _08476_/B _08476_/C VPWR VGND sg13cmos5l_nand3_1
XFILLER_50_373 VPWR VGND sg13cmos5l_fill_2
X_07427_ _07427_/X _13431_/Q _13399_/Q _13367_/Q _13335_/Q _07522_/S0 _07522_/S1 VPWR
+ VGND sg13cmos5l_mux4_1
X_07358_ _07396_/A _14560_/Q _07434_/C _07574_/A VPWR VGND sg13cmos5l_o21ai_1
X_07289_ _07289_/Y _13250_/Q VPWR VGND sg13cmos5l_inv_1
X_09028_ _09028_/Y _09028_/A _09030_/B VPWR VGND sg13cmos5l_nand2_1
Xfanout751 _11557_/A _08913_/A VPWR VGND sg13cmos5l_buf_1
Xfanout740 _07940_/B _07845_/Y VPWR VGND sg13cmos5l_buf_1
XFILLER_19_805 VPWR VGND sg13cmos5l_fill_1
Xfanout784 _08288_/S _07524_/S0 VPWR VGND sg13cmos5l_buf_1
Xfanout773 _11447_/A1 _14624_/Q VPWR VGND sg13cmos5l_buf_1
Xfanout762 _10801_/A _10804_/A VPWR VGND sg13cmos5l_buf_1
X_13990_ _13990_/Q clkload55/A _13990_/D _13990_/RESET_B VPWR VGND sg13cmos5l_dfrbpq_1
XFILLER_92_218 VPWR VGND sg13cmos5l_fill_2
Xfanout795 _08258_/S _08361_/B VPWR VGND sg13cmos5l_buf_1
X_12941_ _12942_/A _14458_/Q _12945_/A2 _11476_/C _12945_/B2 VPWR VGND sg13cmos5l_a22oi_1
XFILLER_85_292 VPWR VGND sg13cmos5l_fill_2
X_12872_ _12872_/X _11092_/A _12595_/Y _12879_/B1 VPWR VGND sg13cmos5l_a21o_1
XFILLER_27_871 VPWR VGND sg13cmos5l_fill_1
XFILLER_74_988 VPWR VGND sg13cmos5l_decap_4
X_11823_ _11823_/Y _07237_/Y _07274_/Y _11801_/D VPWR VGND sg13cmos5l_o21ai_1
X_14611_ _14611_/Q _14654_/CLK _14611_/D _14611_/RESET_B VPWR VGND sg13cmos5l_dfrbpq_1
XFILLER_61_638 VPWR VGND sg13cmos5l_decap_8
XFILLER_61_649 VPWR VGND sg13cmos5l_decap_4
X_11754_ _11757_/A _11805_/A2 _11752_/X _11753_/X _11754_/B2 VPWR VGND sg13cmos5l_a22oi_1
X_14542_ _14542_/Q clkload11/A _14542_/D fanout983/X VPWR VGND sg13cmos5l_dfrbpq_1
XFILLER_41_384 VPWR VGND sg13cmos5l_fill_2
X_10705_ _14125_/D input3/X hold3538/X _10710_/S VPWR VGND sg13cmos5l_mux2_1
X_11685_ _11708_/B _07709_/B _11868_/A2 _11816_/B1 _12607_/B VPWR VGND sg13cmos5l_a22oi_1
X_14473_ _14473_/Q clkload8/A _14473_/D fanout962/X VPWR VGND sg13cmos5l_dfrbpq_1
X_10636_ _10636_/Y _10636_/A _10636_/B VPWR VGND sg13cmos5l_xnor2_1
X_13424_ _13424_/Q _14238_/CLK _13424_/D _13424_/RESET_B VPWR VGND sg13cmos5l_dfrbpq_1
XFILLER_10_771 VPWR VGND sg13cmos5l_fill_1
X_10567_ _14043_/D _10567_/A1 _10566_/B _10566_/Y VPWR VGND sg13cmos5l_o21ai_1
X_13355_ _13355_/Q clkload34/A _13355_/D _13355_/RESET_B VPWR VGND sg13cmos5l_dfrbpq_1
X_10498_ _14009_/D _10563_/A1 _10497_/B _10497_/Y VPWR VGND sg13cmos5l_o21ai_1
X_13286_ _13286_/Q clkload20/A _13286_/D fanout986/X VPWR VGND sg13cmos5l_dfrbpq_1
X_12306_ _12329_/B _14369_/Q _13254_/Q VPWR VGND sg13cmos5l_xor2_1
XFILLER_46_6 VPWR VGND sg13cmos5l_fill_1
X_12237_ _12237_/Y _13706_/Q _12237_/B VPWR VGND sg13cmos5l_nand2_1
XFILLER_96_502 VPWR VGND sg13cmos5l_decap_4
X_14199__1278 _14199_/RESET_B VPWR VGND sg13cmos5l_tiehi
X_12168_ _12169_/C _13960_/Q _12397_/B _12377_/B1 _13704_/Q VPWR VGND sg13cmos5l_a22oi_1
X_11119_ _11119_/Y _11119_/A _11135_/B VPWR VGND sg13cmos5l_nor2_1
X_12099_ _14361_/D _12071_/A _12127_/A _12079_/Y _12098_/Y VPWR VGND sg13cmos5l_a22oi_1
XFILLER_37_602 VPWR VGND sg13cmos5l_decap_4
XFILLER_49_484 VPWR VGND sg13cmos5l_fill_1
XFILLER_77_771 VPWR VGND sg13cmos5l_decap_8
Xinput6 input6/X ui_in[13] VPWR VGND sg13cmos5l_buf_1
XFILLER_37_657 VPWR VGND sg13cmos5l_fill_1
XFILLER_24_307 VPWR VGND sg13cmos5l_fill_2
XFILLER_64_465 VPWR VGND sg13cmos5l_fill_1
XFILLER_17_381 VPWR VGND sg13cmos5l_fill_2
XFILLER_33_830 VPWR VGND sg13cmos5l_fill_1
XFILLER_51_126 VPWR VGND sg13cmos5l_fill_2
X_08330_ _12549_/B _08328_/Y _08329_/X _08320_/Y VPWR VGND sg13cmos5l_o21ai_1
X_13660__1731 _13660_/RESET_B VPWR VGND sg13cmos5l_tiehi
X_08261_ _08261_/Y _08405_/A1 _08258_/X _08311_/C1 VPWR VGND sg13cmos5l_a21oi_1
X_07212_ _07643_/A _14403_/Q VPWR VGND sg13cmos5l_inv_1
Xheichips26_loopcache_rv_2218 uio_oe[6] VPWR VGND sg13cmos5l_tiehi
XFILLER_20_579 VPWR VGND sg13cmos5l_fill_2
X_08192_ _12560_/B _08204_/A1 _08191_/Y _08187_/Y VPWR VGND sg13cmos5l_o21ai_1
X_14040__1351 _14040_/RESET_B VPWR VGND sg13cmos5l_tiehi
X_13693__1698 _13693_/RESET_B VPWR VGND sg13cmos5l_tiehi
X_14652__2195 _14652_/RESET_B VPWR VGND sg13cmos5l_tiehi
XFILLER_0_907 VPWR VGND sg13cmos5l_decap_8
XFILLER_87_535 VPWR VGND sg13cmos5l_fill_2
X_07976_ _07977_/C _14079_/Q _08207_/A2 _08208_/A2 _14518_/Q VPWR VGND sg13cmos5l_a22oi_1
XFILLER_55_410 VPWR VGND sg13cmos5l_fill_1
X_09715_ _13626_/D _10565_/A1 _09714_/B _09714_/Y VPWR VGND sg13cmos5l_a21oi_1
X_14580__2123 _14580_/RESET_B VPWR VGND sg13cmos5l_tiehi
XFILLER_56_966 VPWR VGND sg13cmos5l_fill_1
XFILLER_67_292 VPWR VGND sg13cmos5l_fill_2
X_09646_ _09646_/Y _09671_/A _09646_/B VPWR VGND sg13cmos5l_nor2_1
XFILLER_28_668 VPWR VGND sg13cmos5l_fill_2
X_09577_ _09577_/Y _09571_/A _11343_/B _09589_/C _09576_/Y VPWR VGND sg13cmos5l_a22oi_1
XFILLER_70_479 VPWR VGND sg13cmos5l_fill_2
X_08528_ _08528_/Y _07683_/A _07685_/Y _07682_/Y VPWR VGND sg13cmos5l_o21ai_1
X_08459_ _08460_/B _08471_/A _08457_/X _08458_/Y VPWR VGND sg13cmos5l_o21ai_1
X_11470_ _11471_/B _11482_/A _11470_/B VPWR VGND sg13cmos5l_nand2_1
X_10421_ _13971_/D _10551_/A1 _10432_/B _10420_/Y VPWR VGND sg13cmos5l_a21oi_1
X_10352_ _10352_/Y _10352_/A _10380_/B VPWR VGND sg13cmos5l_nor2_1
X_13140_ _14559_/D _13140_/A _13140_/B VPWR VGND sg13cmos5l_nor2_1
XFILLER_3_723 VPWR VGND sg13cmos5l_fill_2
X_13071_ _13071_/Y _14521_/Q _13071_/B _13071_/C VPWR VGND sg13cmos5l_nand3_1
XFILLER_3_756 VPWR VGND sg13cmos5l_fill_1
X_10283_ _13904_/D fanout57/X _10284_/B _10282_/Y VPWR VGND sg13cmos5l_a21oi_1
X_12022_ _12023_/C _12022_/A _12106_/A VPWR VGND sg13cmos5l_nor2_1
XFILLER_76_64 VPWR VGND sg13cmos5l_fill_1
Xfanout592 _12402_/C1 fanout593/X VPWR VGND sg13cmos5l_buf_1
Xfanout581 _12234_/B _12055_/B VPWR VGND sg13cmos5l_buf_1
Xfanout570 _12203_/A2 _12398_/B1 VPWR VGND sg13cmos5l_buf_1
X_13973_ _13973_/Q clkload16/A _13973_/D _13973_/RESET_B VPWR VGND sg13cmos5l_dfrbpq_1
XFILLER_19_657 VPWR VGND sg13cmos5l_decap_4
XFILLER_46_443 VPWR VGND sg13cmos5l_decap_8
X_12924_ _14449_/D _12924_/A VPWR VGND sg13cmos5l_inv_1
XFILLER_62_925 VPWR VGND sg13cmos5l_fill_2
XFILLER_73_240 VPWR VGND sg13cmos5l_fill_1
XFILLER_74_785 VPWR VGND sg13cmos5l_decap_4
XFILLER_73_284 VPWR VGND sg13cmos5l_fill_2
X_12855_ _12855_/Y _12856_/A _13254_/Q VPWR VGND sg13cmos5l_nor2_1
XFILLER_15_841 VPWR VGND sg13cmos5l_fill_2
X_11806_ _11806_/Y _11802_/Y _11803_/Y _11804_/Y _11805_/Y VPWR VGND sg13cmos5l_a22oi_1
X_12786_ _12787_/A _12783_/B _12785_/Y _12784_/Y VPWR VGND sg13cmos5l_a21oi_1
XFILLER_30_811 VPWR VGND sg13cmos5l_fill_1
X_11737_ _11737_/X _11741_/B _11715_/Y _11736_/Y VPWR VGND sg13cmos5l_a21o_1
X_14525_ _14525_/Q clkload9/A _14525_/D fanout967/X VPWR VGND sg13cmos5l_dfrbpq_1
XFILLER_30_888 VPWR VGND sg13cmos5l_fill_1
X_11668_ _11682_/A _11668_/A _13231_/Q VPWR VGND sg13cmos5l_xnor2_1
X_14456_ _14456_/Q clkload76/A _14456_/D _14456_/RESET_B VPWR VGND sg13cmos5l_dfrbpq_1
X_13371__2051 _13371_/RESET_B VPWR VGND sg13cmos5l_tiehi
X_10619_ _10622_/B _14066_/Q _10621_/C _10621_/D VPWR VGND sg13cmos5l_nand3_1
X_11599_ _11599_/Y _11610_/A _11599_/B _11608_/B VPWR VGND sg13cmos5l_nand3_1
X_14387_ _14387_/Q clkload70/A _14387_/D _14387_/RESET_B VPWR VGND sg13cmos5l_dfrbpq_1
X_13407_ _13407_/Q _13568_/CLK _13407_/D _13407_/RESET_B VPWR VGND sg13cmos5l_dfrbpq_1
X_13338_ _13338_/Q _14117_/CLK _13338_/D _13338_/RESET_B VPWR VGND sg13cmos5l_dfrbpq_1
Xhold3109 _13567_/D _09457_/X VPWR VGND sg13cmos5l_dlygate4sd3_1
X_13269_ _13269_/Q clkload21/A _13269_/D fanout984/X VPWR VGND sg13cmos5l_dfrbpq_1
XFILLER_37_2 VPWR VGND sg13cmos5l_fill_1
Xhold2408 _10835_/A _14182_/Q VPWR VGND sg13cmos5l_dlygate4sd3_1
Xhold2419 _10742_/A _14141_/Q VPWR VGND sg13cmos5l_dlygate4sd3_1
X_13678__1713 _13678_/RESET_B VPWR VGND sg13cmos5l_tiehi
X_07830_ _08815_/A _08479_/B _08491_/C VPWR VGND sg13cmos5l_and2_1
XFILLER_84_538 VPWR VGND sg13cmos5l_decap_4
X_07761_ _08540_/A _08535_/A _08852_/A VPWR VGND sg13cmos5l_nor2_1
X_09500_ _09500_/X _14409_/Q _14628_/Q _09532_/S VPWR VGND sg13cmos5l_mux2_1
XFILLER_65_785 VPWR VGND sg13cmos5l_fill_1
X_07692_ _07693_/B _14385_/Q _14353_/Q VPWR VGND sg13cmos5l_nand2_1
X_14058__1333 _14058_/RESET_B VPWR VGND sg13cmos5l_tiehi
X_13239__1032 _13239_/RESET_B VPWR VGND sg13cmos5l_tiehi
XFILLER_52_413 VPWR VGND sg13cmos5l_decap_4
X_09431_ _09431_/X hold3087/X _13542_/Q _09442_/S VPWR VGND sg13cmos5l_mux2_1
X_09362_ _09362_/X _14116_/Q hold3161/X _09366_/S VPWR VGND sg13cmos5l_mux2_1
X_13581__1841 _13581_/RESET_B VPWR VGND sg13cmos5l_tiehi
XFILLER_61_980 VPWR VGND sg13cmos5l_fill_1
X_08313_ _08313_/Y _08314_/S _13449_/Q _08312_/Y VPWR VGND sg13cmos5l_o21ai_1
XFILLER_21_855 VPWR VGND sg13cmos5l_fill_2
X_09293_ _09293_/Y _09293_/A _09293_/B VPWR VGND sg13cmos5l_nor2_1
X_08244_ _08244_/Y _09219_/A _08307_/B _08244_/C VPWR VGND sg13cmos5l_nand3_1
XFILLER_21_15 VPWR VGND sg13cmos5l_fill_1
X_08175_ _08175_/Y _08199_/A1 _08170_/X _08174_/Y _08187_/B2 VPWR VGND sg13cmos5l_a22oi_1
XFILLER_106_448 VPWR VGND sg13cmos5l_decap_8
XFILLER_106_459 VPWR VGND sg13cmos5l_fill_1
XFILLER_82_1000 VPWR VGND sg13cmos5l_decap_4
X_14462__1033 _14462_/RESET_B VPWR VGND sg13cmos5l_tiehi
XFILLER_0_748 VPWR VGND sg13cmos5l_decap_8
XFILLER_102_643 VPWR VGND sg13cmos5l_fill_2
XFILLER_88_855 VPWR VGND sg13cmos5l_fill_2
Xhold2920 _11126_/A _14299_/Q VPWR VGND sg13cmos5l_dlygate4sd3_1
Xhold2931 _14511_/D _13052_/Y VPWR VGND sg13cmos5l_dlygate4sd3_1
Xhold2942 _09131_/A _13318_/Q VPWR VGND sg13cmos5l_dlygate4sd3_1
Xhold2953 _09125_/A _13317_/Q VPWR VGND sg13cmos5l_dlygate4sd3_1
Xhold2964 _09517_/A _13591_/Q VPWR VGND sg13cmos5l_dlygate4sd3_1
Xhold2975 _09884_/A _13709_/Q VPWR VGND sg13cmos5l_dlygate4sd3_1
X_07959_ _15880_/A _13148_/A _07959_/B _14576_/Q VPWR VGND sg13cmos5l_or3_1
Xhold2986 hold2986/X _13575_/Q VPWR VGND sg13cmos5l_dlygate4sd3_1
Xhold2997 _09758_/A _13648_/Q VPWR VGND sg13cmos5l_dlygate4sd3_1
XFILLER_16_616 VPWR VGND sg13cmos5l_fill_1
XFILLER_29_999 VPWR VGND sg13cmos5l_fill_1
X_10970_ _14225_/D _07898_/B _10829_/S _10969_/Y VPWR VGND sg13cmos5l_a21o_1
X_09629_ _09629_/Y _09629_/A _09682_/B VPWR VGND sg13cmos5l_nor2_1
XFILLER_102_40 VPWR VGND sg13cmos5l_fill_1
X_12640_ _12641_/B _12640_/A _12640_/B VPWR VGND sg13cmos5l_and2_1
XFILLER_70_287 VPWR VGND sg13cmos5l_fill_1
XFILLER_71_788 VPWR VGND sg13cmos5l_fill_1
XFILLER_11_332 VPWR VGND sg13cmos5l_fill_2
Xclkbuf_leaf_50_clk clkload79/A clkload7/A VPWR VGND sg13cmos5l_buf_8
X_14310_ _14310_/Q clkload37/A _14310_/D _14310_/RESET_B VPWR VGND sg13cmos5l_dfrbpq_1
X_12571_ _12571_/X _12583_/A _12571_/B VPWR VGND sg13cmos5l_and2_1
XFILLER_8_815 VPWR VGND sg13cmos5l_fill_1
X_11522_ _11523_/C _11577_/A VPWR VGND sg13cmos5l_inv_1
X_13756__1635 _13756_/RESET_B VPWR VGND sg13cmos5l_tiehi
XFILLER_7_336 VPWR VGND sg13cmos5l_fill_1
X_11453_ _11453_/X _11453_/A _11456_/C _11453_/C _11456_/D VPWR VGND sg13cmos5l_or4_1
X_14241_ _14241_/Q clkload38/A _14241_/D _14241_/RESET_B VPWR VGND sg13cmos5l_dfrbpq_1
X_10404_ _10404_/Y _10404_/A _10412_/B VPWR VGND sg13cmos5l_nor2_1
X_14172_ _14172_/Q _14622_/CLK _14172_/D _14172_/RESET_B VPWR VGND sg13cmos5l_dfrbpq_1
X_13444__1978 _13444_/RESET_B VPWR VGND sg13cmos5l_tiehi
X_11384_ _11384_/Y _11587_/A _11401_/C _12937_/B2 VPWR VGND sg13cmos5l_o21ai_1
X_13123_ _14548_/D _13127_/A _13123_/B VPWR VGND sg13cmos5l_nor2_1
XFILLER_106_971 VPWR VGND sg13cmos5l_decap_8
XFILLER_98_619 VPWR VGND sg13cmos5l_fill_1
X_10335_ _10335_/Y _10335_/A _10345_/B VPWR VGND sg13cmos5l_nor2_1
X_10266_ _10266_/Y _10266_/A _10274_/B VPWR VGND sg13cmos5l_nor2_1
X_13971__1420 _13971_/RESET_B VPWR VGND sg13cmos5l_tiehi
X_13054_ _13054_/Y _15891_/A _13055_/C hold3254/X VPWR VGND sg13cmos5l_a21oi_1
X_12005_ _12008_/A _13698_/Q _12005_/B VPWR VGND sg13cmos5l_nand2_1
XFILLER_66_516 VPWR VGND sg13cmos5l_decap_4
XFILLER_78_376 VPWR VGND sg13cmos5l_fill_1
X_10197_ _10197_/Y _10197_/A _10213_/B VPWR VGND sg13cmos5l_nor2_1
XFILLER_47_730 VPWR VGND sg13cmos5l_fill_2
X_13956_ _13956_/Q _14020_/CLK _13956_/D _13956_/RESET_B VPWR VGND sg13cmos5l_dfrbpq_1
X_13389__2033 _13389_/RESET_B VPWR VGND sg13cmos5l_tiehi
XFILLER_35_947 VPWR VGND sg13cmos5l_fill_2
XFILLER_46_262 VPWR VGND sg13cmos5l_fill_2
X_13887_ _13887_/Q _14045_/CLK _13887_/D _13887_/RESET_B VPWR VGND sg13cmos5l_dfrbpq_1
X_12907_ _12908_/A _14441_/Q _11196_/B _11214_/C _12907_/B2 VPWR VGND sg13cmos5l_a22oi_1
X_14651__2194 _14651_/RESET_B VPWR VGND sg13cmos5l_tiehi
X_12838_ _12839_/B _07167_/Y _07290_/Y _12847_/A VPWR VGND sg13cmos5l_o21ai_1
Xclkbuf_leaf_41_clk clkload65/A clkbuf_4_12_0_clk/X VPWR VGND sg13cmos5l_buf_8
X_12769_ _12769_/X _12783_/A _12769_/B VPWR VGND sg13cmos5l_xor2_1
X_14508_ _15887_/A _14532_/CLK _14508_/D fanout968/X VPWR VGND sg13cmos5l_dfrbpq_1
Xinput20 input20/X uio_in[2] VPWR VGND sg13cmos5l_buf_1
X_14439_ _14439_/Q clkload40/A _14439_/D _14439_/RESET_B VPWR VGND sg13cmos5l_dfrbpq_1
XFILLER_42_0 VPWR VGND sg13cmos5l_fill_2
X_09980_ _13755_/D _10567_/A1 _09979_/B _09979_/Y VPWR VGND sg13cmos5l_o21ai_1
XFILLER_88_129 VPWR VGND sg13cmos5l_fill_2
X_08931_ _13250_/D _07289_/Y _13196_/A2 _13190_/B1 _08930_/Y VPWR VGND sg13cmos5l_a22oi_1
X_08862_ _08863_/D _08862_/A _08869_/B VPWR VGND sg13cmos5l_nand2_1
X_13599__1823 _13599_/RESET_B VPWR VGND sg13cmos5l_tiehi
X_07813_ _08908_/A _14405_/Q _12415_/A VPWR VGND sg13cmos5l_xor2_1
Xhold2238 _14502_/D _13028_/Y VPWR VGND sg13cmos5l_dlygate4sd3_1
Xhold2249 _14160_/D _10800_/Y VPWR VGND sg13cmos5l_dlygate4sd3_1
XFILLER_96_195 VPWR VGND sg13cmos5l_fill_2
X_08793_ _08793_/Y _07343_/Y _08911_/B _08792_/Y VPWR VGND sg13cmos5l_a21oi_1
X_07744_ _07745_/B _14382_/Q _11765_/A VPWR VGND sg13cmos5l_nand2b_1
X_13834__1557 _13834_/RESET_B VPWR VGND sg13cmos5l_tiehi
X_07675_ _07675_/Y _07674_/A _07675_/B VPWR VGND sg13cmos5l_nand2b_1
X_09414_ _13525_/D _09414_/A0 hold3042/X _09421_/S VPWR VGND sg13cmos5l_mux2_1
XFILLER_80_563 VPWR VGND sg13cmos5l_fill_2
XFILLER_12_129 VPWR VGND sg13cmos5l_fill_1
X_09345_ _09345_/X _14099_/Q hold3234/X _09366_/S VPWR VGND sg13cmos5l_mux2_1
Xclkbuf_leaf_32_clk clkload42/A clkload3/A VPWR VGND sg13cmos5l_buf_8
X_09276_ _13400_/D _10685_/A1 hold3219/X _09280_/S VPWR VGND sg13cmos5l_mux2_1
X_08227_ _08227_/Y _08277_/A1 _08227_/A2 _08220_/Y _08222_/Y _08226_/Y VPWR VGND sg13cmos5l_a221oi_1
X_14194__1283 _14194_/RESET_B VPWR VGND sg13cmos5l_tiehi
X_08158_ _08161_/A _13217_/Q _08207_/B1 _08208_/A2 _15891_/A VPWR VGND sg13cmos5l_a22oi_1
X_08089_ _08090_/A _08053_/A _08088_/Y _08058_/B VPWR VGND sg13cmos5l_a21oi_1
X_10120_ _13824_/D _10577_/A1 _10120_/A2 _10119_/Y VPWR VGND sg13cmos5l_o21ai_1
XFILLER_103_941 VPWR VGND sg13cmos5l_fill_1
XFILLER_88_641 VPWR VGND sg13cmos5l_fill_1
X_10051_ _13790_/D _10573_/A1 _10088_/B _10050_/Y VPWR VGND sg13cmos5l_o21ai_1
Xhold3451 hold3451/X _14084_/Q VPWR VGND sg13cmos5l_dlygate4sd3_1
Xhold3440 hold3440/X _14261_/Q VPWR VGND sg13cmos5l_dlygate4sd3_1
Xclkbuf_leaf_99_clk clkload20/A clkbuf_4_2_0_clk/X VPWR VGND sg13cmos5l_buf_8
XFILLER_48_505 VPWR VGND sg13cmos5l_fill_1
XFILLER_76_836 VPWR VGND sg13cmos5l_fill_2
Xhold2750 _10428_/A _13975_/Q VPWR VGND sg13cmos5l_dlygate4sd3_1
Xhold3495 hold3495/X _14200_/Q VPWR VGND sg13cmos5l_dlygate4sd3_1
Xhold3484 hold3484/X _14562_/Q VPWR VGND sg13cmos5l_dlygate4sd3_1
Xhold3473 _07457_/A _14247_/Q VPWR VGND sg13cmos5l_dlygate4sd3_1
Xhold3462 _07180_/A _14229_/Q VPWR VGND sg13cmos5l_dlygate4sd3_1
XFILLER_29_730 VPWR VGND sg13cmos5l_fill_2
Xhold2761 _09680_/A _13615_/Q VPWR VGND sg13cmos5l_dlygate4sd3_1
Xhold2772 _09524_/A _13592_/Q VPWR VGND sg13cmos5l_dlygate4sd3_1
Xhold2783 _10396_/A _13960_/Q VPWR VGND sg13cmos5l_dlygate4sd3_1
X_14398__1110 _14398_/RESET_B VPWR VGND sg13cmos5l_tiehi
Xhold2794 _09722_/A _13630_/Q VPWR VGND sg13cmos5l_dlygate4sd3_1
X_13810_ _13810_/Q clkload54/A _13810_/D _13810_/RESET_B VPWR VGND sg13cmos5l_dfrbpq_1
XFILLER_84_880 VPWR VGND sg13cmos5l_fill_2
XFILLER_84_891 VPWR VGND sg13cmos5l_decap_4
X_10953_ _14219_/D _10848_/Y _10873_/Y _10952_/Y VPWR VGND sg13cmos5l_o21ai_1
X_13741_ _13741_/Q clkload55/A _13741_/D _13741_/RESET_B VPWR VGND sg13cmos5l_dfrbpq_1
XFILLER_73_87 VPWR VGND sg13cmos5l_fill_1
XFILLER_73_98 VPWR VGND sg13cmos5l_fill_2
X_10884_ _10885_/D _14244_/Q _14243_/Q VPWR VGND sg13cmos5l_nand2_1
X_13672_ _13672_/Q _14065_/CLK _13672_/D _13672_/RESET_B VPWR VGND sg13cmos5l_dfrbpq_1
XFILLER_24_490 VPWR VGND sg13cmos5l_fill_2
Xclkbuf_leaf_23_clk clkload29/A clkbuf_4_4_0_clk/X VPWR VGND sg13cmos5l_buf_8
X_14321__1187 _14321_/RESET_B VPWR VGND sg13cmos5l_tiehi
X_13989__1402 _13989_/RESET_B VPWR VGND sg13cmos5l_tiehi
X_12623_ _12623_/Y _11164_/X _12621_/X _12622_/X _11156_/Y VPWR VGND sg13cmos5l_a22oi_1
X_12554_ _12554_/Y _13032_/C _12639_/C _12641_/A _12553_/Y VPWR VGND sg13cmos5l_a22oi_1
XFILLER_8_656 VPWR VGND sg13cmos5l_decap_4
X_11505_ _11505_/Y _11556_/A _11505_/B VPWR VGND sg13cmos5l_nor2_1
XFILLER_11_184 VPWR VGND sg13cmos5l_fill_1
XFILLER_8_689 VPWR VGND sg13cmos5l_fill_2
X_14224_ _14224_/Q clkload44/A _14224_/D _14224_/RESET_B VPWR VGND sg13cmos5l_dfrbpq_1
X_12485_ _12486_/B _12485_/A _12485_/B VPWR VGND sg13cmos5l_nand2_1
X_11436_ _11436_/Y _11436_/A _11436_/B VPWR VGND sg13cmos5l_nand2_1
X_11367_ _11380_/A _11401_/A _11401_/B VPWR VGND sg13cmos5l_and2_1
X_14155_ _14155_/Q clkload26/A _14155_/D fanout987/X VPWR VGND sg13cmos5l_dfrbpq_1
X_13912__1479 _13912_/RESET_B VPWR VGND sg13cmos5l_tiehi
X_10318_ _13921_/D _10514_/A1 _10343_/B _10317_/Y VPWR VGND sg13cmos5l_a21oi_1
X_14086_ _14086_/Q clkload72/A _14086_/D _14086_/RESET_B VPWR VGND sg13cmos5l_dfrbpq_1
X_13106_ _13106_/Y _14536_/Q _13107_/C hold2604/X VPWR VGND sg13cmos5l_a21oi_1
XFILLER_98_449 VPWR VGND sg13cmos5l_decap_4
X_11298_ _11300_/C _11298_/A _11298_/B VPWR VGND sg13cmos5l_nor2_1
X_13037_ _14504_/D _13037_/A VPWR VGND sg13cmos5l_inv_1
XFILLER_67_825 VPWR VGND sg13cmos5l_decap_8
X_10249_ _13887_/D _10379_/A1 _10248_/B _10248_/Y VPWR VGND sg13cmos5l_a21oi_1
XFILLER_67_858 VPWR VGND sg13cmos5l_decap_4
XFILLER_93_154 VPWR VGND sg13cmos5l_fill_2
XFILLER_47_571 VPWR VGND sg13cmos5l_fill_1
XFILLER_75_880 VPWR VGND sg13cmos5l_decap_4
XFILLER_62_541 VPWR VGND sg13cmos5l_fill_2
X_13939_ _13939_/Q clkload18/A _13939_/D _13939_/RESET_B VPWR VGND sg13cmos5l_dfrbpq_1
X_07460_ _07461_/A _13555_/Q _13523_/Q _13491_/Q _13459_/Q _08164_/S0 _08254_/A1 VPWR
+ VGND sg13cmos5l_mux4_1
X_07391_ _07391_/X _07391_/A _07391_/B _07391_/C VPWR VGND sg13cmos5l_or3_1
X_09130_ _09130_/Y _14362_/Q _09135_/B1 _09129_/Y VPWR VGND sg13cmos5l_a21oi_1
Xclkbuf_leaf_14_clk _14621_/CLK clkbuf_4_6_0_clk/X VPWR VGND sg13cmos5l_buf_8
X_09061_ _13306_/D _09077_/B _09059_/Y _09060_/Y VPWR VGND sg13cmos5l_a21oi_1
X_13507__1915 _13507_/RESET_B VPWR VGND sg13cmos5l_tiehi
X_08012_ _08037_/B _08984_/A _13276_/Q _08062_/S VPWR VGND sg13cmos5l_mux2_1
X_09963_ _09963_/Y _09963_/A _09979_/B VPWR VGND sg13cmos5l_nand2_1
X_08914_ _08914_/Y _14181_/Q _08914_/B VPWR VGND sg13cmos5l_nand2b_1
X_09894_ _10090_/B _14234_/Q _09895_/B VPWR VGND sg13cmos5l_nor2_1
X_08845_ _08846_/A _08529_/B _08867_/B _08869_/B hold3406/X _08844_/Y VPWR VGND sg13cmos5l_a221oi_1
XFILLER_85_655 VPWR VGND sg13cmos5l_fill_2
X_08776_ _08776_/Y _08782_/A1 _07337_/Y _08775_/Y VPWR VGND sg13cmos5l_o21ai_1
XFILLER_57_379 VPWR VGND sg13cmos5l_fill_1
X_07727_ _08450_/B _11636_/A _14374_/Q VPWR VGND sg13cmos5l_nor2b_1
XFILLER_25_210 VPWR VGND sg13cmos5l_fill_2
XFILLER_81_850 VPWR VGND sg13cmos5l_fill_2
XFILLER_14_917 VPWR VGND sg13cmos5l_fill_1
X_07658_ _08558_/A _14394_/Q _14362_/Q VPWR VGND sg13cmos5l_or2_1
XFILLER_80_382 VPWR VGND sg13cmos5l_fill_1
X_07589_ _07590_/D _07409_/B _08979_/B _07584_/Y _08974_/B _07588_/Y VPWR VGND sg13cmos5l_a221oi_1
Xclkbuf_4_8_0_clk clkbuf_4_8_0_clk/X clkbuf_0_clk/X VPWR VGND sg13cmos5l_buf_8
X_09328_ _13444_/D _09219_/A hold3333/X _09333_/S VPWR VGND sg13cmos5l_mux2_1
X_09259_ _13384_/D _09295_/A hold3124/X _09268_/S VPWR VGND sg13cmos5l_mux2_1
X_12270_ _12270_/Y _12270_/A _12270_/B _12270_/C VPWR VGND sg13cmos5l_nand3_1
X_14306__1202 _14306_/RESET_B VPWR VGND sg13cmos5l_tiehi
X_11221_ _11222_/B _11234_/A _11221_/B VPWR VGND sg13cmos5l_nand2_1
XFILLER_1_810 VPWR VGND sg13cmos5l_fill_2
X_11152_ _12735_/C _11152_/A _11161_/C VPWR VGND sg13cmos5l_and2_1
X_14650__2193 _14650_/RESET_B VPWR VGND sg13cmos5l_tiehi
X_10103_ _10103_/Y _10103_/A _10107_/B VPWR VGND sg13cmos5l_nand2_1
XFILLER_76_600 VPWR VGND sg13cmos5l_fill_2
XFILLER_88_460 VPWR VGND sg13cmos5l_fill_2
XFILLER_89_961 VPWR VGND sg13cmos5l_fill_2
X_11083_ _11083_/X _14380_/Q _11083_/B VPWR VGND sg13cmos5l_and2_1
X_10034_ _10034_/Y _10034_/A _10034_/B VPWR VGND sg13cmos5l_nand2_1
Xhold3292 hold3292/X _13564_/Q VPWR VGND sg13cmos5l_dlygate4sd3_1
Xhold3281 hold3281/X _13341_/Q VPWR VGND sg13cmos5l_dlygate4sd3_1
Xhold3270 hold3270/X _13379_/Q VPWR VGND sg13cmos5l_dlygate4sd3_1
X_15891_ _15891_/X _15891_/A VPWR VGND sg13cmos5l_buf_1
X_14339__1169 _14339_/RESET_B VPWR VGND sg13cmos5l_tiehi
Xhold2580 _10554_/A _14037_/Q VPWR VGND sg13cmos5l_dlygate4sd3_1
Xhold2591 _09724_/A _13631_/Q VPWR VGND sg13cmos5l_dlygate4sd3_1
XFILLER_57_880 VPWR VGND sg13cmos5l_decap_8
XFILLER_56_390 VPWR VGND sg13cmos5l_decap_8
XFILLER_84_97 VPWR VGND sg13cmos5l_fill_1
X_11985_ _11985_/Y _11848_/A _11874_/Y _11983_/B _11823_/Y VPWR VGND sg13cmos5l_a22oi_1
XFILLER_72_883 VPWR VGND sg13cmos5l_decap_8
X_10936_ _10937_/A _10943_/B _10946_/C VPWR VGND sg13cmos5l_or2_1
X_13724_ _13724_/Q clkload47/A _13724_/D _13724_/RESET_B VPWR VGND sg13cmos5l_dfrbpq_1
XFILLER_16_287 VPWR VGND sg13cmos5l_fill_1
X_10867_ _10880_/B _14255_/Q _14254_/Q VPWR VGND sg13cmos5l_nor2b_1
X_13655_ _13655_/Q _14299_/CLK _13655_/D _13655_/RESET_B VPWR VGND sg13cmos5l_dfrbpq_1
XFILLER_32_769 VPWR VGND sg13cmos5l_fill_2
X_12606_ _12607_/D _12603_/X _12604_/Y _12605_/Y VPWR VGND sg13cmos5l_a21o_1
X_10798_ _10798_/Y _10798_/A _11141_/A VPWR VGND sg13cmos5l_nand2_1
X_13586_ _13586_/Q clkload53/A _13586_/D _13586_/RESET_B VPWR VGND sg13cmos5l_dfrbpq_1
XFILLER_76_6 VPWR VGND sg13cmos5l_fill_1
XFILLER_9_987 VPWR VGND sg13cmos5l_fill_2
X_12537_ _14402_/D _12537_/A _12537_/B VPWR VGND sg13cmos5l_nand2_1
X_12468_ _12468_/Y _12468_/A _12468_/B VPWR VGND sg13cmos5l_nand2_1
X_11419_ _14328_/D _11417_/Y _11418_/Y _11407_/Y VPWR VGND sg13cmos5l_o21ai_1
X_14207_ _14207_/Q _14217_/CLK _14207_/D _14207_/RESET_B VPWR VGND sg13cmos5l_dfrbpq_1
X_14138_ _14138_/Q _14577_/CLK _14138_/D fanout989/X VPWR VGND sg13cmos5l_dfrbpq_1
X_12399_ _12400_/C _13616_/Q _12399_/A2 _12174_/B _13872_/Q VPWR VGND sg13cmos5l_a22oi_1
Xclkbuf_leaf_3_clk clkload10/A clkbuf_4_0_0_clk/X VPWR VGND sg13cmos5l_buf_8
X_14069_ _14069_/Q clkload9/A _14069_/D fanout960/X VPWR VGND sg13cmos5l_dfrbpq_1
XFILLER_95_931 VPWR VGND sg13cmos5l_fill_1
XFILLER_67_677 VPWR VGND sg13cmos5l_decap_8
X_08630_ _08630_/Y _14192_/Q _14187_/Q _08630_/C VPWR VGND sg13cmos5l_nor3_1
XFILLER_94_496 VPWR VGND sg13cmos5l_fill_1
XFILLER_63_850 VPWR VGND sg13cmos5l_decap_4
X_08561_ _14603_/D _08562_/B _08561_/B VPWR VGND sg13cmos5l_xor2_1
XFILLER_62_360 VPWR VGND sg13cmos5l_decap_8
X_07512_ _07515_/B _14525_/Q _07512_/B VPWR VGND sg13cmos5l_nand2_1
X_08492_ _08504_/A _08492_/A _08492_/B VPWR VGND sg13cmos5l_nor2_1
X_13751__1640 _13751_/RESET_B VPWR VGND sg13cmos5l_tiehi
XFILLER_63_894 VPWR VGND sg13cmos5l_fill_2
X_07443_ _14248_/D _14248_/Q _13034_/A _07533_/S VPWR VGND sg13cmos5l_mux2_1
XFILLER_50_588 VPWR VGND sg13cmos5l_decap_8
X_07374_ _07374_/Y _08974_/A _14541_/Q VPWR VGND sg13cmos5l_xnor2_1
X_09113_ _09113_/Y _09113_/A _09125_/B VPWR VGND sg13cmos5l_nor2_1
X_09044_ _11222_/A _14316_/Q _09073_/B VPWR VGND sg13cmos5l_nand2_1
X_14249__1796 _14249_/RESET_B VPWR VGND sg13cmos5l_tiehi
XFILLER_78_909 VPWR VGND sg13cmos5l_decap_8
Xfanout900 _08206_/A _14114_/Q VPWR VGND sg13cmos5l_buf_1
X_09946_ _09946_/Y _09946_/A _09958_/B VPWR VGND sg13cmos5l_nor2_1
Xfanout911 _10683_/A1 _14103_/Q VPWR VGND sg13cmos5l_buf_1
Xfanout922 _12735_/A _12637_/A VPWR VGND sg13cmos5l_buf_1
Xfanout933 _09048_/A _13304_/Q VPWR VGND sg13cmos5l_buf_1
Xfanout944 _08785_/B2 _13258_/Q VPWR VGND sg13cmos5l_buf_1
Xfanout955 _13140_/A _13146_/A VPWR VGND sg13cmos5l_buf_1
Xfanout966 fanout966/X fanout967/X VPWR VGND sg13cmos5l_buf_1
Xfanout977 fanout977/X fanout980/X VPWR VGND sg13cmos5l_buf_1
X_09877_ _13705_/D _10399_/A1 _09886_/B _09876_/Y VPWR VGND sg13cmos5l_a21oi_1
Xfanout988 fanout988/X fanout994/X VPWR VGND sg13cmos5l_buf_1
Xfanout999 _08000_/A _11011_/A VPWR VGND sg13cmos5l_buf_1
XFILLER_46_839 VPWR VGND sg13cmos5l_fill_2
X_08828_ _08828_/Y _08498_/B _08839_/B _08831_/B1 _08497_/A VPWR VGND sg13cmos5l_a22oi_1
XFILLER_45_338 VPWR VGND sg13cmos5l_fill_1
XFILLER_73_658 VPWR VGND sg13cmos5l_fill_2
X_08759_ _08759_/Y _13148_/A _14149_/Q _14133_/Q _14576_/Q VPWR VGND sg13cmos5l_a22oi_1
XFILLER_54_34 VPWR VGND sg13cmos5l_fill_1
X_11770_ _11770_/Y _13722_/Q _11785_/B VPWR VGND sg13cmos5l_nand2_1
XFILLER_26_585 VPWR VGND sg13cmos5l_fill_2
XFILLER_26_596 VPWR VGND sg13cmos5l_fill_2
XFILLER_54_894 VPWR VGND sg13cmos5l_fill_2
X_10721_ _10721_/Y _10721_/A _10802_/B VPWR VGND sg13cmos5l_nand2_1
X_13440_ _13440_/Q _13568_/CLK _13440_/D _13440_/RESET_B VPWR VGND sg13cmos5l_dfrbpq_1
XFILLER_13_268 VPWR VGND sg13cmos5l_fill_2
X_10652_ _10659_/S _10652_/A _10652_/B _10652_/C VPWR VGND sg13cmos5l_nand3_1
XFILLER_103_1014 VPWR VGND sg13cmos5l_decap_8
X_10583_ _14051_/D _10583_/A1 _10582_/B _10582_/Y VPWR VGND sg13cmos5l_o21ai_1
X_13371_ _13371_/Q _14109_/CLK _13371_/D _13371_/RESET_B VPWR VGND sg13cmos5l_dfrbpq_1
X_13614__1777 _13614_/RESET_B VPWR VGND sg13cmos5l_tiehi
X_12322_ _12531_/B _12322_/A1 _12314_/Y _12320_/Y _12321_/Y VPWR VGND sg13cmos5l_a22oi_1
XFILLER_6_979 VPWR VGND sg13cmos5l_fill_2
X_12253_ _12330_/B _14367_/Q _13252_/Q VPWR VGND sg13cmos5l_xor2_1
X_11204_ _11204_/Y _11211_/B _11202_/X _11203_/X _11536_/A _08913_/A VPWR VGND sg13cmos5l_a221oi_1
X_12184_ _12185_/A _14364_/Q _12251_/A _12165_/Y _12183_/Y VPWR VGND sg13cmos5l_a22oi_1
XFILLER_49_600 VPWR VGND sg13cmos5l_fill_2
XFILLER_68_419 VPWR VGND sg13cmos5l_fill_2
X_11135_ _11135_/Y _11135_/A _11135_/B VPWR VGND sg13cmos5l_nor2_1
XFILLER_0_150 VPWR VGND sg13cmos5l_decap_8
X_11066_ _14284_/D _11144_/B _11064_/Y _11065_/Y VPWR VGND sg13cmos5l_a21oi_1
XFILLER_92_901 VPWR VGND sg13cmos5l_fill_2
X_10017_ _10017_/Y _10017_/A _10017_/B VPWR VGND sg13cmos5l_nand2_1
XFILLER_49_677 VPWR VGND sg13cmos5l_fill_1
XFILLER_48_187 VPWR VGND sg13cmos5l_fill_2
XFILLER_64_647 VPWR VGND sg13cmos5l_decap_4
XFILLER_91_455 VPWR VGND sg13cmos5l_fill_2
XFILLER_92_956 VPWR VGND sg13cmos5l_decap_8
XFILLER_60_842 VPWR VGND sg13cmos5l_decap_8
X_11968_ _11968_/Y _11965_/Y _11967_/Y _12012_/A1 VPWR VGND sg13cmos5l_a21oi_1
X_13707_ _13707_/Q _14028_/CLK _13707_/D _13707_/RESET_B VPWR VGND sg13cmos5l_dfrbpq_1
X_10919_ _14205_/D _10818_/Y _10922_/B _10918_/Y VPWR VGND sg13cmos5l_o21ai_1
X_11899_ _11903_/B _14355_/Q _13240_/Q VPWR VGND sg13cmos5l_xnor2_1
X_13638_ _13638_/Q clkload64/A _13638_/D _13638_/RESET_B VPWR VGND sg13cmos5l_dfrbpq_1
X_13569_ _13569_/Q clkload31/A _13569_/D _13569_/RESET_B VPWR VGND sg13cmos5l_dfrbpq_1
XFILLER_99_500 VPWR VGND sg13cmos5l_fill_1
XFILLER_99_544 VPWR VGND sg13cmos5l_fill_1
X_07992_ _07992_/X _13440_/Q _13408_/Q _13376_/Q _13344_/Q _08378_/A1 _07194_/A VPWR
+ VGND sg13cmos5l_mux4_1
X_09800_ _13667_/D _10453_/A1 _09821_/B _09799_/Y VPWR VGND sg13cmos5l_a21oi_1
Xfanout229 _10007_/B _10021_/B VPWR VGND sg13cmos5l_buf_1
Xfanout218 _10082_/B fanout222/X VPWR VGND sg13cmos5l_buf_1
Xfanout207 _10147_/B _10146_/A2 VPWR VGND sg13cmos5l_buf_1
X_13769__1622 _13769_/RESET_B VPWR VGND sg13cmos5l_tiehi
XFILLER_101_516 VPWR VGND sg13cmos5l_fill_1
XFILLER_99_599 VPWR VGND sg13cmos5l_fill_2
X_09731_ _13634_/D _10385_/A1 _09730_/B _09730_/Y VPWR VGND sg13cmos5l_a21oi_1
X_13457__1965 _13457_/RESET_B VPWR VGND sg13cmos5l_tiehi
X_14280__1228 _14280_/RESET_B VPWR VGND sg13cmos5l_tiehi
XFILLER_83_912 VPWR VGND sg13cmos5l_decap_4
X_09662_ _11542_/B _14433_/Q _14652_/Q _09662_/S VPWR VGND sg13cmos5l_mux2_1
X_08613_ _14610_/D _08619_/B _08613_/B VPWR VGND sg13cmos5l_xnor2_1
X_09593_ _13602_/D _09587_/B _10581_/A1 _09587_/Y VPWR VGND sg13cmos5l_a21oi_1
X_08544_ _14600_/D _08582_/B _08544_/B VPWR VGND sg13cmos5l_xor2_1
XFILLER_23_533 VPWR VGND sg13cmos5l_decap_4
XFILLER_51_820 VPWR VGND sg13cmos5l_fill_1
XFILLER_23_555 VPWR VGND sg13cmos5l_fill_1
XFILLER_51_853 VPWR VGND sg13cmos5l_fill_2
X_08475_ _08475_/X _08479_/A _08479_/C VPWR VGND sg13cmos5l_and2_1
XFILLER_23_577 VPWR VGND sg13cmos5l_fill_1
X_07426_ _07426_/Y _07426_/A VPWR VGND sg13cmos5l_inv_1
X_07357_ _07406_/A _07574_/A VPWR VGND sg13cmos5l_inv_1
X_07288_ _07288_/Y _13737_/Q VPWR VGND sg13cmos5l_inv_1
X_09027_ _13295_/D _09030_/B _08980_/B _09026_/Y VPWR VGND sg13cmos5l_o21ai_1
X_13325__2097 _13325_/RESET_B VPWR VGND sg13cmos5l_tiehi
XFILLER_49_34 VPWR VGND sg13cmos5l_fill_2
XFILLER_59_942 VPWR VGND sg13cmos5l_fill_1
Xfanout741 _08964_/B _07369_/Y VPWR VGND sg13cmos5l_buf_1
Xfanout730 _08908_/B _08904_/B VPWR VGND sg13cmos5l_buf_1
XFILLER_58_441 VPWR VGND sg13cmos5l_fill_2
X_09929_ _13730_/D _10581_/A1 _09942_/B _09928_/Y VPWR VGND sg13cmos5l_a21oi_1
Xfanout785 _07524_/S0 fanout804/X VPWR VGND sg13cmos5l_buf_1
Xfanout774 _07522_/S1 _08200_/S1 VPWR VGND sg13cmos5l_buf_1
Xfanout763 _10759_/A _10804_/A VPWR VGND sg13cmos5l_buf_1
Xfanout752 _08913_/A _07255_/Y VPWR VGND sg13cmos5l_buf_1
XFILLER_58_485 VPWR VGND sg13cmos5l_fill_1
XFILLER_59_986 VPWR VGND sg13cmos5l_fill_1
XFILLER_92_208 VPWR VGND sg13cmos5l_fill_1
Xfanout796 _08275_/S _08361_/B VPWR VGND sg13cmos5l_buf_1
X_12940_ _14457_/D _12940_/A VPWR VGND sg13cmos5l_inv_1
XFILLER_46_647 VPWR VGND sg13cmos5l_decap_8
XFILLER_46_658 VPWR VGND sg13cmos5l_fill_2
XFILLER_74_956 VPWR VGND sg13cmos5l_fill_1
X_12871_ _12871_/X _12871_/A _12871_/B VPWR VGND sg13cmos5l_xor2_1
XFILLER_61_617 VPWR VGND sg13cmos5l_decap_8
X_11822_ _11982_/A _14352_/Q _13237_/Q VPWR VGND sg13cmos5l_xnor2_1
X_14610_ _14610_/Q _14654_/CLK _14610_/D _14610_/RESET_B VPWR VGND sg13cmos5l_dfrbpq_1
X_13502__1920 _13502_/RESET_B VPWR VGND sg13cmos5l_tiehi
XFILLER_60_127 VPWR VGND sg13cmos5l_fill_2
XFILLER_42_875 VPWR VGND sg13cmos5l_fill_1
X_11753_ _11753_/X _14009_/Q _13977_/Q _11753_/S VPWR VGND sg13cmos5l_mux2_1
X_14541_ _14541_/Q clkload11/A _14541_/D fanout963/X VPWR VGND sg13cmos5l_dfrbpq_1
X_10704_ _14124_/D input17/X hold3545/X _10710_/S VPWR VGND sg13cmos5l_mux2_1
X_11684_ _11684_/Y _11679_/X _11681_/Y _11683_/Y VPWR VGND sg13cmos5l_o21ai_1
X_14472_ _14472_/Q clkload8/A _14472_/D fanout962/X VPWR VGND sg13cmos5l_dfrbpq_1
X_10635_ _10638_/C _14072_/Q _14073_/Q _14074_/Q _10635_/D VPWR VGND sg13cmos5l_and4_1
X_13847__1544 _13847_/RESET_B VPWR VGND sg13cmos5l_tiehi
X_13423_ _13423_/Q clkload33/A _13423_/D _13423_/RESET_B VPWR VGND sg13cmos5l_dfrbpq_1
XFILLER_6_710 VPWR VGND sg13cmos5l_fill_1
X_13535__1887 _13535_/RESET_B VPWR VGND sg13cmos5l_tiehi
X_13354_ _13354_/Q clkload35/A _13354_/D _13354_/RESET_B VPWR VGND sg13cmos5l_dfrbpq_1
X_10566_ _10566_/Y _10566_/A _10566_/B VPWR VGND sg13cmos5l_nand2_1
X_12305_ _14368_/D _07216_/Y _12385_/A _12286_/Y _12304_/Y VPWR VGND sg13cmos5l_a22oi_1
X_10497_ _10497_/Y _10497_/A _10497_/B VPWR VGND sg13cmos5l_nand2_1
X_13285_ _13285_/Q clkload20/A _13285_/D fanout986/X VPWR VGND sg13cmos5l_dfrbpq_1
X_12236_ _12236_/Y _13610_/Q _12234_/B _12236_/B1 VPWR VGND sg13cmos5l_a21oi_1
X_12167_ _12169_/B _13896_/Q _12174_/B VPWR VGND sg13cmos5l_nand2_1
XFILLER_2_993 VPWR VGND sg13cmos5l_fill_2
X_11118_ _11118_/Y _14396_/Q _11121_/B _11117_/Y VPWR VGND sg13cmos5l_a21oi_1
XFILLER_65_901 VPWR VGND sg13cmos5l_fill_1
XFILLER_96_569 VPWR VGND sg13cmos5l_decap_4
X_12098_ _12098_/Y _12127_/A _12098_/B VPWR VGND sg13cmos5l_nor2_1
X_11049_ _11049_/Y _11049_/A _11147_/B VPWR VGND sg13cmos5l_nor2_1
Xinput7 input7/X ui_in[14] VPWR VGND sg13cmos5l_buf_1
XFILLER_92_731 VPWR VGND sg13cmos5l_fill_2
X_14248__1795 _14248_/RESET_B VPWR VGND sg13cmos5l_tiehi
XFILLER_25_809 VPWR VGND sg13cmos5l_fill_1
XFILLER_80_904 VPWR VGND sg13cmos5l_fill_1
XFILLER_64_499 VPWR VGND sg13cmos5l_fill_1
X_08260_ _08260_/Y _08275_/S _13381_/Q _08259_/Y VPWR VGND sg13cmos5l_o21ai_1
X_07211_ _12417_/A _14372_/Q VPWR VGND sg13cmos5l_inv_1
X_08191_ _08191_/Y _08202_/A _08188_/X _08190_/Y VPWR VGND sg13cmos5l_a21oi_1
XFILLER_72_0 VPWR VGND sg13cmos5l_fill_1
Xheichips26_loopcache_rv_2219 uio_oe[7] VPWR VGND sg13cmos5l_tiehi
XFILLER_106_619 VPWR VGND sg13cmos5l_decap_8
X_14334__1174 _14334_/RESET_B VPWR VGND sg13cmos5l_tiehi
X_13228__1049 _13228_/RESET_B VPWR VGND sg13cmos5l_tiehi
X_07975_ _07977_/B _14536_/Q _11039_/A2 _11039_/B1 _14500_/Q VPWR VGND sg13cmos5l_a22oi_1
XFILLER_56_912 VPWR VGND sg13cmos5l_fill_1
XFILLER_68_783 VPWR VGND sg13cmos5l_fill_1
X_09714_ _09714_/Y _09714_/A _09714_/B VPWR VGND sg13cmos5l_nor2_1
XFILLER_28_636 VPWR VGND sg13cmos5l_fill_1
XFILLER_83_742 VPWR VGND sg13cmos5l_decap_8
XFILLER_83_753 VPWR VGND sg13cmos5l_fill_1
X_09645_ _09645_/Y _14461_/Q _09650_/C VPWR VGND sg13cmos5l_nand2_1
X_13925__1466 _13925_/RESET_B VPWR VGND sg13cmos5l_tiehi
XFILLER_43_628 VPWR VGND sg13cmos5l_decap_8
X_09576_ _09576_/Y _09575_/A _09569_/Y _09571_/A VPWR VGND sg13cmos5l_a21oi_1
X_08527_ _14597_/D _08847_/A _08527_/B VPWR VGND sg13cmos5l_xnor2_1
X_08458_ _08458_/Y _08471_/A _08458_/B VPWR VGND sg13cmos5l_nand2_1
X_07409_ _07413_/A _07595_/A _07409_/B VPWR VGND sg13cmos5l_or2_1
X_08389_ _08389_/Y _08388_/A _08387_/X _08388_/Y VPWR VGND sg13cmos5l_a21oi_1
X_10420_ _10420_/Y _10420_/A _10432_/B VPWR VGND sg13cmos5l_nor2_1
XFILLER_100_1028 VPWR VGND sg13cmos5l_fill_1
X_10351_ _10351_/Y _10351_/A _10351_/B _10351_/C VPWR VGND sg13cmos5l_nor3_1
X_10282_ _10282_/Y _10282_/A _10284_/B VPWR VGND sg13cmos5l_nor2_1
X_13070_ _13075_/A _13070_/A _13070_/B VPWR VGND sg13cmos5l_nor2_1
X_12021_ _12024_/A _12022_/A _12021_/B _12106_/A VPWR VGND sg13cmos5l_nand3_1
XFILLER_105_696 VPWR VGND sg13cmos5l_decap_8
Xfanout560 _08687_/A _11695_/B VPWR VGND sg13cmos5l_buf_1
XFILLER_19_614 VPWR VGND sg13cmos5l_decap_4
Xfanout593 fanout593/X _08643_/Y VPWR VGND sg13cmos5l_buf_1
Xfanout582 _12055_/B _12057_/B VPWR VGND sg13cmos5l_buf_1
Xfanout571 _12297_/C1 _12427_/B1 VPWR VGND sg13cmos5l_buf_1
X_13972_ _13972_/Q clkload17/A _13972_/D _13972_/RESET_B VPWR VGND sg13cmos5l_dfrbpq_1
XFILLER_47_945 VPWR VGND sg13cmos5l_fill_2
XFILLER_74_731 VPWR VGND sg13cmos5l_fill_2
X_12923_ _12924_/A hold3543/X _11262_/B _11311_/B _12923_/B2 VPWR VGND sg13cmos5l_a22oi_1
XFILLER_18_168 VPWR VGND sg13cmos5l_fill_1
XFILLER_62_959 VPWR VGND sg13cmos5l_decap_8
X_12854_ _12854_/Y _12856_/A _13254_/Q VPWR VGND sg13cmos5l_nand2_1
X_11805_ _11805_/Y _13755_/Q _11805_/A2 _08725_/B _13819_/Q VPWR VGND sg13cmos5l_a22oi_1
X_14412__1096 _14412_/RESET_B VPWR VGND sg13cmos5l_tiehi
X_12785_ _12785_/Y _12785_/A _12785_/B VPWR VGND sg13cmos5l_nand2_1
X_11736_ _11736_/Y _11793_/A1 _12449_/B _11735_/Y VPWR VGND sg13cmos5l_o21ai_1
X_14524_ _14524_/Q clkload9/A _14524_/D fanout961/X VPWR VGND sg13cmos5l_dfrbpq_1
X_11667_ _11667_/Y _11668_/A _13231_/Q VPWR VGND sg13cmos5l_nand2_1
X_14455_ _14455_/Q clkload77/A _14455_/D _14455_/RESET_B VPWR VGND sg13cmos5l_dfrbpq_1
X_10618_ _10620_/A _10621_/C _10621_/D hold3233/X VPWR VGND sg13cmos5l_a21oi_1
X_11598_ _11608_/B _11598_/A _11598_/B VPWR VGND sg13cmos5l_xnor2_1
X_14386_ _14386_/Q clkload69/A _14386_/D _14386_/RESET_B VPWR VGND sg13cmos5l_dfrbpq_1
X_13406_ _13406_/Q clkload32/A _13406_/D _13406_/RESET_B VPWR VGND sg13cmos5l_dfrbpq_1
X_10549_ _14034_/D _10549_/A1 _10564_/B _10548_/Y VPWR VGND sg13cmos5l_o21ai_1
X_13337_ _13337_/Q _14621_/CLK _13337_/D _13337_/RESET_B VPWR VGND sg13cmos5l_dfrbpq_1
XFILLER_6_573 VPWR VGND sg13cmos5l_fill_2
X_13268_ _13268_/Q clkload18/A _13268_/D fanout986/X VPWR VGND sg13cmos5l_dfrbpq_1
XFILLER_69_503 VPWR VGND sg13cmos5l_fill_2
X_12219_ _12219_/Y _07656_/B _07289_/Y _12218_/Y VPWR VGND sg13cmos5l_a21oi_1
Xhold2409 _10787_/A _14156_/Q VPWR VGND sg13cmos5l_dlygate4sd3_1
X_13199_ _13199_/Q clkload13/A _13199_/D fanout957/X VPWR VGND sg13cmos5l_dfrbpq_1
XFILLER_69_547 VPWR VGND sg13cmos5l_decap_4
XFILLER_97_867 VPWR VGND sg13cmos5l_fill_1
X_07760_ _08852_/A _14390_/Q _14358_/Q VPWR VGND sg13cmos5l_and2_1
XFILLER_96_399 VPWR VGND sg13cmos5l_fill_1
XFILLER_25_606 VPWR VGND sg13cmos5l_fill_2
X_07691_ _07691_/Y _07691_/A _11846_/A VPWR VGND sg13cmos5l_nor2_1
X_09430_ _09430_/X _14118_/Q hold3056/X _09442_/S VPWR VGND sg13cmos5l_mux2_1
XFILLER_80_723 VPWR VGND sg13cmos5l_decap_8
XFILLER_80_745 VPWR VGND sg13cmos5l_fill_1
X_09361_ _13474_/D _09286_/A hold3071/X _09376_/S VPWR VGND sg13cmos5l_mux2_1
XFILLER_33_661 VPWR VGND sg13cmos5l_fill_1
X_08312_ _08312_/Y _13417_/Q _08314_/S VPWR VGND sg13cmos5l_nand2b_1
X_09292_ _13414_/D _08269_/A hold3098/X _09306_/S VPWR VGND sg13cmos5l_mux2_1
X_08243_ _14259_/D _08281_/B _12562_/A _08231_/Y VPWR VGND sg13cmos5l_o21ai_1
X_08174_ _08174_/Y _08174_/A _08174_/B _08174_/C VPWR VGND sg13cmos5l_nand3_1
XFILLER_0_716 VPWR VGND sg13cmos5l_fill_2
XFILLER_88_823 VPWR VGND sg13cmos5l_fill_1
XFILLER_88_878 VPWR VGND sg13cmos5l_decap_4
Xhold2910 _14492_/D _13009_/Y VPWR VGND sg13cmos5l_dlygate4sd3_1
Xhold2921 _13065_/A _14518_/Q VPWR VGND sg13cmos5l_dlygate4sd3_1
Xhold2932 _10301_/A _13913_/Q VPWR VGND sg13cmos5l_dlygate4sd3_1
XFILLER_101_154 VPWR VGND sg13cmos5l_fill_2
Xhold2943 _09954_/A _13743_/Q VPWR VGND sg13cmos5l_dlygate4sd3_1
Xhold2954 _12448_/A _14380_/Q VPWR VGND sg13cmos5l_dlygate4sd3_1
Xhold2965 hold2965/X _13445_/Q VPWR VGND sg13cmos5l_dlygate4sd3_1
XFILLER_56_731 VPWR VGND sg13cmos5l_decap_8
X_07958_ _07958_/Y _07954_/C _07957_/Y _07956_/Y VPWR VGND sg13cmos5l_o21ai_1
Xhold2976 _10274_/A _13900_/Q VPWR VGND sg13cmos5l_dlygate4sd3_1
Xhold2987 _11085_/A _14289_/Q VPWR VGND sg13cmos5l_dlygate4sd3_1
Xhold2998 _09718_/A _13628_/Q VPWR VGND sg13cmos5l_dlygate4sd3_1
X_07889_ _07890_/C _14204_/Q _14201_/Q _14195_/Q VPWR VGND sg13cmos5l_nor3_1
XFILLER_56_797 VPWR VGND sg13cmos5l_fill_2
XFILLER_83_572 VPWR VGND sg13cmos5l_decap_8
X_09628_ _13607_/D _09682_/B _10395_/A1 _09622_/Y VPWR VGND sg13cmos5l_a21oi_1
XFILLER_43_447 VPWR VGND sg13cmos5l_decap_8
X_09559_ _13597_/D _09578_/B _10375_/A1 _09558_/Y VPWR VGND sg13cmos5l_a21oi_1
X_12570_ _12570_/X _12735_/A _12570_/B VPWR VGND sg13cmos5l_and2_1
X_11521_ _11577_/A _11563_/A _11555_/C VPWR VGND sg13cmos5l_xnor2_1
XFILLER_7_29 VPWR VGND sg13cmos5l_fill_1
X_11452_ _11460_/A _11484_/A _11476_/C VPWR VGND sg13cmos5l_xnor2_1
X_14240_ _14240_/Q clkload42/A _14240_/D _14240_/RESET_B VPWR VGND sg13cmos5l_dfrbpq_1
X_10403_ _13963_/D _10534_/A1 _10402_/B _10402_/Y VPWR VGND sg13cmos5l_a21oi_1
X_11383_ _11383_/Y _10982_/B _11379_/Y _11382_/Y VPWR VGND sg13cmos5l_a21oi_1
X_14171_ _14171_/Q _14622_/CLK _14171_/D _14171_/RESET_B VPWR VGND sg13cmos5l_dfrbpq_1
X_13452__1970 _13452_/RESET_B VPWR VGND sg13cmos5l_tiehi
X_10334_ _13929_/D _10399_/A1 _10347_/B _10333_/Y VPWR VGND sg13cmos5l_a21oi_1
X_14247__1794 _14247_/RESET_B VPWR VGND sg13cmos5l_tiehi
X_13122_ _13123_/B _09410_/A _13119_/B _13119_/Y _14548_/Q VPWR VGND sg13cmos5l_a22oi_1
XFILLER_106_950 VPWR VGND sg13cmos5l_decap_8
XFILLER_2_0 VPWR VGND sg13cmos5l_fill_2
X_10265_ _13895_/D _10395_/A1 _10274_/B _10264_/Y VPWR VGND sg13cmos5l_a21oi_1
X_13797__1594 _13797_/RESET_B VPWR VGND sg13cmos5l_tiehi
X_13053_ _14512_/D _13055_/A _13055_/C VPWR VGND sg13cmos5l_xor2_1
X_10196_ _13861_/D _10326_/A1 _10217_/B _10195_/Y VPWR VGND sg13cmos5l_a21oi_1
X_12004_ _12004_/Y _11996_/Y _11997_/Y _12003_/Y VPWR VGND sg13cmos5l_o21ai_1
XFILLER_4_1001 VPWR VGND sg13cmos5l_fill_1
XFILLER_59_591 VPWR VGND sg13cmos5l_fill_2
Xfanout390 _12380_/B _12353_/B VPWR VGND sg13cmos5l_buf_1
X_13955_ _13955_/Q clkload57/A _13955_/D _13955_/RESET_B VPWR VGND sg13cmos5l_dfrbpq_1
X_13886_ _13886_/Q _14020_/CLK _13886_/D _13886_/RESET_B VPWR VGND sg13cmos5l_dfrbpq_1
X_12906_ _14440_/D _12906_/A VPWR VGND sg13cmos5l_inv_1
X_12837_ _12864_/B _14462_/Q _13252_/Q VPWR VGND sg13cmos5l_xor2_1
XFILLER_15_661 VPWR VGND sg13cmos5l_fill_2
X_12768_ _12776_/B _12783_/A _12769_/B VPWR VGND sg13cmos5l_nand2_1
X_11719_ _11719_/X _13976_/Q _13720_/Q _11719_/S VPWR VGND sg13cmos5l_mux2_1
X_14507_ _15886_/A clkload9/A _14507_/D fanout961/X VPWR VGND sg13cmos5l_dfrbpq_1
X_12699_ _12699_/Y _12699_/A _12699_/B VPWR VGND sg13cmos5l_nor2_1
Xinput10 input10/X ui_in[2] VPWR VGND sg13cmos5l_buf_1
Xinput21 input21/X uio_in[3] VPWR VGND sg13cmos5l_buf_1
X_14438_ _14438_/Q clkload40/A _14438_/D _14438_/RESET_B VPWR VGND sg13cmos5l_dfrbpq_1
XFILLER_6_370 VPWR VGND sg13cmos5l_fill_2
X_14369_ _14369_/Q _14650_/CLK _14369_/D _14369_/RESET_B VPWR VGND sg13cmos5l_dfrbpq_1
X_08930_ _08930_/Y _14265_/Q _13195_/B1 _08938_/B1 VPWR VGND sg13cmos5l_a21oi_1
X_08861_ _08863_/C _08861_/A _14360_/Q _08861_/C VPWR VGND sg13cmos5l_nand3_1
Xhold2228 _11123_/A _14298_/Q VPWR VGND sg13cmos5l_dlygate4sd3_1
X_13627__1764 _13627_/RESET_B VPWR VGND sg13cmos5l_tiehi
XFILLER_85_804 VPWR VGND sg13cmos5l_fill_2
X_07812_ _07812_/Y _07649_/Y _08606_/B _07811_/Y VPWR VGND sg13cmos5l_o21ai_1
Xhold2239 _13109_/A _14538_/Q VPWR VGND sg13cmos5l_dlygate4sd3_1
X_08792_ _08792_/Y _14223_/Q _14657_/D _08791_/Y VPWR VGND sg13cmos5l_a21oi_1
XFILLER_26_904 VPWR VGND sg13cmos5l_fill_1
XFILLER_84_347 VPWR VGND sg13cmos5l_fill_2
X_07743_ _07743_/Y _14385_/Q _11846_/A VPWR VGND sg13cmos5l_nor2_1
XFILLER_53_712 VPWR VGND sg13cmos5l_fill_2
XFILLER_65_561 VPWR VGND sg13cmos5l_fill_1
XFILLER_65_572 VPWR VGND sg13cmos5l_fill_2
X_07674_ _08838_/A _07674_/A _07675_/B VPWR VGND sg13cmos5l_nor2b_1
X_14619__2162 _14619_/RESET_B VPWR VGND sg13cmos5l_tiehi
X_14007__1384 _14007_/RESET_B VPWR VGND sg13cmos5l_tiehi
X_13494__1928 _13494_/RESET_B VPWR VGND sg13cmos5l_tiehi
XFILLER_25_436 VPWR VGND sg13cmos5l_fill_1
X_09413_ _13524_/D _10681_/A1 hold3090/X _09421_/S VPWR VGND sg13cmos5l_mux2_1
X_14465__1027 _14465_/RESET_B VPWR VGND sg13cmos5l_tiehi
X_13530__1892 _13530_/RESET_B VPWR VGND sg13cmos5l_tiehi
XFILLER_40_406 VPWR VGND sg13cmos5l_fill_2
XFILLER_40_417 VPWR VGND sg13cmos5l_fill_1
XFILLER_80_586 VPWR VGND sg13cmos5l_decap_8
XFILLER_33_491 VPWR VGND sg13cmos5l_fill_2
X_09344_ _09344_/Y _09344_/A _09443_/B VPWR VGND sg13cmos5l_nand2_1
X_09275_ _13399_/D _09416_/A0 hold3342/X _09280_/S VPWR VGND sg13cmos5l_mux2_1
XFILLER_20_152 VPWR VGND sg13cmos5l_fill_2
XFILLER_21_697 VPWR VGND sg13cmos5l_fill_1
X_08226_ _08226_/Y _08315_/A _08224_/X _08225_/Y _08223_/X _08391_/B1 VPWR VGND sg13cmos5l_a221oi_1
X_08157_ _08157_/X _08157_/A _08157_/B VPWR VGND sg13cmos5l_and2_1
XFILLER_10_1028 VPWR VGND sg13cmos5l_fill_1
X_08088_ _08088_/Y _09344_/A VPWR VGND sg13cmos5l_inv_1
XFILLER_0_513 VPWR VGND sg13cmos5l_fill_2
X_10050_ _10050_/Y _10050_/A _10088_/B VPWR VGND sg13cmos5l_nand2_1
Xhold3452 hold3452/X _14100_/Q VPWR VGND sg13cmos5l_dlygate4sd3_1
Xhold3441 hold3441/X _14104_/Q VPWR VGND sg13cmos5l_dlygate4sd3_1
Xhold3430 _09012_/A _13287_/Q VPWR VGND sg13cmos5l_dlygate4sd3_1
XFILLER_103_986 VPWR VGND sg13cmos5l_decap_8
Xhold2740 _10226_/A _13876_/Q VPWR VGND sg13cmos5l_dlygate4sd3_1
Xhold3485 _13162_/A _14266_/Q VPWR VGND sg13cmos5l_dlygate4sd3_1
Xhold3474 _09054_/A _13305_/Q VPWR VGND sg13cmos5l_dlygate4sd3_1
Xhold3463 hold3463/X _14115_/Q VPWR VGND sg13cmos5l_dlygate4sd3_1
XFILLER_48_539 VPWR VGND sg13cmos5l_fill_2
Xhold2751 _10131_/A _13830_/Q VPWR VGND sg13cmos5l_dlygate4sd3_1
Xhold2762 _10217_/A _13872_/Q VPWR VGND sg13cmos5l_dlygate4sd3_1
Xhold2773 _09827_/A _13681_/Q VPWR VGND sg13cmos5l_dlygate4sd3_1
Xhold3496 _09003_/A _13280_/Q VPWR VGND sg13cmos5l_dlygate4sd3_1
XFILLER_91_818 VPWR VGND sg13cmos5l_decap_8
Xhold2784 _13021_/A _14498_/Q VPWR VGND sg13cmos5l_dlygate4sd3_1
Xhold2795 _09898_/A _13715_/Q VPWR VGND sg13cmos5l_dlygate4sd3_1
X_10952_ _10952_/Y _10952_/A _10952_/B VPWR VGND sg13cmos5l_nand2_1
X_13740_ _13740_/Q _14028_/CLK _13740_/D _13740_/RESET_B VPWR VGND sg13cmos5l_dfrbpq_1
XFILLER_16_447 VPWR VGND sg13cmos5l_fill_1
XFILLER_32_907 VPWR VGND sg13cmos5l_fill_1
XFILLER_43_222 VPWR VGND sg13cmos5l_fill_2
XFILLER_56_594 VPWR VGND sg13cmos5l_decap_8
XFILLER_16_469 VPWR VGND sg13cmos5l_fill_2
XFILLER_25_981 VPWR VGND sg13cmos5l_fill_2
X_10883_ _10883_/Y _10883_/A _10941_/B VPWR VGND sg13cmos5l_nand2_1
X_14293__1215 _14293_/RESET_B VPWR VGND sg13cmos5l_tiehi
X_13671_ _13671_/Q clkload61/A _13671_/D _13671_/RESET_B VPWR VGND sg13cmos5l_dfrbpq_1
XFILLER_24_480 VPWR VGND sg13cmos5l_fill_2
X_12622_ _12622_/X _12637_/A _12622_/B VPWR VGND sg13cmos5l_and2_1
XFILLER_8_613 VPWR VGND sg13cmos5l_decap_8
X_12553_ _12553_/Y _12553_/A _12637_/A VPWR VGND sg13cmos5l_nor2b_1
XFILLER_7_101 VPWR VGND sg13cmos5l_fill_1
XFILLER_7_123 VPWR VGND sg13cmos5l_fill_1
X_11504_ _11513_/A _11492_/A _11504_/B _11555_/B VPWR VGND sg13cmos5l_nand3b_1
X_13705__1686 _13705_/RESET_B VPWR VGND sg13cmos5l_tiehi
XFILLER_7_156 VPWR VGND sg13cmos5l_fill_2
X_14223_ _14223_/Q clkload72/A _14223_/D _14223_/RESET_B VPWR VGND sg13cmos5l_dfrbpq_1
X_12484_ _12486_/A _12489_/A1 _13242_/Q _12483_/Y VPWR VGND sg13cmos5l_o21ai_1
XFILLER_7_189 VPWR VGND sg13cmos5l_decap_8
X_11435_ _14329_/D _11433_/Y _11434_/Y _11420_/Y VPWR VGND sg13cmos5l_o21ai_1
X_11366_ _11366_/Y _11387_/A _11366_/B VPWR VGND sg13cmos5l_xnor2_1
X_14154_ _14154_/Q _14577_/CLK _14154_/D fanout989/X VPWR VGND sg13cmos5l_dfrbpq_1
X_13884__1507 _13884_/RESET_B VPWR VGND sg13cmos5l_tiehi
X_10317_ _10317_/Y _10317_/A _10343_/B VPWR VGND sg13cmos5l_nor2_1
X_11297_ _11298_/B _11284_/A _11297_/B VPWR VGND sg13cmos5l_nand2b_1
X_14085_ _14085_/Q clkload38/A _14085_/D _14085_/RESET_B VPWR VGND sg13cmos5l_dfrbpq_1
X_13920__1471 _13920_/RESET_B VPWR VGND sg13cmos5l_tiehi
X_13105_ _14536_/D _13105_/A _13107_/C VPWR VGND sg13cmos5l_xor2_1
XFILLER_79_620 VPWR VGND sg13cmos5l_fill_2
XFILLER_79_631 VPWR VGND sg13cmos5l_decap_8
X_10248_ _10248_/Y _10248_/A _10248_/B VPWR VGND sg13cmos5l_nor2_1
X_13036_ _13037_/A _07629_/A _13034_/B _13070_/B hold2540/X VPWR VGND sg13cmos5l_a22oi_1
XFILLER_39_528 VPWR VGND sg13cmos5l_fill_1
XFILLER_78_196 VPWR VGND sg13cmos5l_fill_2
X_10179_ _10179_/Y _10179_/A _10185_/B VPWR VGND sg13cmos5l_nor2_1
X_13338__2084 _13338_/RESET_B VPWR VGND sg13cmos5l_tiehi
X_13938_ _13938_/Q clkload53/A _13938_/D _13938_/RESET_B VPWR VGND sg13cmos5l_dfrbpq_1
XFILLER_47_594 VPWR VGND sg13cmos5l_decap_4
XFILLER_62_553 VPWR VGND sg13cmos5l_decap_8
XFILLER_90_873 VPWR VGND sg13cmos5l_decap_8
X_13869_ _13869_/Q _14053_/CLK _13869_/D _13869_/RESET_B VPWR VGND sg13cmos5l_dfrbpq_1
XFILLER_16_992 VPWR VGND sg13cmos5l_fill_1
X_07390_ _07390_/Y _07391_/A _07391_/B _07391_/C VPWR VGND sg13cmos5l_nor3_1
XFILLER_31_951 VPWR VGND sg13cmos5l_fill_1
X_09060_ _09060_/Y _09060_/A _09060_/B VPWR VGND sg13cmos5l_nor2_1
X_08011_ _08033_/A _14560_/Q _14559_/Q _14562_/Q _14561_/Q VPWR VGND sg13cmos5l_nor4_1
XFILLER_89_406 VPWR VGND sg13cmos5l_fill_2
X_09962_ _13746_/D _10419_/A1 _09977_/B _09961_/Y VPWR VGND sg13cmos5l_o21ai_1
X_08913_ _08913_/Y _08913_/A _14181_/Q VPWR VGND sg13cmos5l_nor2_1
X_13548__1874 _13548_/RESET_B VPWR VGND sg13cmos5l_tiehi
X_09893_ _13713_/D fanout55/X _09892_/B _09892_/Y VPWR VGND sg13cmos5l_a21oi_1
X_14371__1137 _14371_/RESET_B VPWR VGND sg13cmos5l_tiehi
XFILLER_85_634 VPWR VGND sg13cmos5l_fill_2
X_08844_ _08844_/Y _07686_/A _08875_/B _08843_/Y VPWR VGND sg13cmos5l_o21ai_1
X_08775_ _08775_/Y _08781_/A1 _14157_/Q _13266_/Q _08781_/B2 VPWR VGND sg13cmos5l_a22oi_1
XFILLER_26_723 VPWR VGND sg13cmos5l_fill_2
X_07726_ _08450_/A _14375_/Q _11641_/A VPWR VGND sg13cmos5l_xor2_1
X_14092__1315 _14092_/RESET_B VPWR VGND sg13cmos5l_tiehi
XFILLER_53_531 VPWR VGND sg13cmos5l_fill_1
X_14246__1793 _14246_/RESET_B VPWR VGND sg13cmos5l_tiehi
XFILLER_41_704 VPWR VGND sg13cmos5l_fill_1
X_07657_ _08575_/B _07657_/A _07657_/B VPWR VGND sg13cmos5l_nand2_1
XFILLER_13_428 VPWR VGND sg13cmos5l_fill_2
XFILLER_40_203 VPWR VGND sg13cmos5l_fill_1
XFILLER_80_394 VPWR VGND sg13cmos5l_fill_2
X_07588_ _07588_/Y _08964_/B _07588_/B VPWR VGND sg13cmos5l_xnor2_1
X_13962__1429 _13962_/RESET_B VPWR VGND sg13cmos5l_tiehi
XFILLER_22_940 VPWR VGND sg13cmos5l_fill_1
X_09327_ _13443_/D _09288_/A hold3150/X _09333_/S VPWR VGND sg13cmos5l_mux2_1
X_09258_ _13383_/D _09293_/A hold3343/X _09258_/S VPWR VGND sg13cmos5l_mux2_1
XFILLER_5_627 VPWR VGND sg13cmos5l_fill_1
X_08209_ _08210_/C _14538_/Q _07512_/B _08209_/B1 _14486_/Q VPWR VGND sg13cmos5l_a22oi_1
X_09189_ _09189_/Y _11592_/A _09188_/Y _09196_/A2 VPWR VGND sg13cmos5l_a21oi_1
X_11220_ _11220_/Y _11220_/A _11220_/B VPWR VGND sg13cmos5l_nand2_1
X_11151_ _11161_/C _11628_/A _11151_/B VPWR VGND sg13cmos5l_nand2_1
X_10102_ _13815_/D _10559_/A1 _10107_/B _10101_/Y VPWR VGND sg13cmos5l_o21ai_1
XFILLER_1_877 VPWR VGND sg13cmos5l_fill_2
X_11082_ _14288_/D _11141_/B _11080_/Y _11081_/Y VPWR VGND sg13cmos5l_a21oi_1
Xhold3260 hold3260/X _13568_/Q VPWR VGND sg13cmos5l_dlygate4sd3_1
X_10033_ _13781_/D _10425_/A1 _10034_/B _10032_/Y VPWR VGND sg13cmos5l_o21ai_1
Xhold3293 hold3293/X _13520_/Q VPWR VGND sg13cmos5l_dlygate4sd3_1
Xhold3282 hold3282/X _13375_/Q VPWR VGND sg13cmos5l_dlygate4sd3_1
Xhold3271 hold3271/X _13330_/Q VPWR VGND sg13cmos5l_dlygate4sd3_1
X_15890_ _15890_/X _15890_/A VPWR VGND sg13cmos5l_buf_1
X_14347__1161 _14347_/RESET_B VPWR VGND sg13cmos5l_tiehi
XFILLER_48_347 VPWR VGND sg13cmos5l_decap_8
XFILLER_64_818 VPWR VGND sg13cmos5l_fill_2
XFILLER_76_656 VPWR VGND sg13cmos5l_decap_8
XFILLER_76_678 VPWR VGND sg13cmos5l_decap_8
XFILLER_91_604 VPWR VGND sg13cmos5l_fill_1
Xhold2570 _09886_/A _13710_/Q VPWR VGND sg13cmos5l_dlygate4sd3_1
Xhold2581 _08123_/A _13213_/Q VPWR VGND sg13cmos5l_dlygate4sd3_1
Xhold2592 _10408_/A _13966_/Q VPWR VGND sg13cmos5l_dlygate4sd3_1
XFILLER_29_594 VPWR VGND sg13cmos5l_fill_1
XFILLER_63_339 VPWR VGND sg13cmos5l_decap_8
X_11984_ _11984_/Y _11984_/A _11984_/B _11984_/C VPWR VGND sg13cmos5l_nor3_1
X_10935_ _10946_/C _14272_/Q _10935_/B _10935_/C VPWR VGND sg13cmos5l_nand3_1
X_13723_ _13723_/Q _14042_/CLK _13723_/D _13723_/RESET_B VPWR VGND sg13cmos5l_dfrbpq_1
XFILLER_71_394 VPWR VGND sg13cmos5l_decap_4
XFILLER_72_895 VPWR VGND sg13cmos5l_fill_1
X_10866_ _14187_/D _10946_/A _10865_/Y _10864_/Y VPWR VGND sg13cmos5l_o21ai_1
X_13654_ _13654_/Q clkload20/A _13654_/D _13654_/RESET_B VPWR VGND sg13cmos5l_dfrbpq_1
XFILLER_13_962 VPWR VGND sg13cmos5l_fill_2
X_13938__1453 _13938_/RESET_B VPWR VGND sg13cmos5l_tiehi
X_12605_ _12605_/Y _12603_/X _12604_/Y _12648_/B VPWR VGND sg13cmos5l_o21ai_1
X_10797_ _10797_/Y _10751_/B _10795_/Y _10796_/Y VPWR VGND sg13cmos5l_o21ai_1
X_13585_ _13585_/Q clkload33/A _13585_/D _13585_/RESET_B VPWR VGND sg13cmos5l_dfrbpq_1
X_12536_ _12537_/B _12523_/A _13255_/Q _12535_/Y VPWR VGND sg13cmos5l_o21ai_1
XFILLER_69_6 VPWR VGND sg13cmos5l_fill_2
XFILLER_8_465 VPWR VGND sg13cmos5l_fill_2
X_12467_ _14384_/D _12467_/A _12467_/B VPWR VGND sg13cmos5l_nand2_1
XFILLER_99_704 VPWR VGND sg13cmos5l_decap_4
X_11418_ _11418_/Y _11587_/A _11416_/B _12937_/B2 VPWR VGND sg13cmos5l_o21ai_1
X_14618__2161 _14618_/RESET_B VPWR VGND sg13cmos5l_tiehi
X_14206_ _14206_/Q _14217_/CLK _14206_/D _14206_/RESET_B VPWR VGND sg13cmos5l_dfrbpq_1
X_14137_ _14137_/Q clkload22/A _14137_/D fanout990/X VPWR VGND sg13cmos5l_dfrbpq_1
X_12398_ _12400_/B _13680_/Q _12401_/B1 _12398_/B1 VPWR VGND sg13cmos5l_a21oi_1
X_11349_ _11391_/B _11351_/A VPWR VGND sg13cmos5l_inv_1
XFILLER_100_208 VPWR VGND sg13cmos5l_fill_1
XFILLER_67_601 VPWR VGND sg13cmos5l_decap_8
X_14068_ _14068_/Q clkload8/A _14068_/D fanout960/X VPWR VGND sg13cmos5l_dfrbpq_1
XFILLER_79_483 VPWR VGND sg13cmos5l_decap_8
XFILLER_79_494 VPWR VGND sg13cmos5l_fill_1
X_13019_ _14497_/D _13021_/B _13019_/B VPWR VGND sg13cmos5l_and2_1
XFILLER_55_818 VPWR VGND sg13cmos5l_decap_8
XFILLER_94_453 VPWR VGND sg13cmos5l_fill_2
XFILLER_54_317 VPWR VGND sg13cmos5l_fill_1
X_08560_ _08561_/B _08559_/A _08557_/Y _08558_/Y _08559_/Y VPWR VGND sg13cmos5l_a22oi_1
XFILLER_63_884 VPWR VGND sg13cmos5l_fill_1
X_07511_ _07515_/A _14473_/Q _07530_/B1 _07528_/B1 _14489_/Q VPWR VGND sg13cmos5l_a22oi_1
X_08491_ _08491_/Y _08491_/A _08819_/A _08491_/C _08491_/D VPWR VGND sg13cmos5l_nand4_1
XFILLER_23_748 VPWR VGND sg13cmos5l_fill_2
XFILLER_50_534 VPWR VGND sg13cmos5l_decap_8
XFILLER_90_692 VPWR VGND sg13cmos5l_fill_2
X_07442_ _13034_/A _07472_/A _07442_/B VPWR VGND sg13cmos5l_and2_1
X_13310__2202 _13310_/RESET_B VPWR VGND sg13cmos5l_tiehi
XFILLER_50_545 VPWR VGND sg13cmos5l_fill_1
X_07373_ _07570_/A _13307_/Q _14556_/Q VPWR VGND sg13cmos5l_xor2_1
X_09112_ _09112_/Y _14359_/Q _09112_/A2 _09111_/Y VPWR VGND sg13cmos5l_a21oi_1
X_14389__1119 _14389_/RESET_B VPWR VGND sg13cmos5l_tiehi
X_09043_ _13303_/D _08970_/A _13197_/A2 _09041_/Y _09042_/Y VPWR VGND sg13cmos5l_a22oi_1
X_14425__1083 _14425_/RESET_B VPWR VGND sg13cmos5l_tiehi
XFILLER_104_536 VPWR VGND sg13cmos5l_fill_1
X_09945_ _13738_/D _10532_/A1 _09944_/B _09944_/Y VPWR VGND sg13cmos5l_a21oi_1
Xfanout901 _07985_/A _14113_/Q VPWR VGND sg13cmos5l_buf_1
Xfanout912 _09414_/A0 _14102_/Q VPWR VGND sg13cmos5l_buf_1
Xfanout923 _12637_/A _12640_/A VPWR VGND sg13cmos5l_buf_1
Xfanout934 _12963_/A _13303_/Q VPWR VGND sg13cmos5l_buf_1
XFILLER_86_943 VPWR VGND sg13cmos5l_decap_4
X_09876_ _09876_/Y _09876_/A _09886_/B VPWR VGND sg13cmos5l_nor2_1
Xfanout945 _08050_/A _08062_/S VPWR VGND sg13cmos5l_buf_1
Xfanout956 _13146_/A input21/X VPWR VGND sg13cmos5l_buf_1
Xfanout967 fanout967/X fanout994/X VPWR VGND sg13cmos5l_buf_1
XFILLER_100_742 VPWR VGND sg13cmos5l_fill_2
X_08827_ _14634_/D _08827_/A VPWR VGND sg13cmos5l_inv_1
Xfanout978 fanout978/X fanout980/X VPWR VGND sg13cmos5l_buf_1
Xfanout989 fanout989/X fanout990/X VPWR VGND sg13cmos5l_buf_1
XFILLER_79_1028 VPWR VGND sg13cmos5l_fill_1
X_08758_ _08758_/Y _07261_/Y _07328_/Y _08757_/Y VPWR VGND sg13cmos5l_o21ai_1
X_07709_ _07709_/Y _11117_/A _07709_/B VPWR VGND sg13cmos5l_nor2_1
X_08689_ _08689_/Y _13587_/Q _08738_/A2 _08687_/A VPWR VGND sg13cmos5l_a21oi_1
XFILLER_26_575 VPWR VGND sg13cmos5l_fill_1
X_10720_ _10720_/Y _10801_/A _14278_/Q VPWR VGND sg13cmos5l_nand2_1
X_14230__1247 _14230_/RESET_B VPWR VGND sg13cmos5l_tiehi
XFILLER_16_1012 VPWR VGND sg13cmos5l_fill_1
X_10651_ _10652_/C _10653_/A _10651_/B VPWR VGND sg13cmos5l_or2_1
XFILLER_6_903 VPWR VGND sg13cmos5l_fill_1
X_10582_ _10582_/Y _10582_/A _10582_/B VPWR VGND sg13cmos5l_nand2_1
X_13370_ _13370_/Q clkload27/A _13370_/D _13370_/RESET_B VPWR VGND sg13cmos5l_dfrbpq_1
X_12321_ _12321_/Y _12315_/Y _12316_/Y _12322_/A1 VPWR VGND sg13cmos5l_a21oi_1
XFILLER_6_969 VPWR VGND sg13cmos5l_fill_1
X_12252_ _14366_/D _12193_/A _12251_/A _12226_/Y _12251_/Y VPWR VGND sg13cmos5l_a22oi_1
XFILLER_102_0 VPWR VGND sg13cmos5l_fill_2
X_11203_ _11203_/X _11203_/A _11214_/C VPWR VGND sg13cmos5l_xor2_1
X_12183_ _12183_/Y _11624_/B _12182_/Y _12251_/A VPWR VGND sg13cmos5l_a21oi_1
XFILLER_62_1010 VPWR VGND sg13cmos5l_decap_8
XFILLER_96_707 VPWR VGND sg13cmos5l_fill_1
X_11134_ _11134_/Y _14385_/Q _11143_/A2 _11105_/B _14401_/Q _11071_/X VPWR VGND sg13cmos5l_a221oi_1
X_11065_ _11065_/Y _11065_/A _11144_/B VPWR VGND sg13cmos5l_nor2_1
XFILLER_76_442 VPWR VGND sg13cmos5l_decap_4
X_10016_ _13773_/D fanout75/X _10021_/B _10015_/Y VPWR VGND sg13cmos5l_o21ai_1
Xhold3090 hold3090/X _13524_/Q VPWR VGND sg13cmos5l_dlygate4sd3_1
XFILLER_37_818 VPWR VGND sg13cmos5l_fill_1
XFILLER_49_689 VPWR VGND sg13cmos5l_fill_2
XFILLER_76_486 VPWR VGND sg13cmos5l_fill_2
XFILLER_92_935 VPWR VGND sg13cmos5l_fill_2
XFILLER_64_637 VPWR VGND sg13cmos5l_decap_4
XFILLER_45_862 VPWR VGND sg13cmos5l_fill_2
XFILLER_91_478 VPWR VGND sg13cmos5l_fill_1
X_11967_ _11967_/Y _13921_/Q _11969_/A2 _11998_/B1 _13601_/Q _11966_/X VPWR VGND sg13cmos5l_a221oi_1
XFILLER_17_597 VPWR VGND sg13cmos5l_fill_1
X_10918_ _10918_/Y _10918_/A _10976_/B VPWR VGND sg13cmos5l_nand2_1
X_13706_ _13706_/Q clkload51/A _13706_/D _13706_/RESET_B VPWR VGND sg13cmos5l_dfrbpq_1
XFILLER_20_707 VPWR VGND sg13cmos5l_fill_2
XFILLER_32_534 VPWR VGND sg13cmos5l_fill_2
XFILLER_32_556 VPWR VGND sg13cmos5l_fill_2
X_11898_ _14354_/D _11901_/A _11979_/A _11897_/Y VPWR VGND sg13cmos5l_a21oi_1
XFILLER_60_887 VPWR VGND sg13cmos5l_decap_8
XFILLER_60_898 VPWR VGND sg13cmos5l_fill_1
X_10849_ _14183_/D _10946_/A _10848_/Y _10846_/Y VPWR VGND sg13cmos5l_o21ai_1
X_14206__1271 _14206_/RESET_B VPWR VGND sg13cmos5l_tiehi
X_13637_ _13637_/Q _14028_/CLK _13637_/D _13637_/RESET_B VPWR VGND sg13cmos5l_dfrbpq_1
X_13568_ _13568_/Q _13568_/CLK _13568_/D _13568_/RESET_B VPWR VGND sg13cmos5l_dfrbpq_1
X_12519_ _12519_/Y _12523_/A _12519_/B VPWR VGND sg13cmos5l_nand2_1
X_13499_ _13499_/Q _14109_/CLK _13499_/D _13499_/RESET_B VPWR VGND sg13cmos5l_dfrbpq_1
XFILLER_5_40 VPWR VGND sg13cmos5l_fill_1
X_14245__1792 _14245_/RESET_B VPWR VGND sg13cmos5l_tiehi
X_07991_ _07991_/X _13568_/Q _13536_/Q _13504_/Q _13472_/Q _08378_/A1 _07194_/A VPWR
+ VGND sg13cmos5l_mux4_1
Xfanout219 _10078_/B _10088_/B VPWR VGND sg13cmos5l_buf_1
Xfanout208 _10146_/A2 _10090_/Y VPWR VGND sg13cmos5l_buf_1
X_09730_ _09730_/Y _09730_/A _09730_/B VPWR VGND sg13cmos5l_nor2_1
Xclkbuf_4_7_0_clk clkload3/A clkbuf_0_clk/X VPWR VGND sg13cmos5l_buf_8
XFILLER_28_829 VPWR VGND sg13cmos5l_fill_1
XFILLER_55_615 VPWR VGND sg13cmos5l_fill_2
XFILLER_67_475 VPWR VGND sg13cmos5l_fill_1
XFILLER_82_401 VPWR VGND sg13cmos5l_fill_1
X_09661_ _13612_/D _09655_/B fanout77/X _09655_/Y VPWR VGND sg13cmos5l_a21oi_1
XFILLER_55_637 VPWR VGND sg13cmos5l_fill_2
X_08612_ _08613_/B _08625_/A _08619_/C _08606_/Y VPWR VGND sg13cmos5l_o21ai_1
X_09592_ _09592_/Y _09639_/A _11374_/B _09591_/Y VPWR VGND sg13cmos5l_a21oi_1
X_13664__1727 _13664_/RESET_B VPWR VGND sg13cmos5l_tiehi
XFILLER_39_1001 VPWR VGND sg13cmos5l_fill_1
XFILLER_83_979 VPWR VGND sg13cmos5l_fill_1
X_08543_ _08544_/B _08559_/A _08542_/Y _08539_/Y VPWR VGND sg13cmos5l_o21ai_1
X_13700__1691 _13700_/RESET_B VPWR VGND sg13cmos5l_tiehi
X_08474_ _08479_/C _08808_/A _08471_/C _07711_/A VPWR VGND sg13cmos5l_o21ai_1
XFILLER_50_375 VPWR VGND sg13cmos5l_fill_1
X_07425_ _07426_/A _13559_/Q _13527_/Q _13495_/Q _13463_/Q _07522_/S0 _07522_/S1 VPWR
+ VGND sg13cmos5l_mux4_1
X_14044__1347 _14044_/RESET_B VPWR VGND sg13cmos5l_tiehi
X_07356_ _07574_/A _08964_/A _14551_/Q VPWR VGND sg13cmos5l_xnor2_1
X_07287_ _07287_/Y _13249_/Q VPWR VGND sg13cmos5l_inv_1
X_09026_ _09026_/Y _09026_/A _09030_/B VPWR VGND sg13cmos5l_nand2_1
XFILLER_105_834 VPWR VGND sg13cmos5l_decap_8
XFILLER_2_416 VPWR VGND sg13cmos5l_fill_2
X_09928_ _09928_/Y _09928_/A _09942_/B VPWR VGND sg13cmos5l_nor2_1
Xfanout742 _08782_/A1 _07262_/Y VPWR VGND sg13cmos5l_buf_1
Xfanout731 _08867_/B _08904_/B VPWR VGND sg13cmos5l_buf_1
Xfanout720 _08905_/B1 _07883_/X VPWR VGND sg13cmos5l_buf_1
XFILLER_105_41 VPWR VGND sg13cmos5l_fill_1
Xfanout775 _08200_/S1 _08317_/A1 VPWR VGND sg13cmos5l_buf_1
Xfanout764 _10804_/A _07191_/Y VPWR VGND sg13cmos5l_buf_1
Xfanout753 _12445_/A _12468_/A VPWR VGND sg13cmos5l_buf_1
XFILLER_58_464 VPWR VGND sg13cmos5l_decap_8
XFILLER_59_976 VPWR VGND sg13cmos5l_fill_1
XFILLER_74_913 VPWR VGND sg13cmos5l_decap_4
X_09859_ _13696_/D _10381_/A1 _09859_/A2 _09858_/Y VPWR VGND sg13cmos5l_a21oi_1
Xfanout797 _08263_/S _08361_/B VPWR VGND sg13cmos5l_buf_1
Xfanout786 _08309_/A _08238_/S VPWR VGND sg13cmos5l_buf_1
XFILLER_18_328 VPWR VGND sg13cmos5l_fill_1
XFILLER_58_497 VPWR VGND sg13cmos5l_fill_2
X_12870_ _12871_/B _14465_/Q _13255_/Q VPWR VGND sg13cmos5l_xnor2_1
X_11821_ _11873_/A _11821_/A _13237_/Q VPWR VGND sg13cmos5l_nand2_1
X_14617__2160 _14617_/RESET_B VPWR VGND sg13cmos5l_tiehi
XFILLER_14_501 VPWR VGND sg13cmos5l_decap_4
X_14540_ _14540_/Q clkload11/A _14540_/D fanout963/X VPWR VGND sg13cmos5l_dfrbpq_1
X_14269__1816 _14269_/RESET_B VPWR VGND sg13cmos5l_tiehi
X_11752_ _11752_/X _13753_/Q _13721_/Q _11752_/S VPWR VGND sg13cmos5l_mux2_1
X_10703_ _14123_/D input16/X _08320_/A _10710_/S VPWR VGND sg13cmos5l_mux2_1
X_11683_ _11683_/Y _11679_/X _11681_/Y _11715_/A VPWR VGND sg13cmos5l_a21oi_1
X_14471_ _14471_/Q clkload8/A _14471_/D fanout962/X VPWR VGND sg13cmos5l_dfrbpq_1
X_10634_ _14073_/D _10636_/B _10634_/B VPWR VGND sg13cmos5l_and2_1
X_13422_ _13422_/Q clkload33/A _13422_/D _13422_/RESET_B VPWR VGND sg13cmos5l_dfrbpq_1
X_13353_ _13353_/Q clkload37/A _13353_/D _13353_/RESET_B VPWR VGND sg13cmos5l_dfrbpq_1
XFILLER_6_744 VPWR VGND sg13cmos5l_fill_2
X_10565_ _14042_/D _10565_/A1 _10564_/B _10564_/Y VPWR VGND sg13cmos5l_o21ai_1
X_12304_ _12304_/Y _12385_/A _12304_/B VPWR VGND sg13cmos5l_nor2_1
X_10496_ _14008_/D _10496_/A1 _10519_/B _10495_/Y VPWR VGND sg13cmos5l_o21ai_1
X_13284_ _13284_/Q clkload19/A _13284_/D fanout982/X VPWR VGND sg13cmos5l_dfrbpq_1
X_12235_ _12235_/Y _13642_/Q _12237_/B VPWR VGND sg13cmos5l_nand2_1
X_13742__1649 _13742_/RESET_B VPWR VGND sg13cmos5l_tiehi
X_12166_ _12169_/A _13640_/Q _12399_/A2 _12402_/C1 VPWR VGND sg13cmos5l_a21oi_1
X_11117_ _11117_/Y _11117_/A _11121_/B VPWR VGND sg13cmos5l_nor2_1
XFILLER_77_751 VPWR VGND sg13cmos5l_fill_2
X_12097_ _12098_/B _12097_/A1 _12500_/B _12096_/Y VPWR VGND sg13cmos5l_o21ai_1
X_11048_ _14277_/D _11101_/A _11111_/B _11047_/Y VPWR VGND sg13cmos5l_a21oi_1
Xinput8 input8/X ui_in[15] VPWR VGND sg13cmos5l_buf_1
XFILLER_64_412 VPWR VGND sg13cmos5l_fill_2
XFILLER_24_309 VPWR VGND sg13cmos5l_fill_1
XFILLER_36_136 VPWR VGND sg13cmos5l_fill_2
XFILLER_80_916 VPWR VGND sg13cmos5l_fill_1
XFILLER_91_242 VPWR VGND sg13cmos5l_fill_2
XFILLER_51_128 VPWR VGND sg13cmos5l_fill_1
X_12999_ _13003_/B _14488_/Q _14487_/Q _13002_/D VPWR VGND sg13cmos5l_nand3_1
XFILLER_17_383 VPWR VGND sg13cmos5l_fill_1
X_13375__2047 _13375_/RESET_B VPWR VGND sg13cmos5l_tiehi
XFILLER_32_397 VPWR VGND sg13cmos5l_fill_1
X_07210_ _07210_/Y _12415_/A VPWR VGND sg13cmos5l_inv_1
X_08190_ _08190_/Y _08202_/A _08189_/X VPWR VGND sg13cmos5l_nor2b_1
XFILLER_65_0 VPWR VGND sg13cmos5l_fill_2
X_13718__1673 _13718_/RESET_B VPWR VGND sg13cmos5l_tiehi
XFILLER_87_515 VPWR VGND sg13cmos5l_decap_4
XFILLER_87_537 VPWR VGND sg13cmos5l_fill_1
X_07974_ _07977_/A _13223_/Q _08207_/B1 _08209_/B1 _14484_/Q VPWR VGND sg13cmos5l_a22oi_1
X_09713_ _13625_/D _10367_/A1 _09724_/B _09712_/Y VPWR VGND sg13cmos5l_a21oi_1
XFILLER_55_423 VPWR VGND sg13cmos5l_decap_4
XFILLER_67_294 VPWR VGND sg13cmos5l_fill_1
X_09644_ _09646_/B _14461_/Q _09650_/C VPWR VGND sg13cmos5l_nor2_1
X_13585__1837 _13585_/RESET_B VPWR VGND sg13cmos5l_tiehi
XFILLER_71_905 VPWR VGND sg13cmos5l_fill_1
XFILLER_36_681 VPWR VGND sg13cmos5l_fill_2
X_09575_ _09589_/C _09575_/A _09575_/B _09575_/C _09575_/D VPWR VGND sg13cmos5l_or4_1
X_08526_ _08527_/B _08536_/A _08525_/Y _08524_/Y VPWR VGND sg13cmos5l_o21ai_1
X_08457_ _08457_/X _08457_/A _08457_/B VPWR VGND sg13cmos5l_and2_1
XFILLER_50_172 VPWR VGND sg13cmos5l_fill_2
XFILLER_51_695 VPWR VGND sg13cmos5l_decap_8
X_07408_ _07415_/B _07591_/A _07408_/B VPWR VGND sg13cmos5l_nor2_1
X_08388_ _08388_/Y _08388_/A _08388_/B VPWR VGND sg13cmos5l_nor2_1
XFILLER_100_1007 VPWR VGND sg13cmos5l_decap_8
X_07339_ _07339_/Y _14143_/Q VPWR VGND sg13cmos5l_inv_1
X_10350_ _13937_/D fanout55/X _10349_/B _10349_/Y VPWR VGND sg13cmos5l_a21oi_1
X_13420__2002 _13420_/RESET_B VPWR VGND sg13cmos5l_tiehi
XFILLER_3_725 VPWR VGND sg13cmos5l_fill_1
X_09009_ _13284_/D hold3548/X _09048_/A _09012_/B VPWR VGND sg13cmos5l_mux2_1
X_10281_ _13903_/D fanout61/X _10284_/B _10280_/Y VPWR VGND sg13cmos5l_a21oi_1
XFILLER_105_653 VPWR VGND sg13cmos5l_fill_2
X_12020_ _12047_/A _12021_/B _12106_/A VPWR VGND sg13cmos5l_nor2_1
X_14180__1297 _14180_/RESET_B VPWR VGND sg13cmos5l_tiehi
XFILLER_78_559 VPWR VGND sg13cmos5l_fill_2
Xfanout550 _09640_/A1 _09484_/Y VPWR VGND sg13cmos5l_buf_1
Xfanout583 _12057_/B fanout584/X VPWR VGND sg13cmos5l_buf_1
Xfanout572 _12427_/B1 _12398_/B1 VPWR VGND sg13cmos5l_buf_1
Xfanout561 _11695_/B _11934_/B1 VPWR VGND sg13cmos5l_buf_1
X_13971_ _13971_/Q clkload50/A _13971_/D _13971_/RESET_B VPWR VGND sg13cmos5l_dfrbpq_1
XFILLER_101_892 VPWR VGND sg13cmos5l_decap_8
Xfanout594 _11788_/C1 _11865_/A VPWR VGND sg13cmos5l_buf_1
X_12922_ _14448_/D _12922_/A VPWR VGND sg13cmos5l_inv_1
XFILLER_46_478 VPWR VGND sg13cmos5l_decap_4
XFILLER_61_404 VPWR VGND sg13cmos5l_fill_1
XFILLER_73_286 VPWR VGND sg13cmos5l_fill_1
X_14384__1124 _14384_/RESET_B VPWR VGND sg13cmos5l_tiehi
X_12853_ _14432_/D _12323_/Y _12852_/Y _12893_/B1 VPWR VGND sg13cmos5l_a21oi_1
X_11804_ _11804_/Y _14011_/Q _11944_/B2 _11753_/S VPWR VGND sg13cmos5l_a21oi_1
X_14244__1791 _14244_/RESET_B VPWR VGND sg13cmos5l_tiehi
X_12784_ _12784_/Y _12784_/A _12784_/B _12788_/C VPWR VGND sg13cmos5l_nor3_1
X_11735_ _11735_/Y _14443_/Q _11686_/B _11734_/Y VPWR VGND sg13cmos5l_a21oi_1
X_14523_ _14523_/Q clkload8/A _14523_/D fanout961/X VPWR VGND sg13cmos5l_dfrbpq_1
XFILLER_14_397 VPWR VGND sg13cmos5l_fill_1
XFILLER_42_684 VPWR VGND sg13cmos5l_fill_1
X_14454_ _14454_/Q clkload77/A _14454_/D _14454_/RESET_B VPWR VGND sg13cmos5l_dfrbpq_1
X_11666_ _14345_/D _11665_/Y hold3515/X _11708_/A VPWR VGND sg13cmos5l_mux2_1
X_13405_ _13405_/Q clkload31/A _13405_/D _13405_/RESET_B VPWR VGND sg13cmos5l_dfrbpq_1
X_10617_ _10621_/D _13038_/B VPWR VGND sg13cmos5l_inv_1
X_11597_ _11610_/B _11598_/A _11598_/B VPWR VGND sg13cmos5l_nand2_1
X_14385_ _14385_/Q clkload69/A _14385_/D _14385_/RESET_B VPWR VGND sg13cmos5l_dfrbpq_1
XFILLER_41_80 VPWR VGND sg13cmos5l_fill_1
XFILLER_6_541 VPWR VGND sg13cmos5l_fill_1
X_10548_ _10548_/Y _10548_/A _10564_/B VPWR VGND sg13cmos5l_nand2_1
X_13975__1416 _13975_/RESET_B VPWR VGND sg13cmos5l_tiehi
X_13336_ _13336_/Q _14105_/CLK _13336_/D _13336_/RESET_B VPWR VGND sg13cmos5l_dfrbpq_1
X_13267_ _13267_/Q clkload19/A _13267_/D fanout986/X VPWR VGND sg13cmos5l_dfrbpq_1
X_10479_ _14000_/D fanout58/X _10478_/B _10478_/Y VPWR VGND sg13cmos5l_a21oi_1
X_12218_ _12218_/Y _14364_/Q _13249_/Q _13250_/Q _12187_/A VPWR VGND sg13cmos5l_a22oi_1
X_13198_ _13301_/D _09060_/B _08446_/Y _08447_/Y VPWR VGND sg13cmos5l_a21oi_1
X_12149_ _12149_/Y _12403_/B1 _12141_/Y _12147_/Y _12148_/Y VPWR VGND sg13cmos5l_a22oi_1
XFILLER_96_367 VPWR VGND sg13cmos5l_fill_2
XFILLER_99_1009 VPWR VGND sg13cmos5l_decap_8
XFILLER_65_721 VPWR VGND sg13cmos5l_decap_4
XFILLER_64_231 VPWR VGND sg13cmos5l_fill_1
XFILLER_65_776 VPWR VGND sg13cmos5l_decap_8
X_07690_ _07693_/A _07691_/A _11846_/A VPWR VGND sg13cmos5l_nand2_1
XFILLER_52_404 VPWR VGND sg13cmos5l_fill_1
XFILLER_53_938 VPWR VGND sg13cmos5l_decap_8
XFILLER_80_713 VPWR VGND sg13cmos5l_fill_2
XFILLER_52_437 VPWR VGND sg13cmos5l_fill_2
X_09360_ _13473_/D _08206_/A hold3024/X _09373_/S VPWR VGND sg13cmos5l_mux2_1
X_08311_ _08311_/Y _08315_/A _08308_/X _08309_/X _08310_/Y _08311_/C1 VPWR VGND sg13cmos5l_a221oi_1
X_09291_ _13413_/D _08257_/A hold3026/X _09306_/S VPWR VGND sg13cmos5l_mux2_1
X_08242_ _12562_/A _08244_/C _08232_/X _08241_/Y VPWR VGND sg13cmos5l_a21oi_1
X_08173_ _08174_/C _14074_/Q _08207_/A2 _08208_/A2 _15892_/A VPWR VGND sg13cmos5l_a22oi_1
X_14268__1815 _14268_/RESET_B VPWR VGND sg13cmos5l_tiehi
XFILLER_102_645 VPWR VGND sg13cmos5l_fill_1
XFILLER_87_323 VPWR VGND sg13cmos5l_fill_2
XFILLER_88_857 VPWR VGND sg13cmos5l_fill_1
Xhold2900 _10374_/A _13949_/Q VPWR VGND sg13cmos5l_dlygate4sd3_1
Xhold2911 _10181_/A _13854_/Q VPWR VGND sg13cmos5l_dlygate4sd3_1
Xhold2922 _13022_/A _14499_/Q VPWR VGND sg13cmos5l_dlygate4sd3_1
XFILLER_102_689 VPWR VGND sg13cmos5l_fill_2
XFILLER_75_507 VPWR VGND sg13cmos5l_decap_8
X_07957_ _07957_/Y _07959_/B input18/X VPWR VGND sg13cmos5l_nand2_1
Xhold2933 _10406_/A _13965_/Q VPWR VGND sg13cmos5l_dlygate4sd3_1
Xhold2944 _09558_/A _13597_/Q VPWR VGND sg13cmos5l_dlygate4sd3_1
Xhold2955 _10157_/A _13842_/Q VPWR VGND sg13cmos5l_dlygate4sd3_1
Xhold2966 _09488_/A _13586_/Q VPWR VGND sg13cmos5l_dlygate4sd3_1
Xhold2977 _08231_/A _14259_/Q VPWR VGND sg13cmos5l_dlygate4sd3_1
Xhold2988 _09655_/A _13612_/Q VPWR VGND sg13cmos5l_dlygate4sd3_1
Xhold2999 hold2999/X _13492_/Q VPWR VGND sg13cmos5l_dlygate4sd3_1
XFILLER_56_765 VPWR VGND sg13cmos5l_decap_4
X_07888_ _07890_/B _14207_/Q _14215_/Q _14205_/Q _14217_/Q VPWR VGND sg13cmos5l_nor4_1
X_09627_ _09627_/Y _09639_/A _11450_/B _09626_/Y VPWR VGND sg13cmos5l_a21oi_1
XFILLER_70_212 VPWR VGND sg13cmos5l_fill_1
X_09558_ _09558_/Y _09558_/A _09578_/B VPWR VGND sg13cmos5l_nor2_1
X_08509_ _14594_/D _08517_/B _08509_/B VPWR VGND sg13cmos5l_xnor2_1
XFILLER_12_846 VPWR VGND sg13cmos5l_fill_2
XFILLER_23_161 VPWR VGND sg13cmos5l_fill_1
XFILLER_51_492 VPWR VGND sg13cmos5l_fill_2
X_09489_ _13586_/D _09642_/B _10549_/A1 _09488_/Y VPWR VGND sg13cmos5l_a21oi_1
X_11520_ _11534_/A _11563_/A _11555_/C VPWR VGND sg13cmos5l_nand2_1
X_14198__1279 _14198_/RESET_B VPWR VGND sg13cmos5l_tiehi
XFILLER_12_857 VPWR VGND sg13cmos5l_fill_2
XFILLER_11_378 VPWR VGND sg13cmos5l_fill_1
X_11451_ _11476_/C _11451_/A _11451_/B VPWR VGND sg13cmos5l_nand2_1
X_10402_ _10402_/Y _10402_/A _10402_/B VPWR VGND sg13cmos5l_nor2_1
X_11382_ _11382_/Y _11403_/A _11381_/Y _11338_/A VPWR VGND sg13cmos5l_o21ai_1
X_14170_ _14170_/Q clkload38/A _14170_/D _14170_/RESET_B VPWR VGND sg13cmos5l_dfrbpq_1
X_10333_ _10333_/Y _10333_/A _10347_/B VPWR VGND sg13cmos5l_nor2_1
X_13121_ _14547_/D _13127_/A _13121_/B VPWR VGND sg13cmos5l_nor2_1
XFILLER_79_824 VPWR VGND sg13cmos5l_fill_2
X_10264_ _10264_/Y _10264_/A _10274_/B VPWR VGND sg13cmos5l_nor2_1
X_13052_ _13052_/Y _13052_/A _13052_/B VPWR VGND sg13cmos5l_xnor2_1
XFILLER_79_857 VPWR VGND sg13cmos5l_fill_2
X_10195_ _10195_/Y _10195_/A _10217_/B VPWR VGND sg13cmos5l_nor2_1
X_12003_ _12003_/Y _14050_/Q _08687_/Y _12000_/Y _12002_/Y _11999_/Y VPWR VGND sg13cmos5l_a221oi_1
X_14438__1070 _14438_/RESET_B VPWR VGND sg13cmos5l_tiehi
XFILLER_47_710 VPWR VGND sg13cmos5l_decap_8
XFILLER_93_326 VPWR VGND sg13cmos5l_fill_1
XFILLER_94_838 VPWR VGND sg13cmos5l_fill_1
Xfanout391 _12353_/B _11639_/Y VPWR VGND sg13cmos5l_buf_1
Xfanout380 _07403_/A _07397_/Y VPWR VGND sg13cmos5l_buf_1
XFILLER_74_551 VPWR VGND sg13cmos5l_fill_1
X_13954_ _13954_/Q clkload60/A _13954_/D _13954_/RESET_B VPWR VGND sg13cmos5l_dfrbpq_1
XFILLER_19_478 VPWR VGND sg13cmos5l_fill_2
XFILLER_19_489 VPWR VGND sg13cmos5l_fill_1
XFILLER_59_1015 VPWR VGND sg13cmos5l_decap_8
X_13885_ _13885_/Q clkload48/A _13885_/D _13885_/RESET_B VPWR VGND sg13cmos5l_dfrbpq_1
X_13692__1699 _13692_/RESET_B VPWR VGND sg13cmos5l_tiehi
X_12905_ _12906_/A hold3429/X _11196_/B _11214_/B _12907_/B2 VPWR VGND sg13cmos5l_a22oi_1
XFILLER_62_768 VPWR VGND sg13cmos5l_decap_8
X_12836_ _12866_/A _14462_/Q _13252_/Q VPWR VGND sg13cmos5l_nor2_1
XFILLER_15_673 VPWR VGND sg13cmos5l_fill_2
XFILLER_61_267 VPWR VGND sg13cmos5l_fill_2
XFILLER_62_779 VPWR VGND sg13cmos5l_fill_1
XFILLER_70_790 VPWR VGND sg13cmos5l_fill_1
X_14506_ _15885_/A clkload9/A _14506_/D fanout961/X VPWR VGND sg13cmos5l_dfrbpq_1
X_12767_ _12769_/B _12750_/A _12784_/B _12784_/A VPWR VGND sg13cmos5l_a21oi_1
X_11718_ _11718_/Y _11702_/B _11716_/X _11717_/X _08687_/B VPWR VGND sg13cmos5l_a22oi_1
X_12698_ _12699_/B _12698_/A _12698_/B VPWR VGND sg13cmos5l_nand2_1
X_11649_ _11650_/B _11642_/A _11642_/B _11640_/X VPWR VGND sg13cmos5l_a21oi_1
Xinput11 input11/X ui_in[3] VPWR VGND sg13cmos5l_buf_1
Xinput22 input22/X uio_in[4] VPWR VGND sg13cmos5l_buf_1
X_14437_ _14437_/Q clkload73/A _14437_/D _14437_/RESET_B VPWR VGND sg13cmos5l_dfrbpq_1
X_14368_ _14368_/Q _14650_/CLK _14368_/D _14368_/RESET_B VPWR VGND sg13cmos5l_dfrbpq_1
X_13319_ _13319_/Q clkload81/A _13319_/D _13319_/RESET_B VPWR VGND sg13cmos5l_dfrbpq_1
XFILLER_6_382 VPWR VGND sg13cmos5l_fill_2
X_14299_ _14299_/Q _14299_/CLK _14299_/D _14299_/RESET_B VPWR VGND sg13cmos5l_dfrbpq_1
XFILLER_42_2 VPWR VGND sg13cmos5l_fill_1
X_08860_ _08863_/B _08861_/A _14360_/Q _08848_/B VPWR VGND sg13cmos5l_o21ai_1
XFILLER_57_507 VPWR VGND sg13cmos5l_decap_4
XFILLER_97_687 VPWR VGND sg13cmos5l_fill_2
X_07811_ _07811_/Y _08619_/A _07809_/Y _07810_/Y VPWR VGND sg13cmos5l_a21oi_1
Xhold2229 _14154_/D _10782_/Y VPWR VGND sg13cmos5l_dlygate4sd3_1
XFILLER_57_529 VPWR VGND sg13cmos5l_decap_4
XFILLER_85_849 VPWR VGND sg13cmos5l_fill_2
XFILLER_96_197 VPWR VGND sg13cmos5l_fill_1
X_08791_ _08791_/Y _08791_/A _08791_/B _08791_/C VPWR VGND sg13cmos5l_nand3_1
XFILLER_38_754 VPWR VGND sg13cmos5l_fill_2
X_07742_ _07758_/A _14381_/Q _07829_/B _08476_/B _07740_/B _07844_/A VPWR VGND sg13cmos5l_a221oi_1
XFILLER_26_938 VPWR VGND sg13cmos5l_fill_1
X_07673_ _07675_/B _14387_/Q _14355_/Q VPWR VGND sg13cmos5l_nand2_1
XFILLER_92_381 VPWR VGND sg13cmos5l_fill_1
X_09412_ _13523_/D _09445_/A0 hold3224/X _09434_/S VPWR VGND sg13cmos5l_mux2_1
XFILLER_53_779 VPWR VGND sg13cmos5l_fill_2
XFILLER_80_554 VPWR VGND sg13cmos5l_decap_4
X_09343_ _09443_/B input21/X _12594_/A _13128_/B _09343_/D VPWR VGND sg13cmos5l_nor4_1
XFILLER_34_982 VPWR VGND sg13cmos5l_fill_1
X_09274_ _13398_/D _10683_/A1 hold3058/X _09280_/S VPWR VGND sg13cmos5l_mux2_1
XFILLER_20_164 VPWR VGND sg13cmos5l_fill_2
X_08225_ _08225_/Y _08258_/S _07299_/Y _08165_/A VPWR VGND sg13cmos5l_a21oi_1
XFILLER_5_809 VPWR VGND sg13cmos5l_decap_4
X_08156_ _13208_/D _13030_/A _08156_/B _08156_/C _08156_/D VPWR VGND sg13cmos5l_nor4_1
X_08087_ _09344_/A _08087_/A _08087_/B VPWR VGND sg13cmos5l_and2_1
X_14243__1790 _14243_/RESET_B VPWR VGND sg13cmos5l_tiehi
XFILLER_103_921 VPWR VGND sg13cmos5l_fill_1
Xhold3442 hold3442/X _14563_/Q VPWR VGND sg13cmos5l_dlygate4sd3_1
Xhold3431 hold3431/X _13265_/Q VPWR VGND sg13cmos5l_dlygate4sd3_1
Xhold3420 hold3420/X _14594_/Q VPWR VGND sg13cmos5l_dlygate4sd3_1
XFILLER_0_569 VPWR VGND sg13cmos5l_fill_2
XFILLER_103_976 VPWR VGND sg13cmos5l_fill_1
XFILLER_88_665 VPWR VGND sg13cmos5l_fill_1
Xhold2730 _10912_/A _14202_/Q VPWR VGND sg13cmos5l_dlygate4sd3_1
Xhold2741 _10422_/A _13972_/Q VPWR VGND sg13cmos5l_dlygate4sd3_1
Xhold3475 hold3475/X _13285_/Q VPWR VGND sg13cmos5l_dlygate4sd3_1
Xhold3464 _08381_/A _14270_/Q VPWR VGND sg13cmos5l_dlygate4sd3_1
Xhold3453 hold3453/X _14609_/Q VPWR VGND sg13cmos5l_dlygate4sd3_1
XFILLER_76_838 VPWR VGND sg13cmos5l_fill_1
X_08989_ _08990_/B _08989_/A _08989_/B VPWR VGND sg13cmos5l_xnor2_1
Xhold2752 _09803_/A _13669_/Q VPWR VGND sg13cmos5l_dlygate4sd3_1
Xhold2763 _09928_/A _13730_/Q VPWR VGND sg13cmos5l_dlygate4sd3_1
Xhold2774 _10388_/A _13956_/Q VPWR VGND sg13cmos5l_dlygate4sd3_1
Xhold3497 hold3497/X _14448_/Q VPWR VGND sg13cmos5l_dlygate4sd3_1
Xhold3486 _08383_/A _14271_/Q VPWR VGND sg13cmos5l_dlygate4sd3_1
XFILLER_29_732 VPWR VGND sg13cmos5l_fill_1
Xhold2785 _14498_/D _13021_/Y VPWR VGND sg13cmos5l_dlygate4sd3_1
Xhold2796 _10474_/A _13998_/Q VPWR VGND sg13cmos5l_dlygate4sd3_1
X_13370__2052 _13370_/RESET_B VPWR VGND sg13cmos5l_tiehi
XFILLER_44_724 VPWR VGND sg13cmos5l_fill_1
XFILLER_56_584 VPWR VGND sg13cmos5l_fill_2
XFILLER_84_882 VPWR VGND sg13cmos5l_fill_1
X_10951_ _14218_/D _10844_/Y _10873_/Y _10950_/Y VPWR VGND sg13cmos5l_o21ai_1
XFILLER_16_437 VPWR VGND sg13cmos5l_fill_2
XFILLER_73_34 VPWR VGND sg13cmos5l_fill_2
X_13670_ _13670_/Q clkload64/A _13670_/D _13670_/RESET_B VPWR VGND sg13cmos5l_dfrbpq_1
X_10882_ _14192_/D _10865_/Y _10922_/B _10881_/Y VPWR VGND sg13cmos5l_o21ai_1
X_12621_ _12621_/X _12637_/A _12621_/B VPWR VGND sg13cmos5l_and2_1
XFILLER_106_1013 VPWR VGND sg13cmos5l_decap_8
X_13677__1714 _13677_/RESET_B VPWR VGND sg13cmos5l_tiehi
X_12552_ _12641_/A _11091_/B _11160_/Y _11150_/X VPWR VGND sg13cmos5l_a21o_1
X_11503_ _11505_/B _11555_/A _11555_/B VPWR VGND sg13cmos5l_nor2_1
X_12483_ _12483_/Y _12480_/A _11974_/Y _12485_/B VPWR VGND sg13cmos5l_a21oi_1
XFILLER_7_146 VPWR VGND sg13cmos5l_fill_2
X_11434_ _11434_/Y _11447_/A1 _11430_/B _12937_/B2 VPWR VGND sg13cmos5l_o21ai_1
X_14222_ _14222_/Q clkload44/A _14222_/D _14222_/RESET_B VPWR VGND sg13cmos5l_dfrbpq_1
X_11365_ _11378_/B _11387_/A _11366_/B VPWR VGND sg13cmos5l_nand2b_1
Xclkbuf_leaf_100_clk clkload21/A clkbuf_4_2_0_clk/X VPWR VGND sg13cmos5l_buf_8
X_14153_ _14153_/Q clkload26/A _14153_/D fanout985/X VPWR VGND sg13cmos5l_dfrbpq_1
X_14057__1334 _14057_/RESET_B VPWR VGND sg13cmos5l_tiehi
XFILLER_79_610 VPWR VGND sg13cmos5l_fill_1
X_10316_ _13920_/D _10381_/A1 _10315_/B _10315_/Y VPWR VGND sg13cmos5l_a21oi_1
X_11296_ _11327_/A _14177_/Q _11303_/B VPWR VGND sg13cmos5l_xnor2_1
X_14084_ _14084_/Q clkload42/A _14084_/D _14084_/RESET_B VPWR VGND sg13cmos5l_dfrbpq_1
X_13104_ _14535_/D _13104_/A _13104_/B VPWR VGND sg13cmos5l_xor2_1
X_10247_ _13886_/D _10573_/A1 _10280_/B _10246_/Y VPWR VGND sg13cmos5l_a21oi_1
X_13580__1842 _13580_/RESET_B VPWR VGND sg13cmos5l_tiehi
X_13035_ _14503_/D _13032_/Y _13034_/Y _13031_/Y VPWR VGND sg13cmos5l_o21ai_1
XFILLER_39_507 VPWR VGND sg13cmos5l_fill_2
XFILLER_78_164 VPWR VGND sg13cmos5l_fill_2
XFILLER_78_186 VPWR VGND sg13cmos5l_fill_1
X_10178_ _13852_/D _10308_/A1 _10189_/B _10177_/Y VPWR VGND sg13cmos5l_a21oi_1
XFILLER_47_551 VPWR VGND sg13cmos5l_decap_4
XFILLER_93_156 VPWR VGND sg13cmos5l_fill_1
X_13937_ _13937_/Q _14065_/CLK _13937_/D _13937_/RESET_B VPWR VGND sg13cmos5l_dfrbpq_1
XFILLER_90_852 VPWR VGND sg13cmos5l_fill_2
X_13868_ _13868_/Q clkload61/A _13868_/D _13868_/RESET_B VPWR VGND sg13cmos5l_dfrbpq_1
XFILLER_50_738 VPWR VGND sg13cmos5l_decap_4
XFILLER_50_749 VPWR VGND sg13cmos5l_decap_4
XFILLER_62_587 VPWR VGND sg13cmos5l_decap_4
X_14267__1814 _14267_/RESET_B VPWR VGND sg13cmos5l_tiehi
X_13799_ _13799_/Q _14064_/CLK _13799_/D _13799_/RESET_B VPWR VGND sg13cmos5l_dfrbpq_1
X_12819_ _12819_/X _12891_/A1 _12641_/B _12879_/B1 VPWR VGND sg13cmos5l_a21o_1
X_08010_ _09199_/B input21/X _13128_/B VPWR VGND sg13cmos5l_nor2_1
XFILLER_104_707 VPWR VGND sg13cmos5l_decap_8
XFILLER_104_718 VPWR VGND sg13cmos5l_fill_1
XFILLER_89_429 VPWR VGND sg13cmos5l_fill_2
X_09961_ _09961_/Y _09961_/A _09977_/B VPWR VGND sg13cmos5l_nand2_1
XFILLER_98_941 VPWR VGND sg13cmos5l_fill_1
X_08912_ _14656_/D _08912_/A _08912_/B _08912_/C _08912_/D VPWR VGND sg13cmos5l_nand4_1
XFILLER_58_816 VPWR VGND sg13cmos5l_decap_4
X_09892_ _09892_/Y _09892_/A _09892_/B VPWR VGND sg13cmos5l_nor2_1
XFILLER_97_495 VPWR VGND sg13cmos5l_fill_2
XFILLER_98_996 VPWR VGND sg13cmos5l_decap_8
X_08843_ _08843_/Y _07685_/Y _08861_/C VPWR VGND sg13cmos5l_nand2b_1
XFILLER_57_348 VPWR VGND sg13cmos5l_fill_2
X_08774_ _08774_/Y _08782_/A1 _07336_/Y _08773_/Y VPWR VGND sg13cmos5l_o21ai_1
X_13755__1636 _13755_/RESET_B VPWR VGND sg13cmos5l_tiehi
X_07725_ _08456_/B _14375_/Q _11641_/A VPWR VGND sg13cmos5l_nor2_1
X_13443__1979 _13443_/RESET_B VPWR VGND sg13cmos5l_tiehi
XFILLER_25_212 VPWR VGND sg13cmos5l_fill_1
XFILLER_53_554 VPWR VGND sg13cmos5l_decap_8
XFILLER_81_874 VPWR VGND sg13cmos5l_fill_2
X_07656_ _07657_/B _07656_/A _07656_/B VPWR VGND sg13cmos5l_nand2_1
X_07587_ _07590_/C _07587_/A _12963_/C VPWR VGND sg13cmos5l_xnor2_1
X_13970__1421 _13970_/RESET_B VPWR VGND sg13cmos5l_tiehi
X_09326_ _13442_/D _09286_/A hold3021/X _09338_/S VPWR VGND sg13cmos5l_mux2_1
X_09257_ _13382_/D _08269_/A hold3189/X _09266_/S VPWR VGND sg13cmos5l_mux2_1
X_08208_ _08210_/B _14520_/Q _08208_/A2 _07436_/Y _14502_/Q VPWR VGND sg13cmos5l_a22oi_1
XFILLER_4_105 VPWR VGND sg13cmos5l_decap_4
X_09188_ _09188_/Y _14436_/Q _11605_/A VPWR VGND sg13cmos5l_nand2_1
X_08139_ _13219_/D _08139_/A _08140_/B VPWR VGND sg13cmos5l_nor2b_1
X_13388__2034 _13388_/RESET_B VPWR VGND sg13cmos5l_tiehi
X_11150_ _11150_/X _11628_/A _11151_/B VPWR VGND sg13cmos5l_and2_1
XFILLER_1_812 VPWR VGND sg13cmos5l_fill_1
X_10101_ _10101_/Y _10101_/A _10107_/B VPWR VGND sg13cmos5l_nand2_1
XFILLER_1_867 VPWR VGND sg13cmos5l_fill_1
XFILLER_89_963 VPWR VGND sg13cmos5l_fill_1
X_11081_ _11081_/Y _11081_/A _11141_/B VPWR VGND sg13cmos5l_nor2_1
Xhold3250 hold3250/X _13342_/Q VPWR VGND sg13cmos5l_dlygate4sd3_1
XFILLER_103_784 VPWR VGND sg13cmos5l_fill_2
XFILLER_88_462 VPWR VGND sg13cmos5l_fill_1
X_10032_ _10032_/Y _10032_/A _10034_/B VPWR VGND sg13cmos5l_nand2_1
Xhold3294 _11144_/A _14305_/Q VPWR VGND sg13cmos5l_dlygate4sd3_1
Xhold3283 hold3283/X _13344_/Q VPWR VGND sg13cmos5l_dlygate4sd3_1
Xhold3272 hold3272/X _13571_/Q VPWR VGND sg13cmos5l_dlygate4sd3_1
Xhold3261 _13568_/D _09458_/X VPWR VGND sg13cmos5l_dlygate4sd3_1
Xhold2560 hold2560/X _14611_/Q VPWR VGND sg13cmos5l_dlygate4sd3_1
Xhold2571 hold2571/X _14607_/Q VPWR VGND sg13cmos5l_dlygate4sd3_1
Xhold2582 _13213_/D _08123_/Y VPWR VGND sg13cmos5l_dlygate4sd3_1
XFILLER_63_318 VPWR VGND sg13cmos5l_fill_2
Xhold2593 _09143_/A _13320_/Q VPWR VGND sg13cmos5l_dlygate4sd3_1
X_11983_ _11984_/C _11983_/A _11983_/B VPWR VGND sg13cmos5l_nand2_1
X_13722_ _13722_/Q clkload52/A _13722_/D _13722_/RESET_B VPWR VGND sg13cmos5l_dfrbpq_1
XFILLER_17_82 VPWR VGND sg13cmos5l_fill_2
XFILLER_71_351 VPWR VGND sg13cmos5l_fill_1
X_10934_ _10934_/Y _10934_/A _10934_/B VPWR VGND sg13cmos5l_nand2_1
X_10865_ _10865_/Y _14222_/Q _10865_/B _10865_/C VPWR VGND sg13cmos5l_nand3_1
X_13653_ _13653_/Q clkload49/A _13653_/D _13653_/RESET_B VPWR VGND sg13cmos5l_dfrbpq_1
X_13598__1824 _13598_/RESET_B VPWR VGND sg13cmos5l_tiehi
X_13584_ _13584_/Q _14238_/CLK _13584_/D _13584_/RESET_B VPWR VGND sg13cmos5l_dfrbpq_1
X_12604_ _12604_/Y _12591_/A _12591_/B _12588_/Y VPWR VGND sg13cmos5l_o21ai_1
XFILLER_13_974 VPWR VGND sg13cmos5l_fill_2
X_10796_ _10796_/Y _10796_/A _10796_/B VPWR VGND sg13cmos5l_nand2_1
X_12535_ _12535_/Y _12523_/A _12352_/B _12530_/B VPWR VGND sg13cmos5l_a21oi_1
XFILLER_9_956 VPWR VGND sg13cmos5l_fill_1
XFILLER_9_989 VPWR VGND sg13cmos5l_fill_1
X_12466_ _12467_/B _14384_/Q _12466_/B VPWR VGND sg13cmos5l_nand2_1
X_11417_ _11417_/Y _11413_/Y _11415_/Y _11416_/Y _11444_/A _11615_/C1 VPWR VGND sg13cmos5l_a221oi_1
X_14205_ _14205_/Q _14217_/CLK _14205_/D _14205_/RESET_B VPWR VGND sg13cmos5l_dfrbpq_1
X_13833__1558 _13833_/RESET_B VPWR VGND sg13cmos5l_tiehi
X_12397_ _12400_/A _13936_/Q _12397_/B VPWR VGND sg13cmos5l_nand2_1
X_11348_ _11351_/A _11388_/A _11363_/B VPWR VGND sg13cmos5l_nand2b_1
X_14136_ _14136_/Q clkload22/A _14136_/D fanout989/X VPWR VGND sg13cmos5l_dfrbpq_1
XFILLER_3_160 VPWR VGND sg13cmos5l_decap_4
X_11279_ _11279_/Y _11279_/A _11307_/B VPWR VGND sg13cmos5l_nand2_1
X_14067_ _14067_/Q clkload8/A _14067_/D fanout960/X VPWR VGND sg13cmos5l_dfrbpq_1
XFILLER_95_922 VPWR VGND sg13cmos5l_decap_8
XFILLER_95_944 VPWR VGND sg13cmos5l_fill_2
X_13018_ _13019_/B _14496_/Q _13020_/D _14497_/Q VPWR VGND sg13cmos5l_a21o_1
XFILLER_67_646 VPWR VGND sg13cmos5l_decap_8
XFILLER_95_999 VPWR VGND sg13cmos5l_decap_4
X_14193__1284 _14193_/RESET_B VPWR VGND sg13cmos5l_tiehi
X_07510_ _07510_/Y _07526_/A1 _07508_/X _07509_/Y VPWR VGND sg13cmos5l_o21ai_1
X_08490_ _08492_/B _08490_/A _08490_/B VPWR VGND sg13cmos5l_and2_1
X_07441_ _07442_/B _07424_/Y _07429_/Y _07440_/Y _11040_/A VPWR VGND sg13cmos5l_a22oi_1
XFILLER_50_557 VPWR VGND sg13cmos5l_fill_1
X_07372_ _07372_/Y _08995_/A _14557_/Q VPWR VGND sg13cmos5l_xnor2_1
X_09111_ _09111_/Y _11396_/A _09110_/Y _09112_/A2 VPWR VGND sg13cmos5l_a21oi_1
X_14397__1111 _14397_/RESET_B VPWR VGND sg13cmos5l_tiehi
X_09042_ _09042_/Y _14347_/Q _09065_/A2 _13197_/A2 VPWR VGND sg13cmos5l_a21oi_1
X_13809__1582 _13809_/RESET_B VPWR VGND sg13cmos5l_tiehi
XFILLER_98_760 VPWR VGND sg13cmos5l_fill_1
X_09944_ _09944_/Y _09944_/A _09944_/B VPWR VGND sg13cmos5l_nor2_1
Xfanout902 _07973_/A _14112_/Q VPWR VGND sg13cmos5l_buf_1
Xfanout913 _10681_/A1 _14101_/Q VPWR VGND sg13cmos5l_buf_1
Xfanout924 _12640_/A _12583_/A VPWR VGND sg13cmos5l_buf_1
XFILLER_58_624 VPWR VGND sg13cmos5l_decap_4
XFILLER_86_911 VPWR VGND sg13cmos5l_fill_2
X_09875_ _13704_/D _10397_/A1 _09892_/B _09874_/Y VPWR VGND sg13cmos5l_a21oi_1
Xfanout935 _08964_/A _13302_/Q VPWR VGND sg13cmos5l_buf_1
Xfanout946 _08062_/S _10807_/A VPWR VGND sg13cmos5l_buf_1
Xfanout957 fanout957/X fanout959/X VPWR VGND sg13cmos5l_buf_1
Xfanout968 fanout968/X fanout969/X VPWR VGND sg13cmos5l_buf_1
X_14320__1188 _14320_/RESET_B VPWR VGND sg13cmos5l_tiehi
X_13988__1403 _13988_/RESET_B VPWR VGND sg13cmos5l_tiehi
X_08826_ _08827_/A _08491_/A _08819_/B _08841_/B hold2554/X _08825_/Y VPWR VGND sg13cmos5l_a221oi_1
Xfanout979 fanout979/X fanout980/X VPWR VGND sg13cmos5l_buf_1
XFILLER_57_167 VPWR VGND sg13cmos5l_fill_2
XFILLER_58_679 VPWR VGND sg13cmos5l_fill_1
XFILLER_73_605 VPWR VGND sg13cmos5l_decap_8
XFILLER_45_329 VPWR VGND sg13cmos5l_fill_2
X_08757_ _08757_/Y _13148_/A _14148_/Q _14132_/Q _14576_/Q VPWR VGND sg13cmos5l_a22oi_1
X_07708_ _07711_/A _11117_/A _07709_/B VPWR VGND sg13cmos5l_nand2_1
X_08688_ _08688_/X _13907_/Q _11749_/B VPWR VGND sg13cmos5l_and2_1
XFILLER_54_885 VPWR VGND sg13cmos5l_fill_1
X_07639_ _08143_/B _08977_/B VPWR VGND sg13cmos5l_inv_1
X_10650_ _14082_/D _12583_/A _08434_/Y _09071_/B VPWR VGND sg13cmos5l_a21o_1
XFILLER_41_579 VPWR VGND sg13cmos5l_fill_2
XFILLER_9_208 VPWR VGND sg13cmos5l_fill_2
X_09309_ _09309_/Y _09443_/A _09309_/B VPWR VGND sg13cmos5l_nand2_1
X_10581_ _14050_/D _10581_/A1 _10582_/B _10580_/Y VPWR VGND sg13cmos5l_o21ai_1
X_12320_ _12320_/Y _12320_/A _12320_/B _12320_/C VPWR VGND sg13cmos5l_nand3_1
X_12251_ _12251_/Y _12251_/A _12251_/B VPWR VGND sg13cmos5l_nor2_1
X_11202_ _11202_/X _11202_/A _11202_/B VPWR VGND sg13cmos5l_and2_1
X_12182_ _12182_/Y _14459_/Q _11638_/Y _12181_/Y VPWR VGND sg13cmos5l_a21oi_1
X_11133_ _14301_/D _11132_/B _11131_/Y _11132_/Y VPWR VGND sg13cmos5l_a21oi_1
XFILLER_49_602 VPWR VGND sg13cmos5l_fill_1
XFILLER_89_782 VPWR VGND sg13cmos5l_decap_4
X_11064_ _11064_/Y _14383_/Q _11088_/A2 _11063_/X VPWR VGND sg13cmos5l_a21oi_1
X_14266__1813 _14266_/RESET_B VPWR VGND sg13cmos5l_tiehi
XFILLER_0_185 VPWR VGND sg13cmos5l_decap_4
XFILLER_37_808 VPWR VGND sg13cmos5l_fill_2
X_10015_ _10015_/Y _10015_/A _10021_/B VPWR VGND sg13cmos5l_nand2_1
Xhold3080 hold3080/X _13429_/Q VPWR VGND sg13cmos5l_dlygate4sd3_1
Xhold3091 hold3091/X _13333_/Q VPWR VGND sg13cmos5l_dlygate4sd3_1
Xhold2390 _10040_/A _13785_/Q VPWR VGND sg13cmos5l_dlygate4sd3_1
X_13506__1916 _13506_/RESET_B VPWR VGND sg13cmos5l_tiehi
XFILLER_48_189 VPWR VGND sg13cmos5l_fill_1
XFILLER_63_126 VPWR VGND sg13cmos5l_fill_2
X_11966_ _11966_/X _13665_/Q _11966_/B VPWR VGND sg13cmos5l_and2_1
X_10917_ _14204_/D _10818_/Y _10946_/A _10916_/Y VPWR VGND sg13cmos5l_o21ai_1
X_13705_ _13705_/Q clkload63/A _13705_/D _13705_/RESET_B VPWR VGND sg13cmos5l_dfrbpq_1
X_11897_ _11897_/Y _14449_/Q _12380_/B _11877_/Y _12286_/A _11896_/X VPWR VGND sg13cmos5l_a221oi_1
X_13636_ _13636_/Q clkload52/A _13636_/D _13636_/RESET_B VPWR VGND sg13cmos5l_dfrbpq_1
X_10848_ _10848_/Y _10848_/A _14220_/Q _10865_/C VPWR VGND sg13cmos5l_nand3_1
XFILLER_13_782 VPWR VGND sg13cmos5l_fill_2
X_10779_ _10779_/Y _10751_/B _10777_/Y _10778_/Y VPWR VGND sg13cmos5l_o21ai_1
X_13567_ _13567_/Q _13568_/CLK _13567_/D _13567_/RESET_B VPWR VGND sg13cmos5l_dfrbpq_1
X_13498_ _13498_/Q _14117_/CLK _13498_/D _13498_/RESET_B VPWR VGND sg13cmos5l_dfrbpq_1
X_12518_ _12518_/Y _14398_/Q _12522_/B VPWR VGND sg13cmos5l_nand2_1
X_12449_ _12449_/Y _12449_/A _12449_/B VPWR VGND sg13cmos5l_nand2_1
XFILLER_87_708 VPWR VGND sg13cmos5l_decap_8
XFILLER_87_719 VPWR VGND sg13cmos5l_fill_1
X_07990_ _07990_/Y _08356_/C _07985_/X _07989_/Y _11036_/C1 VPWR VGND sg13cmos5l_a22oi_1
Xfanout209 _10143_/B _10153_/B VPWR VGND sg13cmos5l_buf_1
X_14119_ _14119_/Q clkload29/A _14119_/D _11000_/A VPWR VGND sg13cmos5l_dfrbpq_1
X_09660_ _09660_/Y _09671_/A _11530_/B _09659_/Y VPWR VGND sg13cmos5l_a21oi_1
XFILLER_55_605 VPWR VGND sg13cmos5l_fill_1
XFILLER_95_763 VPWR VGND sg13cmos5l_decap_8
XFILLER_95_774 VPWR VGND sg13cmos5l_decap_8
X_08611_ _08619_/C _08589_/B _08607_/X _08610_/Y VPWR VGND sg13cmos5l_a21oi_1
X_09591_ _09591_/Y _09625_/C _09591_/B VPWR VGND sg13cmos5l_nor2_1
X_08542_ _08542_/Y _08535_/B _08582_/C _08541_/Y VPWR VGND sg13cmos5l_o21ai_1
X_14305__1203 _14305_/RESET_B VPWR VGND sg13cmos5l_tiehi
XFILLER_35_351 VPWR VGND sg13cmos5l_fill_2
XFILLER_91_991 VPWR VGND sg13cmos5l_fill_2
X_08473_ _14588_/D _08473_/A _08473_/B VPWR VGND sg13cmos5l_xnor2_1
XFILLER_51_866 VPWR VGND sg13cmos5l_fill_1
X_07424_ _07424_/Y _09416_/A0 _08199_/A1 _11040_/A VPWR VGND sg13cmos5l_a21oi_1
XFILLER_50_387 VPWR VGND sg13cmos5l_fill_2
X_07355_ _07434_/C _07369_/A _08956_/A VPWR VGND sg13cmos5l_nand2b_1
X_07286_ _07286_/Y _13248_/Q VPWR VGND sg13cmos5l_inv_1
X_09025_ _13294_/D _09024_/B _08975_/B _09024_/Y VPWR VGND sg13cmos5l_o21ai_1
X_09927_ _13729_/D _10579_/A1 _09942_/B _09926_/Y VPWR VGND sg13cmos5l_a21oi_1
Xfanout732 _08904_/B _07878_/X VPWR VGND sg13cmos5l_buf_1
Xfanout721 _08875_/B _07882_/Y VPWR VGND sg13cmos5l_buf_1
Xfanout710 _11541_/B _11604_/B VPWR VGND sg13cmos5l_buf_1
XFILLER_58_410 VPWR VGND sg13cmos5l_decap_8
XFILLER_59_955 VPWR VGND sg13cmos5l_decap_8
Xfanout776 _08254_/A1 _08317_/A1 VPWR VGND sg13cmos5l_buf_1
Xfanout765 _08502_/A _08616_/A VPWR VGND sg13cmos5l_buf_1
Xfanout754 _12468_/A _12546_/A1 VPWR VGND sg13cmos5l_buf_1
Xfanout743 _13149_/A1 _07262_/Y VPWR VGND sg13cmos5l_buf_1
XFILLER_58_476 VPWR VGND sg13cmos5l_decap_8
X_09858_ _09858_/Y _09858_/A _09858_/B VPWR VGND sg13cmos5l_nor2_1
Xfanout798 _08361_/B fanout804/X VPWR VGND sg13cmos5l_buf_1
Xfanout787 _08314_/S _08238_/S VPWR VGND sg13cmos5l_buf_1
XFILLER_73_413 VPWR VGND sg13cmos5l_fill_2
X_08809_ _08809_/Y _07836_/A _08875_/B _08808_/Y VPWR VGND sg13cmos5l_o21ai_1
X_09789_ _09789_/Y _09789_/A _09827_/B VPWR VGND sg13cmos5l_nor2_1
XFILLER_61_608 VPWR VGND sg13cmos5l_fill_2
X_11820_ _14351_/D _07237_/Y _11870_/A _11801_/Y _11819_/Y VPWR VGND sg13cmos5l_a22oi_1
X_11751_ _11751_/Y _11748_/Y _11750_/Y _11837_/C1 VPWR VGND sg13cmos5l_a21oi_1
XFILLER_42_844 VPWR VGND sg13cmos5l_fill_2
XFILLER_54_693 VPWR VGND sg13cmos5l_decap_8
X_10702_ _14122_/D input15/X _09225_/A _10709_/S VPWR VGND sg13cmos5l_mux2_1
Xclkbuf_leaf_80_clk clkload47/A clkbuf_4_8_0_clk/X VPWR VGND sg13cmos5l_buf_8
X_11682_ _11713_/A _11682_/A _11682_/B _11682_/C VPWR VGND sg13cmos5l_nor3_1
X_14470_ _14470_/Q _14577_/CLK _14470_/D fanout964/X VPWR VGND sg13cmos5l_dfrbpq_1
X_10633_ _10634_/B _14072_/Q _10635_/D _14073_/Q VPWR VGND sg13cmos5l_a21o_1
X_13421_ _13421_/Q clkload35/A _13421_/D _13421_/RESET_B VPWR VGND sg13cmos5l_dfrbpq_1
X_10564_ _10564_/Y _10564_/A _10564_/B VPWR VGND sg13cmos5l_nand2_1
X_13352_ _13352_/Q clkload28/A _13352_/D _13352_/RESET_B VPWR VGND sg13cmos5l_dfrbpq_1
XFILLER_10_785 VPWR VGND sg13cmos5l_fill_2
X_12303_ _12304_/B _12352_/A _12299_/Y _12302_/Y VPWR VGND sg13cmos5l_o21ai_1
X_10495_ _10495_/Y _10495_/A _10519_/B VPWR VGND sg13cmos5l_nand2_1
X_13283_ _13283_/Q clkload20/A _13283_/D fanout985/X VPWR VGND sg13cmos5l_dfrbpq_1
XFILLER_30_71 VPWR VGND sg13cmos5l_fill_2
X_12234_ _12234_/Y _14058_/Q _12234_/B VPWR VGND sg13cmos5l_nand2_1
X_13750__1641 _13750_/RESET_B VPWR VGND sg13cmos5l_tiehi
XFILLER_2_951 VPWR VGND sg13cmos5l_fill_2
X_12165_ _12165_/Y _12165_/A _12165_/B _12165_/C _12165_/D VPWR VGND sg13cmos5l_nand4_1
X_11116_ _14296_/D _11123_/B _11114_/Y _11115_/Y VPWR VGND sg13cmos5l_a21oi_1
X_12096_ _12096_/Y _14456_/Q _12302_/A2 _12094_/Y _12095_/Y VPWR VGND sg13cmos5l_a22oi_1
XFILLER_49_443 VPWR VGND sg13cmos5l_decap_8
X_11047_ _11047_/Y _11047_/A _11099_/B VPWR VGND sg13cmos5l_nor2_1
XFILLER_65_958 VPWR VGND sg13cmos5l_fill_1
Xinput9 input9/X ui_in[1] VPWR VGND sg13cmos5l_buf_1
XFILLER_18_852 VPWR VGND sg13cmos5l_fill_1
XFILLER_33_811 VPWR VGND sg13cmos5l_fill_2
XFILLER_33_822 VPWR VGND sg13cmos5l_fill_2
X_12998_ _14487_/D _12998_/A _13002_/D VPWR VGND sg13cmos5l_xor2_1
X_11949_ _11949_/Y _07751_/B _12124_/A2 _12162_/B VPWR VGND sg13cmos5l_a21oi_1
Xclkbuf_leaf_71_clk clkload64/A clkload5/A VPWR VGND sg13cmos5l_buf_8
X_13619_ _13619_/Q clkload17/A _13619_/D _13619_/RESET_B VPWR VGND sg13cmos5l_dfrbpq_1
X_14599_ _14599_/Q _14640_/CLK _14599_/D _14599_/RESET_B VPWR VGND sg13cmos5l_dfrbpq_1
XFILLER_58_0 VPWR VGND sg13cmos5l_fill_2
X_07973_ _07973_/X _07973_/A _08409_/B VPWR VGND sg13cmos5l_and2_1
X_09712_ _09712_/Y _09712_/A _09724_/B VPWR VGND sg13cmos5l_nor2_1
XFILLER_56_958 VPWR VGND sg13cmos5l_fill_1
XFILLER_68_796 VPWR VGND sg13cmos5l_fill_2
X_09643_ _11498_/B _14430_/Q _14649_/Q _09662_/S VPWR VGND sg13cmos5l_mux2_1
X_13613__1778 _13613_/RESET_B VPWR VGND sg13cmos5l_tiehi
X_09574_ _11343_/B _14420_/Q _14639_/Q _09615_/S VPWR VGND sg13cmos5l_mux2_1
XFILLER_83_788 VPWR VGND sg13cmos5l_fill_2
X_08525_ _08525_/Y _07686_/A _08520_/Y _07685_/Y VPWR VGND sg13cmos5l_o21ai_1
Xclkbuf_leaf_62_clk _14020_/CLK clkbuf_4_14_0_clk/X VPWR VGND sg13cmos5l_buf_8
X_08456_ _08457_/B _08456_/A _08456_/B _08456_/C VPWR VGND sg13cmos5l_or3_1
XFILLER_11_516 VPWR VGND sg13cmos5l_fill_1
XFILLER_11_538 VPWR VGND sg13cmos5l_fill_2
X_07407_ _07416_/A _07629_/A _07407_/B _07407_/C _07407_/D VPWR VGND sg13cmos5l_nand4_1
X_08387_ _08387_/X _13519_/Q _13487_/Q _08390_/S VPWR VGND sg13cmos5l_mux2_1
X_14265__1812 _14265_/RESET_B VPWR VGND sg13cmos5l_tiehi
XFILLER_7_509 VPWR VGND sg13cmos5l_fill_1
X_07338_ _07338_/Y _14142_/Q VPWR VGND sg13cmos5l_inv_1
X_07269_ _11660_/B _13230_/Q VPWR VGND sg13cmos5l_inv_1
X_09008_ _13283_/D _08970_/A _09012_/B _09007_/Y VPWR VGND sg13cmos5l_a21oi_1
X_10280_ _10280_/Y _10280_/A _10280_/B VPWR VGND sg13cmos5l_nor2_1
XFILLER_104_120 VPWR VGND sg13cmos5l_fill_1
Xfanout551 _13180_/B _08913_/Y VPWR VGND sg13cmos5l_buf_1
Xfanout540 _12792_/A _11008_/Y VPWR VGND sg13cmos5l_buf_1
XFILLER_59_763 VPWR VGND sg13cmos5l_decap_8
XFILLER_59_774 VPWR VGND sg13cmos5l_fill_2
Xfanout584 fanout584/X _08643_/Y VPWR VGND sg13cmos5l_buf_1
Xfanout573 _12398_/B1 _08644_/Y VPWR VGND sg13cmos5l_buf_1
Xfanout562 _11697_/B _11780_/B VPWR VGND sg13cmos5l_buf_1
X_13970_ _13970_/Q clkload54/A _13970_/D _13970_/RESET_B VPWR VGND sg13cmos5l_dfrbpq_1
XFILLER_19_638 VPWR VGND sg13cmos5l_fill_1
XFILLER_76_78 VPWR VGND sg13cmos5l_fill_1
Xfanout595 _11865_/A _12378_/B1 VPWR VGND sg13cmos5l_buf_1
X_12921_ _12922_/A hold3497/X _11262_/B _11303_/B _12923_/B2 VPWR VGND sg13cmos5l_a22oi_1
XFILLER_46_457 VPWR VGND sg13cmos5l_decap_4
XFILLER_74_777 VPWR VGND sg13cmos5l_fill_2
XFILLER_15_800 VPWR VGND sg13cmos5l_fill_2
XFILLER_61_416 VPWR VGND sg13cmos5l_fill_2
X_12852_ _12852_/Y _12859_/A _12850_/X _12851_/X fanout60/X VPWR VGND sg13cmos5l_a22oi_1
XFILLER_61_438 VPWR VGND sg13cmos5l_decap_8
X_11803_ _11803_/Y _13723_/Q _11944_/A1 _11944_/B2 _13979_/Q _11695_/B VPWR VGND sg13cmos5l_a221oi_1
Xclkbuf_leaf_53_clk clkload81/A clkload7/A VPWR VGND sg13cmos5l_buf_8
X_12783_ _12788_/C _12783_/A _12783_/B _12785_/B VPWR VGND sg13cmos5l_nand3_1
XFILLER_70_961 VPWR VGND sg13cmos5l_fill_2
X_11734_ _11734_/Y _07829_/B _11868_/A2 _11816_/B1 _12620_/A _11624_/B VPWR VGND sg13cmos5l_a221oi_1
X_14522_ _14522_/Q clkload21/A _14522_/D fanout964/X VPWR VGND sg13cmos5l_dfrbpq_1
X_13768__1623 _13768_/RESET_B VPWR VGND sg13cmos5l_tiehi
X_11665_ _11665_/Y _08732_/Y _11793_/A1 _11664_/Y VPWR VGND sg13cmos5l_o21ai_1
X_14453_ _14453_/Q _14453_/CLK _14453_/D _14453_/RESET_B VPWR VGND sg13cmos5l_dfrbpq_1
X_10616_ _13038_/B _13040_/C _13040_/D VPWR VGND sg13cmos5l_nand2_1
Xclkbuf_4_6_0_clk clkbuf_4_6_0_clk/X clkbuf_0_clk/X VPWR VGND sg13cmos5l_buf_8
X_13456__1966 _13456_/RESET_B VPWR VGND sg13cmos5l_tiehi
X_13404_ _13404_/Q _14109_/CLK _13404_/D _13404_/RESET_B VPWR VGND sg13cmos5l_dfrbpq_1
X_11596_ _11607_/A _11596_/A _11598_/B VPWR VGND sg13cmos5l_nand2_1
X_14384_ _14384_/Q clkload69/A _14384_/D _14384_/RESET_B VPWR VGND sg13cmos5l_dfrbpq_1
X_10547_ _10547_/Y _10547_/A _10547_/B VPWR VGND sg13cmos5l_nand2_1
X_13335_ _13335_/Q clkload15/A _13335_/D _13335_/RESET_B VPWR VGND sg13cmos5l_dfrbpq_1
X_10478_ _10478_/Y _10478_/A _10478_/B VPWR VGND sg13cmos5l_nor2_1
X_13266_ _13266_/Q clkload19/A _13266_/D fanout986/X VPWR VGND sg13cmos5l_dfrbpq_1
X_12217_ _12217_/Y _12105_/A _12220_/A _12157_/Y VPWR VGND sg13cmos5l_o21ai_1
XFILLER_69_505 VPWR VGND sg13cmos5l_fill_1
XFILLER_69_527 VPWR VGND sg13cmos5l_decap_8
XFILLER_97_814 VPWR VGND sg13cmos5l_decap_4
X_13197_ _13300_/D _07354_/B _13197_/A2 _08440_/Y _08441_/Y VPWR VGND sg13cmos5l_a22oi_1
X_12148_ _12148_/Y _12142_/Y _12143_/Y _12403_/B1 VPWR VGND sg13cmos5l_a21oi_1
XFILLER_65_700 VPWR VGND sg13cmos5l_fill_1
X_12079_ _12079_/Y _12102_/B _12077_/Y _12078_/Y VPWR VGND sg13cmos5l_o21ai_1
XFILLER_2_75 VPWR VGND sg13cmos5l_fill_2
XFILLER_77_582 VPWR VGND sg13cmos5l_decap_4
XFILLER_25_608 VPWR VGND sg13cmos5l_fill_1
XFILLER_53_928 VPWR VGND sg13cmos5l_decap_4
XFILLER_65_799 VPWR VGND sg13cmos5l_decap_4
XFILLER_80_758 VPWR VGND sg13cmos5l_decap_8
Xclkbuf_leaf_44_clk clkload72/A clkload6/A VPWR VGND sg13cmos5l_buf_8
X_08310_ _08310_/Y _08314_/S _07312_/Y _08310_/B1 VPWR VGND sg13cmos5l_a21oi_1
X_09290_ _13412_/D _09219_/A hold3096/X _09297_/S VPWR VGND sg13cmos5l_mux2_1
X_13324__2098 _13324_/RESET_B VPWR VGND sg13cmos5l_tiehi
X_08241_ _08241_/Y _08315_/A _11035_/A1 _08234_/Y _08236_/Y _08240_/Y VPWR VGND sg13cmos5l_a221oi_1
X_08172_ _08174_/B _14531_/Q _11039_/A2 _08209_/B1 _14479_/Q VPWR VGND sg13cmos5l_a22oi_1
X_13501__1921 _13501_/RESET_B VPWR VGND sg13cmos5l_tiehi
XFILLER_0_718 VPWR VGND sg13cmos5l_fill_1
XFILLER_88_814 VPWR VGND sg13cmos5l_decap_8
Xhold2901 _10189_/A _13858_/Q VPWR VGND sg13cmos5l_dlygate4sd3_1
Xhold2912 _10230_/A _13878_/Q VPWR VGND sg13cmos5l_dlygate4sd3_1
Xhold2923 _09155_/A _13322_/Q VPWR VGND sg13cmos5l_dlygate4sd3_1
XFILLER_87_379 VPWR VGND sg13cmos5l_fill_1
X_07956_ _07956_/Y input19/X _14575_/Q VPWR VGND sg13cmos5l_nand2b_1
Xhold2934 _10869_/A _14188_/Q VPWR VGND sg13cmos5l_dlygate4sd3_1
Xhold2945 _10386_/A _13955_/Q VPWR VGND sg13cmos5l_dlygate4sd3_1
Xhold2956 _09702_/A _13620_/Q VPWR VGND sg13cmos5l_dlygate4sd3_1
X_13846__1545 _13846_/RESET_B VPWR VGND sg13cmos5l_tiehi
Xhold2967 _09813_/A _13674_/Q VPWR VGND sg13cmos5l_dlygate4sd3_1
Xhold2978 hold2978/X _13205_/Q VPWR VGND sg13cmos5l_dlygate4sd3_1
Xhold2989 _11107_/A _14294_/Q VPWR VGND sg13cmos5l_dlygate4sd3_1
X_07887_ _07890_/A _14581_/D _08908_/B _08910_/C VPWR VGND sg13cmos5l_nor3_1
X_13534__1888 _13534_/RESET_B VPWR VGND sg13cmos5l_tiehi
XFILLER_56_799 VPWR VGND sg13cmos5l_fill_1
XFILLER_71_725 VPWR VGND sg13cmos5l_fill_2
X_09626_ _09626_/Y _09639_/A _09626_/B _09638_/C VPWR VGND sg13cmos5l_nor3_1
XFILLER_71_736 VPWR VGND sg13cmos5l_fill_1
X_09557_ _09557_/Y _09640_/A1 _11293_/B _09575_/D _09556_/Y VPWR VGND sg13cmos5l_a22oi_1
X_08508_ _08509_/B _08502_/A _08506_/Y _08502_/Y VPWR VGND sg13cmos5l_a21oi_1
X_09488_ _09488_/Y _09488_/A _09642_/B VPWR VGND sg13cmos5l_nor2_1
Xclkbuf_leaf_35_clk clkload44/A clkload3/A VPWR VGND sg13cmos5l_buf_8
X_08439_ _08440_/B _14312_/Q _14408_/Q _11197_/S VPWR VGND sg13cmos5l_mux2_1
X_11450_ _11451_/B _11450_/A _11450_/B VPWR VGND sg13cmos5l_nand2_1
X_10401_ _13962_/D _10597_/A1 _10410_/B _10400_/Y VPWR VGND sg13cmos5l_a21oi_1
X_11381_ _11381_/Y _11380_/A _11401_/C _11444_/A VPWR VGND sg13cmos5l_o21ai_1
X_10332_ _13928_/D _10397_/A1 _10339_/B _10331_/Y VPWR VGND sg13cmos5l_a21oi_1
X_13120_ _13121_/B _09443_/A _13119_/B _13119_/Y hold3477/X VPWR VGND sg13cmos5l_a22oi_1
X_13051_ _13055_/C _13051_/A _13052_/B VPWR VGND sg13cmos5l_nor2_1
XFILLER_106_985 VPWR VGND sg13cmos5l_decap_8
XFILLER_2_2 VPWR VGND sg13cmos5l_fill_1
X_10263_ _13894_/D fanout80/X _10278_/B _10262_/Y VPWR VGND sg13cmos5l_a21oi_1
X_12002_ _12002_/Y _12002_/A VPWR VGND sg13cmos5l_inv_1
X_10194_ _13860_/D _10585_/A1 _10219_/B _10193_/Y VPWR VGND sg13cmos5l_a21oi_1
XFILLER_78_346 VPWR VGND sg13cmos5l_fill_2
Xfanout392 _11793_/A1 _12408_/A1 VPWR VGND sg13cmos5l_buf_1
Xfanout381 _08315_/A _08277_/A1 VPWR VGND sg13cmos5l_buf_1
Xfanout370 _08214_/A _07993_/A VPWR VGND sg13cmos5l_buf_1
XFILLER_59_593 VPWR VGND sg13cmos5l_fill_1
X_13953_ _13953_/Q clkload58/A _13953_/D _13953_/RESET_B VPWR VGND sg13cmos5l_dfrbpq_1
XFILLER_62_714 VPWR VGND sg13cmos5l_fill_1
X_13884_ _13884_/Q clkload47/A _13884_/D _13884_/RESET_B VPWR VGND sg13cmos5l_dfrbpq_1
X_12904_ _14439_/D _12904_/A VPWR VGND sg13cmos5l_inv_1
XFILLER_46_298 VPWR VGND sg13cmos5l_fill_1
XFILLER_62_747 VPWR VGND sg13cmos5l_decap_8
XFILLER_74_596 VPWR VGND sg13cmos5l_fill_1
X_14333__1175 _14333_/RESET_B VPWR VGND sg13cmos5l_tiehi
X_12835_ _14430_/D _12275_/B _12834_/Y _12893_/B1 VPWR VGND sg13cmos5l_a21oi_1
XFILLER_15_663 VPWR VGND sg13cmos5l_fill_1
XFILLER_43_961 VPWR VGND sg13cmos5l_fill_2
Xclkbuf_leaf_26_clk clkload31/A clkload2/A VPWR VGND sg13cmos5l_buf_8
XFILLER_43_983 VPWR VGND sg13cmos5l_fill_2
X_14505_ _15884_/A clkload9/A _14505_/D fanout960/X VPWR VGND sg13cmos5l_dfrbpq_1
X_12766_ _12784_/B _14453_/Q _13243_/Q _13244_/Q _14454_/Q VPWR VGND sg13cmos5l_a22oi_1
X_11717_ _11717_/X _13816_/Q _11697_/B _08653_/B VPWR VGND sg13cmos5l_a21o_1
X_12697_ _12698_/B _12697_/A _12700_/B VPWR VGND sg13cmos5l_nand2_1
XFILLER_30_666 VPWR VGND sg13cmos5l_fill_2
X_11648_ _11650_/A _11656_/A _13229_/Q VPWR VGND sg13cmos5l_xnor2_1
Xinput12 input12/X ui_in[4] VPWR VGND sg13cmos5l_buf_1
X_14436_ _14436_/Q clkload73/A _14436_/D _14436_/RESET_B VPWR VGND sg13cmos5l_dfrbpq_1
XFILLER_7_840 VPWR VGND sg13cmos5l_fill_1
X_11579_ _11580_/B _11553_/B _11575_/C _11563_/A VPWR VGND sg13cmos5l_o21ai_1
X_14367_ _14367_/Q clkload80/A _14367_/D _14367_/RESET_B VPWR VGND sg13cmos5l_dfrbpq_1
X_13924__1467 _13924_/RESET_B VPWR VGND sg13cmos5l_tiehi
X_13318_ _13318_/Q clkload81/A _13318_/D _13318_/RESET_B VPWR VGND sg13cmos5l_dfrbpq_1
X_14298_ _14298_/Q clkload22/A _14298_/D _14298_/RESET_B VPWR VGND sg13cmos5l_dfrbpq_1
X_13249_ _13249_/Q clkload80/A _13249_/D _13249_/RESET_B VPWR VGND sg13cmos5l_dfrbpq_1
XFILLER_69_357 VPWR VGND sg13cmos5l_fill_2
XFILLER_85_806 VPWR VGND sg13cmos5l_fill_1
X_07810_ _07810_/Y _14403_/Q _07810_/B VPWR VGND sg13cmos5l_nor2_1
X_08790_ _08791_/C _14582_/D _08819_/B _08841_/B VPWR VGND sg13cmos5l_a21oi_1
X_14264__1811 _14264_/RESET_B VPWR VGND sg13cmos5l_tiehi
X_07741_ _08488_/C _11121_/A _11740_/A _07740_/Y VPWR VGND sg13cmos5l_o21ai_1
XFILLER_65_552 VPWR VGND sg13cmos5l_decap_8
XFILLER_65_574 VPWR VGND sg13cmos5l_fill_1
X_07672_ _07674_/A _14387_/Q _14355_/Q VPWR VGND sg13cmos5l_nor2_1
X_09411_ _13522_/D _10679_/A1 hold3163/X _09434_/S VPWR VGND sg13cmos5l_mux2_1
XFILLER_34_972 VPWR VGND sg13cmos5l_fill_1
X_09342_ _09342_/Y _13140_/A _09342_/B VPWR VGND sg13cmos5l_nand2_1
Xclkbuf_leaf_17_clk _14117_/CLK clkbuf_4_4_0_clk/X VPWR VGND sg13cmos5l_buf_8
XFILLER_61_791 VPWR VGND sg13cmos5l_decap_8
X_13519__1903 _13519_/RESET_B VPWR VGND sg13cmos5l_tiehi
XFILLER_33_493 VPWR VGND sg13cmos5l_fill_1
X_09273_ _13397_/D _09414_/A0 hold3133/X _09280_/S VPWR VGND sg13cmos5l_mux2_1
X_08224_ _08224_/X _13570_/Q _13538_/Q _08258_/S VPWR VGND sg13cmos5l_mux2_1
X_08155_ _08156_/D _08155_/A _08155_/B VPWR VGND sg13cmos5l_and2_1
X_08086_ _13205_/D _13140_/A _08086_/B _08086_/C VPWR VGND sg13cmos5l_nor3_1
Xhold3443 _09022_/A _13293_/Q VPWR VGND sg13cmos5l_dlygate4sd3_1
Xhold3432 hold3432/X _15887_/A VPWR VGND sg13cmos5l_dlygate4sd3_1
Xhold3421 hold3421/X _13459_/Q VPWR VGND sg13cmos5l_dlygate4sd3_1
Xhold3410 _08869_/A _14602_/Q VPWR VGND sg13cmos5l_dlygate4sd3_1
X_14411__1097 _14411_/RESET_B VPWR VGND sg13cmos5l_tiehi
XFILLER_102_443 VPWR VGND sg13cmos5l_fill_1
XFILLER_103_955 VPWR VGND sg13cmos5l_fill_1
Xhold2720 _12992_/A _14484_/Q VPWR VGND sg13cmos5l_dlygate4sd3_1
Xhold2731 _11054_/A _14281_/Q VPWR VGND sg13cmos5l_dlygate4sd3_1
Xhold3476 hold3476/X _14561_/Q VPWR VGND sg13cmos5l_dlygate4sd3_1
Xhold3465 hold3465/X _14220_/Q VPWR VGND sg13cmos5l_dlygate4sd3_1
Xhold3454 hold3454/X _14233_/Q VPWR VGND sg13cmos5l_dlygate4sd3_1
XFILLER_57_36 VPWR VGND sg13cmos5l_fill_1
X_08988_ _13276_/D _08994_/B _08986_/Y _08987_/Y VPWR VGND sg13cmos5l_o21ai_1
Xhold2742 _09706_/A _13622_/Q VPWR VGND sg13cmos5l_dlygate4sd3_1
Xhold2753 _10203_/A _13865_/Q VPWR VGND sg13cmos5l_dlygate4sd3_1
Xhold2764 _10236_/A _13881_/Q VPWR VGND sg13cmos5l_dlygate4sd3_1
Xhold3498 hold3498/X _14560_/Q VPWR VGND sg13cmos5l_dlygate4sd3_1
Xhold3487 hold3487/X _14227_/Q VPWR VGND sg13cmos5l_dlygate4sd3_1
XFILLER_68_390 VPWR VGND sg13cmos5l_fill_2
XFILLER_91_809 VPWR VGND sg13cmos5l_fill_1
X_07939_ _07939_/X _11622_/A _07939_/B _07939_/C _07939_/D VPWR VGND sg13cmos5l_and4_1
Xhold2775 _09856_/A _13695_/Q VPWR VGND sg13cmos5l_dlygate4sd3_1
Xhold2786 _11207_/A _14315_/Q VPWR VGND sg13cmos5l_dlygate4sd3_1
Xhold2797 _09838_/A _13686_/Q VPWR VGND sg13cmos5l_dlygate4sd3_1
XFILLER_29_788 VPWR VGND sg13cmos5l_fill_2
X_10950_ _10950_/Y _10950_/A _10952_/B VPWR VGND sg13cmos5l_nand2_1
XFILLER_16_427 VPWR VGND sg13cmos5l_fill_2
X_09609_ _11421_/B _14425_/Q _14644_/Q _09615_/S VPWR VGND sg13cmos5l_mux2_1
X_10881_ _10881_/Y _10881_/A _10952_/B VPWR VGND sg13cmos5l_nand2_1
X_12620_ _14411_/D _12620_/A _12620_/B _12620_/C VPWR VGND sg13cmos5l_nand3_1
X_12551_ _12551_/Y _12636_/C _12549_/X _12550_/X _12637_/C VPWR VGND sg13cmos5l_a22oi_1
X_11502_ _11502_/X _11514_/C _11502_/B VPWR VGND sg13cmos5l_xor2_1
X_12482_ _14388_/D _12485_/B _12481_/Y _12479_/Y VPWR VGND sg13cmos5l_o21ai_1
XFILLER_11_198 VPWR VGND sg13cmos5l_fill_1
XFILLER_8_648 VPWR VGND sg13cmos5l_decap_4
X_11433_ _11433_/Y _11433_/A1 _11428_/Y _11432_/Y _10982_/Y VPWR VGND sg13cmos5l_a22oi_1
X_14221_ _14221_/Q clkload44/A _14221_/D _14221_/RESET_B VPWR VGND sg13cmos5l_dfrbpq_1
XFILLER_22_94 VPWR VGND sg13cmos5l_fill_1
X_14152_ _14152_/Q clkload10/A _14152_/D fanout989/X VPWR VGND sg13cmos5l_dfrbpq_1
X_11364_ _11366_/B _11350_/B _11388_/B _11388_/A VPWR VGND sg13cmos5l_a21oi_1
X_10315_ _10315_/Y _10315_/A _10315_/B VPWR VGND sg13cmos5l_nor2_1
X_11295_ _11312_/A _14177_/Q _11303_/B VPWR VGND sg13cmos5l_nand2_1
X_14083_ _14083_/Q clkload42/A _14083_/D _14083_/RESET_B VPWR VGND sg13cmos5l_dfrbpq_1
X_13103_ _13107_/C _13104_/A _13104_/B VPWR VGND sg13cmos5l_and2_1
XFILLER_3_364 VPWR VGND sg13cmos5l_fill_1
X_10246_ _10246_/Y _10246_/A _10280_/B VPWR VGND sg13cmos5l_nor2_1
X_13034_ _13034_/Y _13034_/A _13034_/B _13034_/C VPWR VGND sg13cmos5l_nand3_1
X_10177_ _10177_/Y _10177_/A _10189_/B VPWR VGND sg13cmos5l_nor2_1
XFILLER_14_7 VPWR VGND sg13cmos5l_fill_2
X_13936_ _13936_/Q clkload61/A _13936_/D _13936_/RESET_B VPWR VGND sg13cmos5l_dfrbpq_1
XFILLER_74_371 VPWR VGND sg13cmos5l_fill_1
X_13867_ _13867_/Q clkload62/A _13867_/D _13867_/RESET_B VPWR VGND sg13cmos5l_dfrbpq_1
X_13798_ _13798_/Q clkload55/A _13798_/D _13798_/RESET_B VPWR VGND sg13cmos5l_dfrbpq_1
X_12818_ _12818_/Y _12859_/A _12818_/B _12818_/C VPWR VGND sg13cmos5l_nand3_1
X_14461__1035 _14461_/RESET_B VPWR VGND sg13cmos5l_tiehi
X_12749_ _12750_/A _12789_/A _12788_/A VPWR VGND sg13cmos5l_or2_1
X_14419_ _14419_/Q clkload67/A _14419_/D _14419_/RESET_B VPWR VGND sg13cmos5l_dfrbpq_1
XFILLER_89_408 VPWR VGND sg13cmos5l_fill_1
X_09960_ _09960_/Y _10482_/A _10090_/B VPWR VGND sg13cmos5l_nand2_1
Xclkbuf_leaf_6_clk _14520_/CLK clkload0/A VPWR VGND sg13cmos5l_buf_8
XFILLER_98_931 VPWR VGND sg13cmos5l_fill_2
X_08911_ _08912_/D _08911_/A _08911_/B VPWR VGND sg13cmos5l_nand2_1
XFILLER_97_441 VPWR VGND sg13cmos5l_decap_4
X_09891_ _13712_/D fanout57/X _09890_/B _09890_/Y VPWR VGND sg13cmos5l_a21oi_1
XFILLER_100_925 VPWR VGND sg13cmos5l_decap_8
XFILLER_85_636 VPWR VGND sg13cmos5l_fill_1
XFILLER_98_986 VPWR VGND sg13cmos5l_decap_4
X_08842_ _14638_/D _08842_/A _08842_/B _08842_/C _08842_/D VPWR VGND sg13cmos5l_nand4_1
XFILLER_100_958 VPWR VGND sg13cmos5l_fill_1
XFILLER_73_809 VPWR VGND sg13cmos5l_fill_1
X_08773_ _08773_/Y _08781_/A1 _14156_/Q _13265_/Q _08781_/B2 VPWR VGND sg13cmos5l_a22oi_1
X_07724_ _08455_/A _08457_/A _07724_/B VPWR VGND sg13cmos5l_nand2_1
X_07655_ _07657_/A _14397_/Q _12187_/A VPWR VGND sg13cmos5l_nand2_1
X_13451__1971 _13451_/RESET_B VPWR VGND sg13cmos5l_tiehi
X_07586_ _07590_/B _08970_/A _12963_/C _07399_/B VPWR VGND sg13cmos5l_o21ai_1
XFILLER_80_396 VPWR VGND sg13cmos5l_fill_1
X_09325_ _13441_/D _08206_/A hold3083/X _09341_/S VPWR VGND sg13cmos5l_mux2_1
X_13796__1595 _13796_/RESET_B VPWR VGND sg13cmos5l_tiehi
X_09256_ _13381_/D _08257_/A hold3019/X _09266_/S VPWR VGND sg13cmos5l_mux2_1
X_14429__1079 _14429_/RESET_B VPWR VGND sg13cmos5l_tiehi
X_08207_ _08210_/A _14081_/Q _08207_/A2 _08207_/B1 _13225_/Q VPWR VGND sg13cmos5l_a22oi_1
X_09187_ _11592_/A _14340_/Q _09193_/B VPWR VGND sg13cmos5l_nand2_1
X_08138_ _08140_/B _13219_/Q _08138_/B _08141_/D VPWR VGND sg13cmos5l_nand3_1
X_08069_ _08070_/C hold3178/X _08068_/Y _08066_/A VPWR VGND sg13cmos5l_a21oi_1
X_10100_ _13814_/D _10557_/A1 _10099_/B _10099_/Y VPWR VGND sg13cmos5l_o21ai_1
X_11080_ _11080_/Y _14387_/Q _11088_/A2 _11079_/X VPWR VGND sg13cmos5l_a21oi_1
XFILLER_1_879 VPWR VGND sg13cmos5l_fill_1
XFILLER_68_68 VPWR VGND sg13cmos5l_fill_2
X_10031_ _13780_/D _10553_/A1 _10044_/B _10030_/Y VPWR VGND sg13cmos5l_o21ai_1
Xhold3240 _13584_/D _09474_/X VPWR VGND sg13cmos5l_dlygate4sd3_1
Xhold3251 _13342_/D _09213_/X VPWR VGND sg13cmos5l_dlygate4sd3_1
XFILLER_88_485 VPWR VGND sg13cmos5l_decap_8
Xhold3284 hold3284/X _13366_/Q VPWR VGND sg13cmos5l_dlygate4sd3_1
Xhold3273 hold3273/X _13582_/Q VPWR VGND sg13cmos5l_dlygate4sd3_1
Xhold3262 hold3262/X _13577_/Q VPWR VGND sg13cmos5l_dlygate4sd3_1
Xhold2550 _10262_/A _13894_/Q VPWR VGND sg13cmos5l_dlygate4sd3_1
Xhold2561 _09498_/A _13588_/Q VPWR VGND sg13cmos5l_dlygate4sd3_1
Xhold2572 _10347_/A _13936_/Q VPWR VGND sg13cmos5l_dlygate4sd3_1
Xhold2583 _10070_/A _13800_/Q VPWR VGND sg13cmos5l_dlygate4sd3_1
Xhold3295 hold3295/X _13407_/Q VPWR VGND sg13cmos5l_dlygate4sd3_1
XFILLER_57_861 VPWR VGND sg13cmos5l_fill_2
Xhold2594 _10364_/A _13944_/Q VPWR VGND sg13cmos5l_dlygate4sd3_1
XFILLER_1_1017 VPWR VGND sg13cmos5l_decap_8
XFILLER_1_1028 VPWR VGND sg13cmos5l_fill_1
XFILLER_72_831 VPWR VGND sg13cmos5l_fill_2
XFILLER_72_842 VPWR VGND sg13cmos5l_decap_8
XFILLER_95_1024 VPWR VGND sg13cmos5l_decap_4
X_11982_ _11983_/B _11982_/A _11982_/B VPWR VGND sg13cmos5l_nor2_1
X_13721_ _13721_/Q clkload48/A _13721_/D _13721_/RESET_B VPWR VGND sg13cmos5l_dfrbpq_1
XFILLER_16_257 VPWR VGND sg13cmos5l_fill_2
XFILLER_17_72 VPWR VGND sg13cmos5l_fill_1
X_10933_ _10933_/Y _10844_/Y _10929_/Y _10932_/Y VPWR VGND sg13cmos5l_o21ai_1
X_10864_ _10864_/Y _10864_/A _10932_/B VPWR VGND sg13cmos5l_nand2_1
X_13652_ _13652_/Q clkload18/A _13652_/D _13652_/RESET_B VPWR VGND sg13cmos5l_dfrbpq_1
XFILLER_31_227 VPWR VGND sg13cmos5l_fill_2
X_10795_ _10795_/Y _10801_/A _14303_/Q VPWR VGND sg13cmos5l_nand2_1
X_13626__1765 _13626_/RESET_B VPWR VGND sg13cmos5l_tiehi
X_13583_ _13583_/Q clkload34/A _13583_/D _13583_/RESET_B VPWR VGND sg13cmos5l_dfrbpq_1
X_12603_ _12603_/X _14441_/Q _13231_/Q VPWR VGND sg13cmos5l_xor2_1
XFILLER_13_964 VPWR VGND sg13cmos5l_fill_1
XFILLER_13_986 VPWR VGND sg13cmos5l_fill_2
X_12534_ _12537_/A _14402_/Q _12541_/B VPWR VGND sg13cmos5l_nand2_1
XFILLER_33_93 VPWR VGND sg13cmos5l_fill_2
X_14263__1810 _14263_/RESET_B VPWR VGND sg13cmos5l_tiehi
XFILLER_69_8 VPWR VGND sg13cmos5l_fill_1
XFILLER_8_467 VPWR VGND sg13cmos5l_fill_1
X_12465_ _12467_/A _08646_/A _13237_/Q _12464_/Y VPWR VGND sg13cmos5l_o21ai_1
X_11416_ _11416_/Y _11431_/A _11416_/B VPWR VGND sg13cmos5l_xnor2_1
X_14204_ _14204_/Q _14217_/CLK _14204_/D _14204_/RESET_B VPWR VGND sg13cmos5l_dfrbpq_1
X_14006__1385 _14006_/RESET_B VPWR VGND sg13cmos5l_tiehi
X_12396_ _12396_/Y _12392_/Y _12393_/Y _12394_/Y _12395_/Y VPWR VGND sg13cmos5l_a22oi_1
X_11347_ _11363_/B _14094_/Q _11347_/B VPWR VGND sg13cmos5l_nand2_1
X_14135_ _14135_/Q clkload22/A _14135_/D fanout989/X VPWR VGND sg13cmos5l_dfrbpq_1
X_13841__1550 _13841_/RESET_B VPWR VGND sg13cmos5l_tiehi
X_13493__1929 _13493_/RESET_B VPWR VGND sg13cmos5l_tiehi
XFILLER_79_452 VPWR VGND sg13cmos5l_fill_2
X_11278_ _14319_/D _11276_/Y _11277_/Y _11262_/Y VPWR VGND sg13cmos5l_o21ai_1
X_14066_ _14066_/Q clkload8/A _14066_/D fanout960/X VPWR VGND sg13cmos5l_dfrbpq_1
X_10229_ _13877_/D _10425_/A1 _10230_/B _10228_/Y VPWR VGND sg13cmos5l_a21oi_1
X_13017_ _13021_/B _14496_/Q _14497_/Q _13020_/D VPWR VGND sg13cmos5l_nand3_1
XFILLER_66_113 VPWR VGND sg13cmos5l_fill_2
XFILLER_94_433 VPWR VGND sg13cmos5l_fill_2
XFILLER_63_875 VPWR VGND sg13cmos5l_fill_1
X_13919_ _13919_/Q _14045_/CLK _13919_/D _13919_/RESET_B VPWR VGND sg13cmos5l_dfrbpq_1
XFILLER_50_503 VPWR VGND sg13cmos5l_fill_1
X_07440_ _07440_/Y _14476_/Q _07530_/B1 _07528_/B1 _14492_/Q _07439_/Y VPWR VGND sg13cmos5l_a221oi_1
X_07371_ _07395_/A _14562_/Q _08964_/B _07573_/A VPWR VGND sg13cmos5l_o21ai_1
XFILLER_88_0 VPWR VGND sg13cmos5l_fill_1
X_09110_ _09110_/Y _14423_/Q _11374_/A VPWR VGND sg13cmos5l_nand2_1
XFILLER_30_282 VPWR VGND sg13cmos5l_fill_1
X_09041_ _09041_/Y _09065_/A2 _09041_/B VPWR VGND sg13cmos5l_nand2b_1
X_13469__1953 _13469_/RESET_B VPWR VGND sg13cmos5l_tiehi
X_09943_ _13737_/D _10595_/A1 _09942_/B _09942_/Y VPWR VGND sg13cmos5l_a21oi_1
Xfanout903 _07961_/A _14111_/Q VPWR VGND sg13cmos5l_buf_1
Xfanout914 _09445_/A0 _14100_/Q VPWR VGND sg13cmos5l_buf_1
Xfanout925 _12583_/A _07532_/A VPWR VGND sg13cmos5l_buf_1
X_14292__1216 _14292_/RESET_B VPWR VGND sg13cmos5l_tiehi
XFILLER_98_783 VPWR VGND sg13cmos5l_fill_1
X_09874_ _09874_/Y _09874_/A _09892_/B VPWR VGND sg13cmos5l_nor2_1
Xfanout936 _07614_/A _13302_/Q VPWR VGND sg13cmos5l_buf_1
Xfanout947 _10807_/A _13209_/Q VPWR VGND sg13cmos5l_buf_1
Xfanout958 fanout958/X fanout959/X VPWR VGND sg13cmos5l_buf_1
XFILLER_85_444 VPWR VGND sg13cmos5l_fill_2
X_08825_ _08825_/Y _08492_/A _08875_/B _08824_/Y VPWR VGND sg13cmos5l_o21ai_1
Xfanout969 fanout969/X fanout970/X VPWR VGND sg13cmos5l_buf_1
X_13704__1687 _13704_/RESET_B VPWR VGND sg13cmos5l_tiehi
X_08756_ _08756_/Y _07261_/Y _07327_/Y _08755_/Y VPWR VGND sg13cmos5l_o21ai_1
XFILLER_53_341 VPWR VGND sg13cmos5l_fill_1
XFILLER_54_842 VPWR VGND sg13cmos5l_fill_1
XFILLER_54_864 VPWR VGND sg13cmos5l_fill_2
XFILLER_72_149 VPWR VGND sg13cmos5l_fill_2
X_07707_ _07844_/A _07707_/A _08500_/A _07707_/C VPWR VGND sg13cmos5l_nand3_1
X_08687_ _08687_/Y _08687_/A _08687_/B VPWR VGND sg13cmos5l_nor2_1
X_07638_ _07638_/Y _08975_/A _09001_/B VPWR VGND sg13cmos5l_nor2_1
X_13883__1508 _13883_/RESET_B VPWR VGND sg13cmos5l_tiehi
XFILLER_53_396 VPWR VGND sg13cmos5l_decap_4
X_07569_ _07582_/A _07569_/A _08999_/B VPWR VGND sg13cmos5l_xnor2_1
X_09308_ _13425_/D _07324_/Y _09307_/B _09307_/Y VPWR VGND sg13cmos5l_a21oi_1
XFILLER_21_260 VPWR VGND sg13cmos5l_fill_2
XFILLER_21_282 VPWR VGND sg13cmos5l_fill_1
XFILLER_70_36 VPWR VGND sg13cmos5l_fill_1
X_10580_ _10580_/Y _10580_/A _10582_/B VPWR VGND sg13cmos5l_nand2_1
XFILLER_103_1028 VPWR VGND sg13cmos5l_fill_1
X_09239_ _13364_/D _10681_/A1 hold3321/X _09258_/S VPWR VGND sg13cmos5l_mux2_1
X_12250_ _12251_/B _12352_/A _12519_/B _12249_/Y VPWR VGND sg13cmos5l_o21ai_1
X_13337__2085 _13337_/RESET_B VPWR VGND sg13cmos5l_tiehi
XFILLER_102_2 VPWR VGND sg13cmos5l_fill_1
X_11201_ _11211_/B _11200_/A _11200_/B _11200_/C VPWR VGND sg13cmos5l_a21o_1
X_12181_ _12181_/Y _14579_/Q _12181_/B VPWR VGND sg13cmos5l_nor2_1
X_11132_ _11132_/Y _11132_/A _11132_/B VPWR VGND sg13cmos5l_nor2_1
X_14596__2139 _14596_/RESET_B VPWR VGND sg13cmos5l_tiehi
XFILLER_89_750 VPWR VGND sg13cmos5l_fill_2
XFILLER_1_676 VPWR VGND sg13cmos5l_fill_2
X_11063_ _11063_/X _14375_/Q _11083_/B VPWR VGND sg13cmos5l_and2_1
XFILLER_49_658 VPWR VGND sg13cmos5l_fill_2
XFILLER_77_956 VPWR VGND sg13cmos5l_fill_1
XFILLER_95_44 VPWR VGND sg13cmos5l_fill_1
X_10014_ _13772_/D fanout78/X _10013_/B _10013_/Y VPWR VGND sg13cmos5l_o21ai_1
Xhold3070 hold3070/X _13406_/Q VPWR VGND sg13cmos5l_dlygate4sd3_1
Xhold3081 _09089_/A _13311_/Q VPWR VGND sg13cmos5l_dlygate4sd3_1
Xhold3092 hold3092/X _13526_/Q VPWR VGND sg13cmos5l_dlygate4sd3_1
XFILLER_76_455 VPWR VGND sg13cmos5l_fill_1
XFILLER_77_989 VPWR VGND sg13cmos5l_decap_8
Xhold2380 _10003_/A _13767_/Q VPWR VGND sg13cmos5l_dlygate4sd3_1
Xhold2391 _12495_/A _14392_/Q VPWR VGND sg13cmos5l_dlygate4sd3_1
XFILLER_91_436 VPWR VGND sg13cmos5l_decap_8
X_11965_ _11965_/Y _13857_/Q _11971_/A2 _12010_/C1 VPWR VGND sg13cmos5l_a21oi_1
X_10916_ _10916_/Y _10916_/A _10976_/B VPWR VGND sg13cmos5l_nand2_1
X_13859__1532 _13859_/RESET_B VPWR VGND sg13cmos5l_tiehi
X_13704_ _13704_/Q _14065_/CLK _13704_/D _13704_/RESET_B VPWR VGND sg13cmos5l_dfrbpq_1
X_11896_ _11896_/X _11979_/A _11896_/B VPWR VGND sg13cmos5l_or2_1
X_13635_ _13635_/Q clkload57/A _13635_/D _13635_/RESET_B VPWR VGND sg13cmos5l_dfrbpq_1
X_10847_ _10943_/A _14220_/Q _13166_/B VPWR VGND sg13cmos5l_nand2_1
X_13547__1875 _13547_/RESET_B VPWR VGND sg13cmos5l_tiehi
X_10778_ _10778_/Y _10778_/A _10778_/B VPWR VGND sg13cmos5l_nand2_1
X_14370__1138 _14370_/RESET_B VPWR VGND sg13cmos5l_tiehi
X_13566_ _13566_/Q clkload32/A _13566_/D _13566_/RESET_B VPWR VGND sg13cmos5l_dfrbpq_1
X_13497_ _13497_/Q _14102_/CLK _13497_/D _13497_/RESET_B VPWR VGND sg13cmos5l_dfrbpq_1
X_12517_ _14397_/D _07656_/A _12511_/B _12515_/Y _12516_/Y VPWR VGND sg13cmos5l_a22oi_1
X_14091__1316 _14091_/RESET_B VPWR VGND sg13cmos5l_tiehi
X_12448_ _12448_/Y _12448_/A _12460_/B VPWR VGND sg13cmos5l_nand2_1
X_12379_ _12379_/Y _12368_/Y _12371_/Y _12375_/Y _12378_/Y VPWR VGND sg13cmos5l_a22oi_1
XFILLER_5_86 VPWR VGND sg13cmos5l_fill_2
X_14118_ _14118_/Q clkload41/A _14118_/D fanout998/X VPWR VGND sg13cmos5l_dfrbpq_1
XFILLER_68_923 VPWR VGND sg13cmos5l_decap_8
X_14049_ _14049_/Q clkload58/A _14049_/D _14049_/RESET_B VPWR VGND sg13cmos5l_dfrbpq_1
XFILLER_67_433 VPWR VGND sg13cmos5l_fill_2
XFILLER_68_934 VPWR VGND sg13cmos5l_fill_2
XFILLER_55_617 VPWR VGND sg13cmos5l_fill_1
XFILLER_67_444 VPWR VGND sg13cmos5l_fill_2
XFILLER_68_989 VPWR VGND sg13cmos5l_decap_8
X_08610_ _08610_/Y _08610_/A _08610_/B _08610_/C VPWR VGND sg13cmos5l_nand3_1
XFILLER_83_959 VPWR VGND sg13cmos5l_fill_1
X_09590_ _09591_/B _14453_/Q _09583_/A _09617_/A VPWR VGND sg13cmos5l_o21ai_1
X_08541_ _08541_/Y _08852_/A _07767_/A _07764_/Y VPWR VGND sg13cmos5l_a21oi_1
XFILLER_23_514 VPWR VGND sg13cmos5l_fill_2
XFILLER_35_363 VPWR VGND sg13cmos5l_fill_2
X_08472_ _08473_/B _08471_/A _07736_/X _08471_/Y VPWR VGND sg13cmos5l_a21oi_1
XFILLER_23_525 VPWR VGND sg13cmos5l_decap_4
X_07423_ _07423_/Y _10807_/A _13040_/C VPWR VGND sg13cmos5l_nor2_1
X_07354_ _08961_/A _07369_/A _07354_/B VPWR VGND sg13cmos5l_nor2_1
X_07285_ _12100_/B _13247_/Q VPWR VGND sg13cmos5l_inv_1
X_14346__1162 _14346_/RESET_B VPWR VGND sg13cmos5l_tiehi
X_09024_ _09024_/Y _09024_/A _09024_/B VPWR VGND sg13cmos5l_nand2_1
XFILLER_85_1001 VPWR VGND sg13cmos5l_fill_1
Xfanout700 _10709_/S _10697_/S VPWR VGND sg13cmos5l_buf_1
XFILLER_59_901 VPWR VGND sg13cmos5l_fill_1
X_09926_ _09926_/Y _09926_/A _09942_/B VPWR VGND sg13cmos5l_nor2_1
Xfanout733 _08879_/A2 _07877_/Y VPWR VGND sg13cmos5l_buf_1
Xfanout722 _08895_/B _07882_/Y VPWR VGND sg13cmos5l_buf_1
Xfanout711 _11604_/B _07936_/B1 VPWR VGND sg13cmos5l_buf_1
X_13937__1454 _13937_/RESET_B VPWR VGND sg13cmos5l_tiehi
XFILLER_86_731 VPWR VGND sg13cmos5l_fill_2
Xfanout766 _11193_/A _08914_/B VPWR VGND sg13cmos5l_buf_1
Xfanout755 _12546_/A1 _07252_/Y VPWR VGND sg13cmos5l_buf_1
Xfanout744 _11614_/A _11601_/A VPWR VGND sg13cmos5l_buf_1
XFILLER_18_308 VPWR VGND sg13cmos5l_fill_2
X_09857_ _13695_/D _10379_/A1 _09878_/B _09856_/Y VPWR VGND sg13cmos5l_a21oi_1
Xfanout799 _08390_/S _08393_/A1 VPWR VGND sg13cmos5l_buf_1
Xfanout788 _08238_/S _08164_/S0 VPWR VGND sg13cmos5l_buf_1
Xfanout777 _08317_/A1 _14618_/Q VPWR VGND sg13cmos5l_buf_1
XFILLER_58_499 VPWR VGND sg13cmos5l_fill_1
X_08808_ _08808_/Y _08808_/A _08808_/B VPWR VGND sg13cmos5l_nand2_1
X_09788_ _13661_/D _10375_/A1 _09793_/B _09787_/Y VPWR VGND sg13cmos5l_a21oi_1
XFILLER_73_469 VPWR VGND sg13cmos5l_fill_1
X_08739_ _08739_/Y _13750_/Q _11809_/A2 _08743_/B _13814_/Q VPWR VGND sg13cmos5l_a22oi_1
XFILLER_26_341 VPWR VGND sg13cmos5l_fill_1
XFILLER_54_661 VPWR VGND sg13cmos5l_fill_2
XFILLER_82_970 VPWR VGND sg13cmos5l_decap_8
X_11750_ _11750_/Y _13881_/Q _11944_/B2 _11862_/B _13689_/Q _11749_/X VPWR VGND sg13cmos5l_a221oi_1
X_10701_ _14121_/D input14/X _09295_/A _10709_/S VPWR VGND sg13cmos5l_mux2_1
XFILLER_42_889 VPWR VGND sg13cmos5l_fill_2
X_11681_ _11681_/Y _11682_/A _11682_/B _11667_/Y VPWR VGND sg13cmos5l_o21ai_1
XFILLER_14_62 VPWR VGND sg13cmos5l_fill_1
X_10632_ _10636_/B _14072_/Q _14073_/Q _10635_/D VPWR VGND sg13cmos5l_nand3_1
X_13420_ _13420_/Q _14238_/CLK _13420_/D _13420_/RESET_B VPWR VGND sg13cmos5l_dfrbpq_1
X_10563_ _14041_/D _10563_/A1 _10566_/B _10562_/Y VPWR VGND sg13cmos5l_o21ai_1
X_13351_ _13351_/Q clkload29/A _13351_/D _13351_/RESET_B VPWR VGND sg13cmos5l_dfrbpq_1
X_12302_ _12302_/Y _14463_/Q _12302_/A2 _12300_/Y _12301_/Y VPWR VGND sg13cmos5l_a22oi_1
XFILLER_6_746 VPWR VGND sg13cmos5l_fill_1
X_10494_ _14007_/D _10559_/A1 _10519_/B _10493_/Y VPWR VGND sg13cmos5l_o21ai_1
X_13282_ _13282_/Q clkload20/A _13282_/D fanout985/X VPWR VGND sg13cmos5l_dfrbpq_1
X_12233_ _12233_/Y _14026_/Q _12237_/B _12243_/B1 VPWR VGND sg13cmos5l_a21oi_1
X_12164_ _12165_/D _12187_/A _12164_/B _12164_/C VPWR VGND sg13cmos5l_nand3_1
XFILLER_96_506 VPWR VGND sg13cmos5l_fill_2
X_11115_ _11115_/Y _11115_/A _11123_/B VPWR VGND sg13cmos5l_nor2_1
X_12095_ _12095_/Y _12100_/A _12164_/C VPWR VGND sg13cmos5l_nand2_1
X_11046_ _14276_/D _11097_/A _11099_/B _11045_/Y VPWR VGND sg13cmos5l_a21oi_1
XFILLER_39_81 VPWR VGND sg13cmos5l_fill_2
XFILLER_76_241 VPWR VGND sg13cmos5l_fill_1
XFILLER_77_753 VPWR VGND sg13cmos5l_fill_1
XFILLER_77_764 VPWR VGND sg13cmos5l_decap_8
XFILLER_49_477 VPWR VGND sg13cmos5l_decap_8
XFILLER_64_414 VPWR VGND sg13cmos5l_fill_1
XFILLER_64_425 VPWR VGND sg13cmos5l_fill_1
X_14424__1084 _14424_/RESET_B VPWR VGND sg13cmos5l_tiehi
XFILLER_18_897 VPWR VGND sg13cmos5l_fill_2
XFILLER_73_970 VPWR VGND sg13cmos5l_fill_2
XFILLER_92_789 VPWR VGND sg13cmos5l_fill_2
X_12997_ _13002_/D _14470_/Q _12997_/B _12997_/C VPWR VGND sg13cmos5l_nor3_1
XFILLER_73_992 VPWR VGND sg13cmos5l_fill_1
X_11948_ _12480_/B _11937_/Y _11941_/Y _11947_/Y _11948_/B2 VPWR VGND sg13cmos5l_a22oi_1
X_11879_ _11879_/Y _13982_/Q _12366_/B _12377_/B1 _13790_/Q _12427_/B1 VPWR VGND sg13cmos5l_a221oi_1
X_14598_ _14598_/Q clkload77/A _14598_/D _14598_/RESET_B VPWR VGND sg13cmos5l_dfrbpq_1
X_13618_ _13618_/Q _14631_/CLK _13618_/D _13618_/RESET_B VPWR VGND sg13cmos5l_dfrbpq_1
X_13549_ _13549_/Q clkload41/A _13549_/D _13549_/RESET_B VPWR VGND sg13cmos5l_dfrbpq_1
XFILLER_65_2 VPWR VGND sg13cmos5l_fill_1
XFILLER_87_528 VPWR VGND sg13cmos5l_decap_8
X_07972_ _14254_/D _14254_/Q _12596_/B _08368_/S VPWR VGND sg13cmos5l_mux2_1
X_09711_ _13624_/D _10561_/A1 _09714_/B _09710_/Y VPWR VGND sg13cmos5l_a21oi_1
XFILLER_56_937 VPWR VGND sg13cmos5l_fill_2
X_09642_ _09642_/Y _09642_/A _09642_/B VPWR VGND sg13cmos5l_nor2_1
XFILLER_83_767 VPWR VGND sg13cmos5l_fill_2
X_09573_ _13599_/D _09578_/B _10575_/A1 _09567_/Y VPWR VGND sg13cmos5l_a21oi_1
X_13621__1770 _13621_/RESET_B VPWR VGND sg13cmos5l_tiehi
XFILLER_24_801 VPWR VGND sg13cmos5l_fill_2
X_08524_ _08524_/Y _08536_/A _08524_/B VPWR VGND sg13cmos5l_nand2_1
X_08455_ _14584_/D _08455_/A _08455_/B VPWR VGND sg13cmos5l_xnor2_1
X_14595__2138 _14595_/RESET_B VPWR VGND sg13cmos5l_tiehi
XFILLER_50_174 VPWR VGND sg13cmos5l_fill_1
XFILLER_52_1000 VPWR VGND sg13cmos5l_fill_2
X_07406_ _07407_/D _07406_/A _07414_/A _07570_/A VPWR VGND sg13cmos5l_nor3_1
X_08386_ _08388_/B _08390_/S _13391_/Q _08385_/Y VPWR VGND sg13cmos5l_o21ai_1
X_14001__1390 _14001_/RESET_B VPWR VGND sg13cmos5l_tiehi
X_07337_ _07337_/Y _14141_/Q VPWR VGND sg13cmos5l_inv_1
XFILLER_13_1028 VPWR VGND sg13cmos5l_fill_1
X_07268_ _07268_/Y _13229_/Q VPWR VGND sg13cmos5l_inv_1
X_07199_ _11008_/A _10987_/B VPWR VGND sg13cmos5l_inv_1
X_09007_ _09007_/Y _09007_/A _09012_/B VPWR VGND sg13cmos5l_nor2_1
Xfanout541 _09617_/A _09663_/B1 VPWR VGND sg13cmos5l_buf_1
Xfanout530 _08307_/B _08157_/B VPWR VGND sg13cmos5l_buf_1
X_14169__1308 _14169_/RESET_B VPWR VGND sg13cmos5l_tiehi
XFILLER_47_904 VPWR VGND sg13cmos5l_fill_2
X_09909_ _13720_/D _10561_/A1 _09912_/B _09908_/Y VPWR VGND sg13cmos5l_a21oi_1
Xfanout574 _11752_/S _11753_/S VPWR VGND sg13cmos5l_buf_1
Xfanout563 _11780_/B _11934_/B1 VPWR VGND sg13cmos5l_buf_1
Xfanout552 _10865_/C _13166_/B VPWR VGND sg13cmos5l_buf_1
X_14205__1272 _14205_/RESET_B VPWR VGND sg13cmos5l_tiehi
Xfanout596 _12378_/B1 _08640_/X VPWR VGND sg13cmos5l_buf_1
Xfanout585 _12000_/B _12318_/B1 VPWR VGND sg13cmos5l_buf_1
X_12920_ _14447_/D _12920_/A VPWR VGND sg13cmos5l_inv_1
XFILLER_73_222 VPWR VGND sg13cmos5l_fill_2
X_12851_ _12851_/X _11092_/A _12570_/X _12879_/B1 VPWR VGND sg13cmos5l_a21o_1
XFILLER_62_918 VPWR VGND sg13cmos5l_fill_2
XFILLER_74_789 VPWR VGND sg13cmos5l_fill_2
X_11802_ _11802_/Y _14043_/Q _11939_/B _11862_/B _13787_/Q VPWR VGND sg13cmos5l_a22oi_1
XFILLER_54_480 VPWR VGND sg13cmos5l_decap_8
X_12782_ _12824_/A _14457_/Q _13247_/Q VPWR VGND sg13cmos5l_xor2_1
X_11733_ _12449_/B _11728_/Y _11732_/Y _11723_/Y VPWR VGND sg13cmos5l_o21ai_1
X_14521_ _14521_/Q clkload21/A _14521_/D fanout964/X VPWR VGND sg13cmos5l_dfrbpq_1
XFILLER_30_848 VPWR VGND sg13cmos5l_fill_2
X_11664_ _11664_/Y _12589_/A _11686_/B _11663_/Y _11851_/A _11658_/Y VPWR VGND sg13cmos5l_a221oi_1
X_14452_ _14452_/Q clkload67/A _14452_/D _14452_/RESET_B VPWR VGND sg13cmos5l_dfrbpq_1
X_10615_ _13040_/D _14470_/Q _12964_/A VPWR VGND sg13cmos5l_nor2b_1
X_13403_ _13403_/Q _14109_/CLK _13403_/D _13403_/RESET_B VPWR VGND sg13cmos5l_dfrbpq_1
X_11595_ _11595_/Y _11595_/A _11595_/B VPWR VGND sg13cmos5l_nor2_1
X_14383_ _14383_/Q clkload54/A _14383_/D _14383_/RESET_B VPWR VGND sg13cmos5l_dfrbpq_1
X_10546_ _14033_/D fanout56/X _10545_/B _10545_/Y VPWR VGND sg13cmos5l_o21ai_1
X_13334_ _13334_/Q clkload27/A _13334_/D _13334_/RESET_B VPWR VGND sg13cmos5l_dfrbpq_1
X_10477_ _13999_/D fanout62/X _10480_/B _10476_/Y VPWR VGND sg13cmos5l_a21oi_1
X_13663__1728 _13663_/RESET_B VPWR VGND sg13cmos5l_tiehi
X_13265_ _13265_/Q clkload18/A _13265_/D fanout986/X VPWR VGND sg13cmos5l_dfrbpq_1
X_12216_ _12216_/Y _12216_/A _12216_/B VPWR VGND sg13cmos5l_nor2_1
X_13196_ _13244_/D _07282_/Y _13196_/A2 _13196_/B1 _13195_/Y VPWR VGND sg13cmos5l_a22oi_1
X_12147_ _12147_/Y _12147_/A _12147_/B _12147_/C VPWR VGND sg13cmos5l_nand3_1
XFILLER_77_550 VPWR VGND sg13cmos5l_fill_2
XFILLER_96_369 VPWR VGND sg13cmos5l_fill_1
X_12078_ _12078_/Y _12102_/B _12077_/Y _12136_/A VPWR VGND sg13cmos5l_a21oi_1
X_14043__1348 _14043_/RESET_B VPWR VGND sg13cmos5l_tiehi
XFILLER_2_65 VPWR VGND sg13cmos5l_fill_1
XFILLER_49_263 VPWR VGND sg13cmos5l_fill_1
X_11029_ _11029_/Y _14241_/Q _11029_/B _11029_/C VPWR VGND sg13cmos5l_nor3_1
XFILLER_18_661 VPWR VGND sg13cmos5l_decap_4
XFILLER_52_417 VPWR VGND sg13cmos5l_fill_1
XFILLER_53_918 VPWR VGND sg13cmos5l_fill_2
XFILLER_80_715 VPWR VGND sg13cmos5l_fill_1
XFILLER_61_973 VPWR VGND sg13cmos5l_decap_8
X_13332__2090 _13332_/RESET_B VPWR VGND sg13cmos5l_tiehi
X_08240_ _08240_/Y _08315_/A _08238_/X _08239_/Y _08237_/X _08254_/A1 VPWR VGND sg13cmos5l_a221oi_1
XFILLER_21_848 VPWR VGND sg13cmos5l_fill_2
X_08171_ _08174_/A _13218_/Q _08207_/B1 _11039_/B1 _14495_/Q VPWR VGND sg13cmos5l_a22oi_1
X_13639__1752 _13639_/RESET_B VPWR VGND sg13cmos5l_tiehi
XFILLER_82_1004 VPWR VGND sg13cmos5l_fill_2
Xhold2902 _09948_/A _13740_/Q VPWR VGND sg13cmos5l_dlygate4sd3_1
Xhold2913 _09185_/A _13327_/Q VPWR VGND sg13cmos5l_dlygate4sd3_1
X_07955_ _14576_/D _13149_/A1 input18/X _07954_/Y VPWR VGND sg13cmos5l_o21ai_1
Xhold2924 _10476_/A _13999_/Q VPWR VGND sg13cmos5l_dlygate4sd3_1
Xhold2935 _13095_/A _14532_/Q VPWR VGND sg13cmos5l_dlygate4sd3_1
Xhold2946 _11081_/A _14288_/Q VPWR VGND sg13cmos5l_dlygate4sd3_1
Xhold2957 hold2957/X _14519_/Q VPWR VGND sg13cmos5l_dlygate4sd3_1
X_14019__1372 _14019_/RESET_B VPWR VGND sg13cmos5l_tiehi
XFILLER_68_572 VPWR VGND sg13cmos5l_decap_4
XFILLER_96_881 VPWR VGND sg13cmos5l_fill_2
XFILLER_96_892 VPWR VGND sg13cmos5l_fill_1
Xhold2968 hold2968/X _13446_/Q VPWR VGND sg13cmos5l_dlygate4sd3_1
Xhold2979 _10313_/A _13919_/Q VPWR VGND sg13cmos5l_dlygate4sd3_1
X_07886_ _07896_/A _14216_/Q _14214_/Q _14198_/Q _14199_/Q VPWR VGND sg13cmos5l_nor4_1
X_09625_ _09638_/C _14458_/Q _14454_/Q _09625_/C _09625_/D VPWR VGND sg13cmos5l_and4_1
X_13542__1880 _13542_/RESET_B VPWR VGND sg13cmos5l_tiehi
XFILLER_71_704 VPWR VGND sg13cmos5l_fill_2
XFILLER_83_586 VPWR VGND sg13cmos5l_fill_2
XFILLER_24_620 VPWR VGND sg13cmos5l_fill_2
X_09556_ _09556_/Y _09556_/A _09556_/B VPWR VGND sg13cmos5l_nor2_1
XFILLER_102_88 VPWR VGND sg13cmos5l_fill_2
X_08507_ _08518_/A _08497_/B _08504_/B _08505_/Y VPWR VGND sg13cmos5l_o21ai_1
X_09487_ _09487_/Y _11005_/B1 _14406_/Q _09486_/Y VPWR VGND sg13cmos5l_o21ai_1
X_08438_ _08438_/Y _14237_/Q _14229_/Q VPWR VGND sg13cmos5l_nand2_1
XFILLER_12_848 VPWR VGND sg13cmos5l_fill_1
X_08369_ _08369_/X _09302_/A _08409_/B VPWR VGND sg13cmos5l_and2_1
X_10400_ _10400_/Y _10400_/A _10410_/B VPWR VGND sg13cmos5l_nor2_1
X_11380_ _11403_/A _11380_/A _11401_/C VPWR VGND sg13cmos5l_and2_1
X_10331_ _10331_/Y _10331_/A _10339_/B VPWR VGND sg13cmos5l_nor2_1
X_10262_ _10262_/Y _10262_/A _10278_/B VPWR VGND sg13cmos5l_nor2_1
X_13050_ _14510_/D _13050_/A _13052_/B VPWR VGND sg13cmos5l_nor2b_1
XFILLER_106_964 VPWR VGND sg13cmos5l_decap_8
XFILLER_3_579 VPWR VGND sg13cmos5l_fill_1
X_12001_ _12002_/A _13826_/Q _12000_/B _11966_/B VPWR VGND sg13cmos5l_o21ai_1
XFILLER_79_848 VPWR VGND sg13cmos5l_decap_4
X_10193_ _10193_/Y _10193_/A _10219_/B VPWR VGND sg13cmos5l_nor2_1
X_13374__2048 _13374_/RESET_B VPWR VGND sg13cmos5l_tiehi
XFILLER_47_723 VPWR VGND sg13cmos5l_decap_8
XFILLER_87_881 VPWR VGND sg13cmos5l_decap_4
XFILLER_94_829 VPWR VGND sg13cmos5l_fill_1
Xfanout393 _12097_/A1 _12352_/A VPWR VGND sg13cmos5l_buf_1
Xfanout382 _11034_/A _08376_/A1 VPWR VGND sg13cmos5l_buf_1
Xfanout371 _08339_/B1 _07993_/A VPWR VGND sg13cmos5l_buf_1
Xfanout360 _09071_/B _08435_/Y VPWR VGND sg13cmos5l_buf_1
X_13952_ _13952_/Q _14048_/CLK _13952_/D _13952_/RESET_B VPWR VGND sg13cmos5l_dfrbpq_1
XFILLER_98_1022 VPWR VGND sg13cmos5l_decap_8
X_12903_ _12904_/A _12577_/A _11196_/B _11214_/A _12907_/B2 VPWR VGND sg13cmos5l_a22oi_1
XFILLER_28_970 VPWR VGND sg13cmos5l_fill_1
XFILLER_74_575 VPWR VGND sg13cmos5l_fill_2
X_13883_ _13883_/Q _14042_/CLK _13883_/D _13883_/RESET_B VPWR VGND sg13cmos5l_dfrbpq_1
XFILLER_34_439 VPWR VGND sg13cmos5l_fill_1
X_12834_ _12834_/Y _12859_/A _12832_/Y _12833_/X fanout59/X VPWR VGND sg13cmos5l_a22oi_1
X_12765_ _12783_/A _14455_/Q _13245_/Q VPWR VGND sg13cmos5l_xor2_1
X_11716_ _11716_/X _14040_/Q _13784_/Q _11719_/S VPWR VGND sg13cmos5l_mux2_1
X_14504_ _14504_/Q clkload21/A _14504_/D fanout985/X VPWR VGND sg13cmos5l_dfrbpq_1
X_13717__1674 _13717_/RESET_B VPWR VGND sg13cmos5l_tiehi
X_12696_ _14417_/D _12843_/A _12696_/B _12696_/C _12696_/D VPWR VGND sg13cmos5l_nand4_1
X_11647_ _11647_/Y _11656_/A _13229_/Q VPWR VGND sg13cmos5l_nand2_1
Xinput13 input13/X ui_in[5] VPWR VGND sg13cmos5l_buf_1
X_14435_ _14435_/Q _14654_/CLK _14435_/D _14435_/RESET_B VPWR VGND sg13cmos5l_dfrbpq_1
X_11578_ _11584_/A _11523_/A _11523_/B _11577_/Y VPWR VGND sg13cmos5l_o21ai_1
X_14366_ _14366_/Q clkload80/A _14366_/D _14366_/RESET_B VPWR VGND sg13cmos5l_dfrbpq_1
X_10529_ _10529_/Y _10529_/A _10537_/B VPWR VGND sg13cmos5l_nand2_1
X_13584__1838 _13584_/RESET_B VPWR VGND sg13cmos5l_tiehi
X_13317_ _13317_/Q _14453_/CLK _13317_/D _13317_/RESET_B VPWR VGND sg13cmos5l_dfrbpq_1
XFILLER_6_384 VPWR VGND sg13cmos5l_fill_1
X_14297_ _14297_/Q clkload26/A _14297_/D _14297_/RESET_B VPWR VGND sg13cmos5l_dfrbpq_1
X_13248_ _13248_/Q _14453_/CLK _13248_/D _13248_/RESET_B VPWR VGND sg13cmos5l_dfrbpq_1
XFILLER_97_623 VPWR VGND sg13cmos5l_fill_2
X_14594__2137 _14594_/RESET_B VPWR VGND sg13cmos5l_tiehi
X_13179_ _13179_/Y _11275_/A _14091_/Q _08917_/X hold3524/X VPWR VGND sg13cmos5l_a22oi_1
XFILLER_97_678 VPWR VGND sg13cmos5l_decap_4
XFILLER_38_701 VPWR VGND sg13cmos5l_fill_2
XFILLER_97_689 VPWR VGND sg13cmos5l_fill_1
X_07740_ _07740_/Y _08476_/B _07740_/B VPWR VGND sg13cmos5l_nand2_1
XFILLER_38_756 VPWR VGND sg13cmos5l_fill_1
X_07671_ _07768_/A _14390_/Q _14358_/Q VPWR VGND sg13cmos5l_nand2b_1
XFILLER_52_203 VPWR VGND sg13cmos5l_fill_2
XFILLER_80_523 VPWR VGND sg13cmos5l_decap_4
XFILLER_92_372 VPWR VGND sg13cmos5l_fill_1
X_09410_ _09410_/Y _09410_/A _09443_/B VPWR VGND sg13cmos5l_nand2_1
X_09341_ _13457_/D _09307_/A hold3119/X _09341_/S VPWR VGND sg13cmos5l_mux2_1
XFILLER_20_111 VPWR VGND sg13cmos5l_fill_1
X_09272_ _09272_/X _14101_/Q hold3203/X _09280_/S VPWR VGND sg13cmos5l_mux2_1
X_08223_ _08223_/X _08258_/S _13442_/Q VPWR VGND sg13cmos5l_or2_1
XFILLER_20_188 VPWR VGND sg13cmos5l_fill_1
X_08154_ _08156_/C _07634_/Y _08153_/Y _08155_/B VPWR VGND sg13cmos5l_a21oi_1
X_08085_ _08086_/C hold2978/X _08084_/Y _08082_/A VPWR VGND sg13cmos5l_a21oi_1
Xhold3400 hold3400/X _14172_/Q VPWR VGND sg13cmos5l_dlygate4sd3_1
X_14383__1125 _14383_/RESET_B VPWR VGND sg13cmos5l_tiehi
XFILLER_0_505 VPWR VGND sg13cmos5l_decap_4
XFILLER_0_538 VPWR VGND sg13cmos5l_decap_4
XFILLER_87_111 VPWR VGND sg13cmos5l_fill_2
Xhold3433 _07519_/A _14245_/Q VPWR VGND sg13cmos5l_dlygate4sd3_1
Xhold3422 _07205_/A _15893_/A VPWR VGND sg13cmos5l_dlygate4sd3_1
Xhold3411 hold3411/X _13432_/Q VPWR VGND sg13cmos5l_dlygate4sd3_1
XFILLER_76_818 VPWR VGND sg13cmos5l_fill_1
Xhold2710 _11590_/A _14340_/Q VPWR VGND sg13cmos5l_dlygate4sd3_1
Xhold2721 _14484_/D _12992_/X VPWR VGND sg13cmos5l_dlygate4sd3_1
Xhold2732 _09578_/A _13600_/Q VPWR VGND sg13cmos5l_dlygate4sd3_1
Xhold3466 hold3466/X _14559_/Q VPWR VGND sg13cmos5l_dlygate4sd3_1
Xhold3455 _13156_/A _14264_/Q VPWR VGND sg13cmos5l_dlygate4sd3_1
Xhold3444 hold3444/X _14243_/Q VPWR VGND sg13cmos5l_dlygate4sd3_1
X_08987_ _08987_/Y _08987_/A _08994_/B VPWR VGND sg13cmos5l_nand2_1
Xhold2743 _10219_/A _13873_/Q VPWR VGND sg13cmos5l_dlygate4sd3_1
Xhold2754 _09601_/A _13604_/Q VPWR VGND sg13cmos5l_dlygate4sd3_1
Xhold2765 _09620_/A _13606_/Q VPWR VGND sg13cmos5l_dlygate4sd3_1
Xhold3499 hold3499/X _14090_/Q VPWR VGND sg13cmos5l_dlygate4sd3_1
Xhold3488 hold3488/X _14215_/Q VPWR VGND sg13cmos5l_dlygate4sd3_1
Xhold3477 hold3477/X _14547_/Q VPWR VGND sg13cmos5l_dlygate4sd3_1
Xclkbuf_4_5_0_clk clkload2/A clkbuf_0_clk/X VPWR VGND sg13cmos5l_buf_8
XFILLER_102_499 VPWR VGND sg13cmos5l_fill_2
X_07938_ _07939_/D _10978_/B _11014_/B _11019_/A VPWR VGND sg13cmos5l_nand3_1
Xhold2776 _09902_/A _13717_/Q VPWR VGND sg13cmos5l_dlygate4sd3_1
Xhold2787 _09587_/A _13602_/Q VPWR VGND sg13cmos5l_dlygate4sd3_1
Xhold2798 _09161_/A _13323_/Q VPWR VGND sg13cmos5l_dlygate4sd3_1
XFILLER_84_851 VPWR VGND sg13cmos5l_fill_1
XFILLER_84_873 VPWR VGND sg13cmos5l_decap_8
X_07869_ _07869_/Y _10916_/A _07862_/X _07864_/X _07868_/X VPWR VGND sg13cmos5l_a22oi_1
XFILLER_16_439 VPWR VGND sg13cmos5l_fill_1
XFILLER_71_523 VPWR VGND sg13cmos5l_fill_2
XFILLER_73_36 VPWR VGND sg13cmos5l_fill_1
X_09608_ _09608_/Y _09608_/A _09682_/B VPWR VGND sg13cmos5l_nor2_1
X_10880_ _10922_/B _10877_/A _10880_/B VPWR VGND sg13cmos5l_nand2b_1
X_13974__1417 _13974_/RESET_B VPWR VGND sg13cmos5l_tiehi
X_09539_ _11263_/B _14415_/Q _14634_/Q _09560_/S VPWR VGND sg13cmos5l_mux2_1
XFILLER_24_472 VPWR VGND sg13cmos5l_fill_2
X_12550_ _12550_/X _12583_/A _12550_/B VPWR VGND sg13cmos5l_and2_1
XFILLER_40_987 VPWR VGND sg13cmos5l_fill_1
X_11501_ _11502_/B _11484_/A _11504_/B _11491_/B VPWR VGND sg13cmos5l_a21oi_1
X_12481_ _12481_/Y _12480_/A _13241_/Q _12480_/Y VPWR VGND sg13cmos5l_o21ai_1
X_11432_ _11432_/Y _11429_/Y _11476_/A _11447_/A1 VPWR VGND sg13cmos5l_o21ai_1
X_14220_ _14220_/Q clkload44/A _14220_/D _14220_/RESET_B VPWR VGND sg13cmos5l_dfrbpq_1
XFILLER_4_811 VPWR VGND sg13cmos5l_fill_1
X_14151_ _14151_/Q _14577_/CLK _14151_/D fanout989/X VPWR VGND sg13cmos5l_dfrbpq_1
X_11363_ _11388_/B _11363_/A _11363_/B VPWR VGND sg13cmos5l_and2_1
X_13102_ _13102_/Y _13102_/A _13102_/B VPWR VGND sg13cmos5l_xnor2_1
XFILLER_3_354 VPWR VGND sg13cmos5l_fill_2
XFILLER_65_1021 VPWR VGND sg13cmos5l_decap_8
X_10314_ _13919_/D _10379_/A1 _10319_/B _10313_/Y VPWR VGND sg13cmos5l_a21oi_1
X_11294_ _11303_/B _11294_/A _11294_/B VPWR VGND sg13cmos5l_nand2_1
X_14082_ _14082_/Q clkload38/A _14082_/D _14082_/RESET_B VPWR VGND sg13cmos5l_dfrbpq_1
XFILLER_106_783 VPWR VGND sg13cmos5l_fill_2
XFILLER_78_111 VPWR VGND sg13cmos5l_fill_1
X_10245_ _13885_/D _10375_/A1 _10245_/A2 _10244_/Y VPWR VGND sg13cmos5l_a21oi_1
X_13033_ _13034_/C _13033_/A _13033_/B VPWR VGND sg13cmos5l_nand2_1
X_10176_ _13851_/D _10371_/A1 _10185_/B _10175_/Y VPWR VGND sg13cmos5l_a21oi_1
XFILLER_39_509 VPWR VGND sg13cmos5l_fill_1
XFILLER_67_818 VPWR VGND sg13cmos5l_decap_8
XFILLER_78_166 VPWR VGND sg13cmos5l_fill_1
Xfanout190 _10571_/A1 _09557_/Y VPWR VGND sg13cmos5l_buf_1
XFILLER_47_542 VPWR VGND sg13cmos5l_decap_4
XFILLER_75_862 VPWR VGND sg13cmos5l_fill_2
X_13935_ _13935_/Q _14020_/CLK _13935_/D _13935_/RESET_B VPWR VGND sg13cmos5l_dfrbpq_1
XFILLER_75_884 VPWR VGND sg13cmos5l_fill_2
XFILLER_90_810 VPWR VGND sg13cmos5l_decap_4
X_13866_ _13866_/Q _14020_/CLK _13866_/D _13866_/RESET_B VPWR VGND sg13cmos5l_dfrbpq_1
XFILLER_50_707 VPWR VGND sg13cmos5l_decap_4
XFILLER_90_854 VPWR VGND sg13cmos5l_fill_1
X_12817_ _12818_/C _12817_/A _12817_/B _12828_/C VPWR VGND sg13cmos5l_nand3_1
X_13797_ _13797_/Q _14028_/CLK _13797_/D _13797_/RESET_B VPWR VGND sg13cmos5l_dfrbpq_1
X_12748_ _12788_/A _14453_/Q _13243_/Q VPWR VGND sg13cmos5l_xnor2_1
X_12679_ _12699_/A _12659_/Y _12669_/A _12668_/Y VPWR VGND sg13cmos5l_o21ai_1
X_14418_ _14418_/Q clkload67/A _14418_/D _14418_/RESET_B VPWR VGND sg13cmos5l_dfrbpq_1
X_14349_ _14349_/Q clkload69/A _14349_/D _14349_/RESET_B VPWR VGND sg13cmos5l_dfrbpq_1
XFILLER_98_921 VPWR VGND sg13cmos5l_decap_4
X_08910_ _08912_/C _14405_/Q _14373_/Q _08910_/C VPWR VGND sg13cmos5l_nand3_1
X_09890_ _09890_/Y _09890_/A _09890_/B VPWR VGND sg13cmos5l_nor2_1
XFILLER_98_965 VPWR VGND sg13cmos5l_fill_1
X_08841_ _08842_/D _08841_/A _08841_/B VPWR VGND sg13cmos5l_nand2_1
XFILLER_100_937 VPWR VGND sg13cmos5l_decap_4
XFILLER_57_339 VPWR VGND sg13cmos5l_fill_2
XFILLER_66_840 VPWR VGND sg13cmos5l_fill_2
XFILLER_97_497 VPWR VGND sg13cmos5l_fill_1
X_08772_ _08772_/Y _08782_/A1 _07335_/Y _08771_/Y VPWR VGND sg13cmos5l_o21ai_1
XFILLER_72_309 VPWR VGND sg13cmos5l_fill_1
X_07723_ _07724_/B _14376_/Q _11656_/A VPWR VGND sg13cmos5l_or2_1
XFILLER_81_832 VPWR VGND sg13cmos5l_decap_8
X_07654_ _08579_/B _07656_/A _07656_/B VPWR VGND sg13cmos5l_nor2_1
X_07585_ _07590_/A _14548_/Q _14550_/Q _14549_/Q _14547_/Q _07366_/A _08956_/A VPWR
+ VGND sg13cmos5l_mux4_1
X_09324_ _13440_/D _07985_/A hold3105/X _09341_/S VPWR VGND sg13cmos5l_mux2_1
X_09255_ _13380_/D _09219_/A hold3113/X _09260_/S VPWR VGND sg13cmos5l_mux2_1
X_14437__1071 _14437_/RESET_B VPWR VGND sg13cmos5l_tiehi
X_08206_ _08206_/X _08206_/A _08409_/B VPWR VGND sg13cmos5l_and2_1
X_09186_ _13327_/D _09197_/B _09184_/Y _09185_/Y VPWR VGND sg13cmos5l_a21oi_1
X_08137_ _08139_/A _08138_/B _08141_/D hold2972/X VPWR VGND sg13cmos5l_a21oi_1
X_08068_ _08068_/Y _08068_/A _08092_/B VPWR VGND sg13cmos5l_nand2_1
XFILLER_89_921 VPWR VGND sg13cmos5l_fill_2
XFILLER_68_36 VPWR VGND sg13cmos5l_fill_2
XFILLER_88_431 VPWR VGND sg13cmos5l_decap_4
X_10030_ _10030_/Y _10030_/A _10044_/B VPWR VGND sg13cmos5l_nand2_1
Xhold3230 hold3230/X _13451_/Q VPWR VGND sg13cmos5l_dlygate4sd3_1
Xhold3241 _09779_/A _13657_/Q VPWR VGND sg13cmos5l_dlygate4sd3_1
XFILLER_103_786 VPWR VGND sg13cmos5l_fill_1
XFILLER_88_453 VPWR VGND sg13cmos5l_decap_8
Xhold2540 hold2540/X _14504_/Q VPWR VGND sg13cmos5l_dlygate4sd3_1
Xhold3285 _11061_/A _14283_/Q VPWR VGND sg13cmos5l_dlygate4sd3_1
Xhold3274 hold3274/X _13419_/Q VPWR VGND sg13cmos5l_dlygate4sd3_1
Xhold3263 _13577_/D _09467_/X VPWR VGND sg13cmos5l_dlygate4sd3_1
Xhold3252 hold3252/X _13532_/Q VPWR VGND sg13cmos5l_dlygate4sd3_1
Xhold2551 _10349_/A _13937_/Q VPWR VGND sg13cmos5l_dlygate4sd3_1
Xhold2562 _11049_/A _14278_/Q VPWR VGND sg13cmos5l_dlygate4sd3_1
Xhold2573 _10086_/A _13808_/Q VPWR VGND sg13cmos5l_dlygate4sd3_1
Xhold3296 hold3296/X _13512_/Q VPWR VGND sg13cmos5l_dlygate4sd3_1
XFILLER_29_553 VPWR VGND sg13cmos5l_fill_1
X_11981_ _11984_/B _11981_/A _11981_/B VPWR VGND sg13cmos5l_nand2_1
Xhold2584 _10772_/A _14151_/Q VPWR VGND sg13cmos5l_dlygate4sd3_1
Xhold2595 _10448_/A _13985_/Q VPWR VGND sg13cmos5l_dlygate4sd3_1
XFILLER_56_383 VPWR VGND sg13cmos5l_decap_8
X_10932_ _10932_/Y _10932_/A _10932_/B VPWR VGND sg13cmos5l_nand2_1
X_13720_ _13720_/Q clkload25/A _13720_/D _13720_/RESET_B VPWR VGND sg13cmos5l_dfrbpq_1
XFILLER_72_876 VPWR VGND sg13cmos5l_decap_8
X_10863_ _14186_/D _10863_/A VPWR VGND sg13cmos5l_inv_1
X_13651_ _13651_/Q clkload19/A _13651_/D _13651_/RESET_B VPWR VGND sg13cmos5l_dfrbpq_1
X_10794_ _10794_/Y _10793_/B _10792_/Y _10793_/Y VPWR VGND sg13cmos5l_o21ai_1
X_13582_ _13582_/Q clkload33/A _13582_/D _13582_/RESET_B VPWR VGND sg13cmos5l_dfrbpq_1
X_12602_ _12602_/X _14441_/Q _13231_/Q VPWR VGND sg13cmos5l_and2_1
XFILLER_13_976 VPWR VGND sg13cmos5l_fill_1
X_14593__2136 _14593_/RESET_B VPWR VGND sg13cmos5l_tiehi
X_12533_ _14401_/D _12522_/B _12532_/Y _12530_/Y VPWR VGND sg13cmos5l_o21ai_1
X_14203_ _14203_/Q _14614_/CLK _14203_/D _14203_/RESET_B VPWR VGND sg13cmos5l_dfrbpq_1
X_12464_ _12464_/Y _08638_/A _11838_/Y _12460_/B VPWR VGND sg13cmos5l_a21oi_1
X_11415_ _11415_/Y _11444_/A _11415_/B VPWR VGND sg13cmos5l_nor2_1
X_12395_ _12395_/Y _13776_/Q _12402_/A2 _12395_/B1 _13840_/Q VPWR VGND sg13cmos5l_a22oi_1
X_11346_ _11388_/A _14094_/Q _11347_/B VPWR VGND sg13cmos5l_nor2_1
X_14464__1029 _14464_/RESET_B VPWR VGND sg13cmos5l_tiehi
X_14134_ _14134_/Q clkload23/A _14134_/D fanout992/X VPWR VGND sg13cmos5l_dfrbpq_1
X_14065_ _14065_/Q _14065_/CLK _14065_/D _14065_/RESET_B VPWR VGND sg13cmos5l_dfrbpq_1
XFILLER_106_580 VPWR VGND sg13cmos5l_decap_4
XFILLER_79_420 VPWR VGND sg13cmos5l_fill_1
XFILLER_79_431 VPWR VGND sg13cmos5l_decap_8
X_11277_ _11277_/Y _11243_/A _11302_/B _12923_/B2 VPWR VGND sg13cmos5l_o21ai_1
X_13016_ _14496_/D _13016_/A _13020_/D VPWR VGND sg13cmos5l_xor2_1
X_10228_ _10228_/Y _10228_/A _10230_/B VPWR VGND sg13cmos5l_nor2_1
X_10159_ _10159_/Y _10159_/A _10171_/B VPWR VGND sg13cmos5l_nor2_1
XFILLER_47_383 VPWR VGND sg13cmos5l_fill_1
XFILLER_63_854 VPWR VGND sg13cmos5l_fill_2
X_13918_ _13918_/Q clkload60/A _13918_/D _13918_/RESET_B VPWR VGND sg13cmos5l_dfrbpq_1
X_13849_ _13849_/Q clkload50/A _13849_/D _13849_/RESET_B VPWR VGND sg13cmos5l_dfrbpq_1
X_07370_ _07573_/A _12963_/A _14552_/Q VPWR VGND sg13cmos5l_xnor2_1
XFILLER_30_261 VPWR VGND sg13cmos5l_fill_1
X_09040_ _09041_/B _14315_/Q _14411_/Q _11197_/S VPWR VGND sg13cmos5l_mux2_1
X_09942_ _09942_/Y _09942_/A _09942_/B VPWR VGND sg13cmos5l_nor2_1
Xfanout904 _10690_/A1 _14110_/Q VPWR VGND sg13cmos5l_buf_1
Xfanout915 _10679_/A1 _14099_/Q VPWR VGND sg13cmos5l_buf_1
XFILLER_100_701 VPWR VGND sg13cmos5l_decap_8
XFILLER_58_615 VPWR VGND sg13cmos5l_decap_4
XFILLER_86_913 VPWR VGND sg13cmos5l_fill_1
X_09873_ _13703_/D _10395_/A1 _09882_/B _09872_/Y VPWR VGND sg13cmos5l_a21oi_1
Xfanout926 _07532_/A _07472_/A VPWR VGND sg13cmos5l_buf_1
Xfanout937 _07369_/A _07619_/A VPWR VGND sg13cmos5l_buf_1
Xfanout948 _11014_/A _10998_/A VPWR VGND sg13cmos5l_buf_1
XFILLER_86_935 VPWR VGND sg13cmos5l_decap_4
X_08824_ _08824_/Y _08490_/A _08839_/B VPWR VGND sg13cmos5l_nand2b_1
Xfanout959 fanout959/X fanout967/X VPWR VGND sg13cmos5l_buf_1
X_13676__1715 _13676_/RESET_B VPWR VGND sg13cmos5l_tiehi
X_08755_ _08755_/Y _13148_/A _14147_/Q _14131_/Q _14576_/Q VPWR VGND sg13cmos5l_a22oi_1
XFILLER_66_681 VPWR VGND sg13cmos5l_decap_8
X_07706_ _07706_/Y _08500_/A _07707_/C VPWR VGND sg13cmos5l_nand2_1
XFILLER_26_534 VPWR VGND sg13cmos5l_decap_4
XFILLER_65_180 VPWR VGND sg13cmos5l_fill_1
X_08686_ _08686_/Y _08684_/Y _08685_/Y _11788_/C1 VPWR VGND sg13cmos5l_a21oi_1
XFILLER_14_707 VPWR VGND sg13cmos5l_fill_1
X_07637_ _09001_/B _08050_/A _08152_/C _09024_/B VPWR VGND sg13cmos5l_nor3_1
X_14056__1335 _14056_/RESET_B VPWR VGND sg13cmos5l_tiehi
X_13891__1500 _13891_/RESET_B VPWR VGND sg13cmos5l_tiehi
XFILLER_55_1020 VPWR VGND sg13cmos5l_decap_8
X_07568_ _08999_/B _08995_/A _08995_/B VPWR VGND sg13cmos5l_nand2_1
X_09307_ _09307_/Y _09307_/A _09307_/B VPWR VGND sg13cmos5l_nor2_1
XFILLER_103_1007 VPWR VGND sg13cmos5l_decap_8
X_07499_ _07499_/Y _14529_/Q _11039_/A2 _07527_/B1 _15890_/A _07498_/Y VPWR VGND sg13cmos5l_a221oi_1
X_09238_ _13363_/D _09445_/A0 hold3211/X _09260_/S VPWR VGND sg13cmos5l_mux2_1
X_09169_ _11543_/A _14337_/Q _09175_/B VPWR VGND sg13cmos5l_nand2_1
X_11200_ _11202_/B _11200_/A _11200_/B _11200_/C VPWR VGND sg13cmos5l_nand3_1
X_12180_ _12181_/B _12169_/Y _12172_/Y _12176_/Y _12179_/Y VPWR VGND sg13cmos5l_a22oi_1
X_11131_ _11131_/Y _14384_/Q _11143_/A2 _11093_/B _14400_/Q _11067_/X VPWR VGND sg13cmos5l_a221oi_1
XFILLER_0_143 VPWR VGND sg13cmos5l_decap_8
XFILLER_1_666 VPWR VGND sg13cmos5l_fill_1
XFILLER_62_1024 VPWR VGND sg13cmos5l_decap_4
X_11062_ _14283_/D _11145_/A1 _11060_/Y _11061_/Y VPWR VGND sg13cmos5l_a21oi_1
Xhold3060 _13574_/D _09464_/X VPWR VGND sg13cmos5l_dlygate4sd3_1
XFILLER_77_935 VPWR VGND sg13cmos5l_fill_1
X_10013_ _10013_/Y _10013_/A _10013_/B VPWR VGND sg13cmos5l_nand2_1
Xhold3071 hold3071/X _13474_/Q VPWR VGND sg13cmos5l_dlygate4sd3_1
Xhold3082 hold3082/X _13409_/Q VPWR VGND sg13cmos5l_dlygate4sd3_1
Xhold3093 hold3093/X _13480_/Q VPWR VGND sg13cmos5l_dlygate4sd3_1
XFILLER_92_916 VPWR VGND sg13cmos5l_decap_8
Xhold2370 _09995_/A _13763_/Q VPWR VGND sg13cmos5l_dlygate4sd3_1
Xhold2381 _09991_/A _13761_/Q VPWR VGND sg13cmos5l_dlygate4sd3_1
XFILLER_85_990 VPWR VGND sg13cmos5l_decap_8
XFILLER_92_949 VPWR VGND sg13cmos5l_decap_8
Xhold2392 _10604_/A _14062_/Q VPWR VGND sg13cmos5l_dlygate4sd3_1
XFILLER_91_448 VPWR VGND sg13cmos5l_decap_8
X_11964_ _11964_/Y _11964_/A _11964_/B _11964_/C VPWR VGND sg13cmos5l_nand3_1
X_10915_ _14203_/D _10848_/Y _10877_/Y _10914_/Y VPWR VGND sg13cmos5l_o21ai_1
X_11895_ _11896_/B _12097_/A1 _11891_/Y _11894_/Y VPWR VGND sg13cmos5l_o21ai_1
X_13703_ _13703_/Q _14064_/CLK _13703_/D _13703_/RESET_B VPWR VGND sg13cmos5l_dfrbpq_1
X_10846_ _10846_/Y _10846_/A _10941_/B VPWR VGND sg13cmos5l_nand2_1
X_13634_ _13634_/Q clkload60/A _13634_/D _13634_/RESET_B VPWR VGND sg13cmos5l_dfrbpq_1
XFILLER_13_762 VPWR VGND sg13cmos5l_fill_2
XFILLER_9_733 VPWR VGND sg13cmos5l_fill_2
X_10777_ _10777_/Y _10798_/A _14297_/Q VPWR VGND sg13cmos5l_nand2_1
X_13565_ _13565_/Q clkload30/A _13565_/D _13565_/RESET_B VPWR VGND sg13cmos5l_dfrbpq_1
X_13496_ _13496_/Q _14105_/CLK _13496_/D _13496_/RESET_B VPWR VGND sg13cmos5l_dfrbpq_1
X_12516_ _12516_/Y _12546_/A1 _13250_/Q _12511_/B VPWR VGND sg13cmos5l_a21oi_1
X_13754__1637 _13754_/RESET_B VPWR VGND sg13cmos5l_tiehi
X_12447_ _14379_/D _12446_/Y _14379_/Q _12447_/S VPWR VGND sg13cmos5l_mux2_1
X_14117_ _14117_/Q _14117_/CLK _14117_/D fanout996/X VPWR VGND sg13cmos5l_dfrbpq_1
X_12378_ _12378_/Y _12376_/Y _12377_/Y _12378_/B1 VPWR VGND sg13cmos5l_a21oi_1
X_11329_ _11329_/Y _11329_/A _11329_/B VPWR VGND sg13cmos5l_nor2_1
XFILLER_67_401 VPWR VGND sg13cmos5l_decap_4
X_14048_ _14048_/Q _14048_/CLK _14048_/D _14048_/RESET_B VPWR VGND sg13cmos5l_dfrbpq_1
XFILLER_83_916 VPWR VGND sg13cmos5l_fill_2
XFILLER_94_253 VPWR VGND sg13cmos5l_fill_1
XFILLER_82_426 VPWR VGND sg13cmos5l_fill_1
XFILLER_94_286 VPWR VGND sg13cmos5l_fill_2
XFILLER_36_832 VPWR VGND sg13cmos5l_fill_2
X_08540_ _08582_/C _08540_/A _08540_/B VPWR VGND sg13cmos5l_nand2_1
XFILLER_35_353 VPWR VGND sg13cmos5l_fill_1
XFILLER_91_971 VPWR VGND sg13cmos5l_fill_2
X_08471_ _08471_/Y _08471_/A _08808_/A _08471_/C VPWR VGND sg13cmos5l_nor3_1
X_13387__2035 _13387_/RESET_B VPWR VGND sg13cmos5l_tiehi
XFILLER_23_537 VPWR VGND sg13cmos5l_fill_1
XFILLER_51_835 VPWR VGND sg13cmos5l_fill_2
X_07422_ _07422_/Y _08430_/B VPWR VGND sg13cmos5l_inv_1
X_07353_ _07629_/A _13326_/Q _07391_/A _07353_/C VPWR VGND sg13cmos5l_nor3_1
X_07284_ _07284_/Y _13246_/Q VPWR VGND sg13cmos5l_inv_1
X_09023_ _13293_/D _09024_/B _08971_/B _09022_/Y VPWR VGND sg13cmos5l_o21ai_1
X_09925_ _13728_/D _10577_/A1 _09924_/B _09924_/Y VPWR VGND sg13cmos5l_a21oi_1
Xfanout723 _08808_/B _08910_/C VPWR VGND sg13cmos5l_buf_1
Xfanout712 _07936_/B1 _07935_/Y VPWR VGND sg13cmos5l_buf_1
Xfanout701 _10697_/S _07951_/Y VPWR VGND sg13cmos5l_buf_1
XFILLER_86_710 VPWR VGND sg13cmos5l_fill_2
X_09856_ _09856_/Y _09856_/A _09878_/B VPWR VGND sg13cmos5l_nor2_1
Xfanout767 _08914_/B _11243_/A VPWR VGND sg13cmos5l_buf_1
Xfanout756 _08311_/C1 _07194_/Y VPWR VGND sg13cmos5l_buf_1
Xfanout745 _11444_/A _11536_/A VPWR VGND sg13cmos5l_buf_1
Xfanout734 _08902_/A2 _07877_/Y VPWR VGND sg13cmos5l_buf_1
X_14592__2135 _14592_/RESET_B VPWR VGND sg13cmos5l_tiehi
X_13597__1825 _13597_/RESET_B VPWR VGND sg13cmos5l_tiehi
X_08807_ _14629_/D hold2369/X _08822_/B _08806_/Y VPWR VGND sg13cmos5l_a21o_1
Xfanout789 _08164_/S0 fanout804/X VPWR VGND sg13cmos5l_buf_1
Xfanout778 _07194_/A _11033_/S1 VPWR VGND sg13cmos5l_buf_1
XFILLER_100_586 VPWR VGND sg13cmos5l_fill_2
X_09787_ _09787_/Y _09787_/A _09793_/B VPWR VGND sg13cmos5l_nor2_1
XFILLER_100_597 VPWR VGND sg13cmos5l_fill_1
XFILLER_27_832 VPWR VGND sg13cmos5l_fill_2
X_08738_ _08738_/Y _13718_/Q _08738_/A2 _11754_/B2 _13974_/Q _08687_/A VPWR VGND sg13cmos5l_a221oi_1
X_08669_ _08673_/A _13874_/Q _11725_/B _11780_/B VPWR VGND sg13cmos5l_o21ai_1
X_13832__1559 _13832_/RESET_B VPWR VGND sg13cmos5l_tiehi
XFILLER_14_548 VPWR VGND sg13cmos5l_fill_2
XFILLER_42_835 VPWR VGND sg13cmos5l_fill_1
X_10700_ _14120_/D input13/X _09293_/A _10709_/S VPWR VGND sg13cmos5l_mux2_1
X_11680_ _11682_/C _14347_/Q _13232_/Q VPWR VGND sg13cmos5l_xnor2_1
X_10631_ _14072_/D _10631_/A _10635_/D VPWR VGND sg13cmos5l_xor2_1
X_10562_ _10562_/Y _10562_/A _10566_/B VPWR VGND sg13cmos5l_nand2_1
X_13350_ _13350_/Q clkload41/A _13350_/D _13350_/RESET_B VPWR VGND sg13cmos5l_dfrbpq_1
X_12301_ _12301_/Y _12301_/A _12301_/B VPWR VGND sg13cmos5l_nand2_1
X_13281_ _13281_/Q clkload20/A _13281_/D fanout985/X VPWR VGND sg13cmos5l_dfrbpq_1
X_10493_ _10493_/Y _10493_/A _10519_/B VPWR VGND sg13cmos5l_nand2_1
X_12232_ _12232_/Y _13994_/Q _12234_/B VPWR VGND sg13cmos5l_nand2_1
X_14192__1285 _14192_/RESET_B VPWR VGND sg13cmos5l_tiehi
XFILLER_100_0 VPWR VGND sg13cmos5l_fill_1
X_12163_ _12165_/C _12187_/A _12383_/A2 _12162_/Y VPWR VGND sg13cmos5l_o21ai_1
X_11114_ _11114_/Y _14395_/Q _11105_/B _11113_/Y VPWR VGND sg13cmos5l_a21oi_1
X_12094_ _12094_/Y _12382_/A _12094_/B VPWR VGND sg13cmos5l_nand2_1
X_11045_ _11045_/Y _11045_/A _11099_/B VPWR VGND sg13cmos5l_nor2_1
XFILLER_1_496 VPWR VGND sg13cmos5l_fill_1
XFILLER_49_489 VPWR VGND sg13cmos5l_decap_4
X_14396__1112 _14396_/RESET_B VPWR VGND sg13cmos5l_tiehi
X_12996_ _12996_/Y _12996_/A _12996_/B VPWR VGND sg13cmos5l_xnor2_1
XFILLER_73_960 VPWR VGND sg13cmos5l_fill_2
X_11947_ _11947_/Y _11947_/A _11947_/B VPWR VGND sg13cmos5l_nand2_1
XFILLER_33_835 VPWR VGND sg13cmos5l_fill_2
XFILLER_44_172 VPWR VGND sg13cmos5l_fill_2
X_13808__1583 _13808_/RESET_B VPWR VGND sg13cmos5l_tiehi
XFILLER_60_654 VPWR VGND sg13cmos5l_decap_4
X_11878_ _11878_/Y _14046_/Q _11969_/A2 _11998_/B1 _13726_/Q VPWR VGND sg13cmos5l_a22oi_1
XFILLER_20_518 VPWR VGND sg13cmos5l_decap_4
X_10829_ _14177_/D _14262_/D _14177_/Q _10829_/S VPWR VGND sg13cmos5l_mux2_1
X_14597_ _14597_/Q _14640_/CLK _14597_/D _14597_/RESET_B VPWR VGND sg13cmos5l_dfrbpq_1
X_13617_ _13617_/Q _14065_/CLK _13617_/D _13617_/RESET_B VPWR VGND sg13cmos5l_dfrbpq_1
X_13987__1404 _13987_/RESET_B VPWR VGND sg13cmos5l_tiehi
X_13548_ _13548_/Q _14238_/CLK _13548_/D _13548_/RESET_B VPWR VGND sg13cmos5l_dfrbpq_1
X_13479_ _13479_/Q clkload29/A _13479_/D _13479_/RESET_B VPWR VGND sg13cmos5l_dfrbpq_1
XFILLER_87_507 VPWR VGND sg13cmos5l_fill_1
X_07971_ _12596_/B _08379_/C1 _07970_/Y _07966_/Y VPWR VGND sg13cmos5l_o21ai_1
X_09710_ _09710_/Y _09710_/A _09714_/B VPWR VGND sg13cmos5l_nor2_1
X_09641_ _13609_/D _09666_/B _10595_/A1 _09635_/Y VPWR VGND sg13cmos5l_a21oi_1
XFILLER_82_234 VPWR VGND sg13cmos5l_fill_2
XFILLER_83_735 VPWR VGND sg13cmos5l_decap_8
X_09572_ _09572_/Y _09571_/A _11321_/B _09569_/Y _09571_/Y VPWR VGND sg13cmos5l_a22oi_1
XFILLER_24_813 VPWR VGND sg13cmos5l_fill_2
XFILLER_64_971 VPWR VGND sg13cmos5l_fill_1
XFILLER_64_982 VPWR VGND sg13cmos5l_fill_2
X_08523_ _08524_/B _08529_/B _08516_/B _07754_/Y VPWR VGND sg13cmos5l_o21ai_1
X_08454_ _08455_/B _08502_/A _07729_/Y _08453_/X VPWR VGND sg13cmos5l_o21ai_1
X_07405_ _07407_/C _07187_/Y _08961_/A _07571_/A VPWR VGND sg13cmos5l_a21oi_1
X_08385_ _08385_/Y _13359_/Q _08390_/S VPWR VGND sg13cmos5l_nand2b_1
X_07336_ _07336_/Y _14140_/Q VPWR VGND sg13cmos5l_inv_1
X_13505__1917 _13505_/RESET_B VPWR VGND sg13cmos5l_tiehi
X_07267_ _07267_/Y _13228_/Q VPWR VGND sg13cmos5l_inv_1
X_09006_ _13282_/D hold3425/X _07614_/A _13034_/B VPWR VGND sg13cmos5l_mux2_1
X_07198_ _07198_/Y _07198_/A VPWR VGND sg13cmos5l_inv_1
XFILLER_78_518 VPWR VGND sg13cmos5l_fill_2
XFILLER_105_689 VPWR VGND sg13cmos5l_decap_8
XFILLER_59_732 VPWR VGND sg13cmos5l_decap_8
Xfanout542 _09663_/B1 _09485_/Y VPWR VGND sg13cmos5l_buf_1
Xfanout531 _08157_/B _07391_/X VPWR VGND sg13cmos5l_buf_1
Xfanout520 _13197_/A2 _08436_/Y VPWR VGND sg13cmos5l_buf_1
X_14177__1300 _14177_/RESET_B VPWR VGND sg13cmos5l_tiehi
XFILLER_59_743 VPWR VGND sg13cmos5l_fill_2
X_09908_ _09908_/Y _09908_/A _09912_/B VPWR VGND sg13cmos5l_nor2_1
Xfanout575 _11753_/S fanout584/X VPWR VGND sg13cmos5l_buf_1
Xfanout564 _12058_/B _12060_/B VPWR VGND sg13cmos5l_buf_1
Xfanout553 _13166_/B _08913_/Y VPWR VGND sg13cmos5l_buf_1
XFILLER_18_106 VPWR VGND sg13cmos5l_fill_2
XFILLER_46_415 VPWR VGND sg13cmos5l_decap_8
XFILLER_59_776 VPWR VGND sg13cmos5l_fill_1
X_09839_ _13686_/D _10361_/A1 _09858_/B _09838_/Y VPWR VGND sg13cmos5l_a21oi_1
Xfanout597 _11837_/C1 _08674_/A VPWR VGND sg13cmos5l_buf_1
Xfanout586 _12206_/B _12318_/B1 VPWR VGND sg13cmos5l_buf_1
XFILLER_46_426 VPWR VGND sg13cmos5l_fill_1
X_12850_ _12850_/X _12850_/A _12857_/B VPWR VGND sg13cmos5l_and2_1
XFILLER_74_779 VPWR VGND sg13cmos5l_fill_1
X_11801_ _11801_/Y _11851_/A _11801_/B _11801_/C _11801_/D VPWR VGND sg13cmos5l_nand4_1
XFILLER_54_470 VPWR VGND sg13cmos5l_fill_2
X_14520_ _14520_/Q _14520_/CLK _14520_/D fanout973/X VPWR VGND sg13cmos5l_dfrbpq_1
X_12781_ _14425_/D _12778_/Y _12780_/Y _12755_/A VPWR VGND sg13cmos5l_a21oi_1
XFILLER_30_805 VPWR VGND sg13cmos5l_fill_1
XFILLER_42_632 VPWR VGND sg13cmos5l_decap_8
XFILLER_42_643 VPWR VGND sg13cmos5l_fill_1
XFILLER_70_963 VPWR VGND sg13cmos5l_fill_1
X_11732_ _11732_/Y _11729_/Y _11731_/Y _11865_/A VPWR VGND sg13cmos5l_o21ai_1
X_11663_ _11663_/Y _11663_/A _11663_/B VPWR VGND sg13cmos5l_xnor2_1
X_14451_ _14451_/Q clkload67/A _14451_/D _14451_/RESET_B VPWR VGND sg13cmos5l_dfrbpq_1
X_10614_ _10621_/C _10613_/X _10612_/X _10614_/S VPWR VGND sg13cmos5l_mux2_1
X_14382_ _14382_/Q clkload69/A _14382_/D _14382_/RESET_B VPWR VGND sg13cmos5l_dfrbpq_1
X_13402_ _13402_/Q clkload27/A _13402_/D _13402_/RESET_B VPWR VGND sg13cmos5l_dfrbpq_1
XFILLER_10_540 VPWR VGND sg13cmos5l_fill_1
XFILLER_6_511 VPWR VGND sg13cmos5l_fill_1
X_11594_ _11595_/B _11596_/A _11598_/B VPWR VGND sg13cmos5l_nor2_1
X_13333_ _13333_/Q _14292_/CLK _13333_/D _13333_/RESET_B VPWR VGND sg13cmos5l_dfrbpq_1
X_10545_ _10545_/Y _10545_/A _10545_/B VPWR VGND sg13cmos5l_nand2_1
X_10476_ _10476_/Y _10476_/A _10480_/B VPWR VGND sg13cmos5l_nor2_1
X_14304__1204 _14304_/RESET_B VPWR VGND sg13cmos5l_tiehi
X_13671__1720 _13671_/RESET_B VPWR VGND sg13cmos5l_tiehi
X_13264_ _13264_/Q clkload19/A _13264_/D fanout986/X VPWR VGND sg13cmos5l_dfrbpq_1
X_12215_ _14365_/D _12194_/Y _12214_/Y _12186_/Y VPWR VGND sg13cmos5l_o21ai_1
X_13195_ _13195_/Y _11316_/A _14176_/Q _13195_/B1 _08231_/A VPWR VGND sg13cmos5l_a22oi_1
XFILLER_2_750 VPWR VGND sg13cmos5l_fill_2
X_12146_ _12147_/C _13927_/Q _12397_/B _12395_/B1 _13671_/Q VPWR VGND sg13cmos5l_a22oi_1
XFILLER_2_11 VPWR VGND sg13cmos5l_fill_1
X_12077_ _12077_/Y _12077_/A _12077_/B VPWR VGND sg13cmos5l_nand2_1
X_14051__1340 _14051_/RESET_B VPWR VGND sg13cmos5l_tiehi
XFILLER_2_77 VPWR VGND sg13cmos5l_fill_1
X_11028_ _14241_/D _14241_/Q _11618_/C _07862_/X VPWR VGND sg13cmos5l_a21o_1
XFILLER_46_971 VPWR VGND sg13cmos5l_fill_1
XFILLER_61_930 VPWR VGND sg13cmos5l_decap_8
XFILLER_73_790 VPWR VGND sg13cmos5l_decap_4
X_12979_ _14477_/D _12979_/A _12979_/B VPWR VGND sg13cmos5l_xor2_1
XFILLER_61_941 VPWR VGND sg13cmos5l_fill_1
X_14649_ _14649_/Q _14650_/CLK _14649_/D _14649_/RESET_B VPWR VGND sg13cmos5l_dfrbpq_1
X_08170_ _08170_/X _08170_/A _08307_/B VPWR VGND sg13cmos5l_and2_1
X_14591__2134 _14591_/RESET_B VPWR VGND sg13cmos5l_tiehi
XFILLER_63_0 VPWR VGND sg13cmos5l_fill_1
XFILLER_102_637 VPWR VGND sg13cmos5l_fill_1
Xhold2903 _09797_/A _13666_/Q VPWR VGND sg13cmos5l_dlygate4sd3_1
Xhold2914 _10910_/A _14201_/Q VPWR VGND sg13cmos5l_dlygate4sd3_1
X_07954_ _07954_/Y _07959_/B input18/X _07954_/C VPWR VGND sg13cmos5l_nand3_1
Xhold2925 _10478_/A _14000_/Q VPWR VGND sg13cmos5l_dlygate4sd3_1
Xhold2936 _14532_/D _13095_/Y VPWR VGND sg13cmos5l_dlygate4sd3_1
Xhold2947 _11138_/A _14303_/Q VPWR VGND sg13cmos5l_dlygate4sd3_1
XFILLER_68_584 VPWR VGND sg13cmos5l_fill_2
X_07885_ _07885_/X _14186_/Q _14200_/Q VPWR VGND sg13cmos5l_or2_1
Xhold2958 _10329_/A _13927_/Q VPWR VGND sg13cmos5l_dlygate4sd3_1
Xhold2969 _09910_/A _13721_/Q VPWR VGND sg13cmos5l_dlygate4sd3_1
XFILLER_55_223 VPWR VGND sg13cmos5l_fill_2
X_09624_ _09626_/B _09604_/B _09625_/D _14458_/Q VPWR VGND sg13cmos5l_a21oi_1
XFILLER_83_554 VPWR VGND sg13cmos5l_fill_2
XFILLER_83_565 VPWR VGND sg13cmos5l_decap_8
XFILLER_43_418 VPWR VGND sg13cmos5l_fill_2
XFILLER_64_790 VPWR VGND sg13cmos5l_fill_2
XFILLER_71_727 VPWR VGND sg13cmos5l_fill_1
X_09555_ _09575_/D _14448_/Q _14447_/Q _14446_/Q _09555_/D VPWR VGND sg13cmos5l_nand4_1
XFILLER_51_440 VPWR VGND sg13cmos5l_decap_4
XFILLER_70_248 VPWR VGND sg13cmos5l_fill_2
X_08506_ _08506_/Y _07693_/B _07698_/B _08491_/Y _08504_/Y _07689_/Y VPWR VGND sg13cmos5l_a221oi_1
X_09486_ _09486_/Y _11005_/B1 _07298_/Y _09663_/B1 VPWR VGND sg13cmos5l_a21oi_1
X_08437_ _08437_/X _14237_/Q _14229_/Q VPWR VGND sg13cmos5l_and2_1
XFILLER_11_359 VPWR VGND sg13cmos5l_fill_1
X_08368_ _14269_/D hold3523/X _12582_/B _08368_/S VPWR VGND sg13cmos5l_mux2_1
X_07319_ _07319_/Y _07319_/A VPWR VGND sg13cmos5l_inv_1
X_08299_ _08299_/Y _08363_/S _13384_/Q _08298_/Y VPWR VGND sg13cmos5l_o21ai_1
X_10330_ _13927_/D _10395_/A1 _10339_/B _10329_/Y VPWR VGND sg13cmos5l_a21oi_1
XFILLER_106_943 VPWR VGND sg13cmos5l_decap_8
X_10261_ _13893_/D _10326_/A1 _10274_/B _10260_/Y VPWR VGND sg13cmos5l_a21oi_1
X_12000_ _12000_/Y _13794_/Q _12000_/B VPWR VGND sg13cmos5l_nand2b_1
X_10192_ _13859_/D _10453_/A1 _10213_/B _10191_/Y VPWR VGND sg13cmos5l_a21oi_1
XFILLER_78_348 VPWR VGND sg13cmos5l_fill_1
Xfanout350 _09666_/B _09673_/B VPWR VGND sg13cmos5l_buf_1
X_13382__2040 _13382_/RESET_B VPWR VGND sg13cmos5l_tiehi
XFILLER_4_1016 VPWR VGND sg13cmos5l_decap_4
Xfanout383 _08277_/A1 _08376_/A1 VPWR VGND sg13cmos5l_buf_1
Xfanout372 _08404_/B1 _07993_/A VPWR VGND sg13cmos5l_buf_1
Xfanout361 _09125_/B _09095_/B VPWR VGND sg13cmos5l_buf_1
X_13951_ _13951_/Q clkload51/A _13951_/D _13951_/RESET_B VPWR VGND sg13cmos5l_dfrbpq_1
XFILLER_101_692 VPWR VGND sg13cmos5l_decap_4
XFILLER_46_212 VPWR VGND sg13cmos5l_fill_2
Xfanout394 _12352_/A _12408_/A1 VPWR VGND sg13cmos5l_buf_1
X_12902_ _14438_/D _12902_/A VPWR VGND sg13cmos5l_inv_1
XFILLER_46_245 VPWR VGND sg13cmos5l_fill_2
X_13882_ _13882_/Q clkload52/A _13882_/D _13882_/RESET_B VPWR VGND sg13cmos5l_dfrbpq_1
X_12833_ _12833_/X _11092_/A _12549_/X _12879_/B1 VPWR VGND sg13cmos5l_a21o_1
X_13689__1702 _13689_/RESET_B VPWR VGND sg13cmos5l_tiehi
X_12764_ _12785_/A _14455_/Q _13245_/Q VPWR VGND sg13cmos5l_nand2_1
XFILLER_43_985 VPWR VGND sg13cmos5l_fill_1
XFILLER_70_782 VPWR VGND sg13cmos5l_fill_2
X_11715_ _11715_/Y _11715_/A _11715_/B VPWR VGND sg13cmos5l_nor2_1
X_14503_ _14503_/Q clkload20/A _14503_/D fanout984/X VPWR VGND sg13cmos5l_dfrbpq_1
X_12695_ _12696_/D _12650_/X _12694_/Y _12643_/A VPWR VGND sg13cmos5l_o21ai_1
XFILLER_30_668 VPWR VGND sg13cmos5l_fill_1
X_11646_ _14343_/D _11645_/Y _11641_/A _11708_/A VPWR VGND sg13cmos5l_mux2_1
X_14434_ _14434_/Q _14654_/CLK _14434_/D _14434_/RESET_B VPWR VGND sg13cmos5l_dfrbpq_1
X_11577_ _11577_/Y _11577_/A _11577_/B _11577_/C _11577_/D VPWR VGND sg13cmos5l_nor4_1
Xinput14 input14/X ui_in[6] VPWR VGND sg13cmos5l_buf_1
Xclkbuf_leaf_103_clk clkload13/A clkbuf_4_0_0_clk/X VPWR VGND sg13cmos5l_buf_8
X_14365_ _14365_/Q clkload80/A _14365_/D _14365_/RESET_B VPWR VGND sg13cmos5l_dfrbpq_1
X_10528_ _14024_/D _10593_/A1 _10535_/B _10527_/Y VPWR VGND sg13cmos5l_o21ai_1
X_14296_ _14296_/Q clkload22/A _14296_/D _14296_/RESET_B VPWR VGND sg13cmos5l_dfrbpq_1
X_13612__1779 _13612_/RESET_B VPWR VGND sg13cmos5l_tiehi
X_13592__1830 _13592_/RESET_B VPWR VGND sg13cmos5l_tiehi
X_13316_ _13316_/Q _14453_/CLK _13316_/D _13316_/RESET_B VPWR VGND sg13cmos5l_dfrbpq_1
X_13247_ _13247_/Q clkload77/A _13247_/D _13247_/RESET_B VPWR VGND sg13cmos5l_dfrbpq_1
X_10459_ _13990_/D fanout79/X _10474_/B _10458_/Y VPWR VGND sg13cmos5l_a21oi_1
X_13178_ _13236_/D _07274_/Y _13184_/A2 _13177_/Y VPWR VGND sg13cmos5l_a21oi_1
XFILLER_69_359 VPWR VGND sg13cmos5l_fill_1
X_12129_ _14362_/D _12100_/A _12127_/A _12128_/Y VPWR VGND sg13cmos5l_a21oi_1
XFILLER_38_735 VPWR VGND sg13cmos5l_fill_2
XFILLER_84_329 VPWR VGND sg13cmos5l_fill_1
XFILLER_93_830 VPWR VGND sg13cmos5l_decap_4
XFILLER_96_189 VPWR VGND sg13cmos5l_fill_2
X_07670_ _07838_/C _08582_/A _08582_/B VPWR VGND sg13cmos5l_and2_1
XFILLER_65_587 VPWR VGND sg13cmos5l_fill_1
X_09340_ _13456_/D _08397_/A hold3266/X _09340_/S VPWR VGND sg13cmos5l_mux2_1
XFILLER_80_579 VPWR VGND sg13cmos5l_fill_2
X_09271_ _13395_/D _09445_/A0 hold3139/X _09293_/B VPWR VGND sg13cmos5l_mux2_1
XFILLER_20_123 VPWR VGND sg13cmos5l_fill_1
XFILLER_33_484 VPWR VGND sg13cmos5l_fill_2
X_08222_ _08222_/Y _08258_/S _13378_/Q _08221_/Y VPWR VGND sg13cmos5l_o21ai_1
X_08153_ _08153_/Y _14522_/Q _08155_/A _08152_/X VPWR VGND sg13cmos5l_o21ai_1
XFILLER_9_190 VPWR VGND sg13cmos5l_decap_8
X_08084_ _08084_/Y _08961_/B _08092_/B VPWR VGND sg13cmos5l_nand2_1
XFILLER_106_228 VPWR VGND sg13cmos5l_fill_1
XFILLER_88_613 VPWR VGND sg13cmos5l_fill_1
Xhold3434 hold3434/X _13286_/Q VPWR VGND sg13cmos5l_dlygate4sd3_1
Xhold3423 hold3423/X _14260_/Q VPWR VGND sg13cmos5l_dlygate4sd3_1
Xhold3412 hold3412/X _14598_/Q VPWR VGND sg13cmos5l_dlygate4sd3_1
Xhold3401 _08125_/A _13214_/Q VPWR VGND sg13cmos5l_dlygate4sd3_1
X_08986_ _08986_/Y _13296_/Q _08996_/B _08985_/Y VPWR VGND sg13cmos5l_a21oi_1
Xhold2700 _09504_/A _13589_/Q VPWR VGND sg13cmos5l_dlygate4sd3_1
Xhold2711 _10446_/A _13984_/Q VPWR VGND sg13cmos5l_dlygate4sd3_1
Xhold2722 _09789_/A _13662_/Q VPWR VGND sg13cmos5l_dlygate4sd3_1
Xhold3467 _09024_/A _13294_/Q VPWR VGND sg13cmos5l_dlygate4sd3_1
Xhold3456 _13229_/D _13158_/Y VPWR VGND sg13cmos5l_dlygate4sd3_1
Xhold3445 hold3445/X _13267_/Q VPWR VGND sg13cmos5l_dlygate4sd3_1
X_13767__1624 _13767_/RESET_B VPWR VGND sg13cmos5l_tiehi
XFILLER_69_882 VPWR VGND sg13cmos5l_decap_8
X_07937_ _07939_/C _10871_/A _11019_/A VPWR VGND sg13cmos5l_nand2_1
Xhold2733 _10133_/A _13831_/Q VPWR VGND sg13cmos5l_dlygate4sd3_1
Xhold2744 _10232_/A _13879_/Q VPWR VGND sg13cmos5l_dlygate4sd3_1
Xhold2755 _09918_/A _13725_/Q VPWR VGND sg13cmos5l_dlygate4sd3_1
Xhold3489 _07186_/A _14309_/Q VPWR VGND sg13cmos5l_dlygate4sd3_1
Xhold3478 _07297_/A _13227_/Q VPWR VGND sg13cmos5l_dlygate4sd3_1
X_13455__1967 _13455_/RESET_B VPWR VGND sg13cmos5l_tiehi
XFILLER_29_746 VPWR VGND sg13cmos5l_fill_2
Xhold2766 _09900_/A _13716_/Q VPWR VGND sg13cmos5l_dlygate4sd3_1
Xhold2777 _09704_/A _13621_/Q VPWR VGND sg13cmos5l_dlygate4sd3_1
Xhold2788 _10317_/A _13921_/Q VPWR VGND sg13cmos5l_dlygate4sd3_1
Xhold2799 _11184_/A _14313_/Q VPWR VGND sg13cmos5l_dlygate4sd3_1
XFILLER_56_565 VPWR VGND sg13cmos5l_fill_2
X_07868_ _07868_/X _14196_/Q _14197_/Q VPWR VGND sg13cmos5l_or2_1
X_07799_ _07800_/A _08893_/A _08609_/B _07799_/C VPWR VGND sg13cmos5l_nor3_1
X_09607_ _13604_/D _09642_/B _10128_/A1 _09601_/Y VPWR VGND sg13cmos5l_a21oi_1
XFILLER_19_1002 VPWR VGND sg13cmos5l_fill_2
XFILLER_71_535 VPWR VGND sg13cmos5l_decap_4
X_09538_ _13594_/D _09642_/B _10369_/A1 _09537_/Y VPWR VGND sg13cmos5l_a21oi_1
X_09469_ _09469_/X _14124_/Q hold3312/X _09475_/S VPWR VGND sg13cmos5l_mux2_1
X_11500_ _11514_/C _11563_/A _11555_/B VPWR VGND sg13cmos5l_xnor2_1
XFILLER_106_1027 VPWR VGND sg13cmos5l_fill_2
X_12480_ _12480_/Y _12480_/A _12480_/B VPWR VGND sg13cmos5l_nand2_1
X_11431_ _11476_/A _11431_/A _11431_/B VPWR VGND sg13cmos5l_nor2_1
XFILLER_20_690 VPWR VGND sg13cmos5l_fill_2
XFILLER_22_74 VPWR VGND sg13cmos5l_fill_2
X_11362_ _11387_/A _14174_/Q _11401_/B VPWR VGND sg13cmos5l_xnor2_1
X_14150_ _14150_/Q clkload23/A _14150_/D fanout993/X VPWR VGND sg13cmos5l_dfrbpq_1
XFILLER_98_34 VPWR VGND sg13cmos5l_fill_2
X_10313_ _10313_/Y _10313_/A _10319_/B VPWR VGND sg13cmos5l_nor2_1
X_13101_ _13104_/B _14533_/Q _14534_/Q _13101_/C _13101_/D VPWR VGND sg13cmos5l_and4_1
X_11293_ _11294_/B _11293_/A _11293_/B VPWR VGND sg13cmos5l_nand2_1
X_14081_ _14081_/Q clkload14/A _14081_/D _09199_/A VPWR VGND sg13cmos5l_dfrbpq_1
XFILLER_106_762 VPWR VGND sg13cmos5l_decap_8
X_10244_ _10244_/Y _10244_/A _10250_/B VPWR VGND sg13cmos5l_nor2_1
X_13032_ _13032_/Y _13032_/A _13032_/B _13032_/C _13032_/D VPWR VGND sg13cmos5l_nand4_1
XFILLER_67_808 VPWR VGND sg13cmos5l_fill_1
X_10175_ _10175_/Y _10175_/A _10185_/B VPWR VGND sg13cmos5l_nor2_1
X_13323__2099 _13323_/RESET_B VPWR VGND sg13cmos5l_tiehi
XFILLER_66_307 VPWR VGND sg13cmos5l_fill_2
XFILLER_94_605 VPWR VGND sg13cmos5l_fill_2
Xfanout191 _08975_/A _09000_/A2 VPWR VGND sg13cmos5l_buf_1
Xfanout180 _10575_/A1 _09572_/Y VPWR VGND sg13cmos5l_buf_1
X_14590__2133 _14590_/RESET_B VPWR VGND sg13cmos5l_tiehi
X_13934_ _13934_/Q clkload56/A _13934_/D _13934_/RESET_B VPWR VGND sg13cmos5l_dfrbpq_1
XFILLER_47_598 VPWR VGND sg13cmos5l_fill_1
X_13865_ _13865_/Q clkload63/A _13865_/D _13865_/RESET_B VPWR VGND sg13cmos5l_dfrbpq_1
X_12816_ _12818_/B _12817_/A _12817_/B _12828_/C VPWR VGND sg13cmos5l_a21o_1
XFILLER_16_974 VPWR VGND sg13cmos5l_fill_2
X_13796_ _13796_/Q clkload70/A _13796_/D _13796_/RESET_B VPWR VGND sg13cmos5l_dfrbpq_1
X_13500__1922 _13500_/RESET_B VPWR VGND sg13cmos5l_tiehi
X_12747_ _12789_/A _12704_/A _12744_/Y _12745_/Y _12743_/B _12746_/Y VPWR VGND sg13cmos5l_a221oi_1
X_12678_ _12680_/B _12658_/A _12658_/B _12677_/Y VPWR VGND sg13cmos5l_o21ai_1
XFILLER_8_54 VPWR VGND sg13cmos5l_fill_2
X_11629_ _11629_/Y _14214_/Q _14212_/Q _14213_/Q _14215_/Q VPWR VGND sg13cmos5l_nor4_1
X_14417_ _14417_/Q clkload68/A _14417_/D _14417_/RESET_B VPWR VGND sg13cmos5l_dfrbpq_1
X_13845__1546 _13845_/RESET_B VPWR VGND sg13cmos5l_tiehi
X_13533__1889 _13533_/RESET_B VPWR VGND sg13cmos5l_tiehi
X_14348_ _14348_/Q clkload36/A _14348_/D _14348_/RESET_B VPWR VGND sg13cmos5l_dfrbpq_1
XFILLER_6_182 VPWR VGND sg13cmos5l_fill_2
X_14279_ _14279_/Q clkload23/A _14279_/D _14279_/RESET_B VPWR VGND sg13cmos5l_dfrbpq_1
X_08840_ _08842_/C _07674_/A _08840_/B VPWR VGND sg13cmos5l_nand2b_1
XFILLER_100_905 VPWR VGND sg13cmos5l_fill_1
XFILLER_97_465 VPWR VGND sg13cmos5l_fill_2
XFILLER_69_189 VPWR VGND sg13cmos5l_fill_2
X_08771_ _08771_/Y _08781_/A1 _14155_/Q _13264_/Q _08781_/B2 VPWR VGND sg13cmos5l_a22oi_1
X_07722_ _08456_/A _14376_/Q _11656_/A VPWR VGND sg13cmos5l_nor2_1
XFILLER_65_373 VPWR VGND sg13cmos5l_fill_2
X_07653_ _08575_/A _08875_/A _08579_/A VPWR VGND sg13cmos5l_or2_1
XFILLER_80_321 VPWR VGND sg13cmos5l_fill_1
XFILLER_22_911 VPWR VGND sg13cmos5l_fill_1
XFILLER_53_568 VPWR VGND sg13cmos5l_decap_4
X_07584_ _07584_/Y _14541_/Q _07409_/B _07399_/B VPWR VGND sg13cmos5l_o21ai_1
X_09323_ _13439_/D _07973_/A hold3351/X _09341_/S VPWR VGND sg13cmos5l_mux2_1
XFILLER_80_387 VPWR VGND sg13cmos5l_decap_8
X_09254_ _13379_/D _09288_/A hold3270/X _09260_/S VPWR VGND sg13cmos5l_mux2_1
X_08205_ _14253_/D _13159_/A _12571_/B _11042_/S VPWR VGND sg13cmos5l_mux2_1
X_09185_ _09185_/Y _09185_/A _09197_/B VPWR VGND sg13cmos5l_nor2_1
X_08136_ _08141_/D _08136_/A _08136_/B VPWR VGND sg13cmos5l_nor2_1
X_08067_ _08070_/B _08113_/A _09443_/A _08066_/Y VPWR VGND sg13cmos5l_a21oi_1
X_14332__1176 _14332_/RESET_B VPWR VGND sg13cmos5l_tiehi
Xhold3220 hold3220/X _13488_/Q VPWR VGND sg13cmos5l_dlygate4sd3_1
Xhold3231 hold3231/X _13338_/Q VPWR VGND sg13cmos5l_dlygate4sd3_1
Xhold3242 _07195_/A _13216_/Q VPWR VGND sg13cmos5l_dlygate4sd3_1
XFILLER_49_819 VPWR VGND sg13cmos5l_fill_1
XFILLER_89_999 VPWR VGND sg13cmos5l_fill_2
Xhold2530 _07327_/A _14164_/Q VPWR VGND sg13cmos5l_dlygate4sd3_1
Xhold3275 hold3275/X _13436_/Q VPWR VGND sg13cmos5l_dlygate4sd3_1
Xhold3264 hold3264/X _13546_/Q VPWR VGND sg13cmos5l_dlygate4sd3_1
Xhold3253 hold3253/X _13558_/Q VPWR VGND sg13cmos5l_dlygate4sd3_1
X_08969_ _08969_/Y _08969_/A _08977_/B VPWR VGND sg13cmos5l_nand2_1
Xhold2541 _08134_/A _13218_/Q VPWR VGND sg13cmos5l_dlygate4sd3_1
Xhold2552 _10580_/A _14050_/Q VPWR VGND sg13cmos5l_dlygate4sd3_1
Xhold2563 _08817_/A _14589_/Q VPWR VGND sg13cmos5l_dlygate4sd3_1
Xhold2574 _10950_/A _14218_/Q VPWR VGND sg13cmos5l_dlygate4sd3_1
Xhold3297 _13512_/D _09400_/X VPWR VGND sg13cmos5l_dlygate4sd3_1
Xhold3286 hold3286/X _13476_/Q VPWR VGND sg13cmos5l_dlygate4sd3_1
XFILLER_29_532 VPWR VGND sg13cmos5l_decap_8
XFILLER_29_543 VPWR VGND sg13cmos5l_fill_2
XFILLER_84_36 VPWR VGND sg13cmos5l_fill_2
X_11980_ _14357_/D _11950_/A _11979_/A _11960_/Y _11979_/Y VPWR VGND sg13cmos5l_a22oi_1
Xhold2585 _14151_/D _10773_/Y VPWR VGND sg13cmos5l_dlygate4sd3_1
Xhold2596 _10574_/A _14047_/Q VPWR VGND sg13cmos5l_dlygate4sd3_1
XFILLER_90_129 VPWR VGND sg13cmos5l_fill_2
X_10931_ _10931_/Y _10848_/Y _10929_/Y _10930_/Y VPWR VGND sg13cmos5l_o21ai_1
X_13923__1468 _13923_/RESET_B VPWR VGND sg13cmos5l_tiehi
XFILLER_13_911 VPWR VGND sg13cmos5l_fill_1
XFILLER_71_365 VPWR VGND sg13cmos5l_fill_2
X_10862_ _10863_/A hold3436/X _10960_/B _10857_/Y _10861_/Y VPWR VGND sg13cmos5l_a22oi_1
X_13650_ _13650_/Q clkload53/A _13650_/D _13650_/RESET_B VPWR VGND sg13cmos5l_dfrbpq_1
X_10793_ _10793_/Y _10793_/A _10793_/B VPWR VGND sg13cmos5l_nand2_1
X_13581_ _13581_/Q clkload41/A _13581_/D _13581_/RESET_B VPWR VGND sg13cmos5l_dfrbpq_1
X_12601_ _12607_/C _12601_/A _12601_/B VPWR VGND sg13cmos5l_nand2_1
X_12532_ _12532_/Y _12538_/B _13254_/Q _12531_/Y VPWR VGND sg13cmos5l_o21ai_1
XFILLER_40_796 VPWR VGND sg13cmos5l_fill_2
X_12463_ _14383_/D _12463_/A _12463_/B VPWR VGND sg13cmos5l_nand2_1
X_11414_ _11415_/B _11413_/A _11413_/B _11456_/B VPWR VGND sg13cmos5l_a21oi_1
X_14202_ _14202_/Q _14614_/CLK _14202_/D _14202_/RESET_B VPWR VGND sg13cmos5l_dfrbpq_1
X_12394_ _12394_/Y _14032_/Q _12144_/B _12402_/C1 VPWR VGND sg13cmos5l_a21oi_1
X_11345_ _11352_/D _11347_/B VPWR VGND sg13cmos5l_inv_1
X_14133_ _14133_/Q clkload23/A _14133_/D fanout991/X VPWR VGND sg13cmos5l_dfrbpq_1
X_11276_ _11276_/Y _11275_/A _11272_/X _11288_/A _11275_/Y _08913_/A VPWR VGND sg13cmos5l_a221oi_1
X_14064_ _14064_/Q _14064_/CLK _14064_/D _14064_/RESET_B VPWR VGND sg13cmos5l_dfrbpq_1
XFILLER_106_592 VPWR VGND sg13cmos5l_fill_2
X_10227_ _13876_/D _10357_/A1 _10230_/B _10226_/Y VPWR VGND sg13cmos5l_a21oi_1
X_13015_ _13015_/Y _13015_/A _13015_/B VPWR VGND sg13cmos5l_xnor2_1
XFILLER_94_402 VPWR VGND sg13cmos5l_fill_2
X_13518__1904 _13518_/RESET_B VPWR VGND sg13cmos5l_tiehi
XFILLER_94_435 VPWR VGND sg13cmos5l_fill_1
X_10158_ _13842_/D _10549_/A1 _10169_/B _10157_/Y VPWR VGND sg13cmos5l_a21oi_1
X_10089_ _13809_/D fanout56/X _10088_/B _10088_/Y VPWR VGND sg13cmos5l_o21ai_1
XFILLER_48_874 VPWR VGND sg13cmos5l_fill_1
X_13917_ _13917_/Q _14048_/CLK _13917_/D _13917_/RESET_B VPWR VGND sg13cmos5l_dfrbpq_1
XFILLER_90_674 VPWR VGND sg13cmos5l_fill_2
X_13848_ _13848_/Q _14299_/CLK _13848_/D _13848_/RESET_B VPWR VGND sg13cmos5l_dfrbpq_1
X_14410__1098 _14410_/RESET_B VPWR VGND sg13cmos5l_tiehi
X_13779_ _13779_/Q clkload50/A _13779_/D _13779_/RESET_B VPWR VGND sg13cmos5l_dfrbpq_1
Xclkbuf_4_4_0_clk clkbuf_4_4_0_clk/X clkbuf_0_clk/X VPWR VGND sg13cmos5l_buf_8
X_09941_ _13736_/D _10593_/A1 _09948_/B _09940_/Y VPWR VGND sg13cmos5l_a21oi_1
Xfanout905 _08194_/A _14109_/Q VPWR VGND sg13cmos5l_buf_1
Xfanout916 _11563_/A _11484_/A VPWR VGND sg13cmos5l_buf_1
XFILLER_58_605 VPWR VGND sg13cmos5l_fill_2
X_09872_ _09872_/Y _09872_/A _09882_/B VPWR VGND sg13cmos5l_nor2_1
Xfanout927 _07472_/A _14082_/Q VPWR VGND sg13cmos5l_buf_1
Xfanout938 _07366_/A _07619_/A VPWR VGND sg13cmos5l_buf_1
Xfanout949 _10998_/A _12594_/A VPWR VGND sg13cmos5l_buf_1
XFILLER_58_649 VPWR VGND sg13cmos5l_fill_1
XFILLER_86_947 VPWR VGND sg13cmos5l_fill_1
XFILLER_97_262 VPWR VGND sg13cmos5l_fill_2
X_08823_ _14633_/D _08823_/A _08823_/B _08823_/C _08823_/D VPWR VGND sg13cmos5l_nand4_1
XFILLER_85_446 VPWR VGND sg13cmos5l_fill_1
X_08754_ _14623_/D _11622_/A _08754_/B _08754_/C _08754_/D VPWR VGND sg13cmos5l_nand4_1
X_07705_ _07707_/C _07705_/A _08491_/A _08819_/A VPWR VGND sg13cmos5l_nor3_1
X_08685_ _08685_/Y _13747_/Q _08738_/A2 _08747_/B _13811_/Q VPWR VGND sg13cmos5l_a22oi_1
Xclkbuf_leaf_92_clk clkload26/A clkload1/A VPWR VGND sg13cmos5l_buf_8
XFILLER_54_866 VPWR VGND sg13cmos5l_fill_1
X_07636_ _09032_/S _14522_/Q _13030_/B _13070_/A VPWR VGND sg13cmos5l_nand3_1
X_07567_ _08995_/B _08989_/A _08989_/B VPWR VGND sg13cmos5l_nor2_1
X_09306_ _13424_/D _08397_/A hold3380/X _09306_/S VPWR VGND sg13cmos5l_mux2_1
XFILLER_21_262 VPWR VGND sg13cmos5l_fill_1
X_07498_ _07498_/Y _07498_/A _07498_/B VPWR VGND sg13cmos5l_nand2_1
X_09237_ _13362_/D _10679_/A1 hold3125/X _09260_/S VPWR VGND sg13cmos5l_mux2_1
XFILLER_5_417 VPWR VGND sg13cmos5l_fill_2
X_09168_ _13324_/D _09173_/B _09166_/Y _09167_/Y VPWR VGND sg13cmos5l_a21oi_1
X_08119_ _13211_/D _08119_/A _08119_/B VPWR VGND sg13cmos5l_xnor2_1
X_09099_ _09099_/Y _11360_/A _09098_/Y _09106_/A2 VPWR VGND sg13cmos5l_a21oi_1
X_11130_ _14300_/D _11132_/B _11128_/Y _11129_/Y VPWR VGND sg13cmos5l_a21oi_1
XFILLER_0_133 VPWR VGND sg13cmos5l_fill_1
XFILLER_1_678 VPWR VGND sg13cmos5l_fill_1
XFILLER_62_1003 VPWR VGND sg13cmos5l_decap_8
X_11061_ _11061_/Y _11061_/A _11132_/B VPWR VGND sg13cmos5l_nor2_1
Xhold3050 hold3050/X _13335_/Q VPWR VGND sg13cmos5l_dlygate4sd3_1
XFILLER_49_649 VPWR VGND sg13cmos5l_decap_4
XFILLER_76_435 VPWR VGND sg13cmos5l_decap_8
X_10012_ _13771_/D _10534_/A1 _10013_/B _10011_/Y VPWR VGND sg13cmos5l_o21ai_1
Xhold3061 hold3061/X _14274_/Q VPWR VGND sg13cmos5l_dlygate4sd3_1
Xhold3072 _10250_/A _13888_/Q VPWR VGND sg13cmos5l_dlygate4sd3_1
Xhold3083 hold3083/X _13441_/Q VPWR VGND sg13cmos5l_dlygate4sd3_1
XFILLER_48_148 VPWR VGND sg13cmos5l_fill_2
XFILLER_64_608 VPWR VGND sg13cmos5l_decap_8
Xhold2360 _13270_/D _08959_/Y VPWR VGND sg13cmos5l_dlygate4sd3_1
Xhold2371 _10598_/A _14059_/Q VPWR VGND sg13cmos5l_dlygate4sd3_1
Xhold2382 _10535_/A _14028_/Q VPWR VGND sg13cmos5l_dlygate4sd3_1
Xhold3094 _13480_/D _09367_/X VPWR VGND sg13cmos5l_dlygate4sd3_1
XFILLER_57_660 VPWR VGND sg13cmos5l_fill_1
XFILLER_64_619 VPWR VGND sg13cmos5l_fill_1
XFILLER_92_928 VPWR VGND sg13cmos5l_fill_2
Xhold2393 _10883_/A _14193_/Q VPWR VGND sg13cmos5l_dlygate4sd3_1
XFILLER_44_310 VPWR VGND sg13cmos5l_fill_2
XFILLER_45_855 VPWR VGND sg13cmos5l_fill_2
X_11963_ _11964_/C _13633_/Q _11998_/B1 _11971_/A2 _13889_/Q VPWR VGND sg13cmos5l_a22oi_1
Xclkbuf_leaf_83_clk _14042_/CLK clkbuf_4_8_0_clk/X VPWR VGND sg13cmos5l_buf_8
XFILLER_60_803 VPWR VGND sg13cmos5l_fill_2
X_10914_ _10914_/Y _10914_/A _10952_/B VPWR VGND sg13cmos5l_nand2_1
X_11894_ _11894_/Y _14355_/Q _12124_/A2 _11893_/Y VPWR VGND sg13cmos5l_o21ai_1
X_13702_ _13702_/Q _14053_/CLK _13702_/D _13702_/RESET_B VPWR VGND sg13cmos5l_dfrbpq_1
XFILLER_44_387 VPWR VGND sg13cmos5l_decap_4
X_10845_ _14182_/D _10946_/A _10844_/Y _10835_/Y VPWR VGND sg13cmos5l_o21ai_1
X_13633_ _13633_/Q clkload58/A _13633_/D _13633_/RESET_B VPWR VGND sg13cmos5l_dfrbpq_1
XFILLER_13_774 VPWR VGND sg13cmos5l_fill_2
X_10776_ _10776_/Y _10781_/B _10774_/Y _10775_/Y VPWR VGND sg13cmos5l_o21ai_1
X_13564_ _13564_/Q _14109_/CLK _13564_/D _13564_/RESET_B VPWR VGND sg13cmos5l_dfrbpq_1
X_13495_ _13495_/Q _14105_/CLK _13495_/D _13495_/RESET_B VPWR VGND sg13cmos5l_dfrbpq_1
X_12515_ _12515_/Y _12211_/Y _12515_/B VPWR VGND sg13cmos5l_nand2b_1
X_12446_ _12446_/Y _12445_/A _11706_/Y _12445_/Y VPWR VGND sg13cmos5l_o21ai_1
X_12377_ _12377_/Y _13775_/Q _12373_/B _12377_/B1 _13839_/Q VPWR VGND sg13cmos5l_a22oi_1
XFILLER_4_461 VPWR VGND sg13cmos5l_fill_1
XFILLER_5_33 VPWR VGND sg13cmos5l_fill_1
XFILLER_99_527 VPWR VGND sg13cmos5l_decap_4
X_11328_ _11329_/B _11328_/A _11328_/B VPWR VGND sg13cmos5l_nand2_1
X_14116_ _14116_/Q _14117_/CLK _14116_/D fanout996/X VPWR VGND sg13cmos5l_dfrbpq_1
X_13450__1972 _13450_/RESET_B VPWR VGND sg13cmos5l_tiehi
X_11259_ _11259_/Y _11258_/A _11255_/Y _11257_/X _11258_/Y _08913_/A VPWR VGND sg13cmos5l_a221oi_1
X_14047_ _14047_/Q clkload60/A _14047_/D _14047_/RESET_B VPWR VGND sg13cmos5l_dfrbpq_1
X_13795__1596 _13795_/RESET_B VPWR VGND sg13cmos5l_tiehi
XFILLER_39_137 VPWR VGND sg13cmos5l_fill_1
XFILLER_67_457 VPWR VGND sg13cmos5l_fill_1
XFILLER_67_468 VPWR VGND sg13cmos5l_decap_8
XFILLER_83_906 VPWR VGND sg13cmos5l_fill_1
XFILLER_95_788 VPWR VGND sg13cmos5l_fill_2
Xclkbuf_leaf_74_clk clkload56/A clkbuf_4_10_0_clk/X VPWR VGND sg13cmos5l_buf_8
X_08470_ _08471_/C _07716_/A _08466_/Y _07836_/A VPWR VGND sg13cmos5l_a21oi_1
XFILLER_23_516 VPWR VGND sg13cmos5l_fill_1
XFILLER_51_825 VPWR VGND sg13cmos5l_fill_1
XFILLER_90_471 VPWR VGND sg13cmos5l_fill_1
X_07421_ _07421_/Y _12964_/A _13076_/A VPWR VGND sg13cmos5l_nand2_1
X_07352_ _07353_/C _07352_/A _07352_/B _07389_/B VPWR VGND sg13cmos5l_nand3_1
X_13233__1030 _13233_/RESET_B VPWR VGND sg13cmos5l_tiehi
X_07283_ _07283_/Y _13245_/Q VPWR VGND sg13cmos5l_inv_1
X_09022_ _09022_/Y _09022_/A _09024_/B VPWR VGND sg13cmos5l_nand2_1
X_09924_ _09924_/Y _09924_/A _09924_/B VPWR VGND sg13cmos5l_nor2_1
Xfanout724 _08839_/B _08910_/C VPWR VGND sg13cmos5l_buf_1
Xfanout713 _13191_/B1 _07891_/C VPWR VGND sg13cmos5l_buf_1
Xfanout702 _11196_/B _11307_/B VPWR VGND sg13cmos5l_buf_1
XFILLER_98_593 VPWR VGND sg13cmos5l_fill_2
X_09855_ _13694_/D _10377_/A1 _09892_/B _09854_/Y VPWR VGND sg13cmos5l_a21oi_1
Xfanout757 _08419_/A1 _07194_/Y VPWR VGND sg13cmos5l_buf_1
Xfanout746 _11536_/A _11601_/A VPWR VGND sg13cmos5l_buf_1
Xfanout735 _12286_/A _07846_/X VPWR VGND sg13cmos5l_buf_1
X_13625__1766 _13625_/RESET_B VPWR VGND sg13cmos5l_tiehi
XFILLER_105_56 VPWR VGND sg13cmos5l_fill_1
XFILLER_59_969 VPWR VGND sg13cmos5l_fill_2
XFILLER_86_766 VPWR VGND sg13cmos5l_fill_1
X_08806_ _08806_/Y _08465_/A _08879_/A2 _08805_/Y VPWR VGND sg13cmos5l_o21ai_1
Xfanout779 _11033_/S1 _08405_/C1 VPWR VGND sg13cmos5l_buf_1
Xfanout768 _11243_/A _14624_/Q VPWR VGND sg13cmos5l_buf_1
X_09786_ _13660_/D _10308_/A1 _09797_/B _09785_/Y VPWR VGND sg13cmos5l_a21oi_1
X_08737_ _08737_/Y _14038_/Q _08729_/B _08725_/B _13782_/Q VPWR VGND sg13cmos5l_a22oi_1
Xclkbuf_leaf_65_clk clkload78/A clkbuf_4_14_0_clk/X VPWR VGND sg13cmos5l_buf_8
XFILLER_14_505 VPWR VGND sg13cmos5l_fill_2
XFILLER_54_663 VPWR VGND sg13cmos5l_fill_1
XFILLER_54_674 VPWR VGND sg13cmos5l_decap_4
X_08668_ _08668_/Y _13650_/Q _11727_/B _08667_/Y VPWR VGND sg13cmos5l_o21ai_1
X_14005__1386 _14005_/RESET_B VPWR VGND sg13cmos5l_tiehi
X_13840__1551 _13840_/RESET_B VPWR VGND sg13cmos5l_tiehi
X_07619_ _07631_/D _07619_/A _07619_/B VPWR VGND sg13cmos5l_xnor2_1
X_08599_ _14608_/D _08609_/B _08599_/B VPWR VGND sg13cmos5l_xnor2_1
X_10630_ _10630_/Y _10630_/A _10630_/B VPWR VGND sg13cmos5l_xnor2_1
X_10561_ _14040_/D _10561_/A1 _10596_/B _10560_/Y VPWR VGND sg13cmos5l_o21ai_1
XFILLER_14_97 VPWR VGND sg13cmos5l_fill_2
X_10492_ _14006_/D _10557_/A1 _10497_/B _10491_/Y VPWR VGND sg13cmos5l_o21ai_1
X_12300_ _12300_/Y _12248_/A _12383_/A2 _12417_/B VPWR VGND sg13cmos5l_a21oi_1
X_13280_ _13280_/Q clkload20/A _13280_/D fanout984/X VPWR VGND sg13cmos5l_dfrbpq_1
XFILLER_6_737 VPWR VGND sg13cmos5l_fill_2
X_12231_ _12231_/Y _12227_/Y _12228_/Y _12229_/Y _12230_/Y VPWR VGND sg13cmos5l_a22oi_1
X_12162_ _12162_/Y _12162_/A _12162_/B VPWR VGND sg13cmos5l_nor2_1
X_14209__1268 _14209_/RESET_B VPWR VGND sg13cmos5l_tiehi
X_11113_ _11113_/Y _11121_/B _14379_/Q VPWR VGND sg13cmos5l_nor2b_1
X_12093_ _12094_/B _12093_/A _12164_/B VPWR VGND sg13cmos5l_nand2_1
X_11044_ _14275_/D _11093_/A _11123_/B _11043_/Y VPWR VGND sg13cmos5l_a21oi_1
XFILLER_103_381 VPWR VGND sg13cmos5l_fill_2
XFILLER_49_457 VPWR VGND sg13cmos5l_fill_2
XFILLER_77_744 VPWR VGND sg13cmos5l_decap_8
XFILLER_64_405 VPWR VGND sg13cmos5l_decap_8
XFILLER_65_917 VPWR VGND sg13cmos5l_fill_2
Xclkbuf_leaf_56_clk clkload77/A clkbuf_4_14_0_clk/X VPWR VGND sg13cmos5l_buf_8
X_12995_ _14485_/D _12996_/B _12995_/B VPWR VGND sg13cmos5l_and2_1
XFILLER_73_972 VPWR VGND sg13cmos5l_fill_1
X_11946_ _11947_/B _14048_/Q _08687_/Y _11945_/X _11862_/B VPWR VGND sg13cmos5l_a22oi_1
X_13468__1954 _13468_/RESET_B VPWR VGND sg13cmos5l_tiehi
X_11877_ _11877_/Y _11903_/A _11904_/A VPWR VGND sg13cmos5l_xnor2_1
XFILLER_13_560 VPWR VGND sg13cmos5l_fill_1
X_10828_ _14176_/D _14259_/D _14176_/Q _10894_/D VPWR VGND sg13cmos5l_mux2_1
X_14596_ _14596_/Q _14640_/CLK _14596_/D _14596_/RESET_B VPWR VGND sg13cmos5l_dfrbpq_1
X_14291__1217 _14291_/RESET_B VPWR VGND sg13cmos5l_tiehi
X_13616_ _13616_/Q clkload62/A _13616_/D _13616_/RESET_B VPWR VGND sg13cmos5l_dfrbpq_1
X_10759_ _10759_/Y _10759_/A _14291_/Q VPWR VGND sg13cmos5l_nand2_1
X_13547_ _13547_/Q _14238_/CLK _13547_/D _13547_/RESET_B VPWR VGND sg13cmos5l_dfrbpq_1
X_13703__1688 _13703_/RESET_B VPWR VGND sg13cmos5l_tiehi
X_13478_ _13478_/Q clkload41/A _13478_/D _13478_/RESET_B VPWR VGND sg13cmos5l_dfrbpq_1
X_12429_ _12429_/Y _12424_/Y _12425_/Y _12427_/Y _12428_/Y _12430_/A1 VPWR VGND sg13cmos5l_a221oi_1
X_13882__1509 _13882_/RESET_B VPWR VGND sg13cmos5l_tiehi
X_07970_ _07970_/Y _08214_/A _07967_/X _07969_/Y VPWR VGND sg13cmos5l_a21oi_1
XFILLER_55_416 VPWR VGND sg13cmos5l_fill_2
XFILLER_56_917 VPWR VGND sg13cmos5l_decap_8
XFILLER_56_939 VPWR VGND sg13cmos5l_fill_1
X_09640_ _09640_/Y _09640_/A1 _11482_/B _09639_/Y VPWR VGND sg13cmos5l_a21oi_1
XFILLER_55_427 VPWR VGND sg13cmos5l_fill_1
X_09571_ _09571_/Y _09571_/A _09571_/B VPWR VGND sg13cmos5l_nor2_1
XFILLER_24_803 VPWR VGND sg13cmos5l_fill_1
XFILLER_83_769 VPWR VGND sg13cmos5l_fill_1
X_08522_ _14596_/D _08529_/B _08522_/B VPWR VGND sg13cmos5l_xor2_1
Xclkbuf_leaf_47_clk clkload73/A clkload6/A VPWR VGND sg13cmos5l_buf_8
X_13336__2086 _13336_/RESET_B VPWR VGND sg13cmos5l_tiehi
XFILLER_24_847 VPWR VGND sg13cmos5l_fill_1
X_08453_ _08453_/X _08471_/A _08456_/B _08456_/C VPWR VGND sg13cmos5l_or3_1
XFILLER_51_666 VPWR VGND sg13cmos5l_fill_2
XFILLER_90_290 VPWR VGND sg13cmos5l_fill_2
X_07404_ _07417_/B _12964_/A _08157_/B _07420_/B VPWR VGND sg13cmos5l_nand3_1
XFILLER_11_508 VPWR VGND sg13cmos5l_fill_2
X_08384_ _08384_/X _09304_/A _08397_/B VPWR VGND sg13cmos5l_and2_1
X_07335_ _07335_/Y _14139_/Q VPWR VGND sg13cmos5l_inv_1
X_07266_ _07266_/Y _14095_/Q VPWR VGND sg13cmos5l_inv_1
X_09005_ _13281_/D hold3481/X _07619_/A _13034_/B VPWR VGND sg13cmos5l_mux2_1
X_07197_ _10623_/A _10624_/A VPWR VGND sg13cmos5l_inv_1
X_13858__1533 _13858_/RESET_B VPWR VGND sg13cmos5l_tiehi
X_09907_ _13719_/D _10559_/A1 _09912_/B _09906_/Y VPWR VGND sg13cmos5l_a21oi_1
Xfanout532 _11040_/A _12964_/B VPWR VGND sg13cmos5l_buf_1
Xfanout521 _11166_/A2 _08436_/Y VPWR VGND sg13cmos5l_buf_1
Xfanout510 fanout510/X _12245_/B2 VPWR VGND sg13cmos5l_buf_1
X_13546__1876 _13546_/RESET_B VPWR VGND sg13cmos5l_tiehi
XFILLER_47_906 VPWR VGND sg13cmos5l_fill_1
XFILLER_86_541 VPWR VGND sg13cmos5l_fill_1
Xfanout565 _12237_/B _12060_/B VPWR VGND sg13cmos5l_buf_1
Xfanout554 _08822_/B _08841_/B VPWR VGND sg13cmos5l_buf_1
Xfanout543 _09509_/A _09556_/A VPWR VGND sg13cmos5l_buf_1
XFILLER_101_885 VPWR VGND sg13cmos5l_decap_8
XFILLER_47_917 VPWR VGND sg13cmos5l_fill_1
X_09838_ _09838_/Y _09838_/A _09858_/B VPWR VGND sg13cmos5l_nor2_1
Xfanout598 _11948_/B2 _08674_/A VPWR VGND sg13cmos5l_buf_1
Xfanout587 _12346_/B1 _12318_/B1 VPWR VGND sg13cmos5l_buf_1
Xfanout576 _11945_/S fanout584/X VPWR VGND sg13cmos5l_buf_1
X_09769_ _09769_/Y _09769_/A _09773_/B VPWR VGND sg13cmos5l_nor2_1
XFILLER_55_950 VPWR VGND sg13cmos5l_fill_2
XFILLER_73_268 VPWR VGND sg13cmos5l_fill_1
X_11800_ _11801_/D _14350_/Q _13235_/Q _11983_/A VPWR VGND sg13cmos5l_nand3_1
Xclkbuf_leaf_38_clk clkload39/A clkbuf_4_6_0_clk/X VPWR VGND sg13cmos5l_buf_8
X_14090__1317 _14090_/RESET_B VPWR VGND sg13cmos5l_tiehi
XFILLER_82_780 VPWR VGND sg13cmos5l_fill_1
XFILLER_92_58 VPWR VGND sg13cmos5l_fill_2
X_12780_ _12780_/Y _14361_/Q _12861_/A2 fanout59/X _12779_/X VPWR VGND sg13cmos5l_a22oi_1
XFILLER_14_346 VPWR VGND sg13cmos5l_fill_2
X_11731_ _11731_/Y _13880_/Q _11725_/B _11730_/Y VPWR VGND sg13cmos5l_o21ai_1
XFILLER_42_677 VPWR VGND sg13cmos5l_decap_8
X_11662_ _11663_/B _11650_/A _11650_/B _11647_/Y VPWR VGND sg13cmos5l_o21ai_1
X_14450_ _14450_/Q clkload67/A _14450_/D _14450_/RESET_B VPWR VGND sg13cmos5l_dfrbpq_1
X_10613_ _10613_/X _13199_/Q _13200_/Q _13201_/Q _13202_/Q _07369_/B _07369_/A VPWR
+ VGND sg13cmos5l_mux4_1
X_11593_ _11593_/Y _11587_/A _11598_/B _12961_/B2 VPWR VGND sg13cmos5l_o21ai_1
X_14381_ _14381_/Q clkload54/A _14381_/D _14381_/RESET_B VPWR VGND sg13cmos5l_dfrbpq_1
X_13401_ _13401_/Q _14621_/CLK _13401_/D _13401_/RESET_B VPWR VGND sg13cmos5l_dfrbpq_1
X_10544_ _14032_/D fanout58/X _10545_/B _10543_/Y VPWR VGND sg13cmos5l_o21ai_1
X_13332_ _13332_/Q clkload15/A _13332_/D _13332_/RESET_B VPWR VGND sg13cmos5l_dfrbpq_1
X_10475_ _13998_/D fanout74/X _10474_/B _10474_/Y VPWR VGND sg13cmos5l_a21oi_1
X_13263_ _13263_/Q _14577_/CLK _13263_/D fanout964/X VPWR VGND sg13cmos5l_dfrbpq_1
XFILLER_29_1004 VPWR VGND sg13cmos5l_fill_1
X_12214_ _12214_/Y _12251_/A _12214_/B VPWR VGND sg13cmos5l_nand2b_1
X_13194_ _13243_/D _07281_/Y _13194_/A2 _13196_/B1 _13193_/Y VPWR VGND sg13cmos5l_a22oi_1
X_12145_ _12147_/B _13607_/Q _12402_/A2 _12297_/C1 VPWR VGND sg13cmos5l_a21oi_1
XFILLER_1_294 VPWR VGND sg13cmos5l_fill_2
XFILLER_96_338 VPWR VGND sg13cmos5l_fill_2
X_12076_ _12102_/B _14361_/Q _13246_/Q VPWR VGND sg13cmos5l_xor2_1
X_11027_ _14240_/D _11618_/C _11026_/Y _07997_/X VPWR VGND sg13cmos5l_a21o_1
X_14345__1163 _14345_/RESET_B VPWR VGND sg13cmos5l_tiehi
XFILLER_65_725 VPWR VGND sg13cmos5l_fill_2
XFILLER_92_522 VPWR VGND sg13cmos5l_fill_2
XFILLER_64_246 VPWR VGND sg13cmos5l_fill_2
XFILLER_65_769 VPWR VGND sg13cmos5l_decap_8
Xclkbuf_leaf_29_clk clkload33/A clkload2/A VPWR VGND sg13cmos5l_buf_8
XFILLER_33_622 VPWR VGND sg13cmos5l_fill_1
X_12978_ _12981_/C _14477_/Q _12979_/B VPWR VGND sg13cmos5l_and2_1
X_11929_ _11930_/B _14355_/Q _13240_/Q _11901_/Y VPWR VGND sg13cmos5l_a21oi_1
XFILLER_21_828 VPWR VGND sg13cmos5l_fill_2
XFILLER_60_463 VPWR VGND sg13cmos5l_decap_4
XFILLER_61_986 VPWR VGND sg13cmos5l_fill_1
X_14648_ _14648_/Q clkload81/A _14648_/D _14648_/RESET_B VPWR VGND sg13cmos5l_dfrbpq_1
X_13936__1455 _13936_/RESET_B VPWR VGND sg13cmos5l_tiehi
X_14579_ _14579_/Q _14614_/CLK _14579_/D _14579_/RESET_B VPWR VGND sg13cmos5l_dfrbpq_1
XFILLER_9_394 VPWR VGND sg13cmos5l_fill_2
XFILLER_56_0 VPWR VGND sg13cmos5l_fill_2
XFILLER_82_1017 VPWR VGND sg13cmos5l_fill_2
Xhold2904 _10440_/A _13981_/Q VPWR VGND sg13cmos5l_dlygate4sd3_1
X_07953_ _14577_/D _10697_/S _07953_/B VPWR VGND sg13cmos5l_nand2_1
Xhold2915 _10266_/A _13896_/Q VPWR VGND sg13cmos5l_dlygate4sd3_1
Xhold2926 _10358_/A _13941_/Q VPWR VGND sg13cmos5l_dlygate4sd3_1
Xhold2937 _09530_/A _13593_/Q VPWR VGND sg13cmos5l_dlygate4sd3_1
Xhold2948 hold2948/X _14603_/Q VPWR VGND sg13cmos5l_dlygate4sd3_1
X_07884_ _07893_/B _14189_/Q _14188_/Q VPWR VGND sg13cmos5l_nor2_1
Xhold2959 _10362_/A _13943_/Q VPWR VGND sg13cmos5l_dlygate4sd3_1
X_09623_ _11450_/B _14427_/Q _14646_/Q _09662_/S VPWR VGND sg13cmos5l_mux2_1
XFILLER_56_769 VPWR VGND sg13cmos5l_fill_2
X_09554_ _09556_/B _14447_/Q _09549_/B _14448_/Q VPWR VGND sg13cmos5l_a21oi_1
XFILLER_24_622 VPWR VGND sg13cmos5l_fill_1
X_08505_ _08505_/Y _07693_/B _07698_/B _07689_/Y VPWR VGND sg13cmos5l_a21oi_1
X_09485_ _09485_/Y _14237_/Q _09485_/B VPWR VGND sg13cmos5l_nand2_1
X_08436_ _08436_/Y _11149_/B _08436_/B _10654_/B VPWR VGND sg13cmos5l_nand3_1
XFILLER_12_839 VPWR VGND sg13cmos5l_fill_2
X_08367_ _12582_/B _08360_/Y _08366_/Y _08356_/Y VPWR VGND sg13cmos5l_o21ai_1
X_07318_ _07318_/Y _13356_/Q VPWR VGND sg13cmos5l_inv_1
X_08298_ _08298_/Y _08363_/S _07311_/Y _08165_/A VPWR VGND sg13cmos5l_a21oi_1
X_07249_ _11097_/A _14375_/Q VPWR VGND sg13cmos5l_inv_1
X_14423__1085 _14423_/RESET_B VPWR VGND sg13cmos5l_tiehi
XFILLER_106_922 VPWR VGND sg13cmos5l_decap_8
X_10260_ _10260_/Y _10260_/A _10274_/B VPWR VGND sg13cmos5l_nor2_1
XFILLER_106_999 VPWR VGND sg13cmos5l_decap_8
X_10191_ _10191_/Y _10191_/A _10213_/B VPWR VGND sg13cmos5l_nor2_1
XFILLER_59_541 VPWR VGND sg13cmos5l_fill_2
XFILLER_87_850 VPWR VGND sg13cmos5l_fill_1
Xfanout340 _10355_/A1 _09492_/Y VPWR VGND sg13cmos5l_buf_1
XFILLER_47_703 VPWR VGND sg13cmos5l_fill_2
XFILLER_59_552 VPWR VGND sg13cmos5l_fill_2
Xfanout384 _08411_/A _08376_/A1 VPWR VGND sg13cmos5l_buf_1
Xfanout373 _07993_/A _08310_/B1 VPWR VGND sg13cmos5l_buf_1
Xfanout362 _09095_/B _09137_/B VPWR VGND sg13cmos5l_buf_1
Xfanout351 _09682_/B _09673_/B VPWR VGND sg13cmos5l_buf_1
X_13950_ _13950_/Q clkload51/A _13950_/D _13950_/RESET_B VPWR VGND sg13cmos5l_dfrbpq_1
XFILLER_101_671 VPWR VGND sg13cmos5l_fill_1
XFILLER_47_736 VPWR VGND sg13cmos5l_fill_2
XFILLER_86_360 VPWR VGND sg13cmos5l_fill_1
Xfanout395 _12408_/A1 _11624_/Y VPWR VGND sg13cmos5l_buf_1
X_12901_ _12902_/A _14438_/Q _11196_/B _11170_/A _12907_/B2 VPWR VGND sg13cmos5l_a22oi_1
XFILLER_47_769 VPWR VGND sg13cmos5l_fill_2
XFILLER_59_1008 VPWR VGND sg13cmos5l_decap_8
XFILLER_74_544 VPWR VGND sg13cmos5l_decap_8
X_13881_ _13881_/Q clkload48/A _13881_/D _13881_/RESET_B VPWR VGND sg13cmos5l_dfrbpq_1
XFILLER_55_780 VPWR VGND sg13cmos5l_fill_2
X_12832_ _12832_/Y _12832_/A _12832_/B VPWR VGND sg13cmos5l_xnor2_1
XFILLER_27_482 VPWR VGND sg13cmos5l_fill_1
X_13235__1022 _13235_/RESET_B VPWR VGND sg13cmos5l_tiehi
X_12763_ _14423_/D _12843_/A _12763_/B VPWR VGND sg13cmos5l_and2_1
X_11714_ _11741_/B _11713_/A _11713_/C _11713_/B VPWR VGND sg13cmos5l_o21ai_1
X_14502_ _14502_/Q clkload15/A _14502_/D _09199_/A VPWR VGND sg13cmos5l_dfrbpq_1
XFILLER_30_636 VPWR VGND sg13cmos5l_fill_2
XFILLER_42_485 VPWR VGND sg13cmos5l_decap_8
X_14433_ _14433_/Q _14654_/CLK _14433_/D _14433_/RESET_B VPWR VGND sg13cmos5l_dfrbpq_1
X_12694_ _12694_/Y _12715_/A _12694_/B VPWR VGND sg13cmos5l_nor2_1
X_11645_ _11645_/Y _08694_/Y _11793_/A1 _11644_/Y VPWR VGND sg13cmos5l_o21ai_1
X_11576_ _11576_/Y _11595_/A _11576_/B _11596_/A VPWR VGND sg13cmos5l_nor3_1
Xinput15 input15/X ui_in[7] VPWR VGND sg13cmos5l_buf_1
X_14364_ _14364_/Q clkload80/A _14364_/D _14364_/RESET_B VPWR VGND sg13cmos5l_dfrbpq_1
XFILLER_10_393 VPWR VGND sg13cmos5l_fill_2
X_10527_ _10527_/Y _10527_/A _10535_/B VPWR VGND sg13cmos5l_nand2_1
X_14295_ _14295_/Q clkload24/A _14295_/D _14295_/RESET_B VPWR VGND sg13cmos5l_dfrbpq_1
X_13620__1771 _13620_/RESET_B VPWR VGND sg13cmos5l_tiehi
X_13315_ _13315_/Q _14453_/CLK _13315_/D _13315_/RESET_B VPWR VGND sg13cmos5l_dfrbpq_1
XFILLER_6_364 VPWR VGND sg13cmos5l_fill_1
X_10458_ _10458_/Y _10458_/A _10474_/B VPWR VGND sg13cmos5l_nor2_1
X_13246_ _13246_/Q clkload77/A _13246_/D _13246_/RESET_B VPWR VGND sg13cmos5l_dfrbpq_1
XFILLER_69_305 VPWR VGND sg13cmos5l_fill_1
X_10389_ _13956_/D _10585_/A1 _10410_/B _10388_/Y VPWR VGND sg13cmos5l_a21oi_1
X_13177_ _13177_/Y _11275_/A _14090_/Q _08917_/X _14271_/Q _10904_/B VPWR VGND sg13cmos5l_a221oi_1
X_12128_ _12128_/Y _14457_/Q _12302_/A2 _12110_/X _12286_/A _12127_/X VPWR VGND sg13cmos5l_a221oi_1
X_14000__1391 _14000_/RESET_B VPWR VGND sg13cmos5l_tiehi
XFILLER_38_703 VPWR VGND sg13cmos5l_fill_1
XFILLER_78_850 VPWR VGND sg13cmos5l_decap_8
X_12059_ _12059_/Y _13604_/Q _11785_/B _12236_/B1 VPWR VGND sg13cmos5l_a21oi_1
XFILLER_37_235 VPWR VGND sg13cmos5l_fill_1
XFILLER_46_780 VPWR VGND sg13cmos5l_fill_2
XFILLER_65_599 VPWR VGND sg13cmos5l_decap_8
XFILLER_93_897 VPWR VGND sg13cmos5l_fill_2
XFILLER_80_558 VPWR VGND sg13cmos5l_fill_2
X_09270_ _09270_/X _14099_/Q hold3185/X _09293_/B VPWR VGND sg13cmos5l_mux2_1
X_08221_ _08221_/Y _08258_/S _07300_/Y _08202_/A VPWR VGND sg13cmos5l_a21oi_1
X_14168__1309 _14168_/RESET_B VPWR VGND sg13cmos5l_tiehi
X_14204__1273 _14204_/RESET_B VPWR VGND sg13cmos5l_tiehi
X_08152_ _08152_/X _10780_/A _13071_/B _08152_/C VPWR VGND sg13cmos5l_or3_1
X_08083_ _08086_/B _08052_/Y _09377_/A _08082_/Y VPWR VGND sg13cmos5l_a21oi_1
Xclkbuf_leaf_9_clk _14576_/CLK clkload0/A VPWR VGND sg13cmos5l_buf_8
Xhold3424 hold3424/X _14244_/Q VPWR VGND sg13cmos5l_dlygate4sd3_1
Xhold3413 hold3413/X _15895_/A VPWR VGND sg13cmos5l_dlygate4sd3_1
Xhold3402 hold3402/X _13289_/Q VPWR VGND sg13cmos5l_dlygate4sd3_1
XFILLER_103_969 VPWR VGND sg13cmos5l_decap_8
X_08985_ _08985_/Y _08996_/B _08985_/B VPWR VGND sg13cmos5l_nor2_1
Xhold2701 _10195_/A _13861_/Q VPWR VGND sg13cmos5l_dlygate4sd3_1
Xhold2712 _07312_/A _13353_/Q VPWR VGND sg13cmos5l_dlygate4sd3_1
Xhold2723 _10588_/A _14054_/Q VPWR VGND sg13cmos5l_dlygate4sd3_1
Xhold3457 hold3457/X _13288_/Q VPWR VGND sg13cmos5l_dlygate4sd3_1
Xhold3446 _08841_/A _14595_/Q VPWR VGND sg13cmos5l_dlygate4sd3_1
Xhold3435 hold3435/X _14102_/Q VPWR VGND sg13cmos5l_dlygate4sd3_1
X_07936_ _07939_/B _08000_/A _11024_/A _07936_/B1 VPWR VGND sg13cmos5l_a21o_1
Xhold2734 _11047_/A _14277_/Q VPWR VGND sg13cmos5l_dlygate4sd3_1
Xhold2745 _10370_/A _13947_/Q VPWR VGND sg13cmos5l_dlygate4sd3_1
Xhold2756 _11135_/A _14302_/Q VPWR VGND sg13cmos5l_dlygate4sd3_1
Xhold3479 _07185_/A _14310_/Q VPWR VGND sg13cmos5l_dlygate4sd3_1
Xhold3468 _10939_/A _14213_/Q VPWR VGND sg13cmos5l_dlygate4sd3_1
X_14408__1100 _14408_/RESET_B VPWR VGND sg13cmos5l_tiehi
Xhold2767 _09693_/A _13617_/Q VPWR VGND sg13cmos5l_dlygate4sd3_1
Xhold2778 _10238_/A _13882_/Q VPWR VGND sg13cmos5l_dlygate4sd3_1
Xhold2789 _09876_/A _13705_/Q VPWR VGND sg13cmos5l_dlygate4sd3_1
X_07867_ _14565_/D _07258_/Y _07859_/Y _07866_/Y VPWR VGND sg13cmos5l_o21ai_1
XFILLER_44_739 VPWR VGND sg13cmos5l_fill_2
XFILLER_71_525 VPWR VGND sg13cmos5l_fill_1
X_07798_ _07799_/C _08593_/A _08593_/B VPWR VGND sg13cmos5l_nand2_1
X_09606_ _09606_/Y _09617_/A _11408_/B _09605_/Y VPWR VGND sg13cmos5l_o21ai_1
X_13662__1729 _13662_/RESET_B VPWR VGND sg13cmos5l_tiehi
X_09537_ _09537_/Y _09537_/A _09642_/B VPWR VGND sg13cmos5l_nor2_1
XFILLER_106_1006 VPWR VGND sg13cmos5l_decap_8
XFILLER_24_474 VPWR VGND sg13cmos5l_fill_1
XFILLER_52_783 VPWR VGND sg13cmos5l_fill_2
X_09468_ _09468_/X _14123_/Q hold3226/X _09475_/S VPWR VGND sg13cmos5l_mux2_1
XFILLER_12_669 VPWR VGND sg13cmos5l_fill_1
X_08419_ _08419_/Y _08419_/A1 _08414_/Y _07416_/Y VPWR VGND sg13cmos5l_o21ai_1
X_09399_ _09399_/X _14120_/Q hold3244/X _09401_/S VPWR VGND sg13cmos5l_mux2_1
X_14042__1349 _14042_/RESET_B VPWR VGND sg13cmos5l_tiehi
X_11430_ _11431_/B _11430_/A _11430_/B VPWR VGND sg13cmos5l_nand2_1
X_11361_ _11389_/A _14174_/Q _11401_/B VPWR VGND sg13cmos5l_nand2_1
X_10312_ _13918_/D _10377_/A1 _10345_/B _10311_/Y VPWR VGND sg13cmos5l_a21oi_1
X_13100_ _14533_/D _13100_/A _13102_/B VPWR VGND sg13cmos5l_nor2b_1
XFILLER_106_752 VPWR VGND sg13cmos5l_fill_2
X_11292_ _11292_/Y _11292_/A _11307_/B VPWR VGND sg13cmos5l_nand2_1
X_14080_ _14080_/Q clkload14/A _14080_/D _09199_/A VPWR VGND sg13cmos5l_dfrbpq_1
XFILLER_106_785 VPWR VGND sg13cmos5l_fill_1
X_10243_ _13884_/D _10308_/A1 _10250_/B _10242_/Y VPWR VGND sg13cmos5l_a21oi_1
X_13031_ _13031_/Y _13031_/A _13070_/B VPWR VGND sg13cmos5l_nand2_1
X_10174_ _13850_/D _10565_/A1 _10173_/B _10173_/Y VPWR VGND sg13cmos5l_a21oi_1
X_13331__2091 _13331_/RESET_B VPWR VGND sg13cmos5l_tiehi
XFILLER_94_617 VPWR VGND sg13cmos5l_decap_8
XFILLER_59_382 VPWR VGND sg13cmos5l_fill_2
Xfanout192 _08960_/B _09000_/A2 VPWR VGND sg13cmos5l_buf_1
Xfanout181 _10379_/A1 _09572_/Y VPWR VGND sg13cmos5l_buf_1
Xfanout170 fanout170/X _10799_/B VPWR VGND sg13cmos5l_buf_1
XFILLER_59_393 VPWR VGND sg13cmos5l_fill_2
X_13933_ _13933_/Q _14053_/CLK _13933_/D _13933_/RESET_B VPWR VGND sg13cmos5l_dfrbpq_1
XFILLER_35_717 VPWR VGND sg13cmos5l_fill_1
X_13864_ _13864_/Q _14065_/CLK _13864_/D _13864_/RESET_B VPWR VGND sg13cmos5l_dfrbpq_1
XFILLER_16_942 VPWR VGND sg13cmos5l_decap_8
XFILLER_16_953 VPWR VGND sg13cmos5l_fill_1
XFILLER_90_845 VPWR VGND sg13cmos5l_decap_8
X_13638__1753 _13638_/RESET_B VPWR VGND sg13cmos5l_tiehi
X_12815_ _12828_/C _12813_/Y _12815_/B VPWR VGND sg13cmos5l_nand2b_1
XFILLER_90_889 VPWR VGND sg13cmos5l_fill_2
X_13795_ _13795_/Q clkload57/A _13795_/D _13795_/RESET_B VPWR VGND sg13cmos5l_dfrbpq_1
X_12746_ _12746_/Y _12732_/A _12731_/A _12730_/Y VPWR VGND sg13cmos5l_o21ai_1
X_12677_ _12677_/Y _12677_/A _12669_/Y VPWR VGND sg13cmos5l_nor2b_1
X_11628_ _11628_/Y _11628_/A _11657_/B VPWR VGND sg13cmos5l_nand2_1
X_14416_ _14416_/Q clkload65/A _14416_/D _14416_/RESET_B VPWR VGND sg13cmos5l_dfrbpq_1
X_14018__1373 _14018_/RESET_B VPWR VGND sg13cmos5l_tiehi
XFILLER_8_99 VPWR VGND sg13cmos5l_fill_2
X_14347_ _14347_/Q clkload36/A _14347_/D _14347_/RESET_B VPWR VGND sg13cmos5l_dfrbpq_1
X_11559_ _14337_/D _11557_/Y _11558_/Y _11541_/Y VPWR VGND sg13cmos5l_o21ai_1
X_13541__1881 _13541_/RESET_B VPWR VGND sg13cmos5l_tiehi
X_14278_ _14278_/Q clkload23/A _14278_/D _14278_/RESET_B VPWR VGND sg13cmos5l_dfrbpq_1
X_13229_ _13229_/Q clkload39/A _13229_/D _13229_/RESET_B VPWR VGND sg13cmos5l_dfrbpq_1
X_08770_ _08770_/Y _08782_/A1 _07334_/Y _08769_/Y VPWR VGND sg13cmos5l_o21ai_1
XFILLER_66_842 VPWR VGND sg13cmos5l_fill_1
X_07721_ _08457_/A _14376_/Q _11656_/A VPWR VGND sg13cmos5l_nand2_1
XFILLER_93_661 VPWR VGND sg13cmos5l_fill_1
XFILLER_93_683 VPWR VGND sg13cmos5l_fill_1
X_07652_ _07652_/Y _08875_/A _08579_/A VPWR VGND sg13cmos5l_nor2_1
XFILLER_53_536 VPWR VGND sg13cmos5l_fill_2
XFILLER_53_547 VPWR VGND sg13cmos5l_decap_8
X_07583_ _07597_/C _08995_/A _08999_/A _08995_/B VPWR VGND sg13cmos5l_nand3_1
X_09322_ _13438_/D _07961_/A hold3222/X _09341_/S VPWR VGND sg13cmos5l_mux2_1
X_09253_ _13378_/D _09286_/A hold3199/X _09266_/S VPWR VGND sg13cmos5l_mux2_1
X_13373__2049 _13373_/RESET_B VPWR VGND sg13cmos5l_tiehi
XFILLER_22_989 VPWR VGND sg13cmos5l_fill_2
X_08204_ _12571_/B _08204_/A1 _08203_/Y _08199_/Y VPWR VGND sg13cmos5l_o21ai_1
X_09184_ _09184_/Y _14371_/Q _09196_/A2 _09183_/Y VPWR VGND sg13cmos5l_a21oi_1
X_08135_ _08136_/B _13217_/Q _13218_/Q VPWR VGND sg13cmos5l_nand2_1
XFILLER_4_109 VPWR VGND sg13cmos5l_fill_2
X_08066_ _08066_/Y _08066_/A VPWR VGND sg13cmos5l_inv_1
XFILLER_89_923 VPWR VGND sg13cmos5l_fill_1
XFILLER_102_221 VPWR VGND sg13cmos5l_fill_2
Xhold3210 _13496_/D _09384_/X VPWR VGND sg13cmos5l_dlygate4sd3_1
Xhold3221 hold3221/X _13452_/Q VPWR VGND sg13cmos5l_dlygate4sd3_1
Xhold3232 hold3232/X _13508_/Q VPWR VGND sg13cmos5l_dlygate4sd3_1
X_13716__1675 _13716_/RESET_B VPWR VGND sg13cmos5l_tiehi
XFILLER_103_755 VPWR VGND sg13cmos5l_fill_2
Xhold2520 _10013_/A _13772_/Q VPWR VGND sg13cmos5l_dlygate4sd3_1
Xhold2531 _14164_/D _10810_/Y VPWR VGND sg13cmos5l_dlygate4sd3_1
Xhold3276 hold3276/X _13466_/Q VPWR VGND sg13cmos5l_dlygate4sd3_1
Xhold3265 _13546_/D _09435_/X VPWR VGND sg13cmos5l_dlygate4sd3_1
Xhold3254 hold3254/X _15892_/A VPWR VGND sg13cmos5l_dlygate4sd3_1
Xhold3243 _13216_/D _08131_/Y VPWR VGND sg13cmos5l_dlygate4sd3_1
XFILLER_57_820 VPWR VGND sg13cmos5l_fill_1
X_08968_ _13272_/D _08977_/B _08966_/Y _08967_/Y VPWR VGND sg13cmos5l_o21ai_1
Xhold2542 _13218_/D _08134_/Y VPWR VGND sg13cmos5l_dlygate4sd3_1
Xhold2553 _10291_/A _13908_/Q VPWR VGND sg13cmos5l_dlygate4sd3_1
Xhold2564 _10748_/A _14143_/Q VPWR VGND sg13cmos5l_dlygate4sd3_1
Xhold3298 hold3298/X _13428_/Q VPWR VGND sg13cmos5l_dlygate4sd3_1
Xhold3287 hold3287/X _13561_/Q VPWR VGND sg13cmos5l_dlygate4sd3_1
XFILLER_57_853 VPWR VGND sg13cmos5l_fill_2
X_07919_ _07919_/Y _07997_/C VPWR VGND sg13cmos5l_inv_1
X_08899_ _08899_/Y _08619_/B _08902_/A2 _08898_/Y VPWR VGND sg13cmos5l_o21ai_1
Xhold2575 _10264_/A _13895_/Q VPWR VGND sg13cmos5l_dlygate4sd3_1
Xhold2586 _10456_/A _13989_/Q VPWR VGND sg13cmos5l_dlygate4sd3_1
Xhold2597 _09730_/A _13634_/Q VPWR VGND sg13cmos5l_dlygate4sd3_1
XFILLER_72_812 VPWR VGND sg13cmos5l_decap_4
XFILLER_83_160 VPWR VGND sg13cmos5l_fill_1
X_10930_ _10930_/Y _10963_/C _10932_/B VPWR VGND sg13cmos5l_nand2_1
X_13931__1460 _13931_/RESET_B VPWR VGND sg13cmos5l_tiehi
X_13583__1839 _13583_/RESET_B VPWR VGND sg13cmos5l_tiehi
X_10861_ _10861_/Y _10960_/B _10861_/B VPWR VGND sg13cmos5l_nor2_1
X_12600_ _12601_/B _12548_/Y _12597_/Y _12599_/Y VPWR VGND sg13cmos5l_o21ai_1
XFILLER_12_411 VPWR VGND sg13cmos5l_fill_2
XFILLER_25_772 VPWR VGND sg13cmos5l_fill_2
X_10792_ _10792_/Y _10792_/A _14302_/Q VPWR VGND sg13cmos5l_nand2_1
X_13580_ _13580_/Q clkload43/A _13580_/D _13580_/RESET_B VPWR VGND sg13cmos5l_dfrbpq_1
XFILLER_33_41 VPWR VGND sg13cmos5l_fill_2
X_12531_ _12531_/Y _12538_/B _12531_/B VPWR VGND sg13cmos5l_nand2_1
X_13349__2073 _13349_/RESET_B VPWR VGND sg13cmos5l_tiehi
X_12462_ _12463_/B _08638_/A _13236_/Q _12461_/Y VPWR VGND sg13cmos5l_o21ai_1
X_11413_ _11413_/Y _11413_/A _11413_/B _11456_/B VPWR VGND sg13cmos5l_nand3_1
X_14201_ _14201_/Q clkload44/A _14201_/D _14201_/RESET_B VPWR VGND sg13cmos5l_dfrbpq_1
X_12393_ _12393_/Y _14064_/Q _12426_/B _12395_/B1 _13808_/Q _12398_/B1 VPWR VGND sg13cmos5l_a221oi_1
X_11344_ _11347_/B _11344_/A _11344_/B VPWR VGND sg13cmos5l_nand2_1
X_14132_ _14132_/Q _14576_/CLK _14132_/D fanout991/X VPWR VGND sg13cmos5l_dfrbpq_1
X_11275_ _11275_/Y _11275_/A _11275_/B VPWR VGND sg13cmos5l_nor2_1
X_14063_ _14063_/Q _14065_/CLK _14063_/D _14063_/RESET_B VPWR VGND sg13cmos5l_dfrbpq_1
X_10226_ _10226_/Y _10226_/A _10230_/B VPWR VGND sg13cmos5l_nor2_1
X_13014_ _13020_/D _13014_/A _13015_/B VPWR VGND sg13cmos5l_nor2_1
XFILLER_95_915 VPWR VGND sg13cmos5l_decap_8
XFILLER_67_639 VPWR VGND sg13cmos5l_decap_8
X_10157_ _10157_/Y _10157_/A _10169_/B VPWR VGND sg13cmos5l_nor2_1
X_10088_ _10088_/Y _10088_/A _10088_/B VPWR VGND sg13cmos5l_nand2_1
XFILLER_47_341 VPWR VGND sg13cmos5l_fill_1
XFILLER_48_886 VPWR VGND sg13cmos5l_decap_4
XFILLER_63_812 VPWR VGND sg13cmos5l_fill_2
X_13916_ _13916_/Q clkload47/A _13916_/D _13916_/RESET_B VPWR VGND sg13cmos5l_dfrbpq_1
XFILLER_47_396 VPWR VGND sg13cmos5l_decap_4
X_13847_ _13847_/Q clkload49/A _13847_/D _13847_/RESET_B VPWR VGND sg13cmos5l_dfrbpq_1
X_13559__1863 _13559_/RESET_B VPWR VGND sg13cmos5l_tiehi
X_14382__1126 _14382_/RESET_B VPWR VGND sg13cmos5l_tiehi
X_13778_ _13778_/Q clkload54/A _13778_/D _13778_/RESET_B VPWR VGND sg13cmos5l_dfrbpq_1
XFILLER_95_4 VPWR VGND sg13cmos5l_fill_2
X_12729_ _12731_/A _14452_/Q _13242_/Q VPWR VGND sg13cmos5l_nor2_1
X_13973__1418 _13973_/RESET_B VPWR VGND sg13cmos5l_tiehi
X_09940_ _09940_/Y _09940_/A _09948_/B VPWR VGND sg13cmos5l_nor2_1
Xfanout906 _08182_/A _14108_/Q VPWR VGND sg13cmos5l_buf_1
XFILLER_86_904 VPWR VGND sg13cmos5l_decap_8
X_09871_ _13702_/D fanout80/X _09886_/B _09870_/Y VPWR VGND sg13cmos5l_a21oi_1
Xfanout917 _11484_/A _11598_/A VPWR VGND sg13cmos5l_buf_1
Xfanout928 _08999_/A _13309_/Q VPWR VGND sg13cmos5l_buf_1
Xfanout939 _07619_/A _13301_/Q VPWR VGND sg13cmos5l_buf_1
XFILLER_58_639 VPWR VGND sg13cmos5l_fill_1
X_08822_ _08823_/D _08822_/A _08822_/B VPWR VGND sg13cmos5l_nand2_1
X_08753_ _08754_/D _14085_/Q _08753_/B VPWR VGND sg13cmos5l_nand2_1
X_07704_ _08819_/A _14382_/Q _11765_/A VPWR VGND sg13cmos5l_xor2_1
XFILLER_53_300 VPWR VGND sg13cmos5l_fill_1
X_08684_ _08684_/Y _14003_/Q _08748_/B1 _11752_/S VPWR VGND sg13cmos5l_a21oi_1
X_07635_ _13070_/A _13030_/A _07634_/Y VPWR VGND sg13cmos5l_nor2b_1
X_13237__1047 _13237_/RESET_B VPWR VGND sg13cmos5l_tiehi
X_07566_ _08989_/B _08974_/A _08979_/A _08984_/A _08974_/B VPWR VGND sg13cmos5l_nand4_1
X_09305_ _13423_/D _07321_/Y _09307_/B _09304_/Y VPWR VGND sg13cmos5l_a21oi_1
X_14358__1150 _14358_/RESET_B VPWR VGND sg13cmos5l_tiehi
XFILLER_21_241 VPWR VGND sg13cmos5l_fill_1
X_07497_ _07498_/B _14072_/Q _07465_/B _07528_/B1 _14493_/Q VPWR VGND sg13cmos5l_a22oi_1
X_09236_ _09236_/Y _09377_/A _09309_/B VPWR VGND sg13cmos5l_nand2_1
XFILLER_5_429 VPWR VGND sg13cmos5l_fill_2
X_09167_ _09167_/Y _09167_/A _09173_/B VPWR VGND sg13cmos5l_nor2_1
X_08118_ _08121_/B _13211_/Q _13210_/Q _08143_/B VPWR VGND sg13cmos5l_nand3_1
X_09098_ _09098_/Y _14421_/Q _11374_/A VPWR VGND sg13cmos5l_nand2_1
X_08049_ _13128_/C _08053_/A _08049_/B _08055_/A VPWR VGND sg13cmos5l_or3_1
X_13949__1442 _13949_/RESET_B VPWR VGND sg13cmos5l_tiehi
X_11060_ _11060_/Y _14382_/Q _11088_/A2 _11058_/X VPWR VGND sg13cmos5l_a21oi_1
X_10011_ _10011_/Y _10011_/A _10013_/B VPWR VGND sg13cmos5l_nand2_1
Xhold3040 _09732_/A _13635_/Q VPWR VGND sg13cmos5l_dlygate4sd3_1
Xhold3051 hold3051/X _14311_/Q VPWR VGND sg13cmos5l_dlygate4sd3_1
XFILLER_89_786 VPWR VGND sg13cmos5l_fill_1
Xhold3062 _10864_/A _14187_/Q VPWR VGND sg13cmos5l_dlygate4sd3_1
Xhold3073 _09622_/A _13607_/Q VPWR VGND sg13cmos5l_dlygate4sd3_1
Xhold3084 hold3084/X _13359_/Q VPWR VGND sg13cmos5l_dlygate4sd3_1
X_14460__1037 _14460_/RESET_B VPWR VGND sg13cmos5l_tiehi
Xhold2350 _14132_/D _10716_/Y VPWR VGND sg13cmos5l_dlygate4sd3_1
Xhold2361 _10878_/A _14191_/Q VPWR VGND sg13cmos5l_dlygate4sd3_1
Xhold2372 _10015_/A _13773_/Q VPWR VGND sg13cmos5l_dlygate4sd3_1
Xhold3095 _13085_/A _14527_/Q VPWR VGND sg13cmos5l_dlygate4sd3_1
XFILLER_17_503 VPWR VGND sg13cmos5l_fill_2
XFILLER_29_341 VPWR VGND sg13cmos5l_fill_2
XFILLER_76_469 VPWR VGND sg13cmos5l_decap_4
XFILLER_91_406 VPWR VGND sg13cmos5l_decap_4
Xhold2383 _10011_/A _13771_/Q VPWR VGND sg13cmos5l_dlygate4sd3_1
Xhold2394 _14193_/D _10888_/Y VPWR VGND sg13cmos5l_dlygate4sd3_1
X_14629__2172 _14629_/RESET_B VPWR VGND sg13cmos5l_tiehi
XFILLER_44_322 VPWR VGND sg13cmos5l_fill_2
XFILLER_57_694 VPWR VGND sg13cmos5l_decap_4
X_11962_ _11964_/B _13697_/Q _11966_/B VPWR VGND sg13cmos5l_nand2_1
X_13701_ _13701_/Q clkload64/A _13701_/D _13701_/RESET_B VPWR VGND sg13cmos5l_dfrbpq_1
X_10913_ _14202_/D _10844_/Y _10877_/Y _10912_/Y VPWR VGND sg13cmos5l_o21ai_1
X_11893_ _11893_/Y _12382_/A _12696_/B VPWR VGND sg13cmos5l_nand2_1
X_10844_ _10844_/Y _10865_/B _14221_/Q _10865_/C _10844_/D VPWR VGND sg13cmos5l_nand4_1
X_13632_ _13632_/Q _14048_/CLK _13632_/D _13632_/RESET_B VPWR VGND sg13cmos5l_dfrbpq_1
X_13563_ _13563_/Q _14109_/CLK _13563_/D _13563_/RESET_B VPWR VGND sg13cmos5l_dfrbpq_1
XFILLER_13_764 VPWR VGND sg13cmos5l_fill_1
X_10775_ _10775_/Y _14152_/Q _10781_/B VPWR VGND sg13cmos5l_nand2_1
X_12514_ _14396_/D _12514_/A _12514_/B VPWR VGND sg13cmos5l_nand2_1
XFILLER_12_285 VPWR VGND sg13cmos5l_fill_1
X_13494_ _13494_/Q clkload27/A _13494_/D _13494_/RESET_B VPWR VGND sg13cmos5l_dfrbpq_1
XFILLER_8_278 VPWR VGND sg13cmos5l_fill_2
X_12445_ _12445_/Y _12445_/A _13232_/Q VPWR VGND sg13cmos5l_nand2_1
XFILLER_67_8 VPWR VGND sg13cmos5l_fill_1
X_12376_ _12376_/Y _14031_/Q _12366_/B _12425_/C1 VPWR VGND sg13cmos5l_a21oi_1
XFILLER_99_506 VPWR VGND sg13cmos5l_fill_1
X_11327_ _11328_/B _11327_/A _11327_/B VPWR VGND sg13cmos5l_nor2_1
X_14115_ _14115_/Q _14117_/CLK _14115_/D fanout996/X VPWR VGND sg13cmos5l_dfrbpq_1
X_11258_ _11258_/Y _11258_/A _11302_/A VPWR VGND sg13cmos5l_nor2_1
X_14046_ _14046_/Q clkload59/A _14046_/D _14046_/RESET_B VPWR VGND sg13cmos5l_dfrbpq_1
X_10209_ _10209_/Y _10209_/A _10209_/B VPWR VGND sg13cmos5l_nor2_1
X_11189_ _11192_/B _11189_/A _11189_/B _11189_/C VPWR VGND sg13cmos5l_nand3_1
XFILLER_95_756 VPWR VGND sg13cmos5l_decap_8
X_14436__1072 _14436_/RESET_B VPWR VGND sg13cmos5l_tiehi
XFILLER_36_834 VPWR VGND sg13cmos5l_fill_1
XFILLER_91_973 VPWR VGND sg13cmos5l_fill_1
X_07420_ _13076_/A _08157_/B _07420_/B _07420_/C VPWR VGND sg13cmos5l_nand3_1
XFILLER_51_859 VPWR VGND sg13cmos5l_decap_8
X_07351_ _07391_/B _07352_/A _07352_/B VPWR VGND sg13cmos5l_nand2_1
X_07282_ _07282_/Y _13244_/Q VPWR VGND sg13cmos5l_inv_1
X_09021_ _13292_/D _09024_/B _08965_/B _09020_/Y VPWR VGND sg13cmos5l_o21ai_1
X_14241__1236 _14241_/RESET_B VPWR VGND sg13cmos5l_tiehi
X_09923_ _13727_/D _10575_/A1 _09922_/B _09922_/Y VPWR VGND sg13cmos5l_a21oi_1
Xfanout714 _13189_/B1 _13195_/B1 VPWR VGND sg13cmos5l_buf_1
Xfanout703 _11220_/B _11307_/B VPWR VGND sg13cmos5l_buf_1
X_09854_ _09854_/Y _09854_/A _09892_/B VPWR VGND sg13cmos5l_nor2_1
Xfanout758 _10780_/A _07191_/Y VPWR VGND sg13cmos5l_buf_1
Xfanout747 _12162_/B _11671_/B VPWR VGND sg13cmos5l_buf_1
Xfanout736 _11851_/A _07846_/X VPWR VGND sg13cmos5l_buf_1
Xfanout725 _08910_/C _08905_/A2 VPWR VGND sg13cmos5l_buf_1
XFILLER_105_46 VPWR VGND sg13cmos5l_fill_1
X_08805_ _08805_/Y _07713_/X _08808_/B _08831_/B1 _07716_/B VPWR VGND sg13cmos5l_a22oi_1
Xfanout769 _11338_/A _11587_/A VPWR VGND sg13cmos5l_buf_1
XFILLER_22_1010 VPWR VGND sg13cmos5l_fill_2
XFILLER_39_650 VPWR VGND sg13cmos5l_fill_2
XFILLER_45_108 VPWR VGND sg13cmos5l_fill_1
X_09785_ _09785_/Y _09785_/A _09797_/B VPWR VGND sg13cmos5l_nor2_1
X_08736_ _14622_/D _08736_/A _08736_/B VPWR VGND sg13cmos5l_nand2_1
X_08667_ _08667_/Y _08667_/A _08667_/B _08667_/C VPWR VGND sg13cmos5l_nor3_1
XFILLER_82_984 VPWR VGND sg13cmos5l_fill_2
X_07618_ _07631_/C _14503_/Q _07618_/B _07618_/C _07618_/D VPWR VGND sg13cmos5l_nor4_1
X_08598_ _08599_/B _08596_/Y _08603_/B _08603_/C VPWR VGND sg13cmos5l_mux2_1
X_07549_ _07552_/B _14551_/Q _13292_/Q VPWR VGND sg13cmos5l_xor2_1
XFILLER_14_76 VPWR VGND sg13cmos5l_fill_2
X_10560_ _10560_/Y _10560_/A _10596_/B VPWR VGND sg13cmos5l_nand2_1
X_09219_ _09219_/Y _09219_/A _09225_/B VPWR VGND sg13cmos5l_nor2_1
X_10491_ _10491_/Y _10491_/A _10497_/B VPWR VGND sg13cmos5l_nand2_1
X_12230_ _12230_/Y _13738_/Q _12234_/B _12236_/B1 VPWR VGND sg13cmos5l_a21oi_1
X_12161_ _12165_/B _12286_/A _12161_/B _12161_/C VPWR VGND sg13cmos5l_nand3_1
X_14217__1260 _14217_/RESET_B VPWR VGND sg13cmos5l_tiehi
X_11112_ _14295_/D _11111_/B _11110_/Y _11111_/Y VPWR VGND sg13cmos5l_a21oi_1
X_12092_ _12500_/B _12351_/A1 _12084_/Y _12090_/Y _12091_/Y VPWR VGND sg13cmos5l_a22oi_1
XFILLER_104_872 VPWR VGND sg13cmos5l_fill_2
XFILLER_7_1026 VPWR VGND sg13cmos5l_fill_2
X_11043_ _11043_/Y _11043_/A _11123_/B VPWR VGND sg13cmos5l_nor2_1
XFILLER_65_907 VPWR VGND sg13cmos5l_decap_4
XFILLER_77_778 VPWR VGND sg13cmos5l_decap_8
XFILLER_77_789 VPWR VGND sg13cmos5l_fill_2
Xclkbuf_4_3_0_clk clkload1/A clkbuf_0_clk/X VPWR VGND sg13cmos5l_buf_8
XFILLER_58_981 VPWR VGND sg13cmos5l_fill_2
X_12994_ _12995_/B _14484_/Q _12993_/C hold3533/X VPWR VGND sg13cmos5l_a21o_1
XFILLER_29_193 VPWR VGND sg13cmos5l_fill_2
X_11945_ _11945_/X _13824_/Q _13792_/Q _11945_/S VPWR VGND sg13cmos5l_mux2_1
XFILLER_33_837 VPWR VGND sg13cmos5l_fill_1
XFILLER_60_612 VPWR VGND sg13cmos5l_decap_4
XFILLER_72_494 VPWR VGND sg13cmos5l_fill_2
X_11876_ _11876_/Y _11903_/A _11904_/A VPWR VGND sg13cmos5l_nor2b_1
X_13615_ _13615_/Q _14020_/CLK _13615_/D _13615_/RESET_B VPWR VGND sg13cmos5l_dfrbpq_1
X_10827_ _14175_/D _14258_/D _14175_/Q _10894_/D VPWR VGND sg13cmos5l_mux2_1
X_14595_ _14595_/Q clkload70/A _14595_/D _14595_/RESET_B VPWR VGND sg13cmos5l_dfrbpq_1
XFILLER_9_521 VPWR VGND sg13cmos5l_fill_1
X_10758_ _10758_/Y _10802_/B _10756_/Y _10757_/Y VPWR VGND sg13cmos5l_o21ai_1
X_13546_ _13546_/Q clkload42/A _13546_/D _13546_/RESET_B VPWR VGND sg13cmos5l_dfrbpq_1
X_13675__1716 _13675_/RESET_B VPWR VGND sg13cmos5l_tiehi
X_13477_ _13477_/Q clkload35/A _13477_/D _13477_/RESET_B VPWR VGND sg13cmos5l_dfrbpq_1
X_10689_ _14109_/D input3/X _08194_/A _10692_/S VPWR VGND sg13cmos5l_mux2_1
X_13711__1680 _13711_/RESET_B VPWR VGND sg13cmos5l_tiehi
X_12428_ _12428_/Y _13617_/Q _12428_/A2 _12428_/B1 _13681_/Q _12426_/X VPWR VGND sg13cmos5l_a221oi_1
X_12359_ _12360_/B _12359_/A _12362_/B VPWR VGND sg13cmos5l_nor2b_1
X_14055__1336 _14055_/RESET_B VPWR VGND sg13cmos5l_tiehi
X_13890__1501 _13890_/RESET_B VPWR VGND sg13cmos5l_tiehi
X_14029_ _14029_/Q _14053_/CLK _14029_/D _14029_/RESET_B VPWR VGND sg13cmos5l_dfrbpq_1
XFILLER_48_480 VPWR VGND sg13cmos5l_fill_1
X_09570_ _09571_/B _14450_/Q _09570_/B VPWR VGND sg13cmos5l_nor2_1
X_08521_ _08522_/B _08536_/A _08520_/Y _08516_/Y VPWR VGND sg13cmos5l_o21ai_1
XFILLER_24_815 VPWR VGND sg13cmos5l_fill_1
XFILLER_64_984 VPWR VGND sg13cmos5l_fill_1
X_08452_ _08456_/C _14375_/Q _11641_/A _14374_/Q _11636_/A VPWR VGND sg13cmos5l_a22oi_1
X_07403_ _07403_/X _07403_/A _10614_/S VPWR VGND sg13cmos5l_and2_1
X_08383_ _08383_/Y _08383_/A _08383_/B VPWR VGND sg13cmos5l_nand2_1
X_07334_ _07334_/Y _14138_/Q VPWR VGND sg13cmos5l_inv_1
X_07265_ _07265_/Y _07265_/A VPWR VGND sg13cmos5l_inv_1
X_09004_ _13280_/D _07354_/B _13034_/B _09003_/Y VPWR VGND sg13cmos5l_a21oi_1
X_07196_ _13051_/A _13052_/A VPWR VGND sg13cmos5l_inv_1
X_14628__2171 _14628_/RESET_B VPWR VGND sg13cmos5l_tiehi
XFILLER_105_625 VPWR VGND sg13cmos5l_fill_1
XFILLER_59_712 VPWR VGND sg13cmos5l_decap_8
X_09906_ _09906_/Y _09906_/A _09912_/B VPWR VGND sg13cmos5l_nor2_1
Xfanout533 _12964_/B _07390_/Y VPWR VGND sg13cmos5l_buf_1
Xfanout522 _11039_/A2 _07512_/B VPWR VGND sg13cmos5l_buf_1
Xfanout511 _12245_/B2 _08648_/Y VPWR VGND sg13cmos5l_buf_1
Xfanout500 _12373_/B _12428_/A2 VPWR VGND sg13cmos5l_buf_1
XFILLER_59_756 VPWR VGND sg13cmos5l_decap_8
XFILLER_76_27 VPWR VGND sg13cmos5l_fill_2
Xfanout566 _12060_/B _11934_/B1 VPWR VGND sg13cmos5l_buf_1
Xfanout555 _08841_/B _08911_/B VPWR VGND sg13cmos5l_buf_1
Xfanout544 _09535_/A _09556_/A VPWR VGND sg13cmos5l_buf_1
XFILLER_100_352 VPWR VGND sg13cmos5l_fill_2
XFILLER_46_406 VPWR VGND sg13cmos5l_fill_1
X_09837_ _13685_/D _10425_/A1 _09844_/B _09836_/Y VPWR VGND sg13cmos5l_a21oi_1
Xfanout599 _08674_/A _08639_/Y VPWR VGND sg13cmos5l_buf_1
Xfanout588 _12318_/B1 fanout593/X VPWR VGND sg13cmos5l_buf_1
Xfanout577 _11783_/B fanout584/X VPWR VGND sg13cmos5l_buf_1
XFILLER_18_108 VPWR VGND sg13cmos5l_fill_1
XFILLER_74_737 VPWR VGND sg13cmos5l_decap_8
X_09768_ _13651_/D _10355_/A1 _09773_/B _09767_/Y VPWR VGND sg13cmos5l_a21oi_1
XFILLER_26_130 VPWR VGND sg13cmos5l_fill_1
XFILLER_27_631 VPWR VGND sg13cmos5l_fill_1
XFILLER_61_409 VPWR VGND sg13cmos5l_decap_8
X_08719_ _08720_/C _13621_/Q _11809_/A2 _08725_/B _13685_/Q VPWR VGND sg13cmos5l_a22oi_1
X_13899__1492 _13899_/RESET_B VPWR VGND sg13cmos5l_tiehi
X_13753__1638 _13753_/RESET_B VPWR VGND sg13cmos5l_tiehi
X_09699_ _13618_/D _10419_/A1 _09714_/B _09698_/Y VPWR VGND sg13cmos5l_a21oi_1
X_11730_ _11730_/Y _07271_/Y _12245_/B2 _11730_/B1 _07273_/Y VPWR VGND sg13cmos5l_a22oi_1
X_11661_ _11663_/A _11659_/Y _11661_/B VPWR VGND sg13cmos5l_nand2b_1
X_10612_ _10612_/X _13203_/Q _13204_/Q _13205_/Q _13206_/Q _07369_/B _07369_/A VPWR
+ VGND sg13cmos5l_mux4_1
X_11592_ _11598_/B _11592_/A _11592_/B VPWR VGND sg13cmos5l_nand2_1
X_14380_ _14380_/Q _14631_/CLK _14380_/D _14380_/RESET_B VPWR VGND sg13cmos5l_dfrbpq_1
X_13400_ _13400_/Q _14105_/CLK _13400_/D _13400_/RESET_B VPWR VGND sg13cmos5l_dfrbpq_1
X_10543_ _10543_/Y _10543_/A _10545_/B VPWR VGND sg13cmos5l_nand2_1
X_13331_ _13331_/Q clkload24/A _13331_/D _13331_/RESET_B VPWR VGND sg13cmos5l_dfrbpq_1
XFILLER_68_1021 VPWR VGND sg13cmos5l_decap_8
X_10474_ _10474_/Y _10474_/A _10474_/B VPWR VGND sg13cmos5l_nor2_1
X_13262_ _13262_/Q clkload19/A _13262_/D fanout981/X VPWR VGND sg13cmos5l_dfrbpq_1
X_12213_ _12214_/B _14579_/Q _12211_/Y _12212_/Y VPWR VGND sg13cmos5l_o21ai_1
X_13386__2036 _13386_/RESET_B VPWR VGND sg13cmos5l_tiehi
X_13193_ _13193_/Y _11316_/A _14175_/Q _13195_/B1 _08229_/A VPWR VGND sg13cmos5l_a22oi_1
XFILLER_29_1027 VPWR VGND sg13cmos5l_fill_2
XFILLER_97_818 VPWR VGND sg13cmos5l_fill_2
X_12144_ _12147_/A _13863_/Q _12144_/B VPWR VGND sg13cmos5l_nand2_1
XFILLER_2_752 VPWR VGND sg13cmos5l_fill_1
XFILLER_89_391 VPWR VGND sg13cmos5l_fill_2
X_12075_ _14360_/D _12039_/A _12127_/A _12049_/Y _12074_/Y VPWR VGND sg13cmos5l_a22oi_1
XFILLER_77_575 VPWR VGND sg13cmos5l_fill_2
X_11026_ _11026_/Y _11021_/B _11025_/Y _11021_/Y VPWR VGND sg13cmos5l_o21ai_1
XFILLER_77_586 VPWR VGND sg13cmos5l_fill_1
XFILLER_18_631 VPWR VGND sg13cmos5l_fill_2
XFILLER_65_759 VPWR VGND sg13cmos5l_fill_2
X_13729__1662 _13729_/RESET_B VPWR VGND sg13cmos5l_tiehi
XFILLER_61_910 VPWR VGND sg13cmos5l_decap_8
XFILLER_73_770 VPWR VGND sg13cmos5l_decap_4
X_12977_ _12977_/X _12977_/A _12977_/B VPWR VGND sg13cmos5l_xor2_1
XFILLER_18_697 VPWR VGND sg13cmos5l_fill_2
X_11928_ _11928_/Y _11981_/A VPWR VGND sg13cmos5l_inv_1
XFILLER_32_144 VPWR VGND sg13cmos5l_fill_1
X_11859_ _11860_/C _13917_/Q _11939_/B _11944_/B2 _13853_/Q VPWR VGND sg13cmos5l_a22oi_1
X_14647_ _14647_/Q clkload81/A _14647_/D _14647_/RESET_B VPWR VGND sg13cmos5l_dfrbpq_1
XFILLER_60_486 VPWR VGND sg13cmos5l_fill_2
X_14578_ _14578_/Q clkload22/A _14578_/D fanout990/X VPWR VGND sg13cmos5l_dfrbpq_1
X_13596__1826 _13596_/RESET_B VPWR VGND sg13cmos5l_tiehi
X_13529_ _13529_/Q _14117_/CLK _13529_/D _13529_/RESET_B VPWR VGND sg13cmos5l_dfrbpq_1
XFILLER_49_0 VPWR VGND sg13cmos5l_fill_2
Xhold2905 _09846_/A _13690_/Q VPWR VGND sg13cmos5l_dlygate4sd3_1
XFILLER_99_188 VPWR VGND sg13cmos5l_fill_2
X_07952_ _07953_/B _13148_/A input18/X VPWR VGND sg13cmos5l_nand2_1
Xhold2916 _09760_/A _13649_/Q VPWR VGND sg13cmos5l_dlygate4sd3_1
Xhold2927 _09095_/A _13312_/Q VPWR VGND sg13cmos5l_dlygate4sd3_1
Xhold2938 _09793_/A _13664_/Q VPWR VGND sg13cmos5l_dlygate4sd3_1
XFILLER_56_704 VPWR VGND sg13cmos5l_fill_2
X_07883_ _07883_/X _14203_/Q _14202_/Q VPWR VGND sg13cmos5l_or2_1
Xhold2949 _11099_/A _14292_/Q VPWR VGND sg13cmos5l_dlygate4sd3_1
X_09622_ _09622_/Y _09622_/A _09682_/B VPWR VGND sg13cmos5l_nor2_1
X_09553_ _11293_/B _14417_/Q _14636_/Q _09560_/S VPWR VGND sg13cmos5l_mux2_1
X_14191__1286 _14191_/RESET_B VPWR VGND sg13cmos5l_tiehi
XFILLER_70_206 VPWR VGND sg13cmos5l_fill_1
X_08504_ _08504_/Y _08504_/A _08504_/B VPWR VGND sg13cmos5l_nor2_1
XFILLER_52_954 VPWR VGND sg13cmos5l_fill_1
XFILLER_64_792 VPWR VGND sg13cmos5l_fill_1
X_09484_ _09484_/Y _09484_/A _14229_/Q VPWR VGND sg13cmos5l_nor2_1
X_08435_ _08435_/Y _15882_/A _08435_/B VPWR VGND sg13cmos5l_nor2_1
X_08366_ _08366_/Y _08391_/B1 _08365_/Y _13040_/C VPWR VGND sg13cmos5l_o21ai_1
X_07317_ _07317_/Y _13420_/Q VPWR VGND sg13cmos5l_inv_1
X_08297_ _08297_/Y _11034_/A _08296_/X _08311_/C1 VPWR VGND sg13cmos5l_a21oi_1
XFILLER_106_901 VPWR VGND sg13cmos5l_decap_8
X_07248_ _07720_/B _11656_/A VPWR VGND sg13cmos5l_inv_1
X_14395__1113 _14395_/RESET_B VPWR VGND sg13cmos5l_tiehi
X_07179_ _09484_/A _14237_/Q VPWR VGND sg13cmos5l_inv_1
XFILLER_106_978 VPWR VGND sg13cmos5l_decap_8
X_10190_ _13858_/D _10385_/A1 _10189_/B _10189_/Y VPWR VGND sg13cmos5l_a21oi_1
X_13807__1584 _13807_/RESET_B VPWR VGND sg13cmos5l_tiehi
XFILLER_78_306 VPWR VGND sg13cmos5l_fill_1
XFILLER_87_37 VPWR VGND sg13cmos5l_fill_1
Xfanout341 _10551_/A1 _09492_/Y VPWR VGND sg13cmos5l_buf_1
Xfanout330 _09760_/B _09752_/B VPWR VGND sg13cmos5l_buf_1
Xfanout374 _08310_/B1 _07416_/A VPWR VGND sg13cmos5l_buf_1
Xfanout363 _09137_/B fanout367/X VPWR VGND sg13cmos5l_buf_1
Xfanout352 _09655_/B _09673_/B VPWR VGND sg13cmos5l_buf_1
XFILLER_74_512 VPWR VGND sg13cmos5l_decap_8
XFILLER_74_523 VPWR VGND sg13cmos5l_fill_1
XFILLER_98_1003 VPWR VGND sg13cmos5l_fill_2
Xfanout396 _11463_/B _11476_/B VPWR VGND sg13cmos5l_buf_1
Xfanout385 _08388_/A _08405_/A1 VPWR VGND sg13cmos5l_buf_1
X_13986__1405 _13986_/RESET_B VPWR VGND sg13cmos5l_tiehi
X_13880_ _13880_/Q _14299_/CLK _13880_/D _13880_/RESET_B VPWR VGND sg13cmos5l_dfrbpq_1
X_12900_ _14437_/D _12897_/Y _12899_/Y _12802_/A VPWR VGND sg13cmos5l_a21oi_1
XFILLER_28_940 VPWR VGND sg13cmos5l_fill_2
XFILLER_46_247 VPWR VGND sg13cmos5l_fill_1
X_12831_ _12847_/A _12832_/B _12832_/A VPWR VGND sg13cmos5l_nand2b_1
XFILLER_15_623 VPWR VGND sg13cmos5l_fill_2
XFILLER_42_431 VPWR VGND sg13cmos5l_decap_8
X_12762_ _12763_/B _12792_/A _12759_/Y _12761_/Y VPWR VGND sg13cmos5l_o21ai_1
X_11713_ _11715_/B _11713_/A _11713_/B _11713_/C VPWR VGND sg13cmos5l_nor3_1
X_14501_ _14501_/Q clkload15/A _14501_/D fanout978/X VPWR VGND sg13cmos5l_dfrbpq_1
X_12693_ _12694_/B _11150_/X _12582_/X _12583_/X _11157_/A VPWR VGND sg13cmos5l_a22oi_1
X_11644_ _11644_/Y _14438_/Q _11686_/B _11642_/X _11643_/Y _11637_/Y VPWR VGND sg13cmos5l_a221oi_1
X_14432_ _14432_/Q clkload79/A _14432_/D _14432_/RESET_B VPWR VGND sg13cmos5l_dfrbpq_1
X_11575_ _11596_/A _11575_/A _11575_/B _11575_/C _11587_/B VPWR VGND sg13cmos5l_and4_1
Xinput16 input16/X ui_in[8] VPWR VGND sg13cmos5l_buf_1
X_14363_ _14363_/Q clkload75/A _14363_/D _14363_/RESET_B VPWR VGND sg13cmos5l_dfrbpq_1
XFILLER_7_877 VPWR VGND sg13cmos5l_fill_2
X_10526_ _14023_/D _10591_/A1 _10535_/B _10525_/Y VPWR VGND sg13cmos5l_o21ai_1
X_14294_ _14294_/Q clkload23/A _14294_/D _14294_/RESET_B VPWR VGND sg13cmos5l_dfrbpq_1
X_13314_ _13314_/Q _14453_/CLK _13314_/D _13314_/RESET_B VPWR VGND sg13cmos5l_dfrbpq_1
X_10457_ _13989_/D _10587_/A1 _10470_/B _10456_/Y VPWR VGND sg13cmos5l_a21oi_1
X_13245_ _13245_/Q _14453_/CLK _13245_/D _13245_/RESET_B VPWR VGND sg13cmos5l_dfrbpq_1
X_10388_ _10388_/Y _10388_/A _10410_/B VPWR VGND sg13cmos5l_nor2_1
X_13176_ _13235_/D _13180_/B _13174_/Y _13175_/Y VPWR VGND sg13cmos5l_a21oi_1
X_12127_ _12127_/X _12127_/A _12127_/B VPWR VGND sg13cmos5l_or2_1
X_12058_ _12058_/Y _13636_/Q _12058_/B VPWR VGND sg13cmos5l_nand2_1
XFILLER_77_383 VPWR VGND sg13cmos5l_decap_4
XFILLER_78_884 VPWR VGND sg13cmos5l_decap_4
X_11009_ _11009_/Y _14570_/Q _12648_/B _09484_/A VPWR VGND sg13cmos5l_o21ai_1
XFILLER_65_545 VPWR VGND sg13cmos5l_decap_8
XFILLER_93_843 VPWR VGND sg13cmos5l_decap_8
X_13504__1918 _13504_/RESET_B VPWR VGND sg13cmos5l_tiehi
XFILLER_53_718 VPWR VGND sg13cmos5l_fill_2
X_14627__2170 _14627_/RESET_B VPWR VGND sg13cmos5l_tiehi
XFILLER_52_239 VPWR VGND sg13cmos5l_fill_2
XFILLER_21_626 VPWR VGND sg13cmos5l_fill_1
XFILLER_61_784 VPWR VGND sg13cmos5l_fill_2
X_08220_ _08220_/Y _08315_/A _08219_/X _08311_/C1 VPWR VGND sg13cmos5l_a21oi_1
X_14176__1301 _14176_/RESET_B VPWR VGND sg13cmos5l_tiehi
X_08151_ _08151_/Y _08151_/A _08151_/B VPWR VGND sg13cmos5l_xnor2_1
X_08082_ _08082_/Y _08082_/A VPWR VGND sg13cmos5l_inv_1
Xhold3425 hold3425/X _13282_/Q VPWR VGND sg13cmos5l_dlygate4sd3_1
Xhold3414 hold3414/X _13266_/Q VPWR VGND sg13cmos5l_dlygate4sd3_1
Xhold3403 hold3403/X _14107_/Q VPWR VGND sg13cmos5l_dlygate4sd3_1
XFILLER_102_436 VPWR VGND sg13cmos5l_fill_2
X_08984_ _08985_/B _08984_/A _08984_/B VPWR VGND sg13cmos5l_xor2_1
Xhold2702 _09673_/A _13614_/Q VPWR VGND sg13cmos5l_dlygate4sd3_1
Xhold2713 _10325_/A _13925_/Q VPWR VGND sg13cmos5l_dlygate4sd3_1
Xhold3458 hold3458/X _14094_/Q VPWR VGND sg13cmos5l_dlygate4sd3_1
Xhold3447 hold3447/X _14521_/Q VPWR VGND sg13cmos5l_dlygate4sd3_1
Xhold3436 hold3436/X _14186_/Q VPWR VGND sg13cmos5l_dlygate4sd3_1
XFILLER_102_447 VPWR VGND sg13cmos5l_decap_8
XFILLER_102_458 VPWR VGND sg13cmos5l_fill_1
X_07935_ _07935_/Y _14567_/Q _11014_/A VPWR VGND sg13cmos5l_nor2_1
Xhold2724 _10418_/A _13970_/Q VPWR VGND sg13cmos5l_dlygate4sd3_1
Xhold2735 _10179_/A _13853_/Q VPWR VGND sg13cmos5l_dlygate4sd3_1
Xhold2746 _09823_/A _13679_/Q VPWR VGND sg13cmos5l_dlygate4sd3_1
Xhold3469 _07265_/A _14092_/Q VPWR VGND sg13cmos5l_dlygate4sd3_1
Xhold2757 _10331_/A _13928_/Q VPWR VGND sg13cmos5l_dlygate4sd3_1
Xhold2768 _09936_/A _13734_/Q VPWR VGND sg13cmos5l_dlygate4sd3_1
Xhold2779 _09850_/A _13692_/Q VPWR VGND sg13cmos5l_dlygate4sd3_1
XFILLER_28_225 VPWR VGND sg13cmos5l_fill_2
X_07866_ _07866_/Y _10918_/A _07862_/X _07864_/X _07865_/X VPWR VGND sg13cmos5l_a22oi_1
X_09605_ _09605_/Y _09611_/B _09604_/Y _09617_/A VPWR VGND sg13cmos5l_o21ai_1
XFILLER_56_567 VPWR VGND sg13cmos5l_fill_1
X_07797_ _08593_/B _08885_/A _08594_/B VPWR VGND sg13cmos5l_or2_1
X_09536_ _09536_/Y _09556_/A _11248_/B _09535_/Y VPWR VGND sg13cmos5l_a21oi_1
X_14303__1205 _14303_/RESET_B VPWR VGND sg13cmos5l_tiehi
X_13670__1721 _13670_/RESET_B VPWR VGND sg13cmos5l_tiehi
XFILLER_19_1004 VPWR VGND sg13cmos5l_fill_1
XFILLER_24_442 VPWR VGND sg13cmos5l_fill_2
X_09467_ _09467_/X _14122_/Q hold3262/X _09467_/S VPWR VGND sg13cmos5l_mux2_1
X_08418_ _08418_/Y _08411_/A _08416_/X _08417_/Y _08415_/X _11033_/S1 VPWR VGND sg13cmos5l_a221oi_1
X_09398_ _13510_/D _08269_/A hold3028/X _09405_/S VPWR VGND sg13cmos5l_mux2_1
XFILLER_11_169 VPWR VGND sg13cmos5l_fill_1
X_08349_ _08349_/X _08398_/S _13452_/Q VPWR VGND sg13cmos5l_or2_1
X_14050__1341 _14050_/RESET_B VPWR VGND sg13cmos5l_tiehi
XFILLER_22_76 VPWR VGND sg13cmos5l_fill_1
X_11360_ _11401_/B _11360_/A _11360_/B VPWR VGND sg13cmos5l_nand2_1
X_10311_ _10311_/Y _10311_/A _10345_/B VPWR VGND sg13cmos5l_nor2_1
XFILLER_106_731 VPWR VGND sg13cmos5l_decap_8
X_11291_ _14320_/D _11289_/Y _11290_/Y _11279_/Y VPWR VGND sg13cmos5l_o21ai_1
X_13030_ _13071_/C _13030_/A _13030_/B VPWR VGND sg13cmos5l_or2_1
XFILLER_3_379 VPWR VGND sg13cmos5l_fill_2
XFILLER_79_615 VPWR VGND sg13cmos5l_fill_1
X_10242_ _10242_/Y _10242_/A _10250_/B VPWR VGND sg13cmos5l_nor2_1
X_10173_ _10173_/Y _10173_/A _10173_/B VPWR VGND sg13cmos5l_nor2_1
XFILLER_66_309 VPWR VGND sg13cmos5l_fill_1
XFILLER_94_607 VPWR VGND sg13cmos5l_fill_1
XFILLER_47_523 VPWR VGND sg13cmos5l_fill_1
Xfanout182 _08168_/A _08383_/B VPWR VGND sg13cmos5l_buf_1
Xfanout171 _10799_/B _07949_/X VPWR VGND sg13cmos5l_buf_1
Xfanout160 _10772_/B fanout163/X VPWR VGND sg13cmos5l_buf_1
XFILLER_47_51 VPWR VGND sg13cmos5l_fill_1
Xfanout193 _08996_/B _09000_/A2 VPWR VGND sg13cmos5l_buf_1
X_13932_ _13932_/Q _14028_/CLK _13932_/D _13932_/RESET_B VPWR VGND sg13cmos5l_dfrbpq_1
X_13863_ _13863_/Q _14064_/CLK _13863_/D _13863_/RESET_B VPWR VGND sg13cmos5l_dfrbpq_1
XFILLER_62_537 VPWR VGND sg13cmos5l_decap_4
X_13794_ _13794_/Q clkload46/A _13794_/D _13794_/RESET_B VPWR VGND sg13cmos5l_dfrbpq_1
X_12814_ _12815_/B _14460_/Q _13250_/Q VPWR VGND sg13cmos5l_nand2_1
X_12745_ _12745_/Y _12745_/A _12745_/B VPWR VGND sg13cmos5l_nor2_1
XFILLER_70_581 VPWR VGND sg13cmos5l_fill_2
XFILLER_72_1028 VPWR VGND sg13cmos5l_fill_1
X_12676_ _12676_/Y _12697_/A _12676_/B VPWR VGND sg13cmos5l_nor2_1
XFILLER_30_489 VPWR VGND sg13cmos5l_fill_1
X_11627_ _11627_/Y _11636_/A _14169_/Q _11626_/Y VPWR VGND sg13cmos5l_o21ai_1
X_14415_ _14415_/Q _14630_/CLK _14415_/D _14415_/RESET_B VPWR VGND sg13cmos5l_dfrbpq_1
XFILLER_7_630 VPWR VGND sg13cmos5l_decap_8
X_11558_ _11558_/Y _11586_/A _11553_/B _11558_/B1 VPWR VGND sg13cmos5l_o21ai_1
X_14346_ _14346_/Q clkload36/A _14346_/D _14346_/RESET_B VPWR VGND sg13cmos5l_dfrbpq_1
X_10509_ _10509_/Y _10509_/A _10511_/B VPWR VGND sg13cmos5l_nand2_1
XFILLER_6_184 VPWR VGND sg13cmos5l_fill_1
X_11489_ _11491_/B _11519_/A _11490_/C _11514_/A VPWR VGND sg13cmos5l_a21oi_1
X_14277_ _14277_/Q clkload23/A _14277_/D _14277_/RESET_B VPWR VGND sg13cmos5l_dfrbpq_1
X_13228_ _13228_/Q _14622_/CLK _13228_/D _13228_/RESET_B VPWR VGND sg13cmos5l_dfrbpq_1
XFILLER_98_946 VPWR VGND sg13cmos5l_fill_1
X_13159_ _13159_/Y _13159_/A _13159_/B VPWR VGND sg13cmos5l_nand2_1
XFILLER_100_918 VPWR VGND sg13cmos5l_decap_8
XFILLER_97_445 VPWR VGND sg13cmos5l_fill_2
XFILLER_97_456 VPWR VGND sg13cmos5l_fill_1
XFILLER_97_467 VPWR VGND sg13cmos5l_fill_1
XFILLER_98_979 VPWR VGND sg13cmos5l_decap_8
X_07720_ _07720_/Y _11101_/A _07720_/B VPWR VGND sg13cmos5l_nor2_1
XFILLER_66_832 VPWR VGND sg13cmos5l_fill_2
XFILLER_66_865 VPWR VGND sg13cmos5l_fill_1
XFILLER_65_364 VPWR VGND sg13cmos5l_decap_4
XFILLER_65_375 VPWR VGND sg13cmos5l_fill_1
X_07651_ _08579_/A _14396_/Q _14364_/Q VPWR VGND sg13cmos5l_and2_1
XFILLER_81_846 VPWR VGND sg13cmos5l_decap_4
X_07582_ _07597_/B _07582_/A _07582_/B _07582_/C _07582_/D VPWR VGND sg13cmos5l_nand4_1
X_09321_ _13437_/D _10690_/A1 hold3390/X _09341_/S VPWR VGND sg13cmos5l_mux2_1
X_09252_ _13377_/D _08206_/A hold3048/X _09268_/S VPWR VGND sg13cmos5l_mux2_1
X_08203_ _08203_/Y _08202_/A _08200_/X _08202_/Y VPWR VGND sg13cmos5l_a21oi_1
X_09183_ _09183_/Y _11573_/A _09182_/Y _09196_/A2 VPWR VGND sg13cmos5l_a21oi_1
X_13381__2041 _13381_/RESET_B VPWR VGND sg13cmos5l_tiehi
X_08134_ _08134_/Y _08134_/A _08134_/B VPWR VGND sg13cmos5l_xnor2_1
X_08065_ _08066_/A _08053_/A _08064_/Y _08058_/B VPWR VGND sg13cmos5l_a21oi_1
Xhold3200 hold3200/X _13502_/Q VPWR VGND sg13cmos5l_dlygate4sd3_1
Xhold3211 hold3211/X _13363_/Q VPWR VGND sg13cmos5l_dlygate4sd3_1
Xhold3222 hold3222/X _13438_/Q VPWR VGND sg13cmos5l_dlygate4sd3_1
Xhold3233 hold3233/X _14066_/Q VPWR VGND sg13cmos5l_dlygate4sd3_1
X_13688__1703 _13688_/RESET_B VPWR VGND sg13cmos5l_tiehi
XFILLER_89_979 VPWR VGND sg13cmos5l_fill_2
Xhold2510 _10793_/A _14158_/Q VPWR VGND sg13cmos5l_dlygate4sd3_1
Xhold2521 _09754_/A _13646_/Q VPWR VGND sg13cmos5l_dlygate4sd3_1
Xhold3266 hold3266/X _13456_/Q VPWR VGND sg13cmos5l_dlygate4sd3_1
Xhold3255 _13056_/A _13054_/Y VPWR VGND sg13cmos5l_dlygate4sd3_1
Xhold3244 hold3244/X _13511_/Q VPWR VGND sg13cmos5l_dlygate4sd3_1
XFILLER_29_501 VPWR VGND sg13cmos5l_decap_4
XFILLER_69_681 VPWR VGND sg13cmos5l_fill_1
XFILLER_75_117 VPWR VGND sg13cmos5l_fill_1
X_08967_ _08967_/Y _08967_/A _08977_/B VPWR VGND sg13cmos5l_nand2_1
Xhold2532 _09977_/A _13754_/Q VPWR VGND sg13cmos5l_dlygate4sd3_1
Xhold2543 _07308_/A _13415_/Q VPWR VGND sg13cmos5l_dlygate4sd3_1
Xhold2554 hold2554/X _14591_/Q VPWR VGND sg13cmos5l_dlygate4sd3_1
Xhold2565 _14143_/D _10749_/Y VPWR VGND sg13cmos5l_dlygate4sd3_1
Xhold3299 _13428_/D _09312_/X VPWR VGND sg13cmos5l_dlygate4sd3_1
Xhold3288 hold3288/X _13519_/Q VPWR VGND sg13cmos5l_dlygate4sd3_1
Xhold3277 hold3277/X _13336_/Q VPWR VGND sg13cmos5l_dlygate4sd3_1
XFILLER_84_38 VPWR VGND sg13cmos5l_fill_1
X_07918_ _07997_/C _13226_/Q _14168_/Q VPWR VGND sg13cmos5l_nor2_1
X_08898_ _08898_/Y _07645_/X _08894_/B _08848_/B _08616_/B VPWR VGND sg13cmos5l_a22oi_1
Xhold2576 _10036_/A _13783_/Q VPWR VGND sg13cmos5l_dlygate4sd3_1
Xhold2587 _09746_/A _13642_/Q VPWR VGND sg13cmos5l_dlygate4sd3_1
Xhold2598 _09642_/A _13610_/Q VPWR VGND sg13cmos5l_dlygate4sd3_1
XFILLER_57_887 VPWR VGND sg13cmos5l_fill_2
XFILLER_72_824 VPWR VGND sg13cmos5l_decap_8
XFILLER_95_1006 VPWR VGND sg13cmos5l_decap_8
X_07849_ _08424_/A _14241_/Q _14239_/Q VPWR VGND sg13cmos5l_nor2_1
XFILLER_56_397 VPWR VGND sg13cmos5l_fill_1
XFILLER_71_301 VPWR VGND sg13cmos5l_fill_2
XFILLER_95_1017 VPWR VGND sg13cmos5l_decap_8
XFILLER_95_1028 VPWR VGND sg13cmos5l_fill_1
X_10860_ _10861_/B _14246_/D _10891_/C VPWR VGND sg13cmos5l_nand2b_1
X_13591__1831 _13591_/RESET_B VPWR VGND sg13cmos5l_tiehi
XFILLER_25_751 VPWR VGND sg13cmos5l_fill_1
X_09519_ _11221_/B _14412_/Q _14631_/Q _09532_/S VPWR VGND sg13cmos5l_mux2_1
XFILLER_52_581 VPWR VGND sg13cmos5l_fill_2
X_10791_ _10791_/Y _10790_/B _10789_/Y _10790_/Y VPWR VGND sg13cmos5l_o21ai_1
XFILLER_33_31 VPWR VGND sg13cmos5l_fill_2
XFILLER_52_592 VPWR VGND sg13cmos5l_fill_1
X_12530_ _12530_/Y _14401_/Q _12530_/B VPWR VGND sg13cmos5l_nand2_1
X_12461_ _12461_/Y _08638_/A _11814_/Y _12460_/B VPWR VGND sg13cmos5l_a21oi_1
XFILLER_21_990 VPWR VGND sg13cmos5l_fill_1
X_11412_ _11456_/B _14095_/Q _11416_/B VPWR VGND sg13cmos5l_xnor2_1
X_14200_ _14200_/Q clkload44/A _14200_/D _14200_/RESET_B VPWR VGND sg13cmos5l_dfrbpq_1
X_14131_ _14131_/Q clkload22/A _14131_/D fanout989/X VPWR VGND sg13cmos5l_dfrbpq_1
X_12392_ _12392_/Y _13744_/Q _12402_/A2 _12144_/B _14000_/Q VPWR VGND sg13cmos5l_a22oi_1
XFILLER_3_110 VPWR VGND sg13cmos5l_fill_1
X_11343_ _11344_/B _11374_/A _11343_/B VPWR VGND sg13cmos5l_nand2_1
XFILLER_4_655 VPWR VGND sg13cmos5l_fill_2
X_11274_ _11275_/B _11302_/A _11302_/B VPWR VGND sg13cmos5l_nor2_1
X_14062_ _14062_/Q clkload56/A _14062_/D _14062_/RESET_B VPWR VGND sg13cmos5l_dfrbpq_1
X_10225_ _13875_/D _10355_/A1 _10230_/B _10224_/Y VPWR VGND sg13cmos5l_a21oi_1
X_13013_ _14494_/D _13015_/B _13013_/B VPWR VGND sg13cmos5l_and2_1
XFILLER_79_445 VPWR VGND sg13cmos5l_decap_8
XFILLER_94_404 VPWR VGND sg13cmos5l_fill_1
XFILLER_94_426 VPWR VGND sg13cmos5l_decap_8
X_10156_ _10156_/Y _10417_/A _10351_/C VPWR VGND sg13cmos5l_nor2_1
X_10087_ _13808_/D fanout58/X _10086_/B _10086_/Y VPWR VGND sg13cmos5l_o21ai_1
X_13915_ _13915_/Q _14042_/CLK _13915_/D _13915_/RESET_B VPWR VGND sg13cmos5l_dfrbpq_1
XFILLER_90_621 VPWR VGND sg13cmos5l_fill_1
XFILLER_16_740 VPWR VGND sg13cmos5l_fill_1
XFILLER_62_367 VPWR VGND sg13cmos5l_fill_2
X_13846_ _13846_/Q clkload20/A _13846_/D _13846_/RESET_B VPWR VGND sg13cmos5l_dfrbpq_1
X_10989_ _10989_/Y _14239_/Q _10987_/B _10988_/Y VPWR VGND sg13cmos5l_a21oi_1
X_13777_ _13777_/Q _14640_/CLK _13777_/D _13777_/RESET_B VPWR VGND sg13cmos5l_dfrbpq_1
X_12728_ _14420_/D _11975_/Y _12727_/Y _12755_/A VPWR VGND sg13cmos5l_a21oi_1
X_13766__1625 _13766_/RESET_B VPWR VGND sg13cmos5l_tiehi
X_12659_ _12659_/Y _14445_/Q _13235_/Q VPWR VGND sg13cmos5l_nand2_1
X_13454__1968 _13454_/RESET_B VPWR VGND sg13cmos5l_tiehi
X_14329_ _14329_/Q clkload80/A _14329_/D _14329_/RESET_B VPWR VGND sg13cmos5l_dfrbpq_1
X_13981__1410 _13981_/RESET_B VPWR VGND sg13cmos5l_tiehi
X_09870_ _09870_/Y _09870_/A _09886_/B VPWR VGND sg13cmos5l_nor2_1
Xfanout907 _08170_/A _14107_/Q VPWR VGND sg13cmos5l_buf_1
XFILLER_31_0 VPWR VGND sg13cmos5l_fill_1
X_08821_ _08823_/C _08490_/B _08839_/B VPWR VGND sg13cmos5l_nand2b_1
Xfanout918 _11598_/A _11440_/A VPWR VGND sg13cmos5l_buf_1
Xfanout929 _08995_/A _13308_/Q VPWR VGND sg13cmos5l_buf_1
X_08752_ _08754_/C _11635_/A _14623_/Q _08752_/C VPWR VGND sg13cmos5l_nand3_1
X_13399__2023 _13399_/RESET_B VPWR VGND sg13cmos5l_tiehi
XFILLER_39_887 VPWR VGND sg13cmos5l_fill_2
XFILLER_54_813 VPWR VGND sg13cmos5l_fill_1
X_07703_ _08490_/B _14382_/Q _11765_/A VPWR VGND sg13cmos5l_nand2_1
X_08683_ _08683_/Y _08683_/A _08683_/B _08683_/C VPWR VGND sg13cmos5l_nand3_1
XFILLER_66_695 VPWR VGND sg13cmos5l_decap_8
XFILLER_81_610 VPWR VGND sg13cmos5l_fill_1
X_07634_ _07634_/Y _07634_/A _07634_/B _07634_/C _07634_/D VPWR VGND sg13cmos5l_nor4_1
XFILLER_26_548 VPWR VGND sg13cmos5l_fill_2
XFILLER_53_334 VPWR VGND sg13cmos5l_decap_8
XFILLER_54_857 VPWR VGND sg13cmos5l_decap_8
XFILLER_41_518 VPWR VGND sg13cmos5l_fill_2
XFILLER_53_389 VPWR VGND sg13cmos5l_decap_8
X_07565_ _08984_/B _08974_/A _08979_/A _08974_/B VPWR VGND sg13cmos5l_nand3_1
X_07496_ _07498_/A _13216_/Q _07530_/A2 _07530_/B1 _14477_/Q VPWR VGND sg13cmos5l_a22oi_1
X_09304_ _09304_/Y _09304_/A _09307_/B VPWR VGND sg13cmos5l_nor2_1
XFILLER_16_1018 VPWR VGND sg13cmos5l_fill_2
X_09235_ _13361_/D _09307_/A hold3120/X _09235_/S VPWR VGND sg13cmos5l_mux2_1
X_09166_ _09166_/Y _12282_/A _09178_/A2 _09165_/Y VPWR VGND sg13cmos5l_a21oi_1
X_08117_ _08119_/B _08117_/A _08143_/B VPWR VGND sg13cmos5l_nand2_1
X_09097_ _11360_/A _14325_/Q _09193_/B VPWR VGND sg13cmos5l_nand2_1
X_08048_ _08095_/B _08055_/A VPWR VGND sg13cmos5l_inv_1
XFILLER_0_102 VPWR VGND sg13cmos5l_decap_4
X_14606__2149 _14606_/RESET_B VPWR VGND sg13cmos5l_tiehi
XFILLER_89_743 VPWR VGND sg13cmos5l_fill_1
X_10010_ _13770_/D _10532_/A1 _10009_/B _10009_/Y VPWR VGND sg13cmos5l_o21ai_1
Xhold3030 hold3030/X _13516_/Q VPWR VGND sg13cmos5l_dlygate4sd3_1
Xhold3041 hold3041/X _13261_/Q VPWR VGND sg13cmos5l_dlygate4sd3_1
XFILLER_0_157 VPWR VGND sg13cmos5l_fill_1
X_09999_ _09999_/Y _09999_/A _10017_/B VPWR VGND sg13cmos5l_nand2_1
Xhold2340 _10129_/A _13829_/Q VPWR VGND sg13cmos5l_dlygate4sd3_1
Xhold3052 hold3052/X _13385_/Q VPWR VGND sg13cmos5l_dlygate4sd3_1
Xhold3063 hold3063/X _13351_/Q VPWR VGND sg13cmos5l_dlygate4sd3_1
Xhold3074 hold3074/X _13530_/Q VPWR VGND sg13cmos5l_dlygate4sd3_1
Xhold2351 _10525_/A _14023_/Q VPWR VGND sg13cmos5l_dlygate4sd3_1
Xhold2362 _11497_/A _14334_/Q VPWR VGND sg13cmos5l_dlygate4sd3_1
Xhold2373 _10095_/A _13812_/Q VPWR VGND sg13cmos5l_dlygate4sd3_1
Xhold3085 hold3085/X _13549_/Q VPWR VGND sg13cmos5l_dlygate4sd3_1
Xhold3096 hold3096/X _13412_/Q VPWR VGND sg13cmos5l_dlygate4sd3_1
XFILLER_91_418 VPWR VGND sg13cmos5l_fill_2
X_11961_ _11964_/A _13953_/Q _11969_/A2 _12000_/B VPWR VGND sg13cmos5l_a21oi_1
Xhold2384 _10084_/A _13807_/Q VPWR VGND sg13cmos5l_dlygate4sd3_1
Xhold2395 _11292_/A _14321_/Q VPWR VGND sg13cmos5l_dlygate4sd3_1
X_13844__1547 _13844_/RESET_B VPWR VGND sg13cmos5l_tiehi
XFILLER_44_312 VPWR VGND sg13cmos5l_fill_1
XFILLER_91_429 VPWR VGND sg13cmos5l_decap_8
X_10912_ _10912_/Y _10912_/A _10952_/B VPWR VGND sg13cmos5l_nand2_1
X_13700_ _13700_/Q clkload54/A _13700_/D _13700_/RESET_B VPWR VGND sg13cmos5l_dfrbpq_1
X_11892_ _12696_/B _14353_/Q _12164_/B VPWR VGND sg13cmos5l_nand2_1
XFILLER_60_849 VPWR VGND sg13cmos5l_decap_8
XFILLER_72_687 VPWR VGND sg13cmos5l_fill_1
X_10843_ _10946_/B _10865_/B _10843_/B _10865_/C VPWR VGND sg13cmos5l_nand3_1
X_13631_ _13631_/Q _14045_/CLK _13631_/D _13631_/RESET_B VPWR VGND sg13cmos5l_dfrbpq_1
X_10774_ _10774_/Y _10774_/A _11115_/A VPWR VGND sg13cmos5l_nand2_1
X_13562_ _13562_/Q clkload29/A _13562_/D _13562_/RESET_B VPWR VGND sg13cmos5l_dfrbpq_1
XFILLER_13_776 VPWR VGND sg13cmos5l_fill_1
X_12513_ _12514_/B _12515_/B _13249_/Q _12512_/Y VPWR VGND sg13cmos5l_o21ai_1
X_13493_ _13493_/Q _14102_/CLK _13493_/D _13493_/RESET_B VPWR VGND sg13cmos5l_dfrbpq_1
X_12444_ _14378_/D _11109_/A _12447_/S _12443_/Y _08754_/B VPWR VGND sg13cmos5l_a22oi_1
X_12375_ _12375_/Y _12375_/A _12375_/B _12375_/C VPWR VGND sg13cmos5l_nand3_1
X_11326_ _11326_/Y _14093_/Q _11337_/B VPWR VGND sg13cmos5l_xnor2_1
X_14114_ _14114_/Q clkload31/A _14114_/D _07198_/A VPWR VGND sg13cmos5l_dfrbpq_1
X_14045_ _14045_/Q _14045_/CLK _14045_/D _14045_/RESET_B VPWR VGND sg13cmos5l_dfrbpq_1
X_11257_ _11257_/X _11242_/A _11256_/C _11256_/D VPWR VGND sg13cmos5l_a21o_1
XFILLER_95_724 VPWR VGND sg13cmos5l_decap_4
X_10208_ _13867_/D _10599_/A1 _10209_/B _10207_/Y VPWR VGND sg13cmos5l_a21oi_1
X_11188_ _11200_/B _11189_/A _11189_/B _11189_/C VPWR VGND sg13cmos5l_a21o_1
X_10139_ _10139_/Y _10139_/A _10139_/B VPWR VGND sg13cmos5l_nand2_1
XFILLER_35_312 VPWR VGND sg13cmos5l_fill_1
X_14331__1177 _14331_/RESET_B VPWR VGND sg13cmos5l_tiehi
X_13829_ _13829_/Q _14028_/CLK _13829_/D _13829_/RESET_B VPWR VGND sg13cmos5l_dfrbpq_1
XFILLER_51_849 VPWR VGND sg13cmos5l_decap_4
X_07350_ _07391_/A _07350_/A _07350_/B VPWR VGND sg13cmos5l_nand2_1
X_07281_ _07281_/Y _13243_/Q VPWR VGND sg13cmos5l_inv_1
X_09020_ _09020_/Y _09020_/A _09024_/B VPWR VGND sg13cmos5l_nand2_1
XFILLER_79_0 VPWR VGND sg13cmos5l_fill_1
XFILLER_105_807 VPWR VGND sg13cmos5l_fill_2
XFILLER_85_1016 VPWR VGND sg13cmos5l_decap_4
X_13922__1469 _13922_/RESET_B VPWR VGND sg13cmos5l_tiehi
X_09922_ _09922_/Y _09922_/A _09922_/B VPWR VGND sg13cmos5l_nor2_1
Xfanout715 _13195_/B1 _07891_/C VPWR VGND sg13cmos5l_buf_1
Xfanout704 _11262_/B _11307_/B VPWR VGND sg13cmos5l_buf_1
X_09853_ _13693_/D _10375_/A1 _09858_/B _09852_/Y VPWR VGND sg13cmos5l_a21oi_1
Xfanout748 _12417_/B _11671_/B VPWR VGND sg13cmos5l_buf_1
Xfanout737 _11715_/A _07940_/B VPWR VGND sg13cmos5l_buf_1
Xfanout726 _08861_/C _08894_/B VPWR VGND sg13cmos5l_buf_1
X_08804_ _14628_/D _08804_/A VPWR VGND sg13cmos5l_inv_1
X_09784_ _13659_/D _10371_/A1 _09793_/B _09783_/Y VPWR VGND sg13cmos5l_a21oi_1
Xfanout759 _10774_/A _07191_/Y VPWR VGND sg13cmos5l_buf_1
XFILLER_85_267 VPWR VGND sg13cmos5l_fill_2
X_08735_ _08736_/B _14180_/Q _08753_/B _08734_/X _11657_/B VPWR VGND sg13cmos5l_a22oi_1
XFILLER_67_982 VPWR VGND sg13cmos5l_decap_8
XFILLER_54_654 VPWR VGND sg13cmos5l_fill_2
XFILLER_82_963 VPWR VGND sg13cmos5l_fill_2
X_08666_ _08667_/C _13586_/Q _11726_/B _11785_/B VPWR VGND sg13cmos5l_o21ai_1
XFILLER_26_378 VPWR VGND sg13cmos5l_fill_2
XFILLER_81_484 VPWR VGND sg13cmos5l_decap_4
X_07617_ _07618_/D _08956_/A _13280_/Q VPWR VGND sg13cmos5l_xnor2_1
X_08597_ _08603_/B _07784_/Y _07799_/C _07804_/Y VPWR VGND sg13cmos5l_o21ai_1
XFILLER_81_39 VPWR VGND sg13cmos5l_fill_2
X_07548_ _07552_/A _14556_/Q _13297_/Q VPWR VGND sg13cmos5l_xor2_1
XFILLER_22_551 VPWR VGND sg13cmos5l_fill_2
X_13517__1905 _13517_/RESET_B VPWR VGND sg13cmos5l_tiehi
XFILLER_50_893 VPWR VGND sg13cmos5l_fill_1
X_07479_ _07479_/Y _08252_/A _07477_/X _07478_/Y VPWR VGND sg13cmos5l_o21ai_1
XFILLER_14_99 VPWR VGND sg13cmos5l_fill_1
X_09218_ _13347_/D _09288_/A hold3005/X _09225_/B VPWR VGND sg13cmos5l_mux2_1
X_10490_ _14005_/D _10555_/A1 _10501_/B _10489_/Y VPWR VGND sg13cmos5l_o21ai_1
X_09149_ _09149_/Y _09149_/A _09161_/B VPWR VGND sg13cmos5l_nor2_1
X_12160_ _12161_/C _12216_/A _12160_/B VPWR VGND sg13cmos5l_nand2b_1
XFILLER_1_400 VPWR VGND sg13cmos5l_fill_1
XFILLER_30_98 VPWR VGND sg13cmos5l_fill_2
X_11111_ _11111_/Y _11111_/A _11111_/B VPWR VGND sg13cmos5l_nor2_1
XFILLER_89_540 VPWR VGND sg13cmos5l_fill_1
X_12091_ _12091_/Y _12085_/Y _12086_/Y _12403_/B1 VPWR VGND sg13cmos5l_a21oi_1
XFILLER_2_989 VPWR VGND sg13cmos5l_decap_4
XFILLER_89_573 VPWR VGND sg13cmos5l_fill_2
X_11042_ _14274_/D hold3061/X _12583_/B _11042_/S VPWR VGND sg13cmos5l_mux2_1
XFILLER_49_459 VPWR VGND sg13cmos5l_fill_1
XFILLER_58_960 VPWR VGND sg13cmos5l_fill_1
XFILLER_73_930 VPWR VGND sg13cmos5l_fill_1
X_12993_ _12996_/B _14484_/Q _14485_/Q _12993_/C VPWR VGND sg13cmos5l_nand3_1
X_11944_ _11947_/A _11944_/A1 _11942_/X _11943_/X _11944_/B2 VPWR VGND sg13cmos5l_a22oi_1
X_11875_ _11904_/A _11846_/A _11846_/B _11849_/B _11874_/A VPWR VGND sg13cmos5l_a22oi_1
X_10826_ _14174_/D _14257_/D hold3516/X _10826_/S VPWR VGND sg13cmos5l_mux2_1
X_13614_ _13614_/Q clkload55/A _13614_/D _13614_/RESET_B VPWR VGND sg13cmos5l_dfrbpq_1
XFILLER_13_540 VPWR VGND sg13cmos5l_fill_2
X_14594_ _14594_/Q clkload69/A _14594_/D _14594_/RESET_B VPWR VGND sg13cmos5l_dfrbpq_1
XFILLER_40_370 VPWR VGND sg13cmos5l_fill_1
X_10757_ _10757_/Y _10757_/A _10802_/B VPWR VGND sg13cmos5l_nand2_1
X_13545_ _13545_/Q clkload37/A _13545_/D _13545_/RESET_B VPWR VGND sg13cmos5l_dfrbpq_1
X_10688_ _14108_/D input17/X _08182_/A _10692_/S VPWR VGND sg13cmos5l_mux2_1
X_13476_ _13476_/Q _14117_/CLK _13476_/D _13476_/RESET_B VPWR VGND sg13cmos5l_dfrbpq_1
X_12427_ _12427_/Y _13873_/Q _12427_/A2 _12427_/B1 VPWR VGND sg13cmos5l_a21oi_1
XFILLER_99_315 VPWR VGND sg13cmos5l_fill_2
X_12358_ _12362_/B _14371_/Q _13256_/Q VPWR VGND sg13cmos5l_xor2_1
XFILLER_99_348 VPWR VGND sg13cmos5l_fill_2
X_11309_ _11311_/B _11309_/A _11309_/B VPWR VGND sg13cmos5l_nand2_1
X_12289_ _12289_/Y _13772_/Q _12292_/B _12296_/B1 _13836_/Q VPWR VGND sg13cmos5l_a22oi_1
XFILLER_68_724 VPWR VGND sg13cmos5l_fill_2
X_14349__1159 _14349_/RESET_B VPWR VGND sg13cmos5l_tiehi
X_14028_ _14028_/Q _14028_/CLK _14028_/D _14028_/RESET_B VPWR VGND sg13cmos5l_dfrbpq_1
XFILLER_49_971 VPWR VGND sg13cmos5l_decap_8
XFILLER_68_768 VPWR VGND sg13cmos5l_fill_1
XFILLER_36_621 VPWR VGND sg13cmos5l_fill_1
XFILLER_83_749 VPWR VGND sg13cmos5l_decap_4
X_08520_ _08520_/Y _08520_/A _08520_/B VPWR VGND sg13cmos5l_nor2_1
XFILLER_51_613 VPWR VGND sg13cmos5l_fill_2
X_08451_ _14583_/D _08451_/A _08451_/B VPWR VGND sg13cmos5l_xnor2_1
XFILLER_90_270 VPWR VGND sg13cmos5l_fill_1
XFILLER_90_292 VPWR VGND sg13cmos5l_fill_1
X_07402_ _07402_/Y _07629_/A _07402_/B _07402_/C _07402_/D VPWR VGND sg13cmos5l_nand4_1
X_14605__2148 _14605_/RESET_B VPWR VGND sg13cmos5l_tiehi
X_08382_ _14270_/D _08383_/B _12595_/A _08381_/Y VPWR VGND sg13cmos5l_o21ai_1
X_07333_ _07333_/Y _14137_/Q VPWR VGND sg13cmos5l_inv_1
X_07264_ _07264_/Y _07264_/A VPWR VGND sg13cmos5l_inv_1
X_09003_ _09003_/Y _09003_/A _13034_/B VPWR VGND sg13cmos5l_nor2_1
X_07195_ _07195_/Y _07195_/A VPWR VGND sg13cmos5l_inv_1
XFILLER_105_615 VPWR VGND sg13cmos5l_fill_1
X_09905_ _13718_/D _10557_/A1 _09910_/B _09904_/Y VPWR VGND sg13cmos5l_a21oi_1
Xfanout523 _07512_/B _07433_/Y VPWR VGND sg13cmos5l_buf_1
Xfanout512 _11969_/A2 _12010_/A2 VPWR VGND sg13cmos5l_buf_1
Xfanout501 _12399_/A2 _12428_/A2 VPWR VGND sg13cmos5l_buf_1
Xfanout556 _08869_/B _08900_/A2 VPWR VGND sg13cmos5l_buf_1
Xfanout545 _09556_/A _09640_/A1 VPWR VGND sg13cmos5l_buf_1
Xfanout534 _08187_/B2 _07390_/Y VPWR VGND sg13cmos5l_buf_1
XFILLER_58_256 VPWR VGND sg13cmos5l_fill_2
X_09836_ _09836_/Y _09836_/A _09844_/B VPWR VGND sg13cmos5l_nor2_1
Xfanout589 _12242_/B _12425_/C1 VPWR VGND sg13cmos5l_buf_1
Xfanout578 _11702_/B _08658_/S VPWR VGND sg13cmos5l_buf_1
Xfanout567 _11934_/B1 _08644_/Y VPWR VGND sg13cmos5l_buf_1
XFILLER_74_727 VPWR VGND sg13cmos5l_decap_4
X_09767_ _09767_/Y _09767_/A _09773_/B VPWR VGND sg13cmos5l_nor2_1
XFILLER_55_952 VPWR VGND sg13cmos5l_fill_1
X_08718_ _08720_/B _13941_/Q _11749_/B VPWR VGND sg13cmos5l_nand2_1
X_09698_ _09698_/Y _09698_/A _09714_/B VPWR VGND sg13cmos5l_nor2_1
X_13761__1630 _13761_/RESET_B VPWR VGND sg13cmos5l_tiehi
XFILLER_82_771 VPWR VGND sg13cmos5l_decap_8
X_08649_ _08687_/B _08653_/B _11719_/S VPWR VGND sg13cmos5l_or2_1
XFILLER_82_793 VPWR VGND sg13cmos5l_decap_8
XFILLER_14_348 VPWR VGND sg13cmos5l_fill_1
X_11660_ _11661_/B _11671_/A _11660_/B VPWR VGND sg13cmos5l_nand2_1
X_10611_ _14065_/D fanout56/X _10610_/B _10610_/Y VPWR VGND sg13cmos5l_o21ai_1
X_11591_ _11592_/B _11605_/A _11591_/B VPWR VGND sg13cmos5l_nand2_1
X_10542_ _14031_/D fanout62/X _10545_/B _10541_/Y VPWR VGND sg13cmos5l_o21ai_1
X_13794__1597 _13794_/RESET_B VPWR VGND sg13cmos5l_tiehi
X_13330_ _13330_/Q _14102_/CLK _13330_/D _13330_/RESET_B VPWR VGND sg13cmos5l_dfrbpq_1
X_13261_ _13261_/Q _14577_/CLK _13261_/D fanout975/X VPWR VGND sg13cmos5l_dfrbpq_1
X_10473_ _13997_/D fanout75/X _10474_/B _10472_/Y VPWR VGND sg13cmos5l_a21oi_1
X_12212_ _12212_/Y _14460_/Q _11638_/Y _12165_/A VPWR VGND sg13cmos5l_a21oi_1
X_13192_ _13242_/D _07279_/Y _13194_/A2 _13192_/B1 _13191_/Y VPWR VGND sg13cmos5l_a22oi_1
XFILLER_9_0 VPWR VGND sg13cmos5l_fill_2
X_12143_ _12143_/Y _13959_/Q _12397_/B _12399_/A2 _13639_/Q _12293_/B1 VPWR VGND sg13cmos5l_a221oi_1
X_12074_ _12074_/Y _12127_/A _12074_/B VPWR VGND sg13cmos5l_nor2_1
XFILLER_2_786 VPWR VGND sg13cmos5l_fill_2
XFILLER_77_532 VPWR VGND sg13cmos5l_fill_1
X_11025_ _11025_/Y _11025_/A _14568_/Q _11025_/C _11025_/D VPWR VGND sg13cmos5l_nor4_1
XFILLER_1_296 VPWR VGND sg13cmos5l_fill_1
XFILLER_92_524 VPWR VGND sg13cmos5l_fill_1
XFILLER_64_248 VPWR VGND sg13cmos5l_fill_1
XFILLER_92_557 VPWR VGND sg13cmos5l_fill_1
XFILLER_18_665 VPWR VGND sg13cmos5l_fill_1
XFILLER_75_1004 VPWR VGND sg13cmos5l_fill_1
X_12976_ _12979_/B _12976_/A _12977_/B VPWR VGND sg13cmos5l_and2_1
X_11927_ _11981_/A _14356_/Q _13241_/Q VPWR VGND sg13cmos5l_xor2_1
X_11858_ _11860_/B _13661_/Q _11858_/B VPWR VGND sg13cmos5l_nand2_1
X_14646_ _14646_/Q clkload81/A _14646_/D _14646_/RESET_B VPWR VGND sg13cmos5l_dfrbpq_1
XFILLER_20_307 VPWR VGND sg13cmos5l_fill_2
X_10809_ _10809_/Y _14307_/Q _10759_/A _10766_/B VPWR VGND sg13cmos5l_a21oi_1
X_11789_ _11789_/Y _11782_/Y _11787_/Y _11788_/Y _11774_/Y VPWR VGND sg13cmos5l_a22oi_1
X_14577_ _14577_/Q _14577_/CLK _14577_/D fanout966/X VPWR VGND sg13cmos5l_dfrbpq_1
X_13624__1767 _13624_/RESET_B VPWR VGND sg13cmos5l_tiehi
X_13528_ _13528_/Q _14105_/CLK _13528_/D _13528_/RESET_B VPWR VGND sg13cmos5l_dfrbpq_1
X_13459_ _13459_/Q _14292_/CLK _13459_/D _13459_/RESET_B VPWR VGND sg13cmos5l_dfrbpq_1
X_14004__1387 _14004_/RESET_B VPWR VGND sg13cmos5l_tiehi
XFILLER_82_1019 VPWR VGND sg13cmos5l_fill_1
X_07951_ _07951_/Y _13259_/Q input19/X VPWR VGND sg13cmos5l_nand2_1
Xhold2906 _08121_/A _13212_/Q VPWR VGND sg13cmos5l_dlygate4sd3_1
Xhold2917 _10193_/A _13860_/Q VPWR VGND sg13cmos5l_dlygate4sd3_1
Xhold2928 _08112_/A _13202_/Q VPWR VGND sg13cmos5l_dlygate4sd3_1
Xhold2939 _10289_/A _13907_/Q VPWR VGND sg13cmos5l_dlygate4sd3_1
XFILLER_68_565 VPWR VGND sg13cmos5l_decap_8
X_07882_ _07882_/Y _14203_/Q _14202_/Q VPWR VGND sg13cmos5l_nor2_1
XFILLER_83_502 VPWR VGND sg13cmos5l_decap_4
XFILLER_83_524 VPWR VGND sg13cmos5l_fill_2
X_09621_ _13606_/D _09666_/B fanout80/X _09620_/Y VPWR VGND sg13cmos5l_a21oi_1
X_09552_ _13596_/D _09587_/B _10308_/A1 _09551_/Y VPWR VGND sg13cmos5l_a21oi_1
XFILLER_64_771 VPWR VGND sg13cmos5l_fill_2
XFILLER_83_579 VPWR VGND sg13cmos5l_decap_8
X_08503_ _08504_/B _07689_/Y _07699_/A _07693_/B VPWR VGND sg13cmos5l_o21ai_1
XFILLER_51_410 VPWR VGND sg13cmos5l_decap_8
XFILLER_64_782 VPWR VGND sg13cmos5l_decap_4
XFILLER_91_590 VPWR VGND sg13cmos5l_fill_1
X_09483_ _09483_/Y _09829_/C _10417_/A VPWR VGND sg13cmos5l_nor2_1
XFILLER_51_454 VPWR VGND sg13cmos5l_fill_2
X_08434_ _08434_/Y _10651_/B _08434_/B _10652_/B VPWR VGND sg13cmos5l_nand3_1
X_14208__1269 _14208_/RESET_B VPWR VGND sg13cmos5l_tiehi
XFILLER_23_167 VPWR VGND sg13cmos5l_fill_2
X_08365_ _08365_/Y _08411_/A _08362_/Y _08364_/Y VPWR VGND sg13cmos5l_o21ai_1
X_07316_ _07316_/Y _13355_/Q VPWR VGND sg13cmos5l_inv_1
X_08296_ _08296_/X _13512_/Q _13480_/Q _08301_/S VPWR VGND sg13cmos5l_mux2_1
X_07247_ _11101_/A _14376_/Q VPWR VGND sg13cmos5l_inv_1
Xclkbuf_4_2_0_clk clkbuf_4_2_0_clk/X clkbuf_0_clk/X VPWR VGND sg13cmos5l_buf_8
X_07178_ _10657_/A _14241_/Q VPWR VGND sg13cmos5l_inv_1
XFILLER_106_957 VPWR VGND sg13cmos5l_decap_8
X_13779__1612 _13779_/RESET_B VPWR VGND sg13cmos5l_tiehi
X_13467__1955 _13467_/RESET_B VPWR VGND sg13cmos5l_tiehi
XFILLER_59_510 VPWR VGND sg13cmos5l_decap_8
Xfanout331 _09752_/B _09697_/Y VPWR VGND sg13cmos5l_buf_1
Xfanout320 fanout320/X _09764_/Y VPWR VGND sg13cmos5l_buf_1
X_14290__1218 _14290_/RESET_B VPWR VGND sg13cmos5l_tiehi
XFILLER_47_705 VPWR VGND sg13cmos5l_fill_1
XFILLER_87_874 VPWR VGND sg13cmos5l_decap_8
Xfanout375 _08227_/A2 _10614_/S VPWR VGND sg13cmos5l_buf_1
Xfanout364 _09161_/B fanout367/X VPWR VGND sg13cmos5l_buf_1
Xfanout353 _09673_/B fanout354/X VPWR VGND sg13cmos5l_buf_1
Xfanout342 _10549_/A1 _10419_/A1 VPWR VGND sg13cmos5l_buf_1
XFILLER_47_738 VPWR VGND sg13cmos5l_fill_1
XFILLER_98_1015 VPWR VGND sg13cmos5l_decap_8
X_09819_ _09819_/Y _09819_/A _09821_/B VPWR VGND sg13cmos5l_nor2_1
Xfanout397 _11416_/B _11430_/A VPWR VGND sg13cmos5l_buf_1
Xfanout386 _08405_/A1 _08376_/A1 VPWR VGND sg13cmos5l_buf_1
X_13702__1689 _13702_/RESET_B VPWR VGND sg13cmos5l_tiehi
X_12830_ _12832_/B _14461_/Q _13251_/Q VPWR VGND sg13cmos5l_xnor2_1
XFILLER_27_462 VPWR VGND sg13cmos5l_fill_2
XFILLER_36_64 VPWR VGND sg13cmos5l_fill_2
XFILLER_55_793 VPWR VGND sg13cmos5l_decap_8
X_12761_ _12761_/Y _14359_/Q _12861_/A2 fanout60/X _12760_/X VPWR VGND sg13cmos5l_a22oi_1
XFILLER_14_145 VPWR VGND sg13cmos5l_fill_2
X_11712_ _11713_/C _11667_/Y _11682_/C _11678_/Y VPWR VGND sg13cmos5l_o21ai_1
X_14500_ _14500_/Q clkload15/A _14500_/D _09199_/A VPWR VGND sg13cmos5l_dfrbpq_1
X_12692_ _12696_/C _12689_/Y _12690_/Y _12691_/Y VPWR VGND sg13cmos5l_a21o_1
XFILLER_30_638 VPWR VGND sg13cmos5l_fill_1
X_11643_ _11643_/Y _11642_/A _11642_/B _11715_/A VPWR VGND sg13cmos5l_a21oi_1
X_14431_ _14431_/Q _14650_/CLK _14431_/D _14431_/RESET_B VPWR VGND sg13cmos5l_dfrbpq_1
X_11574_ _11576_/B _11556_/C _11575_/C _11587_/B VPWR VGND sg13cmos5l_a21oi_1
Xinput17 input17/X ui_in[9] VPWR VGND sg13cmos5l_buf_1
X_14362_ _14362_/Q clkload75/A _14362_/D _14362_/RESET_B VPWR VGND sg13cmos5l_dfrbpq_1
XFILLER_10_395 VPWR VGND sg13cmos5l_fill_1
X_10525_ _10525_/Y _10525_/A _10535_/B VPWR VGND sg13cmos5l_nand2_1
X_14293_ _14293_/Q clkload23/A _14293_/D _14293_/RESET_B VPWR VGND sg13cmos5l_dfrbpq_1
X_13313_ _13313_/Q _14453_/CLK _13313_/D _13313_/RESET_B VPWR VGND sg13cmos5l_dfrbpq_1
X_10456_ _10456_/Y _10456_/A _10470_/B VPWR VGND sg13cmos5l_nor2_1
X_13244_ _13244_/Q _14453_/CLK _13244_/D _13244_/RESET_B VPWR VGND sg13cmos5l_dfrbpq_1
X_13335__2087 _13335_/RESET_B VPWR VGND sg13cmos5l_tiehi
X_13175_ _13175_/Y _13235_/Q _13180_/B VPWR VGND sg13cmos5l_nor2_1
XFILLER_2_550 VPWR VGND sg13cmos5l_fill_2
X_10387_ _13955_/D _10583_/A1 _10408_/B _10386_/Y VPWR VGND sg13cmos5l_a21oi_1
X_12126_ _12127_/B _12352_/A _12504_/B _12125_/Y VPWR VGND sg13cmos5l_o21ai_1
X_14604__2147 _14604_/RESET_B VPWR VGND sg13cmos5l_tiehi
X_12057_ _12057_/Y _14052_/Q _12057_/B VPWR VGND sg13cmos5l_nand2_1
X_11008_ _11008_/Y _11008_/A _11671_/B VPWR VGND sg13cmos5l_nand2_1
XFILLER_19_941 VPWR VGND sg13cmos5l_fill_1
XFILLER_77_395 VPWR VGND sg13cmos5l_fill_2
XFILLER_80_516 VPWR VGND sg13cmos5l_decap_8
XFILLER_92_365 VPWR VGND sg13cmos5l_fill_2
X_13512__1910 _13512_/RESET_B VPWR VGND sg13cmos5l_tiehi
XFILLER_46_782 VPWR VGND sg13cmos5l_fill_1
XFILLER_92_398 VPWR VGND sg13cmos5l_decap_8
X_12959_ _12960_/A _14467_/Q _11604_/B _11598_/B _12961_/B2 VPWR VGND sg13cmos5l_a22oi_1
X_14629_ _14629_/Q _14631_/CLK _14629_/D _14629_/RESET_B VPWR VGND sg13cmos5l_dfrbpq_1
X_13857__1534 _13857_/RESET_B VPWR VGND sg13cmos5l_tiehi
X_08150_ _13224_/D _08150_/A _08151_/B VPWR VGND sg13cmos5l_nor2b_1
X_13545__1877 _13545_/RESET_B VPWR VGND sg13cmos5l_tiehi
XFILLER_9_171 VPWR VGND sg13cmos5l_decap_8
X_08081_ _08082_/A _08053_/A _08080_/Y _08058_/B VPWR VGND sg13cmos5l_a21oi_1
Xhold3415 _11111_/A _14295_/Q VPWR VGND sg13cmos5l_dlygate4sd3_1
Xhold3404 hold3404/X _14585_/Q VPWR VGND sg13cmos5l_dlygate4sd3_1
X_08983_ _08983_/Y _08994_/B _08981_/Y _08982_/Y VPWR VGND sg13cmos5l_o21ai_1
Xhold2703 _09874_/A _13704_/Q VPWR VGND sg13cmos5l_dlygate4sd3_1
Xhold2714 _10410_/A _13967_/Q VPWR VGND sg13cmos5l_dlygate4sd3_1
Xhold3448 _13073_/B _13072_/Y VPWR VGND sg13cmos5l_dlygate4sd3_1
Xhold3437 hold3437/X _13262_/Q VPWR VGND sg13cmos5l_dlygate4sd3_1
Xhold3426 _10934_/A _14212_/Q VPWR VGND sg13cmos5l_dlygate4sd3_1
X_07934_ _11622_/A _11671_/B _14623_/Q _08752_/C VPWR VGND sg13cmos5l_or3_1
Xhold2725 _10376_/A _13950_/Q VPWR VGND sg13cmos5l_dlygate4sd3_1
Xhold2736 _09940_/A _13736_/Q VPWR VGND sg13cmos5l_dlygate4sd3_1
Xhold2747 _10228_/A _13877_/Q VPWR VGND sg13cmos5l_dlygate4sd3_1
Xhold3459 hold3459/X _14083_/Q VPWR VGND sg13cmos5l_dlygate4sd3_1
XFILLER_29_738 VPWR VGND sg13cmos5l_fill_2
XFILLER_84_822 VPWR VGND sg13cmos5l_fill_1
X_07865_ _07865_/X _14198_/Q _14199_/Q VPWR VGND sg13cmos5l_or2_1
Xhold2758 _09805_/A _13670_/Q VPWR VGND sg13cmos5l_dlygate4sd3_1
Xhold2769 _09956_/A _13744_/Q VPWR VGND sg13cmos5l_dlygate4sd3_1
X_09604_ _09604_/Y _14455_/Q _09604_/B VPWR VGND sg13cmos5l_nor2_1
XFILLER_37_771 VPWR VGND sg13cmos5l_fill_1
XFILLER_71_516 VPWR VGND sg13cmos5l_decap_8
X_07796_ _08594_/B _14399_/Q _14367_/Q VPWR VGND sg13cmos5l_and2_1
XFILLER_24_410 VPWR VGND sg13cmos5l_fill_1
X_09535_ _09535_/Y _09535_/A _09535_/B _09555_/D VPWR VGND sg13cmos5l_nor3_1
XFILLER_19_1027 VPWR VGND sg13cmos5l_fill_2
X_09466_ _13576_/D _09295_/A hold3192/X _09471_/S VPWR VGND sg13cmos5l_mux2_1
XFILLER_52_785 VPWR VGND sg13cmos5l_fill_1
X_08417_ _08417_/Y _08390_/S _07324_/Y _08214_/A VPWR VGND sg13cmos5l_a21oi_1
X_09397_ _13509_/D _08257_/A hold3238/X _09405_/S VPWR VGND sg13cmos5l_mux2_1
X_08348_ _08348_/Y _08388_/A _08345_/X _08419_/A1 VPWR VGND sg13cmos5l_a21oi_1
X_08279_ _12598_/B _08277_/Y _08278_/X _08269_/Y VPWR VGND sg13cmos5l_o21ai_1
X_14344__1164 _14344_/RESET_B VPWR VGND sg13cmos5l_tiehi
XFILLER_106_710 VPWR VGND sg13cmos5l_decap_8
X_10310_ _13917_/D _10375_/A1 _10315_/B _10309_/Y VPWR VGND sg13cmos5l_a21oi_1
X_11290_ _11290_/Y _11243_/A _11302_/C _12923_/B2 VPWR VGND sg13cmos5l_o21ai_1
X_10241_ _13883_/D _10371_/A1 _10245_/A2 _10240_/Y VPWR VGND sg13cmos5l_a21oi_1
XFILLER_106_776 VPWR VGND sg13cmos5l_decap_8
XFILLER_106_798 VPWR VGND sg13cmos5l_fill_1
XFILLER_79_638 VPWR VGND sg13cmos5l_decap_4
X_10172_ _13849_/D _10367_/A1 _10171_/B _10171_/Y VPWR VGND sg13cmos5l_a21oi_1
XFILLER_59_351 VPWR VGND sg13cmos5l_fill_1
XFILLER_87_660 VPWR VGND sg13cmos5l_fill_2
Xfanout183 _08383_/B _08281_/B VPWR VGND sg13cmos5l_buf_1
Xfanout172 _11042_/S _08421_/S VPWR VGND sg13cmos5l_buf_1
Xfanout161 _10808_/S fanout163/X VPWR VGND sg13cmos5l_buf_1
Xfanout150 _13034_/B _07623_/Y VPWR VGND sg13cmos5l_buf_1
X_13935__1456 _13935_/RESET_B VPWR VGND sg13cmos5l_tiehi
X_13931_ _13931_/Q clkload62/A _13931_/D _13931_/RESET_B VPWR VGND sg13cmos5l_dfrbpq_1
XFILLER_47_535 VPWR VGND sg13cmos5l_fill_2
XFILLER_59_384 VPWR VGND sg13cmos5l_fill_1
XFILLER_59_395 VPWR VGND sg13cmos5l_fill_1
Xfanout194 _09000_/A2 _07562_/Y VPWR VGND sg13cmos5l_buf_1
XFILLER_90_814 VPWR VGND sg13cmos5l_fill_2
X_13862_ _13862_/Q clkload64/A _13862_/D _13862_/RESET_B VPWR VGND sg13cmos5l_dfrbpq_1
X_13793_ _13793_/Q clkload58/A _13793_/D _13793_/RESET_B VPWR VGND sg13cmos5l_dfrbpq_1
X_12813_ _12813_/Y _14460_/Q _13250_/Q VPWR VGND sg13cmos5l_nor2_1
XFILLER_43_741 VPWR VGND sg13cmos5l_fill_1
X_12744_ _12744_/Y _12744_/A _12744_/B VPWR VGND sg13cmos5l_nor2_1
X_12675_ _12676_/B _14447_/Q _13237_/Q VPWR VGND sg13cmos5l_nor2_1
X_11626_ _11626_/Y _11715_/A _11642_/A VPWR VGND sg13cmos5l_nor2_1
X_14414_ _14414_/Q _14630_/CLK _14414_/D _14414_/RESET_B VPWR VGND sg13cmos5l_dfrbpq_1
XFILLER_11_682 VPWR VGND sg13cmos5l_fill_2
X_11557_ _11557_/Y _11557_/A _11557_/B _11557_/C VPWR VGND sg13cmos5l_nor3_1
X_14345_ _14345_/Q _14621_/CLK _14345_/D _14345_/RESET_B VPWR VGND sg13cmos5l_dfrbpq_1
XFILLER_6_130 VPWR VGND sg13cmos5l_fill_1
X_10508_ _14014_/D _10573_/A1 _10517_/B _10507_/Y VPWR VGND sg13cmos5l_o21ai_1
X_11488_ _11490_/C _11517_/A _11459_/B _11487_/Y VPWR VGND sg13cmos5l_o21ai_1
X_14276_ _14276_/Q _14292_/CLK _14276_/D _14276_/RESET_B VPWR VGND sg13cmos5l_dfrbpq_1
XFILLER_98_903 VPWR VGND sg13cmos5l_fill_2
XFILLER_98_914 VPWR VGND sg13cmos5l_decap_8
XFILLER_98_925 VPWR VGND sg13cmos5l_fill_1
X_10439_ _13980_/D _10569_/A1 _10464_/B _10438_/Y VPWR VGND sg13cmos5l_a21oi_1
X_13227_ _13227_/Q clkload66/A _13227_/D _13227_/RESET_B VPWR VGND sg13cmos5l_dfrbpq_1
XFILLER_69_126 VPWR VGND sg13cmos5l_fill_1
X_13158_ _13158_/Y _07268_/Y _13164_/A2 _13156_/Y _13157_/Y VPWR VGND sg13cmos5l_a22oi_1
X_12109_ _12133_/B _12110_/A _12132_/A VPWR VGND sg13cmos5l_nor2_1
X_13089_ _13092_/B _13090_/A _13090_/B VPWR VGND sg13cmos5l_and2_1
XFILLER_65_310 VPWR VGND sg13cmos5l_fill_1
XFILLER_81_803 VPWR VGND sg13cmos5l_fill_2
X_07650_ _08875_/A _14396_/Q _14364_/Q VPWR VGND sg13cmos5l_nor2_1
XFILLER_81_825 VPWR VGND sg13cmos5l_decap_8
XFILLER_93_696 VPWR VGND sg13cmos5l_fill_1
X_07581_ _07582_/D _07372_/Y _08995_/B _07580_/Y VPWR VGND sg13cmos5l_a21oi_1
X_14422__1086 _14422_/RESET_B VPWR VGND sg13cmos5l_tiehi
X_09320_ _13436_/D _08194_/A hold3275/X _09320_/S VPWR VGND sg13cmos5l_mux2_1
XFILLER_61_560 VPWR VGND sg13cmos5l_decap_8
X_09251_ _13376_/D _07985_/A hold3201/X _09268_/S VPWR VGND sg13cmos5l_mux2_1
XFILLER_61_582 VPWR VGND sg13cmos5l_decap_8
X_08202_ _08202_/Y _08202_/A _08201_/X VPWR VGND sg13cmos5l_nor2b_1
X_09182_ _09182_/Y _14435_/Q _11605_/A VPWR VGND sg13cmos5l_nand2_1
X_08133_ _13217_/D _08133_/A _08133_/B VPWR VGND sg13cmos5l_xor2_1
X_08064_ _08064_/Y _09443_/A VPWR VGND sg13cmos5l_inv_1
XFILLER_89_914 VPWR VGND sg13cmos5l_decap_8
Xhold3201 hold3201/X _13376_/Q VPWR VGND sg13cmos5l_dlygate4sd3_1
Xhold3212 hold3212/X _13206_/Q VPWR VGND sg13cmos5l_dlygate4sd3_1
Xhold3223 hold3223/X _13389_/Q VPWR VGND sg13cmos5l_dlygate4sd3_1
XFILLER_88_446 VPWR VGND sg13cmos5l_decap_8
Xhold2500 _07299_/A _13410_/Q VPWR VGND sg13cmos5l_dlygate4sd3_1
Xhold2511 _14158_/D _10794_/Y VPWR VGND sg13cmos5l_dlygate4sd3_1
Xhold2522 _10062_/A _13796_/Q VPWR VGND sg13cmos5l_dlygate4sd3_1
Xhold3234 hold3234/X _13458_/Q VPWR VGND sg13cmos5l_dlygate4sd3_1
Xhold3267 hold3267/X _13450_/Q VPWR VGND sg13cmos5l_dlygate4sd3_1
Xhold3256 _13040_/B _15884_/A VPWR VGND sg13cmos5l_dlygate4sd3_1
Xhold3245 _13511_/D _09399_/X VPWR VGND sg13cmos5l_dlygate4sd3_1
XFILLER_76_619 VPWR VGND sg13cmos5l_fill_2
X_08966_ _08966_/Y _13292_/Q _08975_/A _08965_/Y VPWR VGND sg13cmos5l_a21oi_1
Xhold2533 _10900_/A _14197_/Q VPWR VGND sg13cmos5l_dlygate4sd3_1
Xhold2544 _10745_/A _14142_/Q VPWR VGND sg13cmos5l_dlygate4sd3_1
Xhold2555 _10778_/A _14153_/Q VPWR VGND sg13cmos5l_dlygate4sd3_1
Xhold3289 _13519_/D _09407_/X VPWR VGND sg13cmos5l_dlygate4sd3_1
Xhold3278 hold3278/X _13352_/Q VPWR VGND sg13cmos5l_dlygate4sd3_1
XFILLER_57_855 VPWR VGND sg13cmos5l_fill_1
X_07917_ _07917_/Y _11014_/A _07944_/B VPWR VGND sg13cmos5l_nor2_1
X_08897_ _14652_/D _08897_/A _08897_/B _08897_/C VPWR VGND sg13cmos5l_nand3_1
Xhold2566 _10394_/A _13959_/Q VPWR VGND sg13cmos5l_dlygate4sd3_1
Xhold2577 _07303_/A _13348_/Q VPWR VGND sg13cmos5l_dlygate4sd3_1
Xhold2588 _11147_/A _14306_/Q VPWR VGND sg13cmos5l_dlygate4sd3_1
Xclkbuf_leaf_95_clk clkload50/A clkbuf_4_8_0_clk/X VPWR VGND sg13cmos5l_buf_8
X_07848_ _11149_/B _14084_/Q _14083_/Q VPWR VGND sg13cmos5l_nor2_1
Xhold2599 _10932_/A _14211_/Q VPWR VGND sg13cmos5l_dlygate4sd3_1
X_07779_ _07779_/Y _08575_/A _07779_/B VPWR VGND sg13cmos5l_nand2_1
X_09518_ _13591_/D _09544_/B _10298_/A1 _09517_/Y VPWR VGND sg13cmos5l_a21oi_1
XFILLER_24_240 VPWR VGND sg13cmos5l_fill_2
XFILLER_25_774 VPWR VGND sg13cmos5l_fill_1
X_10790_ _10790_/Y _14157_/Q _10790_/B VPWR VGND sg13cmos5l_nand2_1
X_09449_ _09449_/X _14104_/Q hold3130/X _09453_/S VPWR VGND sg13cmos5l_mux2_1
X_14603__2146 _14603_/RESET_B VPWR VGND sg13cmos5l_tiehi
X_12460_ _12463_/A _12460_/A _12460_/B VPWR VGND sg13cmos5l_nand2_1
X_11411_ _11453_/A _14095_/Q _11416_/B VPWR VGND sg13cmos5l_nor2_1
X_12391_ _12391_/Y _12387_/Y _12389_/Y _12390_/Y VPWR VGND sg13cmos5l_o21ai_1
X_11342_ _11342_/Y _11342_/A _11358_/B VPWR VGND sg13cmos5l_nand2_1
X_14130_ _14130_/Q clkload31/A _14130_/D fanout998/X VPWR VGND sg13cmos5l_dfrbpq_1
X_11273_ _11288_/A _11302_/A _11302_/B VPWR VGND sg13cmos5l_nand2_1
X_14061_ _14061_/Q clkload55/A _14061_/D _14061_/RESET_B VPWR VGND sg13cmos5l_dfrbpq_1
XFILLER_79_413 VPWR VGND sg13cmos5l_decap_8
X_10224_ _10224_/Y _10224_/A _10230_/B VPWR VGND sg13cmos5l_nor2_1
X_13012_ _13013_/B _14493_/Q _13011_/C _14494_/Q VPWR VGND sg13cmos5l_a21o_1
XFILLER_67_608 VPWR VGND sg13cmos5l_fill_1
X_10155_ _10351_/C _14235_/Q _14234_/Q _10155_/C VPWR VGND sg13cmos5l_nand3b_1
X_10086_ _10086_/Y _10086_/A _10086_/B VPWR VGND sg13cmos5l_nand2_1
Xclkbuf_leaf_86_clk clkload52/A clkload4/A VPWR VGND sg13cmos5l_buf_8
X_14203__1274 _14203_/RESET_B VPWR VGND sg13cmos5l_tiehi
XFILLER_59_192 VPWR VGND sg13cmos5l_fill_2
X_13914_ _13914_/Q _14045_/CLK _13914_/D _13914_/RESET_B VPWR VGND sg13cmos5l_dfrbpq_1
X_13845_ _13845_/Q clkload49/A _13845_/D _13845_/RESET_B VPWR VGND sg13cmos5l_dfrbpq_1
X_10988_ _10988_/Y _14567_/Q _10987_/B _11622_/B VPWR VGND sg13cmos5l_o21ai_1
X_13776_ _13776_/Q clkload78/A _13776_/D _13776_/RESET_B VPWR VGND sg13cmos5l_dfrbpq_1
XFILLER_31_722 VPWR VGND sg13cmos5l_fill_2
X_12727_ _12727_/Y _12727_/A1 _12724_/Y _12726_/Y _12643_/A VPWR VGND sg13cmos5l_a22oi_1
X_14407__1101 _14407_/RESET_B VPWR VGND sg13cmos5l_tiehi
X_12658_ _12658_/Y _12658_/A _12658_/B VPWR VGND sg13cmos5l_nor2_1
XFILLER_90_93 VPWR VGND sg13cmos5l_fill_2
X_11609_ _11613_/A _11584_/A _11584_/B _11608_/X VPWR VGND sg13cmos5l_a21oi_1
X_13462__1960 _13462_/RESET_B VPWR VGND sg13cmos5l_tiehi
XFILLER_7_450 VPWR VGND sg13cmos5l_fill_1
Xclkbuf_leaf_10_clk clkload22/A clkload1/A VPWR VGND sg13cmos5l_buf_8
X_12589_ _12591_/A _12589_/A _13230_/Q VPWR VGND sg13cmos5l_xnor2_1
X_14328_ _14328_/Q clkload80/A _14328_/D _14328_/RESET_B VPWR VGND sg13cmos5l_dfrbpq_1
X_14259_ _14259_/Q clkload65/A _14259_/D _14259_/RESET_B VPWR VGND sg13cmos5l_dfrbpq_1
X_08820_ _08823_/B _14382_/Q _11765_/A _08831_/B1 VPWR VGND sg13cmos5l_o21ai_1
Xfanout908 _08157_/A _14106_/Q VPWR VGND sg13cmos5l_buf_1
Xfanout919 _11440_/A _11611_/A VPWR VGND sg13cmos5l_buf_1
XFILLER_39_800 VPWR VGND sg13cmos5l_fill_1
XFILLER_58_619 VPWR VGND sg13cmos5l_fill_1
XFILLER_85_416 VPWR VGND sg13cmos5l_fill_2
XFILLER_39_844 VPWR VGND sg13cmos5l_fill_2
X_08751_ _08754_/B _08750_/Y _12449_/A VPWR VGND sg13cmos5l_nand2b_1
Xclkbuf_leaf_77_clk clkload59/A clkbuf_4_10_0_clk/X VPWR VGND sg13cmos5l_buf_8
XFILLER_66_663 VPWR VGND sg13cmos5l_fill_2
X_07702_ _08491_/A _08492_/A _08490_/A VPWR VGND sg13cmos5l_nor2b_1
X_08682_ _08683_/C _13715_/Q _08738_/A2 _08747_/B _13779_/Q VPWR VGND sg13cmos5l_a22oi_1
XFILLER_0_1011 VPWR VGND sg13cmos5l_decap_8
XFILLER_26_538 VPWR VGND sg13cmos5l_fill_1
X_07633_ _07634_/D _07633_/A _07633_/B VPWR VGND sg13cmos5l_or2_1
XFILLER_0_80 VPWR VGND sg13cmos5l_fill_1
X_07564_ _08979_/B _08974_/A _08974_/B VPWR VGND sg13cmos5l_nand2_1
X_07495_ _07495_/Y _08252_/A _07493_/X _07494_/Y VPWR VGND sg13cmos5l_o21ai_1
X_09303_ _13422_/D _07320_/Y _09307_/B _09302_/Y VPWR VGND sg13cmos5l_a21oi_1
X_09234_ _13360_/D _08397_/A hold3103/X _09234_/S VPWR VGND sg13cmos5l_mux2_1
X_13330__2092 _13330_/RESET_B VPWR VGND sg13cmos5l_tiehi
X_09165_ _09165_/Y _11531_/A _09164_/Y _09178_/A2 VPWR VGND sg13cmos5l_a21oi_1
X_08116_ _13210_/D _09001_/B _08116_/B VPWR VGND sg13cmos5l_xnor2_1
X_09096_ _13312_/D _09095_/B _09094_/Y _09095_/Y VPWR VGND sg13cmos5l_a21oi_1
X_08047_ _08055_/A _09342_/B _08047_/B VPWR VGND sg13cmos5l_and2_1
X_13637__1754 _13637_/RESET_B VPWR VGND sg13cmos5l_tiehi
XFILLER_103_521 VPWR VGND sg13cmos5l_fill_1
XFILLER_62_1017 VPWR VGND sg13cmos5l_decap_8
Xhold3020 _08906_/A _14612_/Q VPWR VGND sg13cmos5l_dlygate4sd3_1
Xhold3031 _09809_/A _13672_/Q VPWR VGND sg13cmos5l_dlygate4sd3_1
Xhold3042 hold3042/X _13525_/Q VPWR VGND sg13cmos5l_dlygate4sd3_1
XFILLER_103_554 VPWR VGND sg13cmos5l_decap_4
XFILLER_49_619 VPWR VGND sg13cmos5l_fill_2
XFILLER_62_1028 VPWR VGND sg13cmos5l_fill_1
XFILLER_95_16 VPWR VGND sg13cmos5l_fill_1
X_09998_ _13764_/D _10128_/A1 _10009_/B _09997_/Y VPWR VGND sg13cmos5l_o21ai_1
Xhold2330 _09989_/A _13760_/Q VPWR VGND sg13cmos5l_dlygate4sd3_1
Xhold3053 _09748_/A _13643_/Q VPWR VGND sg13cmos5l_dlygate4sd3_1
Xhold3064 _10643_/A _14078_/Q VPWR VGND sg13cmos5l_dlygate4sd3_1
Xhold3075 _10430_/A _13976_/Q VPWR VGND sg13cmos5l_dlygate4sd3_1
XFILLER_28_10 VPWR VGND sg13cmos5l_fill_1
XFILLER_92_909 VPWR VGND sg13cmos5l_decap_8
X_08949_ _13263_/D _08041_/B hold3315/X _10781_/B VPWR VGND sg13cmos5l_mux2_1
Xhold2341 _10119_/A _13824_/Q VPWR VGND sg13cmos5l_dlygate4sd3_1
Xhold2352 _08982_/A _13275_/Q VPWR VGND sg13cmos5l_dlygate4sd3_1
Xhold2363 _10107_/A _13818_/Q VPWR VGND sg13cmos5l_dlygate4sd3_1
Xhold3086 hold3086/X _13469_/Q VPWR VGND sg13cmos5l_dlygate4sd3_1
Xhold3097 hold3097/X _13404_/Q VPWR VGND sg13cmos5l_dlygate4sd3_1
X_11960_ _11960_/Y _12286_/A _11960_/B _11960_/C VPWR VGND sg13cmos5l_nand3_1
Xhold2374 _10042_/A _13786_/Q VPWR VGND sg13cmos5l_dlygate4sd3_1
Xhold2385 _10562_/A _14041_/Q VPWR VGND sg13cmos5l_dlygate4sd3_1
Xhold2396 _10519_/A _14020_/Q VPWR VGND sg13cmos5l_dlygate4sd3_1
Xclkbuf_leaf_68_clk _14028_/CLK clkload5/A VPWR VGND sg13cmos5l_buf_8
X_14017__1374 _14017_/RESET_B VPWR VGND sg13cmos5l_tiehi
XFILLER_72_611 VPWR VGND sg13cmos5l_decap_8
XFILLER_72_622 VPWR VGND sg13cmos5l_fill_1
XFILLER_85_983 VPWR VGND sg13cmos5l_decap_8
X_10911_ _14201_/D _10897_/Y _10909_/Y _10910_/Y VPWR VGND sg13cmos5l_o21ai_1
X_13540__1882 _13540_/RESET_B VPWR VGND sg13cmos5l_tiehi
XFILLER_56_184 VPWR VGND sg13cmos5l_fill_1
X_11891_ _11891_/Y _12012_/A1 _11882_/Y _11886_/Y _11890_/Y VPWR VGND sg13cmos5l_a22oi_1
XFILLER_13_711 VPWR VGND sg13cmos5l_fill_1
X_10842_ _10851_/A _10843_/B _10865_/C VPWR VGND sg13cmos5l_nand2_1
X_13630_ _13630_/Q clkload51/A _13630_/D _13630_/RESET_B VPWR VGND sg13cmos5l_dfrbpq_1
X_10773_ _10773_/Y _10772_/B _10771_/Y _10772_/Y VPWR VGND sg13cmos5l_o21ai_1
X_13561_ _13561_/Q _14117_/CLK _13561_/D _13561_/RESET_B VPWR VGND sg13cmos5l_dfrbpq_1
XFILLER_40_563 VPWR VGND sg13cmos5l_fill_1
XFILLER_52_390 VPWR VGND sg13cmos5l_fill_2
X_12512_ _12512_/Y _12515_/B _12181_/B _12522_/B VPWR VGND sg13cmos5l_a21oi_1
XFILLER_13_788 VPWR VGND sg13cmos5l_fill_1
XFILLER_8_225 VPWR VGND sg13cmos5l_fill_2
X_13492_ _13492_/Q _14520_/CLK _13492_/D _13492_/RESET_B VPWR VGND sg13cmos5l_dfrbpq_1
XFILLER_60_63 VPWR VGND sg13cmos5l_fill_1
XFILLER_60_74 VPWR VGND sg13cmos5l_fill_2
X_12443_ _12443_/Y _12445_/A _13231_/Q _12447_/S VPWR VGND sg13cmos5l_a21oi_1
X_12374_ _12375_/C _14063_/Q _12419_/A2 _12377_/B1 _13807_/Q VPWR VGND sg13cmos5l_a22oi_1
XFILLER_4_442 VPWR VGND sg13cmos5l_fill_2
XFILLER_5_943 VPWR VGND sg13cmos5l_fill_2
X_11325_ _11391_/A _14093_/Q _11337_/B VPWR VGND sg13cmos5l_xor2_1
X_14113_ _14113_/Q clkload32/A _14113_/D _07198_/A VPWR VGND sg13cmos5l_dfrbpq_1
X_11256_ _11302_/A _11256_/A _11256_/B _11256_/C _11256_/D VPWR VGND sg13cmos5l_and4_1
X_14044_ _14044_/Q clkload47/A _14044_/D _14044_/RESET_B VPWR VGND sg13cmos5l_dfrbpq_1
XFILLER_79_210 VPWR VGND sg13cmos5l_fill_1
XFILLER_67_405 VPWR VGND sg13cmos5l_fill_1
X_10207_ _10207_/Y _10207_/A _10209_/B VPWR VGND sg13cmos5l_nor2_1
X_11187_ _11189_/C _14180_/Q _11214_/B VPWR VGND sg13cmos5l_xnor2_1
X_10138_ _13833_/D _10595_/A1 _10146_/A2 _10137_/Y VPWR VGND sg13cmos5l_o21ai_1
X_10069_ _13799_/D _10591_/A1 _10078_/B _10068_/Y VPWR VGND sg13cmos5l_o21ai_1
Xclkbuf_leaf_59_clk clkload68/A clkbuf_4_12_0_clk/X VPWR VGND sg13cmos5l_buf_8
XFILLER_75_482 VPWR VGND sg13cmos5l_decap_4
XFILLER_51_806 VPWR VGND sg13cmos5l_decap_8
XFILLER_62_165 VPWR VGND sg13cmos5l_fill_2
XFILLER_63_666 VPWR VGND sg13cmos5l_fill_2
X_13828_ _13828_/Q clkload70/A _13828_/D _13828_/RESET_B VPWR VGND sg13cmos5l_dfrbpq_1
XFILLER_44_880 VPWR VGND sg13cmos5l_fill_1
XFILLER_44_891 VPWR VGND sg13cmos5l_fill_2
X_13759_ _13759_/Q clkload46/A _13759_/D _13759_/RESET_B VPWR VGND sg13cmos5l_dfrbpq_1
X_07280_ _07280_/Y _13730_/Q VPWR VGND sg13cmos5l_inv_1
X_13715__1676 _13715_/RESET_B VPWR VGND sg13cmos5l_tiehi
XFILLER_102_1022 VPWR VGND sg13cmos5l_decap_8
XFILLER_85_1006 VPWR VGND sg13cmos5l_fill_2
X_13930__1461 _13930_/RESET_B VPWR VGND sg13cmos5l_tiehi
X_09921_ _13726_/D _10377_/A1 _09942_/B _09920_/Y VPWR VGND sg13cmos5l_a21oi_1
Xfanout705 _11307_/B _07936_/B1 VPWR VGND sg13cmos5l_buf_1
X_09852_ _09852_/Y _09852_/A _09858_/B VPWR VGND sg13cmos5l_nor2_1
Xfanout749 _11671_/B _07256_/Y VPWR VGND sg13cmos5l_buf_1
Xfanout738 _12136_/A _07940_/B VPWR VGND sg13cmos5l_buf_1
Xfanout727 _08894_/B _08905_/A2 VPWR VGND sg13cmos5l_buf_1
Xfanout716 _07891_/C _07885_/X VPWR VGND sg13cmos5l_buf_1
X_14602__2145 _14602_/RESET_B VPWR VGND sg13cmos5l_tiehi
XFILLER_100_524 VPWR VGND sg13cmos5l_fill_2
X_08803_ _08804_/A _08460_/A _08819_/B _08822_/B hold3404/X _08802_/Y VPWR VGND sg13cmos5l_a221oi_1
X_09783_ _09783_/Y _09783_/A _09793_/B VPWR VGND sg13cmos5l_nor2_1
XFILLER_27_803 VPWR VGND sg13cmos5l_fill_2
XFILLER_39_652 VPWR VGND sg13cmos5l_fill_1
XFILLER_85_246 VPWR VGND sg13cmos5l_fill_1
X_08734_ _08734_/X _14622_/Q _08734_/B VPWR VGND sg13cmos5l_xor2_1
X_13348__2074 _13348_/RESET_B VPWR VGND sg13cmos5l_tiehi
XFILLER_66_471 VPWR VGND sg13cmos5l_decap_4
XFILLER_27_869 VPWR VGND sg13cmos5l_fill_2
X_08665_ _08667_/B _13906_/Q _08687_/B VPWR VGND sg13cmos5l_nor2_1
XFILLER_82_986 VPWR VGND sg13cmos5l_fill_1
X_07616_ _07618_/C _08999_/A _13289_/Q VPWR VGND sg13cmos5l_nor2b_1
X_08596_ _08596_/Y _08589_/B _08607_/C _08609_/C VPWR VGND sg13cmos5l_a21oi_1
X_07547_ _07560_/B _07547_/A _07547_/B _07547_/C VPWR VGND sg13cmos5l_nand3_1
XFILLER_10_703 VPWR VGND sg13cmos5l_fill_1
X_07478_ _07478_/Y _08227_/A2 _07476_/Y _08252_/A VPWR VGND sg13cmos5l_o21ai_1
XFILLER_10_769 VPWR VGND sg13cmos5l_fill_2
X_09217_ _13346_/D _09286_/A hold3128/X _09230_/B VPWR VGND sg13cmos5l_mux2_1
X_09148_ _09148_/Y _14365_/Q _09160_/A2 _09147_/Y VPWR VGND sg13cmos5l_a21oi_1
X_09079_ _11309_/A _14322_/Q _09175_/B VPWR VGND sg13cmos5l_nand2_1
X_11110_ _11110_/Y _14394_/Q _11109_/B _11109_/Y VPWR VGND sg13cmos5l_a21oi_1
X_13558__1864 _13558_/RESET_B VPWR VGND sg13cmos5l_tiehi
XFILLER_104_841 VPWR VGND sg13cmos5l_fill_1
X_12090_ _12090_/Y _12090_/A _12090_/B _12090_/C VPWR VGND sg13cmos5l_nand3_1
XFILLER_104_874 VPWR VGND sg13cmos5l_fill_1
X_11041_ _12583_/B _11041_/A _11040_/Y VPWR VGND sg13cmos5l_nor2b_1
X_14381__1127 _14381_/RESET_B VPWR VGND sg13cmos5l_tiehi
XFILLER_7_1028 VPWR VGND sg13cmos5l_fill_1
XFILLER_18_836 VPWR VGND sg13cmos5l_fill_2
XFILLER_29_151 VPWR VGND sg13cmos5l_fill_1
XFILLER_58_983 VPWR VGND sg13cmos5l_fill_1
X_12992_ _12992_/X _12992_/A _12993_/C VPWR VGND sg13cmos5l_xor2_1
XFILLER_57_493 VPWR VGND sg13cmos5l_decap_8
XFILLER_73_953 VPWR VGND sg13cmos5l_decap_8
X_11943_ _11943_/X _14016_/Q _13984_/Q _11945_/S VPWR VGND sg13cmos5l_mux2_1
XFILLER_33_828 VPWR VGND sg13cmos5l_fill_2
X_11874_ _11874_/Y _11874_/A VPWR VGND sg13cmos5l_inv_1
X_13972__1419 _13972_/RESET_B VPWR VGND sg13cmos5l_tiehi
X_10825_ _14173_/D _14253_/D hold3334/X _10832_/S VPWR VGND sg13cmos5l_mux2_1
X_13613_ _13613_/Q _14053_/CLK _13613_/D _13613_/RESET_B VPWR VGND sg13cmos5l_dfrbpq_1
XFILLER_13_552 VPWR VGND sg13cmos5l_fill_2
XFILLER_60_658 VPWR VGND sg13cmos5l_fill_1
X_14593_ _14593_/Q clkload69/A _14593_/D _14593_/RESET_B VPWR VGND sg13cmos5l_dfrbpq_1
X_10756_ _10756_/Y _10801_/A _14290_/Q VPWR VGND sg13cmos5l_nand2_1
X_13544_ _13544_/Q clkload28/A _13544_/D _13544_/RESET_B VPWR VGND sg13cmos5l_dfrbpq_1
X_10687_ _14107_/D input16/X hold3403/X _10692_/S VPWR VGND sg13cmos5l_mux2_1
X_13475_ _13475_/Q clkload29/A _13475_/D _13475_/RESET_B VPWR VGND sg13cmos5l_dfrbpq_1
X_12426_ _12426_/X _13937_/Q _12426_/B VPWR VGND sg13cmos5l_and2_1
XFILLER_4_250 VPWR VGND sg13cmos5l_fill_2
X_12357_ _14370_/D _12334_/A _12385_/A _12353_/Y _12356_/Y VPWR VGND sg13cmos5l_a22oi_1
X_11308_ _11309_/B _11308_/A _11308_/B VPWR VGND sg13cmos5l_nand2_1
X_12288_ _12288_/Y _14060_/Q _12296_/A2 _12290_/A2 _13996_/Q _12297_/C1 VPWR VGND
+ sg13cmos5l_a221oi_1
X_13236__1059 _13236_/RESET_B VPWR VGND sg13cmos5l_tiehi
XFILLER_68_714 VPWR VGND sg13cmos5l_decap_4
X_11239_ _11239_/Y _11239_/A _11239_/B VPWR VGND sg13cmos5l_nand2_1
X_14357__1151 _14357_/RESET_B VPWR VGND sg13cmos5l_tiehi
X_14027_ _14027_/Q clkload62/A _14027_/D _14027_/RESET_B VPWR VGND sg13cmos5l_dfrbpq_1
XFILLER_67_224 VPWR VGND sg13cmos5l_fill_1
XFILLER_55_408 VPWR VGND sg13cmos5l_fill_2
XFILLER_83_728 VPWR VGND sg13cmos5l_decap_8
XFILLER_91_761 VPWR VGND sg13cmos5l_decap_4
X_08450_ _08451_/B _08450_/A _08450_/B VPWR VGND sg13cmos5l_xor2_1
X_07401_ _07402_/D _07591_/A _07408_/B _07414_/B _07588_/B VPWR VGND sg13cmos5l_nor4_1
X_08381_ _08381_/Y _08381_/A _08383_/B VPWR VGND sg13cmos5l_nand2_1
X_13948__1443 _13948_/RESET_B VPWR VGND sg13cmos5l_tiehi
X_07332_ _07332_/Y _14136_/Q VPWR VGND sg13cmos5l_inv_1
X_07263_ _07263_/Y _07263_/A VPWR VGND sg13cmos5l_inv_1
X_07194_ _07194_/Y _07194_/A VPWR VGND sg13cmos5l_inv_1
X_09002_ _13279_/D _09002_/A _09002_/B VPWR VGND sg13cmos5l_nand2_1
X_09904_ _09904_/Y _09904_/A _09910_/B VPWR VGND sg13cmos5l_nor2_1
Xfanout524 _08207_/B1 _07530_/A2 VPWR VGND sg13cmos5l_buf_1
Xfanout513 _12348_/A2 _12010_/A2 VPWR VGND sg13cmos5l_buf_1
Xfanout502 _12402_/A2 _12428_/A2 VPWR VGND sg13cmos5l_buf_1
XFILLER_101_833 VPWR VGND sg13cmos5l_fill_2
XFILLER_58_202 VPWR VGND sg13cmos5l_fill_2
XFILLER_59_725 VPWR VGND sg13cmos5l_decap_8
XFILLER_76_29 VPWR VGND sg13cmos5l_fill_1
X_09835_ _13684_/D _10357_/A1 _09844_/B _09834_/Y VPWR VGND sg13cmos5l_a21oi_1
Xfanout557 _08900_/A2 _08911_/B VPWR VGND sg13cmos5l_buf_1
Xfanout546 _09571_/A _09639_/A VPWR VGND sg13cmos5l_buf_1
Xfanout535 _11036_/C1 _07390_/Y VPWR VGND sg13cmos5l_buf_1
XFILLER_101_877 VPWR VGND sg13cmos5l_fill_2
Xfanout579 _08658_/S _12057_/B VPWR VGND sg13cmos5l_buf_1
Xfanout568 _12010_/C1 _12203_/A2 VPWR VGND sg13cmos5l_buf_1
XFILLER_100_354 VPWR VGND sg13cmos5l_fill_1
XFILLER_101_899 VPWR VGND sg13cmos5l_decap_4
X_09766_ _13650_/D _10549_/A1 _09801_/B _09765_/Y VPWR VGND sg13cmos5l_a21oi_1
XFILLER_73_238 VPWR VGND sg13cmos5l_fill_2
X_08717_ _08720_/A _13877_/Q _08744_/B1 _11837_/C1 VPWR VGND sg13cmos5l_a21oi_1
X_09697_ _09697_/Y _09829_/C _10221_/A VPWR VGND sg13cmos5l_nor2_1
XFILLER_70_912 VPWR VGND sg13cmos5l_fill_1
X_08648_ _08648_/Y _08653_/B _11719_/S VPWR VGND sg13cmos5l_nor2_1
XFILLER_42_625 VPWR VGND sg13cmos5l_decap_8
XFILLER_70_923 VPWR VGND sg13cmos5l_decap_8
XFILLER_81_293 VPWR VGND sg13cmos5l_fill_1
X_08579_ _08580_/A _08579_/A _08579_/B VPWR VGND sg13cmos5l_nor2_1
X_10610_ _10610_/Y _10610_/A _10610_/B VPWR VGND sg13cmos5l_nand2_1
X_11590_ _11590_/Y _11590_/A _11604_/B VPWR VGND sg13cmos5l_nand2_1
X_14399__1109 _14399_/RESET_B VPWR VGND sg13cmos5l_tiehi
X_10541_ _10541_/Y _10541_/A _10545_/B VPWR VGND sg13cmos5l_nand2_1
X_14435__1073 _14435_/RESET_B VPWR VGND sg13cmos5l_tiehi
XFILLER_6_504 VPWR VGND sg13cmos5l_fill_1
X_13260_ _13260_/Q _14577_/CLK _13260_/D fanout984/X VPWR VGND sg13cmos5l_dfrbpq_1
X_10472_ _10472_/Y _10472_/A _10474_/B VPWR VGND sg13cmos5l_nor2_1
X_12211_ _12211_/Y _12198_/Y _12201_/Y _12210_/Y _12322_/A1 VPWR VGND sg13cmos5l_a22oi_1
X_13191_ _13191_/Y _08923_/A _14174_/Q _13191_/B1 hold3391/X VPWR VGND sg13cmos5l_a22oi_1
X_12142_ _12142_/Y _13895_/Q _12174_/B _12401_/B1 _13703_/Q VPWR VGND sg13cmos5l_a22oi_1
X_12073_ _12074_/B _12097_/A1 _12069_/Y _12072_/Y VPWR VGND sg13cmos5l_o21ai_1
XFILLER_77_511 VPWR VGND sg13cmos5l_fill_2
X_11024_ _11025_/D _11024_/A _11024_/B VPWR VGND sg13cmos5l_nor2_1
XFILLER_2_37 VPWR VGND sg13cmos5l_fill_1
XFILLER_89_393 VPWR VGND sg13cmos5l_fill_1
XFILLER_77_577 VPWR VGND sg13cmos5l_fill_1
XFILLER_77_599 VPWR VGND sg13cmos5l_fill_1
XFILLER_18_633 VPWR VGND sg13cmos5l_fill_1
X_12975_ _14475_/D _12975_/A _12975_/B VPWR VGND sg13cmos5l_xor2_1
XFILLER_46_986 VPWR VGND sg13cmos5l_fill_2
X_11926_ _11988_/A _11926_/A _11926_/B VPWR VGND sg13cmos5l_nor2_1
XFILLER_73_783 VPWR VGND sg13cmos5l_decap_8
X_14240__1237 _14240_/RESET_B VPWR VGND sg13cmos5l_tiehi
X_11857_ _11860_/A _13597_/Q _11914_/A2 _11695_/B VPWR VGND sg13cmos5l_a21oi_1
X_14645_ _14645_/Q clkload75/A _14645_/D _14645_/RESET_B VPWR VGND sg13cmos5l_dfrbpq_1
XFILLER_14_883 VPWR VGND sg13cmos5l_fill_1
X_10808_ _14163_/D _10807_/Y _07954_/C _10808_/S VPWR VGND sg13cmos5l_mux2_1
X_11788_ _11788_/Y _11775_/Y _11776_/Y _11777_/Y _12245_/B2 _11788_/C1 VPWR VGND sg13cmos5l_a221oi_1
X_14576_ _14576_/Q _14576_/CLK _14576_/D fanout990/X VPWR VGND sg13cmos5l_dfrbpq_1
X_10739_ _10739_/Y _10739_/A _10793_/B VPWR VGND sg13cmos5l_nand2_1
X_14601__2144 _14601_/RESET_B VPWR VGND sg13cmos5l_tiehi
X_13527_ _13527_/Q _14105_/CLK _13527_/D _13527_/RESET_B VPWR VGND sg13cmos5l_dfrbpq_1
XFILLER_12_1000 VPWR VGND sg13cmos5l_fill_2
X_13458_ _13458_/Q _14102_/CLK _13458_/D _13458_/RESET_B VPWR VGND sg13cmos5l_dfrbpq_1
X_13389_ _13389_/Q clkload41/A _13389_/D _13389_/RESET_B VPWR VGND sg13cmos5l_dfrbpq_1
X_12409_ _12409_/Y _12409_/A _12409_/B VPWR VGND sg13cmos5l_nor2_1
XFILLER_49_2 VPWR VGND sg13cmos5l_fill_1
X_07950_ _14578_/D _07261_/Y input18/X _10808_/S VPWR VGND sg13cmos5l_o21ai_1
Xhold2907 _13212_/D _08121_/Y VPWR VGND sg13cmos5l_dlygate4sd3_1
Xhold2918 _11119_/A _14297_/Q VPWR VGND sg13cmos5l_dlygate4sd3_1
Xhold2929 _10258_/A _13892_/Q VPWR VGND sg13cmos5l_dlygate4sd3_1
XFILLER_95_341 VPWR VGND sg13cmos5l_fill_1
X_07881_ _14580_/D _10874_/A _07893_/A VPWR VGND sg13cmos5l_nand2b_1
X_09620_ _09620_/Y _09620_/A _09666_/B VPWR VGND sg13cmos5l_nor2_1
XFILLER_83_536 VPWR VGND sg13cmos5l_fill_2
XFILLER_83_547 VPWR VGND sg13cmos5l_decap_8
X_09551_ _09551_/Y _09551_/A _09587_/B VPWR VGND sg13cmos5l_nor2_1
XFILLER_48_290 VPWR VGND sg13cmos5l_fill_2
XFILLER_64_761 VPWR VGND sg13cmos5l_fill_1
X_08502_ _08502_/Y _08502_/A _08502_/B VPWR VGND sg13cmos5l_nor2_1
X_09482_ _10417_/A _10351_/A _10351_/B VPWR VGND sg13cmos5l_nand2_1
XFILLER_51_444 VPWR VGND sg13cmos5l_fill_2
X_08433_ _10652_/B _08168_/A _08431_/Y _08432_/Y _08423_/Y VPWR VGND sg13cmos5l_a22oi_1
X_14216__1261 _14216_/RESET_B VPWR VGND sg13cmos5l_tiehi
X_08364_ _08364_/Y _08411_/A _08364_/B VPWR VGND sg13cmos5l_nand2_1
X_07315_ _07315_/Y _13419_/Q VPWR VGND sg13cmos5l_inv_1
X_08295_ _08295_/X _09295_/A _08307_/B VPWR VGND sg13cmos5l_and2_1
X_07246_ _11671_/A _14345_/Q VPWR VGND sg13cmos5l_inv_1
X_07177_ _07177_/Y _14442_/Q VPWR VGND sg13cmos5l_inv_1
XFILLER_106_936 VPWR VGND sg13cmos5l_decap_8
XFILLER_11_79 VPWR VGND sg13cmos5l_fill_1
Xfanout332 _10561_/A1 _10496_/A1 VPWR VGND sg13cmos5l_buf_1
Xfanout321 _09706_/B _09724_/B VPWR VGND sg13cmos5l_buf_1
Xfanout310 _09890_/B _09829_/Y VPWR VGND sg13cmos5l_buf_1
XFILLER_87_842 VPWR VGND sg13cmos5l_fill_2
Xfanout365 _09173_/B fanout367/X VPWR VGND sg13cmos5l_buf_1
Xfanout354 fanout354/X _09483_/Y VPWR VGND sg13cmos5l_buf_1
Xfanout343 _10419_/A1 _09487_/Y VPWR VGND sg13cmos5l_buf_1
XFILLER_47_717 VPWR VGND sg13cmos5l_fill_2
XFILLER_98_1005 VPWR VGND sg13cmos5l_fill_1
X_09818_ _13676_/D fanout77/X _09817_/B _09817_/Y VPWR VGND sg13cmos5l_a21oi_1
Xfanout398 _11228_/B _11256_/B VPWR VGND sg13cmos5l_buf_1
Xfanout387 _08376_/A1 _07397_/Y VPWR VGND sg13cmos5l_buf_1
Xfanout376 _11035_/A1 _10614_/S VPWR VGND sg13cmos5l_buf_1
X_13674__1717 _13674_/RESET_B VPWR VGND sg13cmos5l_tiehi
XFILLER_28_942 VPWR VGND sg13cmos5l_fill_1
X_09749_ _13643_/D _10534_/A1 _09748_/B _09748_/Y VPWR VGND sg13cmos5l_a21oi_1
X_13710__1681 _13710_/RESET_B VPWR VGND sg13cmos5l_tiehi
XFILLER_62_709 VPWR VGND sg13cmos5l_fill_1
XFILLER_15_625 VPWR VGND sg13cmos5l_fill_1
XFILLER_15_636 VPWR VGND sg13cmos5l_fill_2
X_12760_ _12760_/X _12891_/A1 _12562_/Y _12739_/A VPWR VGND sg13cmos5l_a21o_1
XFILLER_43_967 VPWR VGND sg13cmos5l_fill_2
X_11711_ _11713_/B _11711_/A _13233_/Q VPWR VGND sg13cmos5l_xor2_1
X_14054__1337 _14054_/RESET_B VPWR VGND sg13cmos5l_tiehi
X_12691_ _12691_/Y _12689_/Y _12690_/Y _12727_/A1 VPWR VGND sg13cmos5l_o21ai_1
XFILLER_42_466 VPWR VGND sg13cmos5l_fill_2
X_11642_ _11642_/X _11642_/A _11642_/B VPWR VGND sg13cmos5l_or2_1
X_14430_ _14430_/Q _14650_/CLK _14430_/D _14430_/RESET_B VPWR VGND sg13cmos5l_dfrbpq_1
X_14361_ _14361_/Q clkload76/A _14361_/D _14361_/RESET_B VPWR VGND sg13cmos5l_dfrbpq_1
X_11573_ _11587_/B _11573_/A _11573_/B VPWR VGND sg13cmos5l_nand2_1
Xinput18 input18/X uio_in[0] VPWR VGND sg13cmos5l_buf_1
X_13312_ _13312_/Q clkload67/A _13312_/D _13312_/RESET_B VPWR VGND sg13cmos5l_dfrbpq_1
X_10524_ _14022_/D fanout79/X _10537_/B _10523_/Y VPWR VGND sg13cmos5l_o21ai_1
X_14292_ _14292_/Q _14292_/CLK _14292_/D _14292_/RESET_B VPWR VGND sg13cmos5l_dfrbpq_1
X_10455_ _13988_/D _10585_/A1 _10466_/B _10454_/Y VPWR VGND sg13cmos5l_a21oi_1
X_13243_ _13243_/Q _14453_/CLK _13243_/D _13243_/RESET_B VPWR VGND sg13cmos5l_dfrbpq_1
XFILLER_6_389 VPWR VGND sg13cmos5l_fill_1
X_13174_ _13174_/Y _11275_/A hold3503/X _08917_/X _08381_/A VPWR VGND sg13cmos5l_a22oi_1
XFILLER_97_606 VPWR VGND sg13cmos5l_decap_8
X_10386_ _10386_/Y _10386_/A _10408_/B VPWR VGND sg13cmos5l_nor2_1
X_12125_ _12125_/Y _12130_/A _12383_/A2 _12124_/Y VPWR VGND sg13cmos5l_o21ai_1
XFILLER_78_842 VPWR VGND sg13cmos5l_decap_4
X_12056_ _12056_/Y _14020_/Q _12427_/B1 _12243_/B1 VPWR VGND sg13cmos5l_a21oi_1
X_11007_ _11007_/Y _11007_/A _11635_/A VPWR VGND sg13cmos5l_nor2_1
XFILLER_93_93 VPWR VGND sg13cmos5l_fill_2
X_12958_ _14466_/D _12958_/A VPWR VGND sg13cmos5l_inv_1
X_11909_ _11909_/Y _13759_/Q _11914_/A2 _11783_/B VPWR VGND sg13cmos5l_a21oi_1
X_12889_ _12890_/B _12888_/A _12888_/B _12897_/A VPWR VGND sg13cmos5l_o21ai_1
XFILLER_61_786 VPWR VGND sg13cmos5l_fill_1
X_14628_ _14628_/Q clkload36/A _14628_/D _14628_/RESET_B VPWR VGND sg13cmos5l_dfrbpq_1
X_14559_ _14559_/Q clkload12/A _14559_/D fanout958/X VPWR VGND sg13cmos5l_dfrbpq_1
X_08080_ _08080_/Y _09377_/A VPWR VGND sg13cmos5l_inv_1
X_13752__1639 _13752_/RESET_B VPWR VGND sg13cmos5l_tiehi
XFILLER_54_0 VPWR VGND sg13cmos5l_fill_2
X_13898__1493 _13898_/RESET_B VPWR VGND sg13cmos5l_tiehi
Xhold3416 _09018_/A _13291_/Q VPWR VGND sg13cmos5l_dlygate4sd3_1
Xhold3405 hold3405/X _14189_/Q VPWR VGND sg13cmos5l_dlygate4sd3_1
XFILLER_103_939 VPWR VGND sg13cmos5l_fill_2
XFILLER_69_820 VPWR VGND sg13cmos5l_fill_1
X_08982_ _08982_/Y _08982_/A _08994_/B VPWR VGND sg13cmos5l_nand2_1
Xhold2704 _10254_/A _13890_/Q VPWR VGND sg13cmos5l_dlygate4sd3_1
Xhold3449 hold3449/X _14583_/Q VPWR VGND sg13cmos5l_dlygate4sd3_1
Xhold3438 _12468_/B _13238_/Q VPWR VGND sg13cmos5l_dlygate4sd3_1
Xhold3427 _07929_/C _14224_/Q VPWR VGND sg13cmos5l_dlygate4sd3_1
X_07933_ _14568_/D _07933_/A _07944_/B _11024_/A VPWR VGND sg13cmos5l_and3_1
Xhold2715 _10384_/A _13954_/Q VPWR VGND sg13cmos5l_dlygate4sd3_1
Xhold2726 _10270_/A _13898_/Q VPWR VGND sg13cmos5l_dlygate4sd3_1
Xhold2737 _09904_/A _13718_/Q VPWR VGND sg13cmos5l_dlygate4sd3_1
XFILLER_84_812 VPWR VGND sg13cmos5l_decap_4
X_07864_ _07864_/X _07864_/A _07864_/B VPWR VGND sg13cmos5l_and2_1
Xhold2748 _10874_/A _14190_/Q VPWR VGND sg13cmos5l_dlygate4sd3_1
Xhold2759 _10466_/A _13994_/Q VPWR VGND sg13cmos5l_dlygate4sd3_1
XFILLER_28_227 VPWR VGND sg13cmos5l_fill_1
XFILLER_56_536 VPWR VGND sg13cmos5l_fill_2
X_09603_ _09611_/B _14455_/Q _09604_/B VPWR VGND sg13cmos5l_and2_1
X_07795_ _08885_/A _14399_/Q _14367_/Q VPWR VGND sg13cmos5l_nor2_1
XFILLER_71_539 VPWR VGND sg13cmos5l_fill_1
X_09534_ _09555_/D _09534_/A _09534_/B _09534_/C _09534_/D VPWR VGND sg13cmos5l_nor4_1
XFILLER_24_444 VPWR VGND sg13cmos5l_fill_1
X_09465_ _13575_/D _09293_/A hold2986/X _09467_/S VPWR VGND sg13cmos5l_mux2_1
X_13385__2037 _13385_/RESET_B VPWR VGND sg13cmos5l_tiehi
X_08416_ _08416_/X _13585_/Q _13553_/Q _08416_/S VPWR VGND sg13cmos5l_mux2_1
X_09396_ _13508_/D _09219_/A hold3232/X _09396_/S VPWR VGND sg13cmos5l_mux2_1
X_08347_ _08347_/Y _08398_/S _13388_/Q _08346_/Y VPWR VGND sg13cmos5l_o21ai_1
XFILLER_22_56 VPWR VGND sg13cmos5l_fill_1
X_08278_ _08278_/X _08272_/Y _08273_/Y _08379_/C1 VPWR VGND sg13cmos5l_a21o_1
X_07229_ _11950_/A _14357_/Q VPWR VGND sg13cmos5l_inv_1
X_10240_ _10240_/Y _10240_/A _10250_/B VPWR VGND sg13cmos5l_nor2_1
X_13728__1663 _13728_/RESET_B VPWR VGND sg13cmos5l_tiehi
XFILLER_79_606 VPWR VGND sg13cmos5l_decap_4
X_10171_ _10171_/Y _10171_/A _10171_/B VPWR VGND sg13cmos5l_nor2_1
Xfanout140 _10397_/A1 _09633_/Y VPWR VGND sg13cmos5l_buf_1
Xfanout173 _07533_/S _08421_/S VPWR VGND sg13cmos5l_buf_1
Xfanout162 _10763_/B fanout163/X VPWR VGND sg13cmos5l_buf_1
Xfanout151 _09012_/B _07623_/Y VPWR VGND sg13cmos5l_buf_1
X_14600__2143 _14600_/RESET_B VPWR VGND sg13cmos5l_tiehi
X_13930_ _13930_/Q _14020_/CLK _13930_/D _13930_/RESET_B VPWR VGND sg13cmos5l_dfrbpq_1
XFILLER_102_994 VPWR VGND sg13cmos5l_decap_8
XFILLER_86_160 VPWR VGND sg13cmos5l_fill_1
Xfanout195 _08199_/A1 _08244_/C VPWR VGND sg13cmos5l_buf_1
Xfanout184 _08281_/B _08430_/B VPWR VGND sg13cmos5l_buf_1
X_13595__1827 _13595_/RESET_B VPWR VGND sg13cmos5l_tiehi
XFILLER_47_97 VPWR VGND sg13cmos5l_fill_2
X_13861_ _13861_/Q clkload64/A _13861_/D _13861_/RESET_B VPWR VGND sg13cmos5l_dfrbpq_1
XFILLER_16_912 VPWR VGND sg13cmos5l_fill_2
XFILLER_90_826 VPWR VGND sg13cmos5l_fill_2
X_13792_ _13792_/Q clkload47/A _13792_/D _13792_/RESET_B VPWR VGND sg13cmos5l_dfrbpq_1
X_12812_ _14428_/D _12809_/Y _12811_/Y _12893_/B1 VPWR VGND sg13cmos5l_a21oi_1
XFILLER_15_422 VPWR VGND sg13cmos5l_fill_2
XFILLER_42_230 VPWR VGND sg13cmos5l_fill_2
X_12743_ _12744_/B _12743_/A _12743_/B VPWR VGND sg13cmos5l_nand2_1
XFILLER_15_466 VPWR VGND sg13cmos5l_fill_1
XFILLER_70_583 VPWR VGND sg13cmos5l_fill_1
X_14413_ _14413_/Q _14630_/CLK _14413_/D _14413_/RESET_B VPWR VGND sg13cmos5l_dfrbpq_1
X_12674_ _12697_/A _14447_/Q _13237_/Q VPWR VGND sg13cmos5l_and2_1
X_11625_ _11642_/A _11636_/A _14169_/Q VPWR VGND sg13cmos5l_and2_1
X_11556_ _11557_/C _11556_/A _11556_/B _11556_/C VPWR VGND sg13cmos5l_nor3_1
X_14344_ _14344_/Q _14621_/CLK _14344_/D _14344_/RESET_B VPWR VGND sg13cmos5l_dfrbpq_1
XFILLER_10_171 VPWR VGND sg13cmos5l_decap_4
X_10507_ _10507_/Y _10507_/A _10517_/B VPWR VGND sg13cmos5l_nand2_1
X_14275_ _14275_/Q clkload22/A _14275_/D _14275_/RESET_B VPWR VGND sg13cmos5l_dfrbpq_1
X_11487_ _11487_/Y _11514_/B VPWR VGND sg13cmos5l_inv_1
X_14190__1287 _14190_/RESET_B VPWR VGND sg13cmos5l_tiehi
X_13226_ _13226_/Q clkload43/A _13226_/D _13226_/RESET_B VPWR VGND sg13cmos5l_dfrbpq_1
X_10438_ _10438_/Y _10438_/A _10464_/B VPWR VGND sg13cmos5l_nor2_1
X_10369_ _13946_/D _10369_/A1 _10368_/B _10368_/Y VPWR VGND sg13cmos5l_a21oi_1
X_13157_ _13157_/Y _11192_/A _14179_/Q _13159_/B _14252_/Q _13164_/A2 VPWR VGND sg13cmos5l_a221oi_1
X_12108_ _12132_/A _11993_/A _12221_/A _12105_/Y VPWR VGND sg13cmos5l_a21oi_1
X_13088_ _14528_/D _13090_/B _13088_/B VPWR VGND sg13cmos5l_nor2_1
XFILLER_78_661 VPWR VGND sg13cmos5l_decap_8
XFILLER_78_672 VPWR VGND sg13cmos5l_fill_2
X_12039_ _12039_/Y _12039_/A _12164_/C VPWR VGND sg13cmos5l_nand2_1
XFILLER_66_834 VPWR VGND sg13cmos5l_fill_1
Xclkbuf_4_1_0_clk clkload0/A clkbuf_0_clk/X VPWR VGND sg13cmos5l_buf_8
X_07580_ _07580_/Y _07372_/Y _08995_/B _07579_/Y VPWR VGND sg13cmos5l_o21ai_1
X_14394__1114 _14394_/RESET_B VPWR VGND sg13cmos5l_tiehi
X_09250_ _13375_/D _07973_/A hold3282/X _09268_/S VPWR VGND sg13cmos5l_mux2_1
X_13806__1585 _13806_/RESET_B VPWR VGND sg13cmos5l_tiehi
X_08201_ _08201_/X _13436_/Q _13404_/Q _13372_/Q _13340_/Q _08283_/S _08317_/A1 VPWR
+ VGND sg13cmos5l_mux4_1
X_09181_ _11573_/A _14339_/Q _09193_/B VPWR VGND sg13cmos5l_nand2_1
X_08132_ _08134_/B _13217_/Q _08133_/B VPWR VGND sg13cmos5l_nand2_1
X_13985__1406 _13985_/RESET_B VPWR VGND sg13cmos5l_tiehi
X_08063_ _09443_/A _08087_/A _08087_/B VPWR VGND sg13cmos5l_nor2_1
Xhold3202 hold3202/X _13527_/Q VPWR VGND sg13cmos5l_dlygate4sd3_1
Xhold3213 hold3213/X _13434_/Q VPWR VGND sg13cmos5l_dlygate4sd3_1
Xhold3224 hold3224/X _13523_/Q VPWR VGND sg13cmos5l_dlygate4sd3_1
XFILLER_0_329 VPWR VGND sg13cmos5l_fill_1
XFILLER_25_1010 VPWR VGND sg13cmos5l_fill_1
X_08965_ _08965_/Y _08975_/A _08965_/B VPWR VGND sg13cmos5l_nor2_1
Xhold2501 _10602_/A _14061_/Q VPWR VGND sg13cmos5l_dlygate4sd3_1
Xhold2512 _10115_/A _13822_/Q VPWR VGND sg13cmos5l_dlygate4sd3_1
Xhold3235 _13458_/D _09345_/X VPWR VGND sg13cmos5l_dlygate4sd3_1
Xhold3257 hold3257/X _13390_/Q VPWR VGND sg13cmos5l_dlygate4sd3_1
Xhold3246 hold3246/X _13551_/Q VPWR VGND sg13cmos5l_dlygate4sd3_1
X_07916_ _14571_/D _11020_/A _07915_/Y _07911_/A VPWR VGND sg13cmos5l_a21oi_1
Xhold2523 _10491_/A _14006_/Q VPWR VGND sg13cmos5l_dlygate4sd3_1
Xhold2534 hold2534/X _14593_/Q VPWR VGND sg13cmos5l_dlygate4sd3_1
Xhold2545 _14142_/D _10746_/Y VPWR VGND sg13cmos5l_dlygate4sd3_1
Xhold2556 _14153_/D _10779_/Y VPWR VGND sg13cmos5l_dlygate4sd3_1
Xhold3279 hold3279/X _13569_/Q VPWR VGND sg13cmos5l_dlygate4sd3_1
Xhold3268 hold3268/X _13557_/Q VPWR VGND sg13cmos5l_dlygate4sd3_1
XFILLER_69_694 VPWR VGND sg13cmos5l_fill_2
X_08896_ _08897_/C hold3453/X _08900_/A2 _08895_/Y VPWR VGND sg13cmos5l_a21oi_1
Xhold2567 _10234_/A _13880_/Q VPWR VGND sg13cmos5l_dlygate4sd3_1
Xhold2578 _10854_/A _14185_/Q VPWR VGND sg13cmos5l_dlygate4sd3_1
Xhold2589 _10341_/A _13933_/Q VPWR VGND sg13cmos5l_dlygate4sd3_1
XFILLER_29_569 VPWR VGND sg13cmos5l_fill_1
X_07847_ _08431_/C _14084_/Q _14083_/Q VPWR VGND sg13cmos5l_and2_1
X_07778_ _07779_/B _08562_/B _07777_/Y _07776_/Y VPWR VGND sg13cmos5l_o21ai_1
X_09517_ _09517_/Y _09517_/A _09544_/B VPWR VGND sg13cmos5l_nor2_1
XFILLER_52_583 VPWR VGND sg13cmos5l_fill_1
X_09448_ _13558_/D _10683_/A1 hold3253/X _09453_/S VPWR VGND sg13cmos5l_mux2_1
XFILLER_33_77 VPWR VGND sg13cmos5l_fill_1
X_09379_ _09379_/X _14100_/Q hold3205/X _09396_/S VPWR VGND sg13cmos5l_mux2_1
X_11410_ _11410_/Y _11416_/B VPWR VGND sg13cmos5l_inv_1
X_12390_ _12390_/Y _12387_/Y _12389_/Y _12364_/A VPWR VGND sg13cmos5l_a21oi_1
X_11341_ _14323_/D _11339_/Y _11340_/Y _11320_/Y VPWR VGND sg13cmos5l_o21ai_1
X_13503__1919 _13503_/RESET_B VPWR VGND sg13cmos5l_tiehi
XFILLER_106_541 VPWR VGND sg13cmos5l_fill_1
XFILLER_4_657 VPWR VGND sg13cmos5l_fill_1
X_11272_ _11272_/X _11329_/A _11272_/B VPWR VGND sg13cmos5l_xor2_1
X_14060_ _14060_/Q clkload61/A _14060_/D _14060_/RESET_B VPWR VGND sg13cmos5l_dfrbpq_1
XFILLER_3_178 VPWR VGND sg13cmos5l_fill_1
X_10223_ _13874_/D _10419_/A1 _10238_/B _10222_/Y VPWR VGND sg13cmos5l_a21oi_1
X_13011_ _13015_/B _14493_/Q _14494_/Q _13011_/C VPWR VGND sg13cmos5l_nand3_1
XFILLER_0_830 VPWR VGND sg13cmos5l_decap_8
XFILLER_0_841 VPWR VGND sg13cmos5l_fill_1
X_10154_ _13841_/D fanout56/X _10153_/B _10153_/Y VPWR VGND sg13cmos5l_o21ai_1
XFILLER_95_929 VPWR VGND sg13cmos5l_fill_2
X_14175__1302 _14175_/RESET_B VPWR VGND sg13cmos5l_tiehi
XFILLER_47_311 VPWR VGND sg13cmos5l_fill_1
XFILLER_75_631 VPWR VGND sg13cmos5l_fill_1
XFILLER_87_480 VPWR VGND sg13cmos5l_decap_8
X_10085_ _13807_/D fanout62/X _10088_/B _10084_/Y VPWR VGND sg13cmos5l_o21ai_1
XFILLER_75_664 VPWR VGND sg13cmos5l_fill_2
X_13913_ _13913_/Q clkload48/A _13913_/D _13913_/RESET_B VPWR VGND sg13cmos5l_dfrbpq_1
X_13844_ _13844_/Q clkload18/A _13844_/D _13844_/RESET_B VPWR VGND sg13cmos5l_dfrbpq_1
XFILLER_16_720 VPWR VGND sg13cmos5l_fill_2
XFILLER_90_667 VPWR VGND sg13cmos5l_fill_2
X_10987_ _11622_/B _10987_/A _10987_/B _10987_/C VPWR VGND sg13cmos5l_nand3_1
X_13775_ _13775_/Q clkload62/A _13775_/D _13775_/RESET_B VPWR VGND sg13cmos5l_dfrbpq_1
X_12726_ _12726_/Y _12715_/A _12725_/Y _12651_/Y VPWR VGND sg13cmos5l_o21ai_1
X_12657_ _12663_/C _12650_/X _12656_/Y _12643_/A VPWR VGND sg13cmos5l_o21ai_1
X_11608_ _11608_/X _11608_/A _11608_/B VPWR VGND sg13cmos5l_or2_1
X_14327_ _14327_/Q _14453_/CLK _14327_/D _14327_/RESET_B VPWR VGND sg13cmos5l_dfrbpq_1
X_12588_ _12588_/Y _12589_/A _13230_/Q VPWR VGND sg13cmos5l_nand2_1
X_11539_ _11539_/Y _11466_/A _11553_/A _11558_/B1 VPWR VGND sg13cmos5l_o21ai_1
X_14258_ _14258_/Q clkload65/A _14258_/D _14258_/RESET_B VPWR VGND sg13cmos5l_dfrbpq_1
X_14302__1206 _14302_/RESET_B VPWR VGND sg13cmos5l_tiehi
X_14189_ _14189_/Q _14614_/CLK _14189_/D _14189_/RESET_B VPWR VGND sg13cmos5l_dfrbpq_1
X_13209_ _13209_/Q _14577_/CLK _13209_/D fanout964/X VPWR VGND sg13cmos5l_dfrbpq_1
XFILLER_98_734 VPWR VGND sg13cmos5l_fill_1
Xfanout909 _10685_/A1 _14105_/Q VPWR VGND sg13cmos5l_buf_1
XFILLER_79_970 VPWR VGND sg13cmos5l_decap_4
X_08750_ _08750_/Y _08745_/Y _08749_/Y _08741_/Y VPWR VGND sg13cmos5l_a21oi_1
XFILLER_54_804 VPWR VGND sg13cmos5l_decap_4
XFILLER_66_642 VPWR VGND sg13cmos5l_fill_2
XFILLER_66_653 VPWR VGND sg13cmos5l_fill_2
XFILLER_94_973 VPWR VGND sg13cmos5l_decap_4
X_07701_ _08490_/A _14383_/Q _14351_/Q VPWR VGND sg13cmos5l_nand2_1
X_08681_ _08683_/B _14035_/Q _11749_/B VPWR VGND sg13cmos5l_nand2_1
X_07632_ _07633_/B _08984_/A _07632_/B VPWR VGND sg13cmos5l_xnor2_1
XFILLER_80_144 VPWR VGND sg13cmos5l_fill_1
X_07563_ _08974_/B _08970_/A _12963_/C VPWR VGND sg13cmos5l_nor2_1
X_09302_ _09302_/Y _09302_/A _09307_/B VPWR VGND sg13cmos5l_nor2_1
XFILLER_34_572 VPWR VGND sg13cmos5l_fill_1
XFILLER_34_594 VPWR VGND sg13cmos5l_fill_1
X_07494_ _07494_/Y _08227_/A2 _07492_/Y _07526_/A1 VPWR VGND sg13cmos5l_o21ai_1
X_09233_ _13359_/D _09304_/A hold3084/X _09234_/S VPWR VGND sg13cmos5l_mux2_1
X_09164_ _09164_/Y _14432_/Q _11530_/A VPWR VGND sg13cmos5l_nand2_1
X_08115_ _08116_/B _13210_/Q _08975_/A VPWR VGND sg13cmos5l_xnor2_1
X_09095_ _09095_/Y _09095_/A _09095_/B VPWR VGND sg13cmos5l_nor2_1
X_08046_ _08047_/B _08046_/A _08046_/B _08046_/C _08046_/D VPWR VGND sg13cmos5l_nor4_1
XFILLER_0_126 VPWR VGND sg13cmos5l_decap_8
Xhold3010 _09197_/A _13329_/Q VPWR VGND sg13cmos5l_dlygate4sd3_1
Xhold3021 hold3021/X _13442_/Q VPWR VGND sg13cmos5l_dlygate4sd3_1
Xhold3032 hold3032/X _14346_/Q VPWR VGND sg13cmos5l_dlygate4sd3_1
X_09997_ _09997_/Y _09997_/A _10009_/B VPWR VGND sg13cmos5l_nand2_1
Xhold2320 _10109_/A _13819_/Q VPWR VGND sg13cmos5l_dlygate4sd3_1
Xhold2331 _10117_/A _13823_/Q VPWR VGND sg13cmos5l_dlygate4sd3_1
Xhold3043 _09107_/A _13314_/Q VPWR VGND sg13cmos5l_dlygate4sd3_1
Xhold3054 hold3054/X _13515_/Q VPWR VGND sg13cmos5l_dlygate4sd3_1
Xhold3065 _09878_/A _13706_/Q VPWR VGND sg13cmos5l_dlygate4sd3_1
XFILLER_76_428 VPWR VGND sg13cmos5l_decap_8
X_08948_ _13262_/D _08039_/B hold3437/X _10778_/B VPWR VGND sg13cmos5l_mux2_1
Xhold2342 _10608_/A _14064_/Q VPWR VGND sg13cmos5l_dlygate4sd3_1
Xhold2353 _13275_/D _08983_/Y VPWR VGND sg13cmos5l_dlygate4sd3_1
Xhold2364 _10769_/A _14150_/Q VPWR VGND sg13cmos5l_dlygate4sd3_1
Xhold3076 hold3076/X _13449_/Q VPWR VGND sg13cmos5l_dlygate4sd3_1
Xhold3087 hold3087/X _14119_/Q VPWR VGND sg13cmos5l_dlygate4sd3_1
Xhold3098 hold3098/X _13414_/Q VPWR VGND sg13cmos5l_dlygate4sd3_1
XFILLER_57_642 VPWR VGND sg13cmos5l_decap_8
XFILLER_85_940 VPWR VGND sg13cmos5l_decap_4
X_08879_ _08879_/Y _08575_/B _08879_/A2 _08878_/Y VPWR VGND sg13cmos5l_o21ai_1
Xhold2375 _13027_/A _14501_/Q VPWR VGND sg13cmos5l_dlygate4sd3_1
Xhold2386 _10564_/A _14042_/Q VPWR VGND sg13cmos5l_dlygate4sd3_1
Xhold2397 _11604_/A _14341_/Q VPWR VGND sg13cmos5l_dlygate4sd3_1
X_10910_ _10910_/Y _10910_/A _10976_/B VPWR VGND sg13cmos5l_nand2_1
X_11890_ _11890_/Y _11887_/Y _11889_/Y _12012_/A1 VPWR VGND sg13cmos5l_a21oi_1
XFILLER_13_701 VPWR VGND sg13cmos5l_fill_1
X_10841_ _10844_/D _14271_/Q _14272_/Q _14273_/Q _10841_/D VPWR VGND sg13cmos5l_nor4_1
X_10772_ _10772_/Y _10772_/A _10772_/B VPWR VGND sg13cmos5l_nand2_1
X_13560_ _13560_/Q _14105_/CLK _13560_/D _13560_/RESET_B VPWR VGND sg13cmos5l_dfrbpq_1
XFILLER_44_98 VPWR VGND sg13cmos5l_fill_1
X_13491_ _13491_/Q _14292_/CLK _13491_/D _13491_/RESET_B VPWR VGND sg13cmos5l_dfrbpq_1
X_12511_ _12514_/A _14396_/Q _12511_/B VPWR VGND sg13cmos5l_nand2_1
XFILLER_100_60 VPWR VGND sg13cmos5l_fill_2
X_12442_ _14377_/D _11105_/A _12447_/S _12441_/Y _08736_/A VPWR VGND sg13cmos5l_a22oi_1
X_12373_ _12375_/B _13743_/Q _12373_/B VPWR VGND sg13cmos5l_nand2_1
X_11324_ _11363_/A _14093_/Q _11337_/B VPWR VGND sg13cmos5l_nand2_1
X_14112_ _14112_/Q clkload31/A _14112_/D _07198_/A VPWR VGND sg13cmos5l_dfrbpq_1
XFILLER_5_999 VPWR VGND sg13cmos5l_fill_2
X_11255_ _11255_/Y _11268_/B _11255_/B VPWR VGND sg13cmos5l_xnor2_1
X_14043_ _14043_/Q clkload48/A _14043_/D _14043_/RESET_B VPWR VGND sg13cmos5l_dfrbpq_1
XFILLER_106_371 VPWR VGND sg13cmos5l_fill_1
X_10206_ _13866_/D _10597_/A1 _10219_/B _10205_/Y VPWR VGND sg13cmos5l_a21oi_1
X_11186_ _11200_/A _14180_/Q _11214_/B VPWR VGND sg13cmos5l_nand2_1
XFILLER_0_671 VPWR VGND sg13cmos5l_fill_2
X_10137_ _10137_/Y _10137_/A _10137_/B VPWR VGND sg13cmos5l_nand2_1
X_13380__2042 _13380_/RESET_B VPWR VGND sg13cmos5l_tiehi
X_10068_ _10068_/Y _10068_/A _10078_/B VPWR VGND sg13cmos5l_nand2_1
XFILLER_36_815 VPWR VGND sg13cmos5l_fill_2
XFILLER_75_450 VPWR VGND sg13cmos5l_decap_8
XFILLER_76_984 VPWR VGND sg13cmos5l_decap_8
XFILLER_90_431 VPWR VGND sg13cmos5l_fill_1
XFILLER_51_818 VPWR VGND sg13cmos5l_fill_2
X_13827_ _13827_/Q clkload57/A _13827_/D _13827_/RESET_B VPWR VGND sg13cmos5l_dfrbpq_1
X_13758_ _13758_/Q clkload63/A _13758_/D _13758_/RESET_B VPWR VGND sg13cmos5l_dfrbpq_1
X_13687__1704 _13687_/RESET_B VPWR VGND sg13cmos5l_tiehi
XFILLER_43_391 VPWR VGND sg13cmos5l_fill_2
X_12709_ _14418_/D _12755_/A _12709_/B VPWR VGND sg13cmos5l_nor2_1
X_13689_ _13689_/Q clkload48/A _13689_/D _13689_/RESET_B VPWR VGND sg13cmos5l_dfrbpq_1
XFILLER_102_1001 VPWR VGND sg13cmos5l_decap_8
X_09920_ _09920_/Y _09920_/A _09942_/B VPWR VGND sg13cmos5l_nor2_1
X_13590__1832 _13590_/RESET_B VPWR VGND sg13cmos5l_tiehi
Xfanout706 _11358_/B _11436_/B VPWR VGND sg13cmos5l_buf_1
XFILLER_59_929 VPWR VGND sg13cmos5l_decap_8
X_09851_ _13692_/D _10308_/A1 _09862_/B _09850_/Y VPWR VGND sg13cmos5l_a21oi_1
Xfanout739 _12364_/A _07940_/B VPWR VGND sg13cmos5l_buf_1
Xfanout728 _08905_/A2 _07879_/X VPWR VGND sg13cmos5l_buf_1
Xfanout717 _08831_/B1 _08840_/B VPWR VGND sg13cmos5l_buf_1
XFILLER_105_16 VPWR VGND sg13cmos5l_fill_2
XFILLER_105_27 VPWR VGND sg13cmos5l_fill_1
XFILLER_58_417 VPWR VGND sg13cmos5l_decap_8
X_08802_ _08802_/Y _07833_/A _08875_/B _08801_/Y VPWR VGND sg13cmos5l_o21ai_1
X_09782_ _13658_/D _10565_/A1 _09801_/B _09781_/Y VPWR VGND sg13cmos5l_a21oi_1
XFILLER_67_940 VPWR VGND sg13cmos5l_fill_1
X_08733_ _08736_/A _08732_/Y _12449_/A VPWR VGND sg13cmos5l_nand2b_1
XFILLER_54_612 VPWR VGND sg13cmos5l_decap_4
XFILLER_66_450 VPWR VGND sg13cmos5l_fill_2
XFILLER_82_910 VPWR VGND sg13cmos5l_fill_1
XFILLER_85_269 VPWR VGND sg13cmos5l_fill_1
XFILLER_54_656 VPWR VGND sg13cmos5l_fill_1
XFILLER_82_954 VPWR VGND sg13cmos5l_decap_4
XFILLER_82_965 VPWR VGND sg13cmos5l_fill_1
X_08664_ _08667_/A _13842_/Q _11725_/B VPWR VGND sg13cmos5l_nor2_1
X_07615_ _07619_/B _13280_/Q _13281_/Q VPWR VGND sg13cmos5l_xor2_1
X_08595_ _08609_/C _08885_/A _08595_/B VPWR VGND sg13cmos5l_nor2_1
X_07546_ _07547_/C _07546_/A _07546_/B _07546_/C _07546_/D VPWR VGND sg13cmos5l_nor4_1
XFILLER_50_862 VPWR VGND sg13cmos5l_fill_1
X_07477_ _07477_/X _13426_/Q _13394_/Q _13362_/Q _13330_/Q _08164_/S0 _08254_/A1 VPWR
+ VGND sg13cmos5l_mux4_1
X_09216_ _13345_/D _08206_/A hold3174/X _09230_/B VPWR VGND sg13cmos5l_mux2_1
X_09147_ _09147_/Y _11483_/A _09146_/Y _09160_/A2 VPWR VGND sg13cmos5l_a21oi_1
X_09078_ _13309_/D _09077_/B _09076_/Y _09077_/Y VPWR VGND sg13cmos5l_a21oi_1
X_08029_ _08030_/C _14553_/Q _08040_/B VPWR VGND sg13cmos5l_xnor2_1
XFILLER_1_457 VPWR VGND sg13cmos5l_fill_2
X_11040_ _11040_/Y _11040_/A _11040_/B _11040_/C _11040_/D VPWR VGND sg13cmos5l_nand4_1
XFILLER_49_428 VPWR VGND sg13cmos5l_decap_8
X_13765__1626 _13765_/RESET_B VPWR VGND sg13cmos5l_tiehi
X_13801__1590 _13801_/RESET_B VPWR VGND sg13cmos5l_tiehi
X_13453__1969 _13453_/RESET_B VPWR VGND sg13cmos5l_tiehi
X_12991_ _12991_/X _12991_/A _12991_/B VPWR VGND sg13cmos5l_xor2_1
XFILLER_17_336 VPWR VGND sg13cmos5l_fill_2
X_11942_ _11942_/X _13760_/Q _13728_/Q _11945_/S VPWR VGND sg13cmos5l_mux2_1
XFILLER_55_75 VPWR VGND sg13cmos5l_fill_2
XFILLER_55_86 VPWR VGND sg13cmos5l_fill_2
XFILLER_72_442 VPWR VGND sg13cmos5l_fill_2
X_11873_ _11874_/A _11873_/A _11873_/B VPWR VGND sg13cmos5l_and2_1
X_10824_ _14172_/D _14252_/D hold3400/X _10832_/S VPWR VGND sg13cmos5l_mux2_1
X_14592_ _14592_/Q clkload69/A _14592_/D _14592_/RESET_B VPWR VGND sg13cmos5l_dfrbpq_1
X_13980__1411 _13980_/RESET_B VPWR VGND sg13cmos5l_tiehi
X_13612_ _13612_/Q clkload61/A _13612_/D _13612_/RESET_B VPWR VGND sg13cmos5l_dfrbpq_1
XFILLER_13_542 VPWR VGND sg13cmos5l_fill_1
XFILLER_25_380 VPWR VGND sg13cmos5l_fill_1
XFILLER_71_30 VPWR VGND sg13cmos5l_fill_1
X_13543_ _13543_/Q clkload28/A _13543_/D _13543_/RESET_B VPWR VGND sg13cmos5l_dfrbpq_1
X_10755_ _10755_/Y _10802_/B _10753_/Y _10754_/Y VPWR VGND sg13cmos5l_o21ai_1
X_10686_ _14106_/D input15/X _08157_/A _10692_/S VPWR VGND sg13cmos5l_mux2_1
X_13474_ _13474_/Q clkload41/A _13474_/D _13474_/RESET_B VPWR VGND sg13cmos5l_dfrbpq_1
X_13398__2024 _13398_/RESET_B VPWR VGND sg13cmos5l_tiehi
X_12425_ _12425_/Y _13905_/Q _12427_/A2 _12428_/B1 _13713_/Q _12425_/C1 VPWR VGND
+ sg13cmos5l_a221oi_1
XFILLER_5_730 VPWR VGND sg13cmos5l_fill_2
X_12356_ _12356_/Y _12385_/A _12356_/B _12356_/C _12356_/D VPWR VGND sg13cmos5l_nor4_1
X_11307_ _11307_/Y _11307_/A _11307_/B VPWR VGND sg13cmos5l_nand2_1
XFILLER_45_1002 VPWR VGND sg13cmos5l_fill_2
X_12287_ _12287_/Y _13740_/Q _12292_/B _12260_/B _13804_/Q VPWR VGND sg13cmos5l_a22oi_1
X_11238_ _11239_/B _14086_/Q _11214_/D _11228_/B _14087_/Q VPWR VGND sg13cmos5l_a22oi_1
X_14026_ _14026_/Q clkload51/A _14026_/D _14026_/RESET_B VPWR VGND sg13cmos5l_dfrbpq_1
XFILLER_68_726 VPWR VGND sg13cmos5l_fill_1
X_11169_ _11170_/B _11193_/A _11192_/A _14178_/Q VPWR VGND sg13cmos5l_nand3_1
XFILLER_49_995 VPWR VGND sg13cmos5l_fill_1
XFILLER_64_910 VPWR VGND sg13cmos5l_fill_1
XFILLER_83_718 VPWR VGND sg13cmos5l_fill_2
X_13429__1993 _13429_/RESET_B VPWR VGND sg13cmos5l_tiehi
XFILLER_64_965 VPWR VGND sg13cmos5l_fill_1
X_07400_ _07402_/C _07400_/A _07400_/B _07595_/A _07409_/B VPWR VGND sg13cmos5l_nor4_1
X_08380_ _12595_/A _08356_/C _08369_/X _08379_/Y VPWR VGND sg13cmos5l_a21oi_1
X_07331_ _07331_/Y _14135_/Q VPWR VGND sg13cmos5l_inv_1
X_07262_ _07262_/Y _14576_/Q VPWR VGND sg13cmos5l_inv_1
X_07193_ _13008_/A _14492_/Q VPWR VGND sg13cmos5l_inv_1
X_09001_ _09002_/B _08960_/B _09001_/B _09001_/C VPWR VGND sg13cmos5l_nand3b_1
X_13843__1548 _13843_/RESET_B VPWR VGND sg13cmos5l_tiehi
X_09903_ _13717_/D _10425_/A1 _09922_/B _09902_/Y VPWR VGND sg13cmos5l_a21oi_1
Xfanout514 _12319_/A2 _12010_/A2 VPWR VGND sg13cmos5l_buf_1
Xfanout503 _12292_/B _12428_/A2 VPWR VGND sg13cmos5l_buf_1
X_09834_ _09834_/Y _09834_/A _09844_/B VPWR VGND sg13cmos5l_nor2_1
Xfanout547 _09639_/A _09640_/A1 VPWR VGND sg13cmos5l_buf_1
Xfanout536 _11816_/B1 _11840_/A VPWR VGND sg13cmos5l_buf_1
Xfanout525 _07530_/A2 _07432_/Y VPWR VGND sg13cmos5l_buf_1
Xfanout569 _12349_/C1 _12203_/A2 VPWR VGND sg13cmos5l_buf_1
Xfanout558 _08911_/B _08787_/Y VPWR VGND sg13cmos5l_buf_1
X_09765_ _09765_/Y _09765_/A _09801_/B VPWR VGND sg13cmos5l_nor2_1
XFILLER_26_100 VPWR VGND sg13cmos5l_fill_2
XFILLER_55_932 VPWR VGND sg13cmos5l_fill_1
X_08716_ _14621_/D _08716_/A _08716_/B VPWR VGND sg13cmos5l_nand2_1
X_09696_ _10221_/A _10351_/B _10351_/A VPWR VGND sg13cmos5l_nand2b_1
XFILLER_15_818 VPWR VGND sg13cmos5l_fill_1
XFILLER_54_431 VPWR VGND sg13cmos5l_fill_2
XFILLER_54_464 VPWR VGND sg13cmos5l_fill_1
XFILLER_66_291 VPWR VGND sg13cmos5l_fill_2
XFILLER_82_762 VPWR VGND sg13cmos5l_decap_4
X_08647_ _08652_/A _08646_/A _07266_/Y _08646_/Y VPWR VGND sg13cmos5l_o21ai_1
XFILLER_25_78 VPWR VGND sg13cmos5l_fill_1
XFILLER_42_648 VPWR VGND sg13cmos5l_fill_2
XFILLER_70_968 VPWR VGND sg13cmos5l_decap_4
X_08578_ _08578_/Y _08582_/D _08577_/Y _08564_/Y VPWR VGND sg13cmos5l_o21ai_1
XFILLER_50_670 VPWR VGND sg13cmos5l_fill_2
X_07529_ _07529_/Y _07529_/A _07529_/B VPWR VGND sg13cmos5l_nand2_1
X_10540_ _14030_/D fanout74/X _10539_/B _10539_/Y VPWR VGND sg13cmos5l_o21ai_1
X_10471_ _13996_/D fanout77/X _10470_/B _10470_/Y VPWR VGND sg13cmos5l_a21oi_1
X_12210_ _12210_/Y _12202_/Y _12203_/Y _12209_/Y VPWR VGND sg13cmos5l_o21ai_1
X_13819__1572 _13819_/RESET_B VPWR VGND sg13cmos5l_tiehi
X_13190_ _13241_/D _11926_/B _13194_/A2 _13190_/B1 _13189_/Y VPWR VGND sg13cmos5l_a22oi_1
X_12141_ _12141_/Y _12137_/Y _12138_/Y _12139_/Y _12140_/Y VPWR VGND sg13cmos5l_a22oi_1
XFILLER_89_350 VPWR VGND sg13cmos5l_fill_1
X_12072_ _12072_/Y _14455_/Q _12302_/A2 _12070_/Y _12071_/Y VPWR VGND sg13cmos5l_a22oi_1
X_14330__1178 _14330_/RESET_B VPWR VGND sg13cmos5l_tiehi
XFILLER_1_265 VPWR VGND sg13cmos5l_fill_2
XFILLER_89_372 VPWR VGND sg13cmos5l_fill_1
X_11023_ _11025_/C _14168_/Q _11671_/B _11022_/Y VPWR VGND sg13cmos5l_a21oi_1
XFILLER_58_770 VPWR VGND sg13cmos5l_fill_1
XFILLER_17_111 VPWR VGND sg13cmos5l_fill_2
XFILLER_58_792 VPWR VGND sg13cmos5l_decap_8
X_12974_ _12977_/B _14475_/Q _12975_/B VPWR VGND sg13cmos5l_and2_1
XFILLER_33_604 VPWR VGND sg13cmos5l_fill_2
X_11925_ _14355_/D _07751_/B _11979_/A _11906_/Y _11924_/Y VPWR VGND sg13cmos5l_a22oi_1
XFILLER_61_924 VPWR VGND sg13cmos5l_fill_2
XFILLER_75_1028 VPWR VGND sg13cmos5l_fill_1
XFILLER_33_659 VPWR VGND sg13cmos5l_fill_2
X_11856_ _11856_/Y _11852_/Y _11853_/Y _11854_/Y _11855_/Y _11865_/A VPWR VGND sg13cmos5l_a221oi_1
X_14644_ _14644_/Q clkload75/A _14644_/D _14644_/RESET_B VPWR VGND sg13cmos5l_dfrbpq_1
XFILLER_60_467 VPWR VGND sg13cmos5l_fill_2
X_10807_ _10807_/Y _10807_/A _12963_/B VPWR VGND sg13cmos5l_nor2_1
X_11787_ _11787_/Y _12245_/B2 _11784_/Y _11785_/Y _11786_/Y _08674_/A VPWR VGND sg13cmos5l_a221oi_1
X_14575_ _14575_/Q _14576_/CLK _14575_/D fanout979/X VPWR VGND sg13cmos5l_dfrbpq_1
X_10738_ _10738_/Y _10798_/A _14284_/Q VPWR VGND sg13cmos5l_nand2_1
X_13526_ _13526_/Q clkload27/A _13526_/D _13526_/RESET_B VPWR VGND sg13cmos5l_dfrbpq_1
X_13457_ _13457_/Q clkload35/A _13457_/D _13457_/RESET_B VPWR VGND sg13cmos5l_dfrbpq_1
X_10669_ _14092_/D _07265_/Y _10826_/S _10668_/Y VPWR VGND sg13cmos5l_a21oi_1
X_12408_ _12409_/B _12408_/A1 _12542_/B _12407_/Y VPWR VGND sg13cmos5l_o21ai_1
X_13388_ _13388_/Q _14238_/CLK _13388_/D _13388_/RESET_B VPWR VGND sg13cmos5l_dfrbpq_1
XFILLER_5_582 VPWR VGND sg13cmos5l_fill_1
X_12339_ _12339_/Y _14062_/Q _12348_/A2 _12346_/A2 _13742_/Q VPWR VGND sg13cmos5l_a22oi_1
Xhold2908 _09868_/A _13701_/Q VPWR VGND sg13cmos5l_dlygate4sd3_1
Xhold2919 _12984_/A _14480_/Q VPWR VGND sg13cmos5l_dlygate4sd3_1
X_14009_ _14009_/Q clkload17/A _14009_/D _14009_/RESET_B VPWR VGND sg13cmos5l_dfrbpq_1
X_07880_ _07893_/A _10927_/A _10925_/A VPWR VGND sg13cmos5l_nor2_1
X_13516__1906 _13516_/RESET_B VPWR VGND sg13cmos5l_tiehi
X_09550_ _09550_/Y _09556_/A _09549_/X _09548_/Y VPWR VGND sg13cmos5l_o21ai_1
X_08501_ _08502_/B _07706_/Y _08488_/C _07749_/Y VPWR VGND sg13cmos5l_o21ai_1
X_09481_ _09829_/C _14235_/Q _14234_/Q _10155_/C VPWR VGND sg13cmos5l_nand3_1
XFILLER_52_913 VPWR VGND sg13cmos5l_fill_1
XFILLER_64_773 VPWR VGND sg13cmos5l_fill_1
XFILLER_91_570 VPWR VGND sg13cmos5l_fill_1
X_08432_ _08432_/Y _14241_/Q _11029_/C VPWR VGND sg13cmos5l_nor2_1
XFILLER_23_114 VPWR VGND sg13cmos5l_fill_1
XFILLER_63_283 VPWR VGND sg13cmos5l_fill_2
XFILLER_23_169 VPWR VGND sg13cmos5l_fill_1
X_08363_ _08364_/B _13581_/Q _13549_/Q _08363_/S VPWR VGND sg13cmos5l_mux2_1
X_07314_ _07314_/Y _13354_/Q VPWR VGND sg13cmos5l_inv_1
X_08294_ _08294_/Y _13156_/A _08430_/B VPWR VGND sg13cmos5l_nand2_1
X_07245_ _11105_/A _14377_/Q VPWR VGND sg13cmos5l_inv_1
XFILLER_106_915 VPWR VGND sg13cmos5l_decap_8
X_07176_ _09534_/C _14443_/Q VPWR VGND sg13cmos5l_inv_1
Xfanout322 _09724_/B _09726_/B VPWR VGND sg13cmos5l_buf_1
Xfanout311 _09773_/B _09813_/B VPWR VGND sg13cmos5l_buf_1
Xfanout300 fanout300/X _09895_/Y VPWR VGND sg13cmos5l_buf_1
XFILLER_101_642 VPWR VGND sg13cmos5l_fill_2
XFILLER_87_832 VPWR VGND sg13cmos5l_fill_2
Xfanout366 _09197_/B fanout367/X VPWR VGND sg13cmos5l_buf_1
Xfanout355 _13190_/B1 _13196_/B1 VPWR VGND sg13cmos5l_buf_1
Xfanout344 _09511_/B _09544_/B VPWR VGND sg13cmos5l_buf_1
Xfanout333 _10496_/A1 _09523_/Y VPWR VGND sg13cmos5l_buf_1
XFILLER_59_578 VPWR VGND sg13cmos5l_fill_2
X_09817_ _09817_/Y _09817_/A _09817_/B VPWR VGND sg13cmos5l_nor2_1
Xfanout399 _12639_/C _11153_/X VPWR VGND sg13cmos5l_buf_1
Xfanout388 _11686_/B _12353_/B VPWR VGND sg13cmos5l_buf_1
Xfanout377 _10614_/S _07402_/Y VPWR VGND sg13cmos5l_buf_1
X_09748_ _09748_/Y _09748_/A _09748_/B VPWR VGND sg13cmos5l_nor2_1
XFILLER_27_464 VPWR VGND sg13cmos5l_fill_1
X_09679_ _09679_/Y _09691_/A _11572_/B _09678_/Y VPWR VGND sg13cmos5l_a21oi_1
X_11710_ _11741_/A _11711_/A _13233_/Q VPWR VGND sg13cmos5l_nand2_1
XFILLER_42_445 VPWR VGND sg13cmos5l_decap_4
X_12690_ _12690_/Y _12676_/Y _12680_/Y _12697_/A VPWR VGND sg13cmos5l_a21oi_1
XFILLER_30_629 VPWR VGND sg13cmos5l_fill_2
X_11641_ _11642_/B _11641_/A _13228_/Q VPWR VGND sg13cmos5l_xor2_1
X_11572_ _11573_/B _11605_/A _11572_/B VPWR VGND sg13cmos5l_nand2_1
X_14360_ _14360_/Q clkload76/A _14360_/D _14360_/RESET_B VPWR VGND sg13cmos5l_dfrbpq_1
X_10523_ _10523_/Y _10523_/A _10537_/B VPWR VGND sg13cmos5l_nand2_1
Xinput19 input19/X uio_in[1] VPWR VGND sg13cmos5l_buf_1
X_13311_ _13311_/Q clkload67/A _13311_/D _13311_/RESET_B VPWR VGND sg13cmos5l_dfrbpq_1
X_14291_ _14291_/Q clkload23/A _14291_/D _14291_/RESET_B VPWR VGND sg13cmos5l_dfrbpq_1
X_10454_ _10454_/Y _10454_/A _10480_/B VPWR VGND sg13cmos5l_nor2_1
X_13242_ _13242_/Q clkload66/A _13242_/D _13242_/RESET_B VPWR VGND sg13cmos5l_dfrbpq_1
X_10385_ _13954_/D _10385_/A1 _10384_/B _10384_/Y VPWR VGND sg13cmos5l_a21oi_1
X_13173_ _13234_/D _13180_/B _13171_/Y _13172_/Y VPWR VGND sg13cmos5l_a21oi_1
X_12124_ _12124_/Y _12071_/A _12124_/A2 _12162_/B VPWR VGND sg13cmos5l_a21oi_1
XFILLER_105_981 VPWR VGND sg13cmos5l_decap_8
XFILLER_77_73 VPWR VGND sg13cmos5l_fill_2
X_12055_ _12055_/Y _13988_/Q _12055_/B VPWR VGND sg13cmos5l_nand2_1
XFILLER_65_515 VPWR VGND sg13cmos5l_decap_8
XFILLER_78_898 VPWR VGND sg13cmos5l_fill_2
XFILLER_93_802 VPWR VGND sg13cmos5l_fill_2
XFILLER_93_813 VPWR VGND sg13cmos5l_fill_2
X_11006_ _14236_/D _07939_/C _11005_/Y _10998_/A VPWR VGND sg13cmos5l_a21oi_1
XFILLER_65_559 VPWR VGND sg13cmos5l_fill_2
X_12957_ _12958_/A hold3546/X _11604_/B _11587_/B _12961_/B2 VPWR VGND sg13cmos5l_a22oi_1
XFILLER_45_294 VPWR VGND sg13cmos5l_fill_2
X_11908_ _11908_/Y _13727_/Q _11944_/A1 _11944_/B2 _13983_/Q _11695_/B VPWR VGND sg13cmos5l_a221oi_1
X_12888_ _12895_/B _12888_/A _12888_/B VPWR VGND sg13cmos5l_and2_1
X_11839_ _12673_/B _14351_/Q _11867_/B VPWR VGND sg13cmos5l_nand2_1
X_14627_ _14627_/Q clkload36/A _14627_/D _14627_/RESET_B VPWR VGND sg13cmos5l_dfrbpq_1
XFILLER_20_117 VPWR VGND sg13cmos5l_fill_1
XFILLER_61_798 VPWR VGND sg13cmos5l_fill_2
X_14558_ _14558_/Q clkload21/A _14558_/D fanout983/X VPWR VGND sg13cmos5l_dfrbpq_1
X_14489_ _14489_/Q clkload9/A _14489_/D fanout965/X VPWR VGND sg13cmos5l_dfrbpq_1
X_13509_ _13509_/Q clkload35/A _13509_/D _13509_/RESET_B VPWR VGND sg13cmos5l_dfrbpq_1
X_13760__1631 _13760_/RESET_B VPWR VGND sg13cmos5l_tiehi
XFILLER_47_0 VPWR VGND sg13cmos5l_fill_2
Xhold3406 hold3406/X _14596_/Q VPWR VGND sg13cmos5l_dlygate4sd3_1
X_08981_ _08981_/Y _13295_/Q _08996_/B _08980_/Y VPWR VGND sg13cmos5l_a21oi_1
Xhold2705 _13010_/A _14493_/Q VPWR VGND sg13cmos5l_dlygate4sd3_1
Xhold3439 hold3439/X _13215_/Q VPWR VGND sg13cmos5l_dlygate4sd3_1
Xhold3428 hold3428/X _13269_/Q VPWR VGND sg13cmos5l_dlygate4sd3_1
Xhold3417 _08850_/A _14597_/Q VPWR VGND sg13cmos5l_dlygate4sd3_1
X_07932_ _11012_/B _07933_/A _11024_/A VPWR VGND sg13cmos5l_nand2_1
Xhold2716 _10948_/A _14217_/Q VPWR VGND sg13cmos5l_dlygate4sd3_1
Xhold2727 _10470_/A _13996_/Q VPWR VGND sg13cmos5l_dlygate4sd3_1
Xhold2738 _09629_/A _13608_/Q VPWR VGND sg13cmos5l_dlygate4sd3_1
XFILLER_3_92 VPWR VGND sg13cmos5l_fill_1
XFILLER_56_504 VPWR VGND sg13cmos5l_fill_2
X_07863_ _07864_/B _14239_/Q _11014_/A _11008_/A VPWR VGND sg13cmos5l_nor3_1
Xhold2749 _09544_/A _13595_/Q VPWR VGND sg13cmos5l_dlygate4sd3_1
X_13793__1598 _13793_/RESET_B VPWR VGND sg13cmos5l_tiehi
XFILLER_68_386 VPWR VGND sg13cmos5l_decap_4
X_09602_ _11408_/B _14424_/Q _14643_/Q _09615_/S VPWR VGND sg13cmos5l_mux2_1
X_07794_ _08593_/A _08594_/A _08881_/A VPWR VGND sg13cmos5l_or2_1
X_09533_ _09535_/B _14444_/Q _09522_/B _14445_/Q VPWR VGND sg13cmos5l_a21oi_1
XFILLER_64_570 VPWR VGND sg13cmos5l_decap_8
X_09464_ _09464_/X _14119_/Q hold3059/X _09475_/S VPWR VGND sg13cmos5l_mux2_1
XFILLER_51_253 VPWR VGND sg13cmos5l_fill_2
X_08415_ _08415_/X _08416_/S _13457_/Q VPWR VGND sg13cmos5l_or2_1
X_09395_ _09395_/X _14116_/Q hold3148/X _09401_/S VPWR VGND sg13cmos5l_mux2_1
X_08346_ _08346_/Y _08398_/S _07318_/Y _08404_/B1 VPWR VGND sg13cmos5l_a21oi_1
XFILLER_20_651 VPWR VGND sg13cmos5l_decap_4
X_08277_ _08277_/Y _08277_/A1 _08275_/X _08276_/Y _08274_/X _08391_/B1 VPWR VGND sg13cmos5l_a221oi_1
X_07228_ _07228_/Y _14358_/Q VPWR VGND sg13cmos5l_inv_1
XFILLER_106_745 VPWR VGND sg13cmos5l_decap_8
X_10170_ _13848_/D _10496_/A1 _10169_/B _10169_/Y VPWR VGND sg13cmos5l_a21oi_1
Xfanout130 _09376_/S _09375_/S VPWR VGND sg13cmos5l_buf_1
XFILLER_87_662 VPWR VGND sg13cmos5l_fill_1
Xfanout174 _08368_/S _08421_/S VPWR VGND sg13cmos5l_buf_1
Xfanout163 fanout163/X _10799_/B VPWR VGND sg13cmos5l_buf_1
Xfanout152 _10583_/A1 _10453_/A1 VPWR VGND sg13cmos5l_buf_1
Xfanout141 _10593_/A1 _09633_/Y VPWR VGND sg13cmos5l_buf_1
XFILLER_86_183 VPWR VGND sg13cmos5l_fill_2
Xfanout196 _08244_/C _07423_/Y VPWR VGND sg13cmos5l_buf_1
Xfanout185 _08430_/B _08098_/B VPWR VGND sg13cmos5l_buf_1
X_13623__1768 _13623_/RESET_B VPWR VGND sg13cmos5l_tiehi
X_13860_ _13860_/Q clkload52/A _13860_/D _13860_/RESET_B VPWR VGND sg13cmos5l_dfrbpq_1
X_13791_ _13791_/Q clkload60/A _13791_/D _13791_/RESET_B VPWR VGND sg13cmos5l_dfrbpq_1
X_12811_ _12811_/Y fanout59/X _12810_/X _12192_/Y VPWR VGND sg13cmos5l_a21oi_1
X_12742_ _12743_/B _12742_/A _12731_/Y VPWR VGND sg13cmos5l_nor2b_1
XFILLER_30_404 VPWR VGND sg13cmos5l_fill_2
X_14003__1388 _14003_/RESET_B VPWR VGND sg13cmos5l_tiehi
X_12673_ _14415_/D _12686_/A _12673_/B _12673_/C _12673_/D VPWR VGND sg13cmos5l_nand4_1
XFILLER_63_97 VPWR VGND sg13cmos5l_fill_2
X_11624_ _11624_/Y _11638_/B _11624_/B VPWR VGND sg13cmos5l_nand2_1
X_14412_ _14412_/Q _14630_/CLK _14412_/D _14412_/RESET_B VPWR VGND sg13cmos5l_dfrbpq_1
X_11555_ _11566_/A _11555_/A _11555_/B _11555_/C _11575_/B VPWR VGND sg13cmos5l_nand4_1
X_14343_ _14343_/Q _14621_/CLK _14343_/D _14343_/RESET_B VPWR VGND sg13cmos5l_dfrbpq_1
X_10506_ _14013_/D _10571_/A1 _10511_/B _10505_/Y VPWR VGND sg13cmos5l_o21ai_1
X_11486_ _11514_/B _11460_/A _11486_/B VPWR VGND sg13cmos5l_nand2b_1
X_14274_ _14274_/Q clkload38/A _14274_/D _14274_/RESET_B VPWR VGND sg13cmos5l_dfrbpq_1
X_10437_ _13979_/D _10567_/A1 _10436_/B _10436_/Y VPWR VGND sg13cmos5l_a21oi_1
X_13225_ _13225_/Q _14576_/CLK _13225_/D fanout979/X VPWR VGND sg13cmos5l_dfrbpq_1
XFILLER_98_905 VPWR VGND sg13cmos5l_fill_1
XFILLER_3_850 VPWR VGND sg13cmos5l_fill_1
XFILLER_97_404 VPWR VGND sg13cmos5l_fill_2
X_10368_ _10368_/Y _10368_/A _10368_/B VPWR VGND sg13cmos5l_nor2_1
X_13156_ _13156_/Y _13156_/A _13162_/B VPWR VGND sg13cmos5l_nand2_1
X_10299_ _10299_/Y _10299_/A _10299_/B VPWR VGND sg13cmos5l_nor2_1
X_12107_ _12221_/A _12107_/A _12107_/B VPWR VGND sg13cmos5l_and2_1
X_13087_ _13087_/Y _14527_/Q _13086_/C hold2889/X VPWR VGND sg13cmos5l_a21oi_1
X_12038_ _12038_/Y _07228_/Y _12124_/A2 _12162_/B VPWR VGND sg13cmos5l_a21oi_1
X_13989_ _13989_/Q _14028_/CLK _13989_/D _13989_/RESET_B VPWR VGND sg13cmos5l_dfrbpq_1
XFILLER_21_404 VPWR VGND sg13cmos5l_fill_1
X_13778__1613 _13778_/RESET_B VPWR VGND sg13cmos5l_tiehi
XFILLER_22_938 VPWR VGND sg13cmos5l_fill_2
X_08200_ _08200_/X _13564_/Q _13532_/Q _13500_/Q _13468_/Q _08283_/S _08200_/S1 VPWR
+ VGND sg13cmos5l_mux4_1
X_13466__1956 _13466_/RESET_B VPWR VGND sg13cmos5l_tiehi
X_09180_ _13326_/D _09197_/B _09178_/Y _09179_/Y VPWR VGND sg13cmos5l_a21oi_1
X_08131_ _08131_/Y _07195_/Y _08127_/Y _08133_/B VPWR VGND sg13cmos5l_a21oi_1
X_08062_ _08087_/B _07369_/A _13271_/Q _08062_/S VPWR VGND sg13cmos5l_mux2_1
Xhold3203 hold3203/X _13396_/Q VPWR VGND sg13cmos5l_dlygate4sd3_1
Xhold3214 hold3214/X _13354_/Q VPWR VGND sg13cmos5l_dlygate4sd3_1
X_08964_ _08965_/B _08964_/A _08964_/B VPWR VGND sg13cmos5l_xor2_1
Xhold2502 _11560_/A _14338_/Q VPWR VGND sg13cmos5l_dlygate4sd3_1
Xhold2513 _10078_/A _13804_/Q VPWR VGND sg13cmos5l_dlygate4sd3_1
Xhold3225 _13058_/A _15893_/A VPWR VGND sg13cmos5l_dlygate4sd3_1
Xhold3236 hold3236/X _14587_/Q VPWR VGND sg13cmos5l_dlygate4sd3_1
Xhold3258 hold3258/X _13497_/Q VPWR VGND sg13cmos5l_dlygate4sd3_1
Xhold3247 hold3247/X _13472_/Q VPWR VGND sg13cmos5l_dlygate4sd3_1
XFILLER_97_960 VPWR VGND sg13cmos5l_fill_1
X_07915_ _07915_/Y _11025_/A hold3487/X _10976_/A _14568_/Q VPWR VGND sg13cmos5l_a22oi_1
Xhold2524 _13159_/A _14253_/Q VPWR VGND sg13cmos5l_dlygate4sd3_1
Xhold2535 _08992_/A _13277_/Q VPWR VGND sg13cmos5l_dlygate4sd3_1
Xhold2546 _10454_/A _13988_/Q VPWR VGND sg13cmos5l_dlygate4sd3_1
Xhold3269 _13557_/D _09447_/X VPWR VGND sg13cmos5l_dlygate4sd3_1
X_08895_ _08895_/Y _08895_/A _08895_/B VPWR VGND sg13cmos5l_nor2_1
Xhold2557 _07301_/A _13411_/Q VPWR VGND sg13cmos5l_dlygate4sd3_1
Xhold2568 _10205_/A _13866_/Q VPWR VGND sg13cmos5l_dlygate4sd3_1
Xhold2579 _10309_/A _13917_/Q VPWR VGND sg13cmos5l_dlygate4sd3_1
XFILLER_84_654 VPWR VGND sg13cmos5l_decap_4
X_07846_ _07846_/X _10987_/B _14572_/Q VPWR VGND sg13cmos5l_or2_1
XFILLER_56_367 VPWR VGND sg13cmos5l_fill_1
X_07777_ _07777_/Y _14394_/Q _14362_/Q VPWR VGND sg13cmos5l_nand2b_1
XFILLER_72_849 VPWR VGND sg13cmos5l_decap_8
X_09516_ _09516_/Y _09509_/A _09513_/X _09534_/D _09515_/Y VPWR VGND sg13cmos5l_a22oi_1
X_13334__2088 _13334_/RESET_B VPWR VGND sg13cmos5l_tiehi
XFILLER_24_242 VPWR VGND sg13cmos5l_fill_1
X_09447_ _09447_/X _14102_/Q hold3268/X _09453_/S VPWR VGND sg13cmos5l_mux2_1
XFILLER_32_1004 VPWR VGND sg13cmos5l_fill_2
X_09378_ _13490_/D _10679_/A1 hold3165/X _09396_/S VPWR VGND sg13cmos5l_mux2_1
X_08329_ _08329_/X _08323_/Y _08324_/Y _08379_/C1 VPWR VGND sg13cmos5l_a21o_1
XFILLER_20_470 VPWR VGND sg13cmos5l_fill_1
X_11340_ _11340_/Y _11338_/A _11337_/B _12933_/B2 VPWR VGND sg13cmos5l_o21ai_1
X_13511__1911 _13511_/RESET_B VPWR VGND sg13cmos5l_tiehi
X_11271_ _11298_/A _11329_/A _11272_/B VPWR VGND sg13cmos5l_nor2_1
X_13010_ _14493_/D _13010_/A _13011_/C VPWR VGND sg13cmos5l_xor2_1
X_10222_ _10222_/Y _10222_/A _10238_/B VPWR VGND sg13cmos5l_nor2_1
X_10153_ _10153_/Y _10153_/A _10153_/B VPWR VGND sg13cmos5l_nand2_1
X_13856__1535 _13856_/RESET_B VPWR VGND sg13cmos5l_tiehi
XFILLER_0_897 VPWR VGND sg13cmos5l_fill_1
XFILLER_75_610 VPWR VGND sg13cmos5l_fill_1
X_10084_ _10084_/Y _10084_/A _10088_/B VPWR VGND sg13cmos5l_nand2_1
X_13544__1878 _13544_/RESET_B VPWR VGND sg13cmos5l_tiehi
XFILLER_47_345 VPWR VGND sg13cmos5l_fill_2
XFILLER_59_194 VPWR VGND sg13cmos5l_fill_1
X_13912_ _13912_/Q _14299_/CLK _13912_/D _13912_/RESET_B VPWR VGND sg13cmos5l_dfrbpq_1
XFILLER_35_529 VPWR VGND sg13cmos5l_fill_2
XFILLER_47_389 VPWR VGND sg13cmos5l_decap_8
X_13843_ _13843_/Q clkload18/A _13843_/D _13843_/RESET_B VPWR VGND sg13cmos5l_dfrbpq_1
X_10986_ _14229_/D _09485_/B _10983_/Y _10985_/Y VPWR VGND sg13cmos5l_a21oi_1
X_13774_ _13774_/Q clkload56/A _13774_/D _13774_/RESET_B VPWR VGND sg13cmos5l_dfrbpq_1
XFILLER_31_724 VPWR VGND sg13cmos5l_fill_1
X_12725_ _12725_/Y _11150_/X _12621_/X _12622_/X _12735_/C VPWR VGND sg13cmos5l_a22oi_1
X_12656_ _12656_/Y _12715_/A _12656_/B VPWR VGND sg13cmos5l_nor2_1
XFILLER_30_267 VPWR VGND sg13cmos5l_fill_2
XFILLER_90_95 VPWR VGND sg13cmos5l_fill_1
X_11607_ _11607_/Y _11607_/A _11611_/B VPWR VGND sg13cmos5l_xnor2_1
X_12587_ _12587_/Y _12548_/Y _12584_/Y _12586_/Y VPWR VGND sg13cmos5l_o21ai_1
X_14326_ _14326_/Q _14453_/CLK _14326_/D _14326_/RESET_B VPWR VGND sg13cmos5l_dfrbpq_1
XFILLER_7_485 VPWR VGND sg13cmos5l_fill_2
X_11538_ _11538_/Y _11534_/Y _11536_/Y _11537_/Y VPWR VGND sg13cmos5l_a21oi_1
XFILLER_48_1000 VPWR VGND sg13cmos5l_fill_1
XFILLER_7_496 VPWR VGND sg13cmos5l_fill_2
X_11469_ _11469_/Y _11469_/A _11560_/B VPWR VGND sg13cmos5l_nand2_1
X_14257_ _14257_/Q clkload66/A _14257_/D _14257_/RESET_B VPWR VGND sg13cmos5l_dfrbpq_1
X_14188_ _14188_/Q _14614_/CLK _14188_/D _14188_/RESET_B VPWR VGND sg13cmos5l_dfrbpq_1
X_13208_ _13208_/Q clkload21/A _13208_/D fanout984/X VPWR VGND sg13cmos5l_dfrbpq_1
X_13139_ _13140_/B _09443_/A _13138_/B _13138_/Y hold3466/X VPWR VGND sg13cmos5l_a22oi_1
XFILLER_86_919 VPWR VGND sg13cmos5l_fill_2
XFILLER_98_779 VPWR VGND sg13cmos5l_decap_4
XFILLER_97_278 VPWR VGND sg13cmos5l_fill_1
X_07700_ _08492_/A _14383_/Q _14351_/Q VPWR VGND sg13cmos5l_nor2_1
X_13230__1042 _13230_/RESET_B VPWR VGND sg13cmos5l_tiehi
XFILLER_38_345 VPWR VGND sg13cmos5l_fill_1
XFILLER_39_846 VPWR VGND sg13cmos5l_fill_1
XFILLER_39_868 VPWR VGND sg13cmos5l_fill_1
XFILLER_94_952 VPWR VGND sg13cmos5l_decap_4
X_08680_ _08683_/A _13971_/Q _08748_/B1 _08687_/A VPWR VGND sg13cmos5l_a21oi_1
XFILLER_54_827 VPWR VGND sg13cmos5l_fill_1
X_07631_ _07633_/A _07631_/A _07631_/B _07631_/C _07631_/D VPWR VGND sg13cmos5l_nand4_1
X_14343__1165 _14343_/RESET_B VPWR VGND sg13cmos5l_tiehi
XFILLER_93_495 VPWR VGND sg13cmos5l_fill_2
X_07562_ _07562_/Y _13030_/A _08156_/B VPWR VGND sg13cmos5l_nor2b_1
X_09301_ _13421_/D hold3067/X hold3135/X _09306_/S VPWR VGND sg13cmos5l_mux2_1
X_07493_ _07493_/X _13432_/Q _13400_/Q _13368_/Q _13336_/Q _07522_/S0 _07522_/S1 VPWR
+ VGND sg13cmos5l_mux4_1
X_09232_ _13358_/D _09302_/A hold3319/X _09235_/S VPWR VGND sg13cmos5l_mux2_1
X_09163_ _11531_/A _14336_/Q _09163_/B VPWR VGND sg13cmos5l_nand2_1
X_08114_ _13202_/D _08112_/Y _08113_/Y _13127_/A VPWR VGND sg13cmos5l_a21oi_1
X_13934__1457 _13934_/RESET_B VPWR VGND sg13cmos5l_tiehi
X_13319__2103 _13319_/RESET_B VPWR VGND sg13cmos5l_tiehi
X_09094_ _09094_/Y _14356_/Q _09112_/A2 _09093_/Y VPWR VGND sg13cmos5l_a21oi_1
X_08045_ _08046_/D _08045_/A _08045_/B _08045_/C VPWR VGND sg13cmos5l_nand3_1
XFILLER_88_234 VPWR VGND sg13cmos5l_fill_2
Xhold3000 _09567_/A _13599_/Q VPWR VGND sg13cmos5l_dlygate4sd3_1
Xhold3011 _13329_/D _09198_/Y VPWR VGND sg13cmos5l_dlygate4sd3_1
Xhold3022 _08108_/A _13201_/Q VPWR VGND sg13cmos5l_dlygate4sd3_1
Xhold3033 hold3033/X _13479_/Q VPWR VGND sg13cmos5l_dlygate4sd3_1
X_09996_ _13763_/D _10583_/A1 _10017_/B _09995_/Y VPWR VGND sg13cmos5l_o21ai_1
Xhold2310 _10028_/A _13779_/Q VPWR VGND sg13cmos5l_dlygate4sd3_1
Xhold2321 _10730_/A _14137_/Q VPWR VGND sg13cmos5l_dlygate4sd3_1
Xhold3044 _11045_/A _14276_/Q VPWR VGND sg13cmos5l_dlygate4sd3_1
Xhold3055 _10392_/A _13958_/Q VPWR VGND sg13cmos5l_dlygate4sd3_1
Xhold3066 hold3066/X _13392_/Q VPWR VGND sg13cmos5l_dlygate4sd3_1
XFILLER_103_589 VPWR VGND sg13cmos5l_decap_4
XFILLER_57_621 VPWR VGND sg13cmos5l_fill_2
XFILLER_69_481 VPWR VGND sg13cmos5l_fill_2
X_08947_ _13261_/D _08087_/B hold3041/X _10781_/B VPWR VGND sg13cmos5l_mux2_1
Xhold2332 _10596_/A _14058_/Q VPWR VGND sg13cmos5l_dlygate4sd3_1
Xhold2343 _10718_/A _14133_/Q VPWR VGND sg13cmos5l_dlygate4sd3_1
Xhold2354 hold2354/X _14606_/Q VPWR VGND sg13cmos5l_dlygate4sd3_1
Xhold3077 _09880_/A _13707_/Q VPWR VGND sg13cmos5l_dlygate4sd3_1
Xhold3088 _13542_/D _09431_/X VPWR VGND sg13cmos5l_dlygate4sd3_1
Xhold3099 hold3099/X _13495_/Q VPWR VGND sg13cmos5l_dlygate4sd3_1
XFILLER_84_440 VPWR VGND sg13cmos5l_fill_1
X_08878_ _08878_/Y _08579_/B _08894_/B _08848_/B _07657_/B VPWR VGND sg13cmos5l_a22oi_1
Xhold2365 _14150_/D _10770_/Y VPWR VGND sg13cmos5l_dlygate4sd3_1
Xhold2376 _14501_/D _13027_/Y VPWR VGND sg13cmos5l_dlygate4sd3_1
Xhold2387 _10097_/A _13813_/Q VPWR VGND sg13cmos5l_dlygate4sd3_1
Xhold2398 _09971_/A _13751_/Q VPWR VGND sg13cmos5l_dlygate4sd3_1
XFILLER_57_687 VPWR VGND sg13cmos5l_decap_8
X_07829_ _08491_/C _11121_/A _07829_/B VPWR VGND sg13cmos5l_nand2_1
XFILLER_57_698 VPWR VGND sg13cmos5l_fill_1
X_10840_ _10935_/C _14271_/Q _14273_/Q VPWR VGND sg13cmos5l_nor2_1
XFILLER_44_359 VPWR VGND sg13cmos5l_decap_4
XFILLER_13_724 VPWR VGND sg13cmos5l_fill_1
X_10771_ _10771_/Y _10798_/A _14295_/Q VPWR VGND sg13cmos5l_nand2_1
XFILLER_13_746 VPWR VGND sg13cmos5l_fill_2
XFILLER_52_392 VPWR VGND sg13cmos5l_fill_1
X_13490_ _13490_/Q _14102_/CLK _13490_/D _13490_/RESET_B VPWR VGND sg13cmos5l_dfrbpq_1
X_12510_ _14395_/D _12510_/A _12510_/B VPWR VGND sg13cmos5l_nand2_1
X_12441_ _12441_/Y _12445_/A _13230_/Q _12441_/B1 VPWR VGND sg13cmos5l_a21oi_1
XFILLER_60_76 VPWR VGND sg13cmos5l_fill_1
X_12372_ _12375_/A _13999_/Q _12366_/B _12427_/B1 VPWR VGND sg13cmos5l_a21oi_1
XFILLER_5_945 VPWR VGND sg13cmos5l_fill_1
X_11323_ _11352_/C _11337_/B VPWR VGND sg13cmos5l_inv_1
Xclkbuf_4_0_0_clk clkbuf_4_0_0_clk/X clkbuf_0_clk/X VPWR VGND sg13cmos5l_buf_8
X_14111_ _14111_/Q clkload31/A _14111_/D _07198_/A VPWR VGND sg13cmos5l_dfrbpq_1
XFILLER_5_978 VPWR VGND sg13cmos5l_decap_8
X_11254_ _11255_/B _11268_/A _11241_/B _11236_/Y VPWR VGND sg13cmos5l_o21ai_1
X_14421__1087 _14421_/RESET_B VPWR VGND sg13cmos5l_tiehi
X_14042_ _14042_/Q _14042_/CLK _14042_/D _14042_/RESET_B VPWR VGND sg13cmos5l_dfrbpq_1
X_10205_ _10205_/Y _10205_/A _10219_/B VPWR VGND sg13cmos5l_nor2_1
XFILLER_69_96 VPWR VGND sg13cmos5l_fill_2
X_11185_ _11214_/B _14313_/Q _09500_/X _11197_/S VPWR VGND sg13cmos5l_mux2_1
XFILLER_0_650 VPWR VGND sg13cmos5l_fill_1
XFILLER_95_749 VPWR VGND sg13cmos5l_decap_8
X_10136_ _13832_/D _10593_/A1 _10153_/B _10135_/Y VPWR VGND sg13cmos5l_o21ai_1
XFILLER_48_632 VPWR VGND sg13cmos5l_decap_8
XFILLER_48_654 VPWR VGND sg13cmos5l_fill_1
XFILLER_88_790 VPWR VGND sg13cmos5l_fill_1
X_10067_ _13798_/D fanout79/X _10082_/B _10066_/Y VPWR VGND sg13cmos5l_o21ai_1
XFILLER_36_805 VPWR VGND sg13cmos5l_fill_2
XFILLER_48_687 VPWR VGND sg13cmos5l_decap_4
XFILLER_78_1015 VPWR VGND sg13cmos5l_fill_1
XFILLER_47_197 VPWR VGND sg13cmos5l_fill_1
X_13826_ _13826_/Q clkload46/A _13826_/D _13826_/RESET_B VPWR VGND sg13cmos5l_dfrbpq_1
XFILLER_44_893 VPWR VGND sg13cmos5l_fill_1
X_10969_ _10969_/Y _14248_/D _14247_/D _10969_/C VPWR VGND sg13cmos5l_nor3_1
X_13757_ _13757_/Q _14045_/CLK _13757_/D _13757_/RESET_B VPWR VGND sg13cmos5l_dfrbpq_1
X_12708_ _12709_/B _14354_/Q _12164_/B _12897_/A _12704_/X _12707_/Y VPWR VGND sg13cmos5l_a221oi_1
X_13688_ _13688_/Q _14299_/CLK _13688_/D _13688_/RESET_B VPWR VGND sg13cmos5l_dfrbpq_1
X_12639_ _12642_/B _12640_/A _12639_/B _12639_/C VPWR VGND sg13cmos5l_nand3_1
X_14309_ _14309_/Q clkload39/A _14309_/D _14309_/RESET_B VPWR VGND sg13cmos5l_dfrbpq_1
X_09850_ _09850_/Y _09850_/A _09862_/B VPWR VGND sg13cmos5l_nor2_1
Xfanout729 _08819_/B _08908_/B VPWR VGND sg13cmos5l_buf_1
Xfanout718 _08840_/B _08905_/B1 VPWR VGND sg13cmos5l_buf_1
Xfanout707 _11436_/B _07936_/B1 VPWR VGND sg13cmos5l_buf_1
X_08801_ _08801_/Y _08801_/A _08808_/B VPWR VGND sg13cmos5l_nand2_1
X_09781_ _09781_/Y _09781_/A _09801_/B VPWR VGND sg13cmos5l_nor2_1
XFILLER_79_790 VPWR VGND sg13cmos5l_fill_1
X_08732_ _08732_/Y _08720_/Y _08723_/Y _08727_/Y _08731_/Y VPWR VGND sg13cmos5l_a22oi_1
XFILLER_82_922 VPWR VGND sg13cmos5l_fill_1
X_08663_ _08663_/Y _11726_/B _08658_/X _08662_/Y VPWR VGND sg13cmos5l_o21ai_1
XFILLER_82_933 VPWR VGND sg13cmos5l_decap_4
XFILLER_54_668 VPWR VGND sg13cmos5l_fill_1
XFILLER_82_977 VPWR VGND sg13cmos5l_fill_2
X_07614_ _07631_/B _07614_/A _07614_/B VPWR VGND sg13cmos5l_xor2_1
X_08594_ _08595_/B _08594_/A _08594_/B VPWR VGND sg13cmos5l_nor2_1
X_07545_ _07546_/D _14539_/Q _13292_/Q VPWR VGND sg13cmos5l_xor2_1
X_07476_ _07476_/Y _07476_/A VPWR VGND sg13cmos5l_inv_1
X_09215_ _13344_/D _07985_/A hold3283/X _09235_/S VPWR VGND sg13cmos5l_mux2_1
X_09146_ _09146_/Y _14429_/Q _11450_/A VPWR VGND sg13cmos5l_nand2_1
X_14202__1275 _14202_/RESET_B VPWR VGND sg13cmos5l_tiehi
X_09077_ _09077_/Y _09077_/A _09077_/B VPWR VGND sg13cmos5l_nor2_1
XFILLER_2_904 VPWR VGND sg13cmos5l_fill_2
X_08028_ _08040_/B _08974_/A _13274_/Q _08050_/A VPWR VGND sg13cmos5l_mux2_1
XFILLER_77_705 VPWR VGND sg13cmos5l_fill_1
XFILLER_77_738 VPWR VGND sg13cmos5l_fill_1
XFILLER_7_1019 VPWR VGND sg13cmos5l_decap_8
X_09979_ _09979_/Y _09979_/A _09979_/B VPWR VGND sg13cmos5l_nand2_1
XFILLER_103_397 VPWR VGND sg13cmos5l_fill_1
X_14406__1102 _14406_/RESET_B VPWR VGND sg13cmos5l_tiehi
XFILLER_58_974 VPWR VGND sg13cmos5l_decap_8
X_13461__1961 _13461_/RESET_B VPWR VGND sg13cmos5l_tiehi
X_12990_ _12993_/C _14483_/Q _12991_/B VPWR VGND sg13cmos5l_and2_1
X_11941_ _11941_/Y _11938_/Y _11940_/Y _11948_/B2 VPWR VGND sg13cmos5l_a21oi_1
XFILLER_72_465 VPWR VGND sg13cmos5l_fill_2
XFILLER_73_977 VPWR VGND sg13cmos5l_fill_1
XFILLER_73_988 VPWR VGND sg13cmos5l_decap_4
X_11872_ _11903_/A _14354_/Q _13239_/Q VPWR VGND sg13cmos5l_xnor2_1
XFILLER_60_616 VPWR VGND sg13cmos5l_fill_1
XFILLER_72_476 VPWR VGND sg13cmos5l_fill_2
XFILLER_72_487 VPWR VGND sg13cmos5l_decap_8
X_10823_ _14171_/D _14251_/D hold3362/X _10832_/S VPWR VGND sg13cmos5l_mux2_1
X_14591_ _14591_/Q clkload54/A _14591_/D _14591_/RESET_B VPWR VGND sg13cmos5l_dfrbpq_1
X_13611_ _13611_/Q _14028_/CLK _13611_/D _13611_/RESET_B VPWR VGND sg13cmos5l_dfrbpq_1
X_14447__1060 _14447_/RESET_B VPWR VGND sg13cmos5l_tiehi
X_14439__1069 _14439_/RESET_B VPWR VGND sg13cmos5l_tiehi
X_13542_ _13542_/Q clkload39/A _13542_/D _13542_/RESET_B VPWR VGND sg13cmos5l_dfrbpq_1
XFILLER_13_554 VPWR VGND sg13cmos5l_fill_1
X_10754_ _10754_/Y _10754_/A _10802_/B VPWR VGND sg13cmos5l_nand2_1
X_10685_ _14105_/D input14/X _10685_/A1 _10685_/S VPWR VGND sg13cmos5l_mux2_1
X_13473_ _13473_/Q clkload30/A _13473_/D _13473_/RESET_B VPWR VGND sg13cmos5l_dfrbpq_1
X_12424_ _12424_/Y _13969_/Q _12426_/B _12428_/A2 _13649_/Q VPWR VGND sg13cmos5l_a22oi_1
X_12355_ _12356_/D _07810_/B _12301_/B _12382_/A _12354_/Y VPWR VGND sg13cmos5l_a22oi_1
X_11306_ _14321_/D _11304_/Y _11305_/Y _11292_/Y VPWR VGND sg13cmos5l_o21ai_1
X_12286_ _12286_/Y _12286_/A _12286_/B _12307_/B VPWR VGND sg13cmos5l_nand3_1
X_11237_ _11268_/A _14088_/Q _11256_/C VPWR VGND sg13cmos5l_xnor2_1
X_14025_ _14025_/Q clkload63/A _14025_/D _14025_/RESET_B VPWR VGND sg13cmos5l_dfrbpq_1
X_11168_ _11179_/A _14178_/Q _11170_/A VPWR VGND sg13cmos5l_nand2_1
XFILLER_0_491 VPWR VGND sg13cmos5l_fill_2
X_10119_ _10119_/Y _10119_/A _10119_/B VPWR VGND sg13cmos5l_nand2_1
X_11099_ _11099_/Y _11099_/A _11099_/B VPWR VGND sg13cmos5l_nor2_1
XFILLER_82_218 VPWR VGND sg13cmos5l_fill_2
XFILLER_91_796 VPWR VGND sg13cmos5l_fill_2
X_13809_ _13809_/Q _14065_/CLK _13809_/D _13809_/RESET_B VPWR VGND sg13cmos5l_dfrbpq_1
X_07330_ _07330_/Y _07330_/A VPWR VGND sg13cmos5l_inv_1
X_13636__1755 _13636_/RESET_B VPWR VGND sg13cmos5l_tiehi
X_07261_ _07261_/Y _07959_/B VPWR VGND sg13cmos5l_inv_1
X_09000_ _09002_/A hold3569/X _09000_/A2 _08963_/S hold3385/X VPWR VGND sg13cmos5l_a22oi_1
XFILLER_77_0 VPWR VGND sg13cmos5l_fill_2
X_07192_ _10629_/A _14071_/Q VPWR VGND sg13cmos5l_inv_1
XFILLER_8_580 VPWR VGND sg13cmos5l_fill_2
X_14016__1375 _14016_/RESET_B VPWR VGND sg13cmos5l_tiehi
X_13851__1540 _13851_/RESET_B VPWR VGND sg13cmos5l_tiehi
X_09902_ _09902_/Y _09902_/A _09922_/B VPWR VGND sg13cmos5l_nor2_1
Xfanout515 _12010_/A2 _08648_/Y VPWR VGND sg13cmos5l_buf_1
Xfanout504 _12428_/A2 fanout505/X VPWR VGND sg13cmos5l_buf_1
XFILLER_58_204 VPWR VGND sg13cmos5l_fill_1
X_09833_ _13683_/D _10355_/A1 _09844_/B _09832_/Y VPWR VGND sg13cmos5l_a21oi_1
Xfanout548 _09671_/A _09691_/A VPWR VGND sg13cmos5l_buf_1
Xfanout537 _12382_/A _11840_/A VPWR VGND sg13cmos5l_buf_1
Xfanout526 _08207_/A2 _07465_/B VPWR VGND sg13cmos5l_buf_1
XFILLER_101_835 VPWR VGND sg13cmos5l_fill_1
XFILLER_58_237 VPWR VGND sg13cmos5l_fill_1
XFILLER_59_749 VPWR VGND sg13cmos5l_fill_2
Xfanout559 _11719_/S _08652_/A VPWR VGND sg13cmos5l_buf_1
X_09764_ _09764_/Y _09829_/C _10286_/A VPWR VGND sg13cmos5l_nor2_1
XFILLER_54_410 VPWR VGND sg13cmos5l_decap_8
X_08715_ _08716_/B _14179_/Q _08753_/B _08714_/Y _11657_/B VPWR VGND sg13cmos5l_a22oi_1
X_09695_ _10482_/A _10351_/B _10351_/A VPWR VGND sg13cmos5l_nor2b_1
XFILLER_82_741 VPWR VGND sg13cmos5l_fill_1
X_08646_ _08646_/Y _08646_/A _14180_/Q VPWR VGND sg13cmos5l_nand2_1
XFILLER_54_487 VPWR VGND sg13cmos5l_decap_4
X_08577_ _08577_/Y _08577_/A _08576_/Y VPWR VGND sg13cmos5l_nor2b_1
X_07528_ _07529_/B _14069_/Q _07465_/B _07528_/B1 _14490_/Q VPWR VGND sg13cmos5l_a22oi_1
XFILLER_10_524 VPWR VGND sg13cmos5l_fill_2
XFILLER_22_384 VPWR VGND sg13cmos5l_fill_2
XFILLER_50_682 VPWR VGND sg13cmos5l_decap_8
X_07459_ _07459_/Y _09445_/A0 _08244_/C _11040_/A VPWR VGND sg13cmos5l_a21oi_1
X_10470_ _10470_/Y _10470_/A _10470_/B VPWR VGND sg13cmos5l_nor2_1
XFILLER_68_1003 VPWR VGND sg13cmos5l_fill_1
XFILLER_6_539 VPWR VGND sg13cmos5l_fill_2
X_09129_ _09129_/Y _11438_/A _09128_/Y _09135_/B1 VPWR VGND sg13cmos5l_a21oi_1
X_12140_ _12140_/Y _14023_/Q _12174_/B _12293_/B1 VPWR VGND sg13cmos5l_a21oi_1
X_13479__1943 _13479_/RESET_B VPWR VGND sg13cmos5l_tiehi
X_12071_ _12071_/Y _12071_/A _12164_/C VPWR VGND sg13cmos5l_nand2_1
XFILLER_77_502 VPWR VGND sg13cmos5l_fill_1
X_11022_ _11022_/Y _14238_/Q _11024_/B VPWR VGND sg13cmos5l_nand2_1
X_13232__1034 _13232_/RESET_B VPWR VGND sg13cmos5l_tiehi
XFILLER_104_695 VPWR VGND sg13cmos5l_fill_1
XFILLER_2_28 VPWR VGND sg13cmos5l_fill_1
XFILLER_49_226 VPWR VGND sg13cmos5l_fill_1
XFILLER_49_237 VPWR VGND sg13cmos5l_fill_1
X_13714__1677 _13714_/RESET_B VPWR VGND sg13cmos5l_tiehi
XFILLER_77_568 VPWR VGND sg13cmos5l_decap_8
XFILLER_92_505 VPWR VGND sg13cmos5l_decap_4
XFILLER_45_410 VPWR VGND sg13cmos5l_decap_4
X_12973_ _14474_/D _12973_/A _12973_/B VPWR VGND sg13cmos5l_xor2_1
XFILLER_61_903 VPWR VGND sg13cmos5l_decap_8
XFILLER_73_763 VPWR VGND sg13cmos5l_decap_8
X_11924_ _11924_/Y _11979_/A _11924_/B VPWR VGND sg13cmos5l_nor2_1
XFILLER_46_988 VPWR VGND sg13cmos5l_fill_1
XFILLER_60_413 VPWR VGND sg13cmos5l_decap_4
XFILLER_73_774 VPWR VGND sg13cmos5l_fill_1
X_14643_ _14643_/Q clkload76/A _14643_/D _14643_/RESET_B VPWR VGND sg13cmos5l_dfrbpq_1
X_11855_ _11855_/Y _14013_/Q _11916_/A2 _11858_/B _13821_/Q VPWR VGND sg13cmos5l_a22oi_1
X_10806_ _14162_/D _10805_/B _10804_/Y _10805_/Y VPWR VGND sg13cmos5l_o21ai_1
X_11786_ _11786_/Y _13882_/Q _12058_/B _12243_/B1 VPWR VGND sg13cmos5l_a21oi_1
X_14574_ _14574_/Q _14577_/CLK _14574_/D fanout966/X VPWR VGND sg13cmos5l_dfrbpq_1
X_10737_ _10737_/Y _10796_/B _10735_/Y _10736_/Y VPWR VGND sg13cmos5l_o21ai_1
X_13525_ _13525_/Q _14102_/CLK _13525_/D _13525_/RESET_B VPWR VGND sg13cmos5l_dfrbpq_1
XFILLER_12_1002 VPWR VGND sg13cmos5l_fill_1
X_13456_ _13456_/Q _14238_/CLK _13456_/D _13456_/RESET_B VPWR VGND sg13cmos5l_dfrbpq_1
X_13347__2075 _13347_/RESET_B VPWR VGND sg13cmos5l_tiehi
X_10668_ _10668_/Y _14254_/D _10826_/S VPWR VGND sg13cmos5l_nor2_1
X_12407_ _12407_/Y _14467_/Q _12380_/B _12406_/Y VPWR VGND sg13cmos5l_a21oi_1
X_10599_ _14059_/D _10599_/A1 _10610_/B _10598_/Y VPWR VGND sg13cmos5l_o21ai_1
X_13387_ _13387_/Q _14238_/CLK _13387_/D _13387_/RESET_B VPWR VGND sg13cmos5l_dfrbpq_1
X_12338_ _12356_/B _12364_/A _12361_/B _12338_/C VPWR VGND sg13cmos5l_nor3_1
X_12269_ _12270_/C _14059_/Q _12296_/A2 _12290_/A2 _13995_/Q VPWR VGND sg13cmos5l_a22oi_1
X_14278__1230 _14278_/RESET_B VPWR VGND sg13cmos5l_tiehi
XFILLER_96_822 VPWR VGND sg13cmos5l_fill_2
Xhold2909 _13009_/A _14492_/Q VPWR VGND sg13cmos5l_dlygate4sd3_1
X_14008_ _14008_/Q _14631_/CLK _14008_/D _14008_/RESET_B VPWR VGND sg13cmos5l_dfrbpq_1
XFILLER_96_888 VPWR VGND sg13cmos5l_decap_4
XFILLER_83_538 VPWR VGND sg13cmos5l_fill_1
XFILLER_64_741 VPWR VGND sg13cmos5l_fill_2
XFILLER_64_752 VPWR VGND sg13cmos5l_fill_1
X_08500_ _14593_/D _08500_/A _08500_/B VPWR VGND sg13cmos5l_xnor2_1
X_09480_ _09895_/B _14235_/Q _10155_/C VPWR VGND sg13cmos5l_nand2_1
XFILLER_37_999 VPWR VGND sg13cmos5l_fill_1
X_08431_ _08431_/Y _11014_/A _15882_/A _08431_/C _11149_/B VPWR VGND sg13cmos5l_nor4_1
X_13869__1522 _13869_/RESET_B VPWR VGND sg13cmos5l_tiehi
XFILLER_63_295 VPWR VGND sg13cmos5l_fill_2
X_13557__1865 _13557_/RESET_B VPWR VGND sg13cmos5l_tiehi
XFILLER_23_159 VPWR VGND sg13cmos5l_fill_2
X_08362_ _08362_/Y _08361_/B _13453_/Q _08361_/Y VPWR VGND sg13cmos5l_o21ai_1
X_14380__1128 _14380_/RESET_B VPWR VGND sg13cmos5l_tiehi
X_07313_ _07313_/Y _13418_/Q VPWR VGND sg13cmos5l_inv_1
X_08293_ _14263_/D _08281_/B _12611_/A _08281_/Y VPWR VGND sg13cmos5l_o21ai_1
X_07244_ _11109_/A _14378_/Q VPWR VGND sg13cmos5l_inv_1
X_07175_ _09534_/B _14444_/Q VPWR VGND sg13cmos5l_inv_1
Xfanout323 _09714_/B _09726_/B VPWR VGND sg13cmos5l_buf_1
Xfanout312 _09801_/B _09813_/B VPWR VGND sg13cmos5l_buf_1
Xfanout301 _09844_/B _09858_/B VPWR VGND sg13cmos5l_buf_1
XFILLER_59_524 VPWR VGND sg13cmos5l_decap_8
XFILLER_59_546 VPWR VGND sg13cmos5l_fill_2
Xfanout356 _13192_/B1 _13196_/B1 VPWR VGND sg13cmos5l_buf_1
Xfanout345 _09544_/B fanout354/X VPWR VGND sg13cmos5l_buf_1
Xfanout334 _10559_/A1 _09516_/Y VPWR VGND sg13cmos5l_buf_1
X_09816_ _13675_/D _10599_/A1 _09817_/B _09815_/Y VPWR VGND sg13cmos5l_a21oi_1
Xfanout389 _12302_/A2 _12380_/B VPWR VGND sg13cmos5l_buf_1
Xfanout378 _07526_/A1 _08252_/A VPWR VGND sg13cmos5l_buf_1
Xfanout367 fanout367/X _08435_/Y VPWR VGND sg13cmos5l_buf_1
XFILLER_86_398 VPWR VGND sg13cmos5l_fill_2
X_09747_ _13642_/D _10532_/A1 _09746_/B _09746_/Y VPWR VGND sg13cmos5l_a21oi_1
XFILLER_36_34 VPWR VGND sg13cmos5l_fill_1
XFILLER_55_741 VPWR VGND sg13cmos5l_fill_2
XFILLER_28_988 VPWR VGND sg13cmos5l_fill_1
XFILLER_42_402 VPWR VGND sg13cmos5l_fill_1
XFILLER_82_571 VPWR VGND sg13cmos5l_decap_4
X_09678_ _09678_/Y _09685_/B _09677_/Y VPWR VGND sg13cmos5l_nor2b_1
X_08629_ _08630_/C _14581_/Q _14615_/Q _14616_/Q _14580_/Q VPWR VGND sg13cmos5l_a22oi_1
XFILLER_14_159 VPWR VGND sg13cmos5l_fill_1
XFILLER_70_788 VPWR VGND sg13cmos5l_fill_2
X_11640_ _11640_/X _11641_/A _13228_/Q VPWR VGND sg13cmos5l_and2_1
XFILLER_23_682 VPWR VGND sg13cmos5l_fill_2
X_11571_ _11571_/Y _11571_/A _11604_/B VPWR VGND sg13cmos5l_nand2_1
X_14356__1152 _14356_/RESET_B VPWR VGND sg13cmos5l_tiehi
X_10522_ _14021_/D _10587_/A1 _10537_/B _10521_/Y VPWR VGND sg13cmos5l_o21ai_1
X_13310_ _13310_/Q clkload67/A _13310_/D _13310_/RESET_B VPWR VGND sg13cmos5l_dfrbpq_1
XFILLER_10_365 VPWR VGND sg13cmos5l_fill_1
X_14290_ _14290_/Q clkload25/A _14290_/D _14290_/RESET_B VPWR VGND sg13cmos5l_dfrbpq_1
X_13602__1820 _13602_/RESET_B VPWR VGND sg13cmos5l_tiehi
X_10453_ _13987_/D _10453_/A1 _10474_/B _10452_/Y VPWR VGND sg13cmos5l_a21oi_1
X_13241_ _13241_/Q clkload67/A _13241_/D _13241_/RESET_B VPWR VGND sg13cmos5l_dfrbpq_1
X_10384_ _10384_/Y _10384_/A _10384_/B VPWR VGND sg13cmos5l_nor2_1
X_13172_ _13172_/Y _13234_/Q _13180_/B VPWR VGND sg13cmos5l_nor2_1
X_12123_ _12504_/B _12351_/A1 _12115_/Y _12121_/Y _12122_/Y VPWR VGND sg13cmos5l_a22oi_1
XFILLER_105_960 VPWR VGND sg13cmos5l_decap_8
XFILLER_81_1000 VPWR VGND sg13cmos5l_fill_2
X_12054_ _12054_/Y _12050_/Y _12051_/Y _12052_/Y _12053_/Y VPWR VGND sg13cmos5l_a22oi_1
X_13947__1444 _13947_/RESET_B VPWR VGND sg13cmos5l_tiehi
XFILLER_78_877 VPWR VGND sg13cmos5l_decap_8
XFILLER_78_888 VPWR VGND sg13cmos5l_fill_1
X_11005_ _11005_/Y _10981_/A _14570_/Q _11005_/B1 VPWR VGND sg13cmos5l_o21ai_1
XFILLER_65_538 VPWR VGND sg13cmos5l_decap_8
XFILLER_77_387 VPWR VGND sg13cmos5l_fill_1
XFILLER_92_324 VPWR VGND sg13cmos5l_fill_1
Xfanout890 _08332_/A _14124_/Q VPWR VGND sg13cmos5l_buf_1
XFILLER_18_421 VPWR VGND sg13cmos5l_fill_2
XFILLER_58_590 VPWR VGND sg13cmos5l_fill_1
X_12956_ _14465_/D _12956_/A VPWR VGND sg13cmos5l_inv_1
XFILLER_73_593 VPWR VGND sg13cmos5l_fill_2
XFILLER_93_95 VPWR VGND sg13cmos5l_fill_1
X_11907_ _11907_/Y _14047_/Q _11969_/A2 _12005_/B _13791_/Q VPWR VGND sg13cmos5l_a22oi_1
X_12887_ _12888_/B _12871_/A _12884_/Y _12886_/Y VPWR VGND sg13cmos5l_o21ai_1
XFILLER_61_766 VPWR VGND sg13cmos5l_fill_2
X_11838_ _11838_/Y _12012_/A1 _11831_/Y _11837_/Y VPWR VGND sg13cmos5l_a21oi_1
X_14626_ _14626_/Q clkload40/A _14626_/D _14626_/RESET_B VPWR VGND sg13cmos5l_dfrbpq_1
XFILLER_20_129 VPWR VGND sg13cmos5l_fill_2
X_14557_ _14557_/Q clkload11/A _14557_/D fanout966/X VPWR VGND sg13cmos5l_dfrbpq_1
XFILLER_13_192 VPWR VGND sg13cmos5l_fill_1
XFILLER_9_141 VPWR VGND sg13cmos5l_decap_4
X_11769_ _11769_/Y _11851_/A _11798_/A _11769_/C VPWR VGND sg13cmos5l_nand3_1
Xclkbuf_leaf_40_clk _14630_/CLK clkbuf_4_12_0_clk/X VPWR VGND sg13cmos5l_buf_8
X_13508_ _13508_/Q _14117_/CLK _13508_/D _13508_/RESET_B VPWR VGND sg13cmos5l_dfrbpq_1
X_14488_ _14488_/Q clkload9/A _14488_/D fanout965/X VPWR VGND sg13cmos5l_dfrbpq_1
X_13439_ _13439_/Q _13568_/CLK _13439_/D _13439_/RESET_B VPWR VGND sg13cmos5l_dfrbpq_1
Xhold3407 _13047_/A _15888_/A VPWR VGND sg13cmos5l_dlygate4sd3_1
X_08980_ _08980_/Y _08996_/B _08980_/B VPWR VGND sg13cmos5l_nor2_1
Xhold3429 hold3429/X _14440_/Q VPWR VGND sg13cmos5l_dlygate4sd3_1
Xhold3418 _09026_/A _13295_/Q VPWR VGND sg13cmos5l_dlygate4sd3_1
X_07931_ _11024_/A _08913_/A _11202_/A VPWR VGND sg13cmos5l_nor2_1
Xhold2706 _10637_/A _14075_/Q VPWR VGND sg13cmos5l_dlygate4sd3_1
Xhold2717 _09842_/A _13688_/Q VPWR VGND sg13cmos5l_dlygate4sd3_1
Xhold2728 _10211_/A _13869_/Q VPWR VGND sg13cmos5l_dlygate4sd3_1
X_07862_ _07862_/X _10657_/A _08000_/A _14572_/Q _07864_/A VPWR VGND sg13cmos5l_and4_1
Xhold2739 _09700_/A _13619_/Q VPWR VGND sg13cmos5l_dlygate4sd3_1
XFILLER_56_538 VPWR VGND sg13cmos5l_fill_1
XFILLER_84_847 VPWR VGND sg13cmos5l_decap_4
X_09601_ _09601_/Y _09601_/A _09642_/B VPWR VGND sg13cmos5l_nor2_1
X_14434__1074 _14434_/RESET_B VPWR VGND sg13cmos5l_tiehi
XFILLER_37_741 VPWR VGND sg13cmos5l_fill_1
X_07793_ _08881_/A _14398_/Q _14366_/Q VPWR VGND sg13cmos5l_nor2_1
X_09532_ _11248_/B _14414_/Q _14633_/Q _09532_/S VPWR VGND sg13cmos5l_mux2_1
XFILLER_58_1013 VPWR VGND sg13cmos5l_decap_8
XFILLER_58_1024 VPWR VGND sg13cmos5l_decap_4
X_09463_ _09463_/X _14118_/Q hold3338/X _09475_/S VPWR VGND sg13cmos5l_mux2_1
X_08414_ _08414_/Y _08411_/A _08413_/Y _08411_/Y VPWR VGND sg13cmos5l_o21ai_1
X_09394_ _09394_/X _14115_/Q hold3140/X _09405_/S VPWR VGND sg13cmos5l_mux2_1
XFILLER_52_799 VPWR VGND sg13cmos5l_decap_4
X_08345_ _08345_/X _13516_/Q _13484_/Q _08398_/S VPWR VGND sg13cmos5l_mux2_1
Xclkbuf_leaf_31_clk clkload35/A clkload2/A VPWR VGND sg13cmos5l_buf_8
X_08276_ _08276_/Y _08275_/S _07306_/Y _08339_/B1 VPWR VGND sg13cmos5l_a21oi_1
X_07227_ _07764_/B _14359_/Q VPWR VGND sg13cmos5l_inv_1
XFILLER_106_724 VPWR VGND sg13cmos5l_decap_8
XFILLER_4_829 VPWR VGND sg13cmos5l_decap_4
XFILLER_3_328 VPWR VGND sg13cmos5l_fill_1
XFILLER_65_1028 VPWR VGND sg13cmos5l_fill_1
XFILLER_78_129 VPWR VGND sg13cmos5l_fill_1
Xfanout131 _09375_/S _09344_/Y VPWR VGND sg13cmos5l_buf_1
Xfanout120 _09442_/S _09441_/S VPWR VGND sg13cmos5l_buf_1
Xclkbuf_leaf_98_clk clkload19/A clkbuf_4_2_0_clk/X VPWR VGND sg13cmos5l_buf_8
Xfanout164 _10796_/B _10751_/B VPWR VGND sg13cmos5l_buf_1
Xfanout153 _10453_/A1 _09599_/Y VPWR VGND sg13cmos5l_buf_1
Xfanout142 _10395_/A1 _10591_/A1 VPWR VGND sg13cmos5l_buf_1
XFILLER_47_516 VPWR VGND sg13cmos5l_decap_8
Xfanout197 _08356_/C _08409_/C VPWR VGND sg13cmos5l_buf_1
Xfanout186 _08098_/B _07421_/Y VPWR VGND sg13cmos5l_buf_1
Xfanout175 _08421_/S _07422_/Y VPWR VGND sg13cmos5l_buf_1
X_13631__1760 _13631_/RESET_B VPWR VGND sg13cmos5l_tiehi
XFILLER_75_869 VPWR VGND sg13cmos5l_fill_2
X_12810_ _12810_/X _12891_/A1 _12624_/Y _12739_/A VPWR VGND sg13cmos5l_a21o_1
XFILLER_16_914 VPWR VGND sg13cmos5l_fill_1
XFILLER_47_99 VPWR VGND sg13cmos5l_fill_1
XFILLER_62_519 VPWR VGND sg13cmos5l_fill_1
XFILLER_90_828 VPWR VGND sg13cmos5l_fill_1
X_13790_ _13790_/Q clkload63/A _13790_/D _13790_/RESET_B VPWR VGND sg13cmos5l_dfrbpq_1
XFILLER_15_424 VPWR VGND sg13cmos5l_fill_1
XFILLER_70_530 VPWR VGND sg13cmos5l_decap_8
X_12741_ _14421_/D _12734_/Y _12740_/Y _12755_/A VPWR VGND sg13cmos5l_a21oi_1
X_14011__1380 _14011_/RESET_B VPWR VGND sg13cmos5l_tiehi
X_12672_ _12673_/D _12669_/Y _12670_/Y _12671_/Y VPWR VGND sg13cmos5l_o21ai_1
X_11623_ _11623_/Y _14579_/Q _12165_/A VPWR VGND sg13cmos5l_nor2_1
X_14411_ _14411_/Q _14630_/CLK _14411_/D _14411_/RESET_B VPWR VGND sg13cmos5l_dfrbpq_1
XFILLER_11_641 VPWR VGND sg13cmos5l_fill_1
Xclkbuf_leaf_22_clk clkload28/A clkbuf_4_4_0_clk/X VPWR VGND sg13cmos5l_buf_8
X_11554_ _11556_/C _11575_/A _11575_/B VPWR VGND sg13cmos5l_and2_1
X_14342_ _14342_/Q clkload36/A _14342_/D _14342_/RESET_B VPWR VGND sg13cmos5l_dfrbpq_1
XFILLER_10_195 VPWR VGND sg13cmos5l_decap_8
XFILLER_7_656 VPWR VGND sg13cmos5l_fill_1
X_10505_ _10505_/Y _10505_/A _10511_/B VPWR VGND sg13cmos5l_nand2_1
X_11485_ _11519_/A _11476_/C _11493_/B _11484_/A VPWR VGND sg13cmos5l_o21ai_1
X_14273_ _14273_/Q clkload66/A _14273_/D _14273_/RESET_B VPWR VGND sg13cmos5l_dfrbpq_1
X_10436_ _10436_/Y _10436_/A _10436_/B VPWR VGND sg13cmos5l_nor2_1
X_13224_ _13224_/Q _14576_/CLK _13224_/D fanout979/X VPWR VGND sg13cmos5l_dfrbpq_1
X_10367_ _13945_/D _10367_/A1 _10366_/B _10366_/Y VPWR VGND sg13cmos5l_a21oi_1
X_13155_ _13155_/Y _07267_/Y _13164_/A2 _13153_/Y _13154_/Y VPWR VGND sg13cmos5l_a22oi_1
XFILLER_78_630 VPWR VGND sg13cmos5l_fill_1
X_10298_ _13911_/D _10298_/A1 _10299_/B _10297_/Y VPWR VGND sg13cmos5l_a21oi_1
X_12106_ _12107_/B _12106_/A _12102_/X VPWR VGND sg13cmos5l_nor2b_1
X_14215__1262 _14215_/RESET_B VPWR VGND sg13cmos5l_tiehi
X_13086_ _13090_/B _14528_/Q _14527_/Q _13086_/C VPWR VGND sg13cmos5l_and3_1
X_12037_ _12492_/B _12351_/A1 _12029_/Y _12033_/Y _12036_/Y VPWR VGND sg13cmos5l_a22oi_1
Xclkbuf_leaf_89_clk _14631_/CLK clkload4/A VPWR VGND sg13cmos5l_buf_8
XFILLER_93_600 VPWR VGND sg13cmos5l_decap_8
XFILLER_19_730 VPWR VGND sg13cmos5l_fill_2
XFILLER_65_346 VPWR VGND sg13cmos5l_decap_4
XFILLER_77_195 VPWR VGND sg13cmos5l_fill_1
XFILLER_93_666 VPWR VGND sg13cmos5l_fill_1
XFILLER_34_700 VPWR VGND sg13cmos5l_fill_2
XFILLER_65_368 VPWR VGND sg13cmos5l_fill_2
XFILLER_81_839 VPWR VGND sg13cmos5l_decap_8
X_13988_ _13988_/Q clkload70/A _13988_/D _13988_/RESET_B VPWR VGND sg13cmos5l_dfrbpq_1
XFILLER_74_880 VPWR VGND sg13cmos5l_fill_1
XFILLER_92_187 VPWR VGND sg13cmos5l_fill_2
X_12939_ _12940_/A _14457_/Q _12945_/A2 _11463_/B _12945_/B2 VPWR VGND sg13cmos5l_a22oi_1
XFILLER_61_596 VPWR VGND sg13cmos5l_fill_1
X_14609_ _14609_/Q clkload79/A _14609_/D _14609_/RESET_B VPWR VGND sg13cmos5l_dfrbpq_1
X_08130_ _08133_/B _13215_/Q _13214_/Q _13216_/Q _08138_/B VPWR VGND sg13cmos5l_and4_1
Xclkbuf_leaf_13_clk clkload36/A clkbuf_4_6_0_clk/X VPWR VGND sg13cmos5l_buf_8
XFILLER_88_1028 VPWR VGND sg13cmos5l_fill_1
X_08061_ _08087_/A _07354_/B _08062_/S _08060_/Y VPWR VGND sg13cmos5l_o21ai_1
X_13673__1718 _13673_/RESET_B VPWR VGND sg13cmos5l_tiehi
XFILLER_89_928 VPWR VGND sg13cmos5l_fill_2
Xhold3204 _13396_/D _09272_/X VPWR VGND sg13cmos5l_dlygate4sd3_1
Xhold3215 _09920_/A _13726_/Q VPWR VGND sg13cmos5l_dlygate4sd3_1
X_13234__1026 _13234_/RESET_B VPWR VGND sg13cmos5l_tiehi
XFILLER_102_204 VPWR VGND sg13cmos5l_fill_1
XFILLER_102_215 VPWR VGND sg13cmos5l_fill_1
X_08963_ _13271_/D _08962_/Y hold3218/X _08963_/S VPWR VGND sg13cmos5l_mux2_1
Xhold2503 _10568_/A _14044_/Q VPWR VGND sg13cmos5l_dlygate4sd3_1
Xhold3226 hold3226/X _13578_/Q VPWR VGND sg13cmos5l_dlygate4sd3_1
Xhold3237 hold3237/X _13417_/Q VPWR VGND sg13cmos5l_dlygate4sd3_1
Xhold3248 hold3248/X _13585_/Q VPWR VGND sg13cmos5l_dlygate4sd3_1
X_14053__1338 _14053_/RESET_B VPWR VGND sg13cmos5l_tiehi
X_07914_ _11020_/A _14623_/Q _08752_/C _11635_/A VPWR VGND sg13cmos5l_o21ai_1
Xhold2514 _10151_/A _13840_/Q VPWR VGND sg13cmos5l_dlygate4sd3_1
Xhold2525 _10315_/A _13920_/Q VPWR VGND sg13cmos5l_dlygate4sd3_1
Xhold2536 _10460_/A _13991_/Q VPWR VGND sg13cmos5l_dlygate4sd3_1
Xhold2547 _07310_/A _13416_/Q VPWR VGND sg13cmos5l_dlygate4sd3_1
Xhold3259 _13094_/A _14531_/Q VPWR VGND sg13cmos5l_dlygate4sd3_1
XFILLER_69_696 VPWR VGND sg13cmos5l_fill_1
X_08894_ _08897_/B _08610_/A _08894_/B VPWR VGND sg13cmos5l_nand2b_1
Xhold2558 _07328_/A _14165_/Q VPWR VGND sg13cmos5l_dlygate4sd3_1
Xhold2569 _11373_/A _14326_/Q VPWR VGND sg13cmos5l_dlygate4sd3_1
XFILLER_29_549 VPWR VGND sg13cmos5l_decap_4
XFILLER_57_869 VPWR VGND sg13cmos5l_fill_2
XFILLER_96_493 VPWR VGND sg13cmos5l_decap_4
X_07845_ _07845_/Y _11007_/A _14572_/Q VPWR VGND sg13cmos5l_nor2_1
X_13249__1015 _13249_/RESET_B VPWR VGND sg13cmos5l_tiehi
XFILLER_84_677 VPWR VGND sg13cmos5l_fill_1
X_07776_ _07776_/Y _14395_/Q _12130_/A VPWR VGND sg13cmos5l_nand2b_1
XFILLER_65_880 VPWR VGND sg13cmos5l_fill_2
XFILLER_71_349 VPWR VGND sg13cmos5l_fill_2
X_09515_ _09515_/Y _07177_/Y _09508_/Y _09509_/A VPWR VGND sg13cmos5l_a21oi_1
X_09446_ _13556_/D _10681_/A1 hold3290/X _09453_/S VPWR VGND sg13cmos5l_mux2_1
X_13342__2080 _13342_/RESET_B VPWR VGND sg13cmos5l_tiehi
X_09377_ _09377_/Y _09377_/A _09443_/B VPWR VGND sg13cmos5l_nand2_1
X_08328_ _08328_/Y _08405_/A1 _08326_/X _08327_/Y _08325_/X _08391_/B1 VPWR VGND sg13cmos5l_a221oi_1
X_08259_ _08259_/Y _08275_/S _07305_/Y _08339_/B1 VPWR VGND sg13cmos5l_a21oi_1
X_13649__1742 _13649_/RESET_B VPWR VGND sg13cmos5l_tiehi
X_11270_ _11272_/B _11270_/A _11270_/B VPWR VGND sg13cmos5l_nor2_1
X_10221_ _10221_/Y _10221_/A _10351_/C VPWR VGND sg13cmos5l_nor2_1
XFILLER_79_438 VPWR VGND sg13cmos5l_decap_8
X_10152_ _13840_/D fanout58/X _10153_/B _10151_/Y VPWR VGND sg13cmos5l_o21ai_1
XFILLER_88_961 VPWR VGND sg13cmos5l_decap_8
X_10083_ _13806_/D fanout74/X _10082_/B _10082_/Y VPWR VGND sg13cmos5l_o21ai_1
X_14029__1362 _14029_/RESET_B VPWR VGND sg13cmos5l_tiehi
XFILLER_47_302 VPWR VGND sg13cmos5l_fill_1
XFILLER_48_836 VPWR VGND sg13cmos5l_fill_2
XFILLER_75_622 VPWR VGND sg13cmos5l_decap_8
XFILLER_88_994 VPWR VGND sg13cmos5l_decap_4
XFILLER_94_419 VPWR VGND sg13cmos5l_decap_8
X_13911_ _13911_/Q clkload49/A _13911_/D _13911_/RESET_B VPWR VGND sg13cmos5l_dfrbpq_1
X_13552__1870 _13552_/RESET_B VPWR VGND sg13cmos5l_tiehi
XFILLER_74_132 VPWR VGND sg13cmos5l_fill_1
X_13842_ _13842_/Q clkload53/A _13842_/D _13842_/RESET_B VPWR VGND sg13cmos5l_dfrbpq_1
XFILLER_56_880 VPWR VGND sg13cmos5l_fill_1
X_13773_ _13773_/Q _14053_/CLK _13773_/D _13773_/RESET_B VPWR VGND sg13cmos5l_dfrbpq_1
X_10985_ _10985_/Y _10983_/Y _10984_/Y _10848_/A VPWR VGND sg13cmos5l_o21ai_1
X_13897__1494 _13897_/RESET_B VPWR VGND sg13cmos5l_tiehi
X_12724_ _12724_/Y _12742_/A _12724_/B VPWR VGND sg13cmos5l_xnor2_1
XFILLER_15_276 VPWR VGND sg13cmos5l_fill_2
XFILLER_71_872 VPWR VGND sg13cmos5l_fill_2
XFILLER_71_883 VPWR VGND sg13cmos5l_fill_1
XFILLER_12_950 VPWR VGND sg13cmos5l_fill_2
X_12655_ _12656_/B _11150_/X _12549_/X _12550_/X _11157_/A VPWR VGND sg13cmos5l_a22oi_1
X_11606_ _11611_/B _11606_/A _11606_/B VPWR VGND sg13cmos5l_nand2_1
X_12586_ _12586_/Y _13033_/B _12639_/C _12641_/A _12585_/X VPWR VGND sg13cmos5l_a22oi_1
XFILLER_11_493 VPWR VGND sg13cmos5l_decap_4
X_11537_ _11537_/Y _11464_/A _11532_/Y _11466_/A VPWR VGND sg13cmos5l_o21ai_1
X_14325_ _14325_/Q _14453_/CLK _14325_/D _14325_/RESET_B VPWR VGND sg13cmos5l_dfrbpq_1
X_11468_ _14331_/D _11466_/Y _11467_/Y _11449_/Y VPWR VGND sg13cmos5l_o21ai_1
X_14256_ _14256_/Q clkload66/A _14256_/D _14256_/RESET_B VPWR VGND sg13cmos5l_dfrbpq_1
X_10419_ _13970_/D _10419_/A1 _10466_/B _10418_/Y VPWR VGND sg13cmos5l_a21oi_1
X_11399_ _11413_/B _11399_/A _11456_/A VPWR VGND sg13cmos5l_or2_1
X_14187_ _14187_/Q _14614_/CLK _14187_/D _14187_/RESET_B VPWR VGND sg13cmos5l_dfrbpq_1
X_13207_ _13207_/Q clkload8/A _13207_/D fanout958/X VPWR VGND sg13cmos5l_dfrbpq_1
XFILLER_3_670 VPWR VGND sg13cmos5l_fill_2
X_13384__2038 _13384_/RESET_B VPWR VGND sg13cmos5l_tiehi
X_13138_ _13138_/Y _08032_/Y _13138_/B VPWR VGND sg13cmos5l_nand2b_1
XFILLER_100_708 VPWR VGND sg13cmos5l_decap_8
XFILLER_79_950 VPWR VGND sg13cmos5l_decap_8
XFILLER_79_961 VPWR VGND sg13cmos5l_fill_2
XFILLER_85_408 VPWR VGND sg13cmos5l_fill_1
Xclkbuf_leaf_2_clk _14577_/CLK clkbuf_4_2_0_clk/X VPWR VGND sg13cmos5l_buf_8
X_13069_ _13069_/Y _13069_/A _13069_/B VPWR VGND sg13cmos5l_xnor2_1
XFILLER_66_644 VPWR VGND sg13cmos5l_fill_1
XFILLER_78_493 VPWR VGND sg13cmos5l_decap_4
XFILLER_66_688 VPWR VGND sg13cmos5l_decap_8
X_07630_ _07634_/C _07630_/A _07630_/B VPWR VGND sg13cmos5l_xnor2_1
XFILLER_0_1025 VPWR VGND sg13cmos5l_decap_4
XFILLER_53_327 VPWR VGND sg13cmos5l_decap_8
X_07561_ _08156_/B _08062_/S _12964_/A _08155_/A VPWR VGND sg13cmos5l_nor3_1
XFILLER_34_530 VPWR VGND sg13cmos5l_fill_1
X_09300_ _13420_/D _08344_/A hold3320/X _09307_/B VPWR VGND sg13cmos5l_mux2_1
X_13727__1664 _13727_/RESET_B VPWR VGND sg13cmos5l_tiehi
XFILLER_55_1027 VPWR VGND sg13cmos5l_fill_2
XFILLER_62_872 VPWR VGND sg13cmos5l_decap_8
X_07492_ _07492_/Y _07492_/A VPWR VGND sg13cmos5l_inv_1
X_09231_ _13357_/D _07319_/Y _09230_/B _09230_/Y VPWR VGND sg13cmos5l_a21oi_1
X_09162_ _13323_/D _09161_/B _09160_/Y _09161_/Y VPWR VGND sg13cmos5l_a21oi_1
X_08113_ _08113_/Y _08113_/A _09344_/A _13119_/B VPWR VGND sg13cmos5l_nand3_1
X_13594__1828 _13594_/RESET_B VPWR VGND sg13cmos5l_tiehi
X_09093_ _09093_/Y _11344_/A _09092_/Y _09112_/A2 VPWR VGND sg13cmos5l_a21oi_1
X_08044_ _08046_/C _08044_/A _08044_/B _08044_/C VPWR VGND sg13cmos5l_nand3_1
XFILLER_0_106 VPWR VGND sg13cmos5l_fill_1
Xhold3001 hold3001/X _13433_/Q VPWR VGND sg13cmos5l_dlygate4sd3_1
Xhold3012 hold3012/X _13447_/Q VPWR VGND sg13cmos5l_dlygate4sd3_1
Xhold3023 _09635_/A _13609_/Q VPWR VGND sg13cmos5l_dlygate4sd3_1
X_09995_ _09995_/Y _09995_/A _10017_/B VPWR VGND sg13cmos5l_nand2_1
Xhold2300 _10103_/A _13816_/Q VPWR VGND sg13cmos5l_dlygate4sd3_1
Xhold2311 _11386_/A _14327_/Q VPWR VGND sg13cmos5l_dlygate4sd3_1
Xhold2322 _14137_/D _10731_/Y VPWR VGND sg13cmos5l_dlygate4sd3_1
Xhold3034 _13479_/D _09366_/X VPWR VGND sg13cmos5l_dlygate4sd3_1
Xhold3045 _09720_/A _13629_/Q VPWR VGND sg13cmos5l_dlygate4sd3_1
Xhold3056 hold3056/X _13541_/Q VPWR VGND sg13cmos5l_dlygate4sd3_1
XFILLER_69_471 VPWR VGND sg13cmos5l_fill_1
XFILLER_85_920 VPWR VGND sg13cmos5l_fill_2
X_08946_ _13260_/D _08087_/A hold3372/X _10781_/B VPWR VGND sg13cmos5l_mux2_1
Xhold2333 _10001_/A _13766_/Q VPWR VGND sg13cmos5l_dlygate4sd3_1
Xhold2344 _14133_/D _10719_/Y VPWR VGND sg13cmos5l_dlygate4sd3_1
Xhold2355 _08146_/A _13222_/Q VPWR VGND sg13cmos5l_dlygate4sd3_1
Xhold3067 hold3067/X _14126_/Q VPWR VGND sg13cmos5l_dlygate4sd3_1
Xhold3078 hold3078/X _14604_/Q VPWR VGND sg13cmos5l_dlygate4sd3_1
Xhold3089 hold3089/X _13373_/Q VPWR VGND sg13cmos5l_dlygate4sd3_1
X_08877_ _14647_/D _08877_/A _08877_/B VPWR VGND sg13cmos5l_nand2_1
Xhold2366 _10754_/A _14145_/Q VPWR VGND sg13cmos5l_dlygate4sd3_1
Xhold2377 _12973_/A _14474_/Q VPWR VGND sg13cmos5l_dlygate4sd3_1
Xhold2388 _10507_/A _14014_/Q VPWR VGND sg13cmos5l_dlygate4sd3_1
XFILLER_29_357 VPWR VGND sg13cmos5l_fill_2
XFILLER_45_806 VPWR VGND sg13cmos5l_fill_2
XFILLER_85_997 VPWR VGND sg13cmos5l_decap_4
X_07828_ _08479_/B _14381_/Q _11740_/A VPWR VGND sg13cmos5l_nand2_1
Xhold2399 _10501_/A _14011_/Q VPWR VGND sg13cmos5l_dlygate4sd3_1
XFILLER_84_485 VPWR VGND sg13cmos5l_fill_2
X_07759_ _08535_/A _14390_/Q _14358_/Q VPWR VGND sg13cmos5l_nor2_1
XFILLER_40_511 VPWR VGND sg13cmos5l_fill_1
X_10770_ _10770_/Y _10805_/B _10768_/Y _10769_/Y VPWR VGND sg13cmos5l_o21ai_1
X_09429_ _09429_/X _14117_/Q hold3046/X _09434_/S VPWR VGND sg13cmos5l_mux2_1
XFILLER_100_62 VPWR VGND sg13cmos5l_fill_1
X_12440_ _14376_/D _11101_/A _12447_/S _12439_/Y _08716_/A VPWR VGND sg13cmos5l_a22oi_1
XFILLER_21_791 VPWR VGND sg13cmos5l_fill_1
X_14110_ _14110_/Q clkload31/A _14110_/D _07198_/A VPWR VGND sg13cmos5l_dfrbpq_1
X_12371_ _12371_/Y _12369_/Y _12370_/Y _12430_/A1 VPWR VGND sg13cmos5l_a21oi_1
X_11322_ _11337_/B _11322_/A _11322_/B VPWR VGND sg13cmos5l_nand2_1
X_14393__1115 _14393_/RESET_B VPWR VGND sg13cmos5l_tiehi
X_11253_ _11268_/B _11253_/A _11253_/B VPWR VGND sg13cmos5l_nand2_1
X_14041_ _14041_/Q _14048_/CLK _14041_/D _14041_/RESET_B VPWR VGND sg13cmos5l_dfrbpq_1
XFILLER_4_489 VPWR VGND sg13cmos5l_fill_2
X_10204_ _13865_/D _10399_/A1 _10217_/B _10203_/Y VPWR VGND sg13cmos5l_a21oi_1
X_11184_ _11184_/Y _11184_/A _11196_/B VPWR VGND sg13cmos5l_nand2_1
X_13805__1586 _13805_/RESET_B VPWR VGND sg13cmos5l_tiehi
XFILLER_0_673 VPWR VGND sg13cmos5l_fill_1
XFILLER_95_728 VPWR VGND sg13cmos5l_fill_1
X_10135_ _10135_/Y _10135_/A _10143_/B VPWR VGND sg13cmos5l_nand2_1
X_10066_ _10066_/Y _10066_/A _10082_/B VPWR VGND sg13cmos5l_nand2_1
XFILLER_36_817 VPWR VGND sg13cmos5l_fill_1
X_13984__1407 _13984_/RESET_B VPWR VGND sg13cmos5l_tiehi
XFILLER_85_96 VPWR VGND sg13cmos5l_fill_1
X_13825_ _13825_/Q clkload57/A _13825_/D _13825_/RESET_B VPWR VGND sg13cmos5l_dfrbpq_1
XFILLER_44_850 VPWR VGND sg13cmos5l_fill_2
X_10968_ _10969_/C _10971_/A _10971_/C VPWR VGND sg13cmos5l_nand2_1
X_13756_ _13756_/Q clkload47/A _13756_/D _13756_/RESET_B VPWR VGND sg13cmos5l_dfrbpq_1
X_13687_ _13687_/Q clkload16/A _13687_/D _13687_/RESET_B VPWR VGND sg13cmos5l_dfrbpq_1
X_12707_ _12707_/Y _12651_/Y _12706_/X _11008_/A VPWR VGND sg13cmos5l_a21oi_1
XFILLER_31_577 VPWR VGND sg13cmos5l_fill_1
X_10899_ _14196_/D _10946_/A _10897_/Y _10898_/Y VPWR VGND sg13cmos5l_o21ai_1
X_12638_ _12642_/A _12636_/Y _12637_/Y _12548_/Y VPWR VGND sg13cmos5l_a21o_1
X_12569_ _14407_/D _12594_/A _12569_/B VPWR VGND sg13cmos5l_nor2_1
X_14308_ _14308_/Q clkload39/A _14308_/D _14308_/RESET_B VPWR VGND sg13cmos5l_dfrbpq_1
X_14239_ _14239_/Q clkload45/A _14239_/D _14239_/RESET_B VPWR VGND sg13cmos5l_dfrbpq_1
XFILLER_86_706 VPWR VGND sg13cmos5l_decap_4
X_08800_ _14627_/D hold2821/X _08822_/B _08799_/Y VPWR VGND sg13cmos5l_a21o_1
Xfanout719 _08848_/B _08905_/B1 VPWR VGND sg13cmos5l_buf_1
Xfanout708 _12945_/A2 _07936_/B1 VPWR VGND sg13cmos5l_buf_1
XFILLER_22_0 VPWR VGND sg13cmos5l_fill_1
X_09780_ _13657_/D _10367_/A1 _09793_/B _09779_/Y VPWR VGND sg13cmos5l_a21oi_1
X_08731_ _08731_/Y _08728_/Y _08730_/Y _08687_/A VPWR VGND sg13cmos5l_a21oi_1
XFILLER_67_975 VPWR VGND sg13cmos5l_decap_8
X_08662_ _08662_/Y _08654_/Y _08657_/Y _08659_/Y _08660_/Y _08661_/Y VPWR VGND sg13cmos5l_a221oi_1
XFILLER_53_113 VPWR VGND sg13cmos5l_fill_2
XFILLER_54_636 VPWR VGND sg13cmos5l_decap_8
XFILLER_54_647 VPWR VGND sg13cmos5l_decap_8
X_07613_ _07614_/B _07613_/A _07613_/B VPWR VGND sg13cmos5l_nand2_1
XFILLER_53_124 VPWR VGND sg13cmos5l_fill_2
XFILLER_81_444 VPWR VGND sg13cmos5l_decap_8
X_08593_ _08607_/C _08593_/A _08593_/B VPWR VGND sg13cmos5l_nor2_1
XFILLER_81_488 VPWR VGND sg13cmos5l_fill_1
X_07544_ _07546_/C _14544_/Q _13297_/Q VPWR VGND sg13cmos5l_xor2_1
XFILLER_22_522 VPWR VGND sg13cmos5l_fill_2
X_07475_ _07476_/A _13554_/Q _13522_/Q _13490_/Q _13458_/Q _08164_/S0 _08254_/A1 VPWR
+ VGND sg13cmos5l_mux4_1
X_09214_ _13343_/D _07973_/A hold3142/X _09235_/S VPWR VGND sg13cmos5l_mux2_1
X_14174__1303 _14174_/RESET_B VPWR VGND sg13cmos5l_tiehi
X_09145_ _11483_/A _14333_/Q _09163_/B VPWR VGND sg13cmos5l_nand2_1
X_09076_ _09076_/Y _14353_/Q _09076_/A2 _09075_/Y VPWR VGND sg13cmos5l_a21oi_1
X_08027_ _08032_/A _14557_/Q _08043_/B VPWR VGND sg13cmos5l_xor2_1
XFILLER_104_833 VPWR VGND sg13cmos5l_fill_2
XFILLER_1_459 VPWR VGND sg13cmos5l_fill_1
XFILLER_104_899 VPWR VGND sg13cmos5l_fill_1
XFILLER_49_408 VPWR VGND sg13cmos5l_decap_8
XFILLER_58_920 VPWR VGND sg13cmos5l_fill_1
X_09978_ _13754_/D _10369_/A1 _09977_/B _09977_/Y VPWR VGND sg13cmos5l_o21ai_1
X_08929_ _13249_/D _07287_/Y _13196_/A2 _13190_/B1 _08928_/Y VPWR VGND sg13cmos5l_a22oi_1
XFILLER_57_452 VPWR VGND sg13cmos5l_fill_2
XFILLER_57_463 VPWR VGND sg13cmos5l_fill_2
X_11940_ _11940_/Y _13888_/Q _11944_/B2 _11862_/B _13696_/Q _11939_/X VPWR VGND sg13cmos5l_a221oi_1
X_11871_ _14353_/D _11846_/A _11738_/S _11851_/Y _11870_/Y VPWR VGND sg13cmos5l_a22oi_1
X_10822_ _14170_/D _14250_/D hold3310/X _10832_/S VPWR VGND sg13cmos5l_mux2_1
X_14590_ _14590_/Q clkload54/A _14590_/D _14590_/RESET_B VPWR VGND sg13cmos5l_dfrbpq_1
X_13610_ _13610_/Q clkload51/A _13610_/D _13610_/RESET_B VPWR VGND sg13cmos5l_dfrbpq_1
XFILLER_13_511 VPWR VGND sg13cmos5l_fill_2
XFILLER_53_680 VPWR VGND sg13cmos5l_decap_4
X_10753_ _10753_/Y _10801_/A _14289_/Q VPWR VGND sg13cmos5l_nand2_1
X_14301__1207 _14301_/RESET_B VPWR VGND sg13cmos5l_tiehi
X_13541_ _13541_/Q clkload42/A _13541_/D _13541_/RESET_B VPWR VGND sg13cmos5l_dfrbpq_1
X_10684_ _14104_/D input13/X hold3441/X _10685_/S VPWR VGND sg13cmos5l_mux2_1
X_13472_ _13472_/Q clkload33/A _13472_/D _13472_/RESET_B VPWR VGND sg13cmos5l_dfrbpq_1
X_12423_ _12423_/Y _12419_/Y _12420_/Y _12421_/Y _12422_/Y VPWR VGND sg13cmos5l_a22oi_1
XFILLER_5_732 VPWR VGND sg13cmos5l_fill_1
X_12354_ _12354_/Y _14369_/Q _12405_/B VPWR VGND sg13cmos5l_nand2_1
X_11305_ _11305_/Y _11243_/A _11303_/B _11318_/B1 VPWR VGND sg13cmos5l_o21ai_1
XFILLER_4_264 VPWR VGND sg13cmos5l_fill_2
X_12285_ _12307_/B _12284_/A _12284_/C _12329_/A VPWR VGND sg13cmos5l_o21ai_1
X_14024_ _14024_/Q clkload78/A _14024_/D _14024_/RESET_B VPWR VGND sg13cmos5l_dfrbpq_1
XFILLER_45_1004 VPWR VGND sg13cmos5l_fill_1
X_11236_ _11236_/Y _14088_/Q _11256_/C VPWR VGND sg13cmos5l_nand2_1
X_11167_ _11170_/A _14311_/Q _09491_/B _11197_/S VPWR VGND sg13cmos5l_mux2_1
X_10118_ _13823_/D _10575_/A1 _10119_/B _10117_/Y VPWR VGND sg13cmos5l_o21ai_1
XFILLER_64_901 VPWR VGND sg13cmos5l_decap_8
X_11098_ _11098_/Y _14391_/Q _11121_/B _11097_/Y VPWR VGND sg13cmos5l_a21oi_1
XFILLER_76_794 VPWR VGND sg13cmos5l_decap_8
X_10049_ _13789_/D _10571_/A1 _10052_/B _10048_/Y VPWR VGND sg13cmos5l_o21ai_1
XFILLER_17_861 VPWR VGND sg13cmos5l_fill_2
XFILLER_51_606 VPWR VGND sg13cmos5l_decap_8
XFILLER_90_252 VPWR VGND sg13cmos5l_fill_2
X_13808_ _13808_/Q _14064_/CLK _13808_/D _13808_/RESET_B VPWR VGND sg13cmos5l_dfrbpq_1
X_13739_ _13739_/Q clkload62/A _13739_/D _13739_/RESET_B VPWR VGND sg13cmos5l_dfrbpq_1
X_07260_ _11638_/B _14579_/Q VPWR VGND sg13cmos5l_inv_1
X_07191_ _07191_/Y _10807_/A VPWR VGND sg13cmos5l_inv_1
X_09901_ _13716_/D _10553_/A1 _09910_/B _09900_/Y VPWR VGND sg13cmos5l_a21oi_1
Xfanout505 fanout505/X _08650_/X VPWR VGND sg13cmos5l_buf_1
XFILLER_59_739 VPWR VGND sg13cmos5l_decap_4
XFILLER_86_503 VPWR VGND sg13cmos5l_fill_2
X_09832_ _09832_/Y _09832_/A _09844_/B VPWR VGND sg13cmos5l_nor2_1
Xfanout538 _11840_/A _11635_/Y VPWR VGND sg13cmos5l_buf_1
Xfanout527 _07465_/B _07431_/Y VPWR VGND sg13cmos5l_buf_1
Xfanout516 _12419_/A2 _12426_/B VPWR VGND sg13cmos5l_buf_1
XFILLER_100_302 VPWR VGND sg13cmos5l_fill_2
X_09763_ _10286_/A _10351_/A _10351_/B VPWR VGND sg13cmos5l_nand2b_1
Xfanout549 _09691_/A _09640_/A1 VPWR VGND sg13cmos5l_buf_1
X_08714_ _08714_/Y _08734_/B _08714_/B VPWR VGND sg13cmos5l_nand2b_1
XFILLER_66_271 VPWR VGND sg13cmos5l_fill_2
X_09694_ _13617_/D _09693_/B fanout55/X _09693_/Y VPWR VGND sg13cmos5l_a21oi_1
XFILLER_54_455 VPWR VGND sg13cmos5l_decap_4
XFILLER_55_978 VPWR VGND sg13cmos5l_fill_2
X_08645_ _08655_/A _14175_/Q _14178_/Q _12449_/A VPWR VGND sg13cmos5l_mux2_1
X_08576_ _08576_/Y _08541_/Y _08576_/B VPWR VGND sg13cmos5l_nand2b_1
X_07527_ _07529_/A _14526_/Q _07512_/B _07527_/B1 _15887_/A VPWR VGND sg13cmos5l_a22oi_1
X_07458_ _14247_/D _08168_/A _13032_/A _07457_/Y VPWR VGND sg13cmos5l_o21ai_1
X_07389_ _07391_/C _13326_/Q _07389_/B _07389_/C VPWR VGND sg13cmos5l_nand3_1
X_09128_ _09128_/Y _14426_/Q _11450_/A VPWR VGND sg13cmos5l_nand2_1
XFILLER_1_201 VPWR VGND sg13cmos5l_fill_1
X_09059_ _09059_/Y _11765_/A _09076_/A2 _09058_/Y VPWR VGND sg13cmos5l_a21oi_1
XFILLER_89_341 VPWR VGND sg13cmos5l_fill_2
X_12070_ _12070_/Y _07764_/B _12124_/A2 _12162_/B VPWR VGND sg13cmos5l_a21oi_1
X_11021_ _11021_/Y _14240_/Q _11021_/B VPWR VGND sg13cmos5l_nand2_1
X_13686__1705 _13686_/RESET_B VPWR VGND sg13cmos5l_tiehi
XFILLER_106_50 VPWR VGND sg13cmos5l_fill_1
X_12972_ _12975_/B _12973_/A _12973_/B VPWR VGND sg13cmos5l_and2_1
X_11923_ _11924_/B _12097_/A1 _12476_/B _11922_/Y VPWR VGND sg13cmos5l_o21ai_1
X_11854_ _11854_/Y _13757_/Q _11914_/A2 _11783_/B VPWR VGND sg13cmos5l_a21oi_1
X_14642_ _14642_/Q clkload76/A _14642_/D _14642_/RESET_B VPWR VGND sg13cmos5l_dfrbpq_1
X_10805_ _10805_/Y _10805_/A _10805_/B VPWR VGND sg13cmos5l_nand2_1
X_11785_ _11785_/Y _13850_/Q _11785_/B VPWR VGND sg13cmos5l_nand2_1
X_14573_ _14573_/Q clkload44/A _14573_/D _14573_/RESET_B VPWR VGND sg13cmos5l_dfrbpq_1
X_10736_ _10736_/Y _10736_/A _10796_/B VPWR VGND sg13cmos5l_nand2_1
X_13524_ _13524_/Q _14520_/CLK _13524_/D _13524_/RESET_B VPWR VGND sg13cmos5l_dfrbpq_1
X_10667_ _14091_/D _14272_/D hold3480/X _10675_/S VPWR VGND sg13cmos5l_mux2_1
X_13455_ _13455_/Q clkload33/A _13455_/D _13455_/RESET_B VPWR VGND sg13cmos5l_dfrbpq_1
X_12406_ _12406_/Y _07210_/Y _12301_/B _11840_/A _12405_/Y VPWR VGND sg13cmos5l_a22oi_1
X_10598_ _10598_/Y _10598_/A _10610_/B VPWR VGND sg13cmos5l_nand2_1
X_13386_ _13386_/Q clkload35/A _13386_/D _13386_/RESET_B VPWR VGND sg13cmos5l_dfrbpq_1
X_12337_ _12338_/C _12360_/A _12359_/A VPWR VGND sg13cmos5l_nor2b_1
XFILLER_99_149 VPWR VGND sg13cmos5l_fill_1
X_12268_ _12270_/B _13739_/Q _12292_/B VPWR VGND sg13cmos5l_nand2_1
X_11219_ _14315_/D _11217_/Y _11218_/Y _11207_/Y VPWR VGND sg13cmos5l_o21ai_1
X_14007_ _14007_/Q _14299_/CLK _14007_/D _14007_/RESET_B VPWR VGND sg13cmos5l_dfrbpq_1
X_12199_ _12199_/Y _13897_/Q _12195_/B _12087_/B _13705_/Q VPWR VGND sg13cmos5l_a22oi_1
XFILLER_83_506 VPWR VGND sg13cmos5l_fill_1
X_14639__2182 _14639_/RESET_B VPWR VGND sg13cmos5l_tiehi
XFILLER_64_731 VPWR VGND sg13cmos5l_fill_2
X_08430_ _08434_/B _10652_/A _08430_/B VPWR VGND sg13cmos5l_nand2b_1
X_15889_ _15889_/X _15889_/A VPWR VGND sg13cmos5l_buf_1
XFILLER_23_105 VPWR VGND sg13cmos5l_fill_1
XFILLER_51_425 VPWR VGND sg13cmos5l_decap_8
X_08361_ _08361_/Y _13421_/Q _08361_/B VPWR VGND sg13cmos5l_nand2b_1
X_07312_ _07312_/Y _07312_/A VPWR VGND sg13cmos5l_inv_1
X_08292_ _12611_/A _08244_/C _08282_/X _08291_/Y VPWR VGND sg13cmos5l_a21oi_1
X_07243_ _07712_/B _14347_/Q VPWR VGND sg13cmos5l_inv_1
X_13764__1627 _13764_/RESET_B VPWR VGND sg13cmos5l_tiehi
X_13800__1591 _13800_/RESET_B VPWR VGND sg13cmos5l_tiehi
X_07174_ _09534_/A _14445_/Q VPWR VGND sg13cmos5l_inv_1
XFILLER_105_427 VPWR VGND sg13cmos5l_fill_1
XFILLER_101_600 VPWR VGND sg13cmos5l_fill_1
Xfanout313 _09793_/B _09813_/B VPWR VGND sg13cmos5l_buf_1
Xfanout302 _09858_/B _09859_/A2 VPWR VGND sg13cmos5l_buf_1
X_09815_ _09815_/Y _09815_/A _09817_/B VPWR VGND sg13cmos5l_nor2_1
Xfanout357 _13196_/B1 _08918_/Y VPWR VGND sg13cmos5l_buf_1
Xfanout346 _09578_/B fanout354/X VPWR VGND sg13cmos5l_buf_1
Xfanout335 _10298_/A1 _09516_/Y VPWR VGND sg13cmos5l_buf_1
Xfanout324 _09746_/B _09726_/B VPWR VGND sg13cmos5l_buf_1
XFILLER_59_558 VPWR VGND sg13cmos5l_fill_2
Xfanout379 _08252_/A _07403_/A VPWR VGND sg13cmos5l_buf_1
Xfanout368 _08202_/A _08165_/A VPWR VGND sg13cmos5l_buf_1
XFILLER_28_934 VPWR VGND sg13cmos5l_fill_2
XFILLER_67_580 VPWR VGND sg13cmos5l_decap_8
X_09746_ _09746_/Y _09746_/A _09746_/B VPWR VGND sg13cmos5l_nor2_1
X_09677_ _09677_/Y _09676_/A _09676_/B _09691_/A VPWR VGND sg13cmos5l_a21oi_1
X_13397__2025 _13397_/RESET_B VPWR VGND sg13cmos5l_tiehi
XFILLER_54_263 VPWR VGND sg13cmos5l_fill_2
XFILLER_55_786 VPWR VGND sg13cmos5l_decap_8
X_08628_ _14613_/D _08628_/A _08628_/B VPWR VGND sg13cmos5l_xnor2_1
XFILLER_14_127 VPWR VGND sg13cmos5l_fill_1
XFILLER_82_583 VPWR VGND sg13cmos5l_decap_4
XFILLER_23_650 VPWR VGND sg13cmos5l_fill_1
X_08559_ _08559_/Y _08559_/A _08559_/B VPWR VGND sg13cmos5l_nor2_1
X_11570_ _14338_/D _11568_/Y _11569_/Y _11560_/Y VPWR VGND sg13cmos5l_o21ai_1
X_10521_ _10521_/Y _10521_/A _10537_/B VPWR VGND sg13cmos5l_nand2_1
X_13240_ _13240_/Q clkload66/A _13240_/D _13240_/RESET_B VPWR VGND sg13cmos5l_dfrbpq_1
X_10452_ _10452_/Y _10452_/A _10474_/B VPWR VGND sg13cmos5l_nor2_1
X_13428__1994 _13428_/RESET_B VPWR VGND sg13cmos5l_tiehi
X_10383_ _13953_/D _10514_/A1 _10384_/B _10382_/Y VPWR VGND sg13cmos5l_a21oi_1
X_13171_ _13171_/Y _11258_/A _14088_/Q _08917_/X hold3523/X VPWR VGND sg13cmos5l_a22oi_1
X_12122_ _12122_/Y _12116_/Y _12117_/Y _12351_/A1 VPWR VGND sg13cmos5l_a21oi_1
X_12053_ _12053_/Y _13796_/Q _12055_/B _12238_/B1 VPWR VGND sg13cmos5l_a21oi_1
XFILLER_104_460 VPWR VGND sg13cmos5l_fill_1
XFILLER_77_322 VPWR VGND sg13cmos5l_fill_1
XFILLER_89_160 VPWR VGND sg13cmos5l_fill_2
X_11004_ _14235_/D _12594_/A _11004_/B VPWR VGND sg13cmos5l_nor2_1
XFILLER_93_815 VPWR VGND sg13cmos5l_fill_1
Xfanout891 _08320_/A _14123_/Q VPWR VGND sg13cmos5l_buf_1
Xfanout880 _11556_/A _11464_/A VPWR VGND sg13cmos5l_buf_1
X_13842__1549 _13842_/RESET_B VPWR VGND sg13cmos5l_tiehi
X_12955_ _12956_/A _14465_/Q _11560_/B _11575_/C _12955_/B2 VPWR VGND sg13cmos5l_a22oi_1
XFILLER_80_509 VPWR VGND sg13cmos5l_decap_8
X_11906_ _11906_/Y _11903_/B _11900_/Y _11905_/Y VPWR VGND sg13cmos5l_o21ai_1
XFILLER_45_296 VPWR VGND sg13cmos5l_fill_1
X_12886_ _12886_/Y _14466_/Q _13256_/Q _12885_/Y VPWR VGND sg13cmos5l_a21oi_1
X_11837_ _11837_/Y _11832_/Y _11833_/Y _11834_/Y _11836_/Y _11837_/C1 VPWR VGND sg13cmos5l_a221oi_1
X_14625_ _14625_/Q clkload45/A _14625_/D _14625_/RESET_B VPWR VGND sg13cmos5l_dfrbpq_1
X_11768_ _11769_/C _11768_/A _11768_/B _11768_/C VPWR VGND sg13cmos5l_nand3_1
X_14556_ _14556_/Q clkload11/A _14556_/D fanout983/X VPWR VGND sg13cmos5l_dfrbpq_1
X_10719_ _10719_/Y _10766_/B _10717_/Y _10718_/Y VPWR VGND sg13cmos5l_o21ai_1
X_13507_ _13507_/Q clkload29/A _13507_/D _13507_/RESET_B VPWR VGND sg13cmos5l_dfrbpq_1
XFILLER_9_164 VPWR VGND sg13cmos5l_decap_8
X_11699_ _11699_/Y _11695_/Y _11696_/Y _11697_/Y _11698_/Y VPWR VGND sg13cmos5l_a22oi_1
X_14487_ _14487_/Q _14577_/CLK _14487_/D fanout965/X VPWR VGND sg13cmos5l_dfrbpq_1
XFILLER_9_197 VPWR VGND sg13cmos5l_fill_2
X_13438_ _13438_/Q clkload32/A _13438_/D _13438_/RESET_B VPWR VGND sg13cmos5l_dfrbpq_1
X_13369_ _13369_/Q _14621_/CLK _13369_/D _13369_/RESET_B VPWR VGND sg13cmos5l_dfrbpq_1
XFILLER_88_609 VPWR VGND sg13cmos5l_decap_4
X_07930_ _14569_/D _07944_/A _07930_/B _07930_/C VPWR VGND sg13cmos5l_nor3_1
Xhold3419 hold3419/X _14251_/Q VPWR VGND sg13cmos5l_dlygate4sd3_1
Xhold3408 hold3408/X _14252_/Q VPWR VGND sg13cmos5l_dlygate4sd3_1
Xhold2707 _08100_/A _13199_/Q VPWR VGND sg13cmos5l_dlygate4sd3_1
Xhold2718 _10339_/A _13932_/Q VPWR VGND sg13cmos5l_dlygate4sd3_1
Xhold2729 _09710_/A _13624_/Q VPWR VGND sg13cmos5l_dlygate4sd3_1
XFILLER_69_889 VPWR VGND sg13cmos5l_decap_4
X_07861_ _07864_/A _10987_/A _10987_/C VPWR VGND sg13cmos5l_nand2_1
XFILLER_56_506 VPWR VGND sg13cmos5l_fill_1
X_07792_ _08594_/A _14398_/Q _14366_/Q VPWR VGND sg13cmos5l_and2_1
X_09600_ _13603_/D _09666_/B _10453_/A1 _09594_/Y VPWR VGND sg13cmos5l_a21oi_1
XFILLER_49_580 VPWR VGND sg13cmos5l_fill_1
X_09531_ _13593_/D _09578_/B _10563_/A1 _09530_/Y VPWR VGND sg13cmos5l_a21oi_1
X_13818__1573 _13818_/RESET_B VPWR VGND sg13cmos5l_tiehi
XFILLER_52_734 VPWR VGND sg13cmos5l_decap_8
XFILLER_64_583 VPWR VGND sg13cmos5l_fill_2
X_09462_ _09462_/X _14117_/Q hold3155/X _09467_/S VPWR VGND sg13cmos5l_mux2_1
XFILLER_91_391 VPWR VGND sg13cmos5l_fill_2
X_08413_ _08413_/Y _08416_/S _13393_/Q _08412_/Y VPWR VGND sg13cmos5l_o21ai_1
X_09393_ _13505_/D _08206_/A hold3017/X _09405_/S VPWR VGND sg13cmos5l_mux2_1
X_08344_ _08344_/Y _08344_/A _08397_/B _08344_/C VPWR VGND sg13cmos5l_nand3_1
XFILLER_32_491 VPWR VGND sg13cmos5l_fill_2
XFILLER_20_664 VPWR VGND sg13cmos5l_fill_1
XFILLER_20_675 VPWR VGND sg13cmos5l_fill_1
X_08275_ _08275_/X _13574_/Q _13542_/Q _08275_/S VPWR VGND sg13cmos5l_mux2_1
X_07226_ _07764_/A _14391_/Q VPWR VGND sg13cmos5l_inv_1
XFILLER_106_703 VPWR VGND sg13cmos5l_decap_8
XFILLER_106_769 VPWR VGND sg13cmos5l_decap_8
Xfanout121 _09441_/S _09410_/Y VPWR VGND sg13cmos5l_buf_1
Xfanout110 _10326_/A1 _09613_/Y VPWR VGND sg13cmos5l_buf_1
Xfanout165 _10751_/B _10799_/B VPWR VGND sg13cmos5l_buf_1
Xfanout154 _10581_/A1 _09592_/Y VPWR VGND sg13cmos5l_buf_1
Xfanout143 _10591_/A1 _09627_/Y VPWR VGND sg13cmos5l_buf_1
Xfanout132 _10832_/S _10829_/S VPWR VGND sg13cmos5l_buf_1
XFILLER_19_219 VPWR VGND sg13cmos5l_fill_2
XFILLER_47_528 VPWR VGND sg13cmos5l_decap_8
Xfanout198 _08344_/C _08409_/C VPWR VGND sg13cmos5l_buf_1
Xfanout187 _10377_/A1 _09564_/Y VPWR VGND sg13cmos5l_buf_1
Xfanout176 _10579_/A1 _10514_/A1 VPWR VGND sg13cmos5l_buf_1
XFILLER_47_67 VPWR VGND sg13cmos5l_fill_2
XFILLER_74_336 VPWR VGND sg13cmos5l_fill_2
X_09729_ _13633_/D _10579_/A1 _09730_/B _09728_/Y VPWR VGND sg13cmos5l_a21oi_1
XFILLER_74_369 VPWR VGND sg13cmos5l_fill_2
XFILLER_43_712 VPWR VGND sg13cmos5l_fill_2
X_12740_ _12740_/Y _14357_/Q _12164_/B fanout60/X _12739_/X VPWR VGND sg13cmos5l_a22oi_1
XFILLER_103_95 VPWR VGND sg13cmos5l_fill_1
XFILLER_63_55 VPWR VGND sg13cmos5l_fill_1
XFILLER_63_66 VPWR VGND sg13cmos5l_fill_2
XFILLER_70_564 VPWR VGND sg13cmos5l_fill_1
X_12671_ _12671_/Y _12669_/Y _12670_/Y _12792_/A VPWR VGND sg13cmos5l_a21oi_1
XFILLER_70_597 VPWR VGND sg13cmos5l_decap_4
X_11622_ _11622_/Y _11622_/A _11622_/B _11622_/C _11622_/D VPWR VGND sg13cmos5l_nand4_1
X_14410_ _14410_/Q clkload40/A _14410_/D _14410_/RESET_B VPWR VGND sg13cmos5l_dfrbpq_1
X_14341_ _14341_/Q clkload73/A _14341_/D _14341_/RESET_B VPWR VGND sg13cmos5l_dfrbpq_1
X_11553_ _11575_/B _11553_/A _11553_/B VPWR VGND sg13cmos5l_and2_1
X_13515__1907 _13515_/RESET_B VPWR VGND sg13cmos5l_tiehi
XFILLER_6_112 VPWR VGND sg13cmos5l_fill_2
X_10504_ _14012_/D _10569_/A1 _10511_/B _10503_/Y VPWR VGND sg13cmos5l_o21ai_1
X_11484_ _11514_/A _11484_/A _11504_/B VPWR VGND sg13cmos5l_xnor2_1
X_14638__2181 _14638_/RESET_B VPWR VGND sg13cmos5l_tiehi
X_14272_ _14272_/Q clkload66/A _14272_/D _14272_/RESET_B VPWR VGND sg13cmos5l_dfrbpq_1
X_10435_ _13978_/D _10565_/A1 _10436_/B _10434_/Y VPWR VGND sg13cmos5l_a21oi_1
X_13223_ _13223_/Q _14292_/CLK _13223_/D fanout979/X VPWR VGND sg13cmos5l_dfrbpq_1
X_13154_ _13154_/Y _11192_/A _14178_/Q _13159_/B _14251_/Q _13164_/A2 VPWR VGND sg13cmos5l_a221oi_1
XFILLER_3_863 VPWR VGND sg13cmos5l_fill_2
X_10366_ _10366_/Y _10366_/A _10366_/B VPWR VGND sg13cmos5l_nor2_1
X_12105_ _12105_/Y _12105_/A VPWR VGND sg13cmos5l_inv_1
XFILLER_105_780 VPWR VGND sg13cmos5l_fill_1
XFILLER_2_362 VPWR VGND sg13cmos5l_fill_1
XFILLER_2_384 VPWR VGND sg13cmos5l_fill_2
XFILLER_97_428 VPWR VGND sg13cmos5l_fill_1
X_10297_ _10297_/Y _10297_/A _10299_/B VPWR VGND sg13cmos5l_nor2_1
X_13085_ _14527_/D _13085_/A _13086_/C VPWR VGND sg13cmos5l_xor2_1
XFILLER_77_130 VPWR VGND sg13cmos5l_fill_1
X_12036_ _12036_/Y _12034_/Y _12035_/Y _12351_/A1 VPWR VGND sg13cmos5l_a21oi_1
XFILLER_93_623 VPWR VGND sg13cmos5l_fill_2
XFILLER_66_859 VPWR VGND sg13cmos5l_fill_1
XFILLER_19_764 VPWR VGND sg13cmos5l_fill_2
XFILLER_81_818 VPWR VGND sg13cmos5l_decap_8
X_13987_ _13987_/Q clkload57/A _13987_/D _13987_/RESET_B VPWR VGND sg13cmos5l_dfrbpq_1
XFILLER_19_797 VPWR VGND sg13cmos5l_fill_1
X_12938_ _14456_/D _12938_/A VPWR VGND sg13cmos5l_inv_1
XFILLER_61_553 VPWR VGND sg13cmos5l_decap_8
X_14608_ _14608_/Q _14650_/CLK _14608_/D _14608_/RESET_B VPWR VGND sg13cmos5l_dfrbpq_1
X_12869_ _12869_/Y _14465_/Q _13255_/Q VPWR VGND sg13cmos5l_nand2_1
XFILLER_105_1023 VPWR VGND sg13cmos5l_decap_4
X_14539_ _14539_/Q clkload11/A _14539_/D fanout963/X VPWR VGND sg13cmos5l_dfrbpq_1
XFILLER_88_1018 VPWR VGND sg13cmos5l_fill_1
X_08060_ _08060_/Y _08062_/S _13270_/Q VPWR VGND sg13cmos5l_nand2_1
X_13681__1710 _13681_/RESET_B VPWR VGND sg13cmos5l_tiehi
XFILLER_52_0 VPWR VGND sg13cmos5l_fill_1
XFILLER_89_907 VPWR VGND sg13cmos5l_decap_8
Xhold3205 hold3205/X _13491_/Q VPWR VGND sg13cmos5l_dlygate4sd3_1
XFILLER_88_439 VPWR VGND sg13cmos5l_decap_8
X_08962_ _08962_/Y _08960_/B _08961_/Y _08960_/Y VPWR VGND sg13cmos5l_o21ai_1
Xhold2504 _10630_/A _14071_/Q VPWR VGND sg13cmos5l_dlygate4sd3_1
Xhold3216 _09773_/A _13654_/Q VPWR VGND sg13cmos5l_dlygate4sd3_1
Xhold3227 _13578_/D _09468_/X VPWR VGND sg13cmos5l_dlygate4sd3_1
Xhold3238 hold3238/X _13509_/Q VPWR VGND sg13cmos5l_dlygate4sd3_1
Xhold3249 _13585_/D _09475_/X VPWR VGND sg13cmos5l_dlygate4sd3_1
X_14061__1330 _14061_/RESET_B VPWR VGND sg13cmos5l_tiehi
X_07913_ _08752_/C _14622_/Q _08734_/B VPWR VGND sg13cmos5l_nand2b_1
X_08893_ _08897_/A _08893_/A _08904_/B VPWR VGND sg13cmos5l_nand2_1
Xhold2515 _13015_/A _14495_/Q VPWR VGND sg13cmos5l_dlygate4sd3_1
Xhold2526 _10920_/A _14206_/Q VPWR VGND sg13cmos5l_dlygate4sd3_1
Xhold2537 _08994_/A _13278_/Q VPWR VGND sg13cmos5l_dlygate4sd3_1
X_07844_ _14614_/D _07844_/A _07844_/B _07844_/C VPWR VGND sg13cmos5l_nor3_1
Xhold2548 _10784_/A _14155_/Q VPWR VGND sg13cmos5l_dlygate4sd3_1
Xhold2559 _14165_/D _10812_/Y VPWR VGND sg13cmos5l_dlygate4sd3_1
XFILLER_56_336 VPWR VGND sg13cmos5l_decap_4
X_07775_ _08554_/B _07775_/A VPWR VGND sg13cmos5l_inv_1
XFILLER_17_48 VPWR VGND sg13cmos5l_fill_2
XFILLER_37_572 VPWR VGND sg13cmos5l_decap_4
XFILLER_52_520 VPWR VGND sg13cmos5l_fill_1
XFILLER_65_892 VPWR VGND sg13cmos5l_decap_8
X_09514_ _09534_/D _14442_/Q _14441_/Q _12589_/A _14439_/Q VPWR VGND sg13cmos5l_nand4_1
X_09445_ _13555_/D _09445_/A0 hold3300/X _09467_/S VPWR VGND sg13cmos5l_mux2_1
X_09376_ _13489_/D _09307_/A hold3143/X _09376_/S VPWR VGND sg13cmos5l_mux2_1
XFILLER_32_1006 VPWR VGND sg13cmos5l_fill_1
X_08327_ _08327_/Y _08263_/S _07313_/Y _08339_/B1 VPWR VGND sg13cmos5l_a21oi_1
X_08258_ _08258_/X _13509_/Q _13477_/Q _08258_/S VPWR VGND sg13cmos5l_mux2_1
X_07209_ _07823_/A _14405_/Q VPWR VGND sg13cmos5l_inv_1
X_08189_ _08189_/X _13435_/Q _13403_/Q _13371_/Q _13339_/Q _08283_/S _08200_/S1 VPWR
+ VGND sg13cmos5l_mux4_1
X_10220_ _13873_/D fanout55/X _10219_/B _10219_/Y VPWR VGND sg13cmos5l_a21oi_1
XFILLER_106_588 VPWR VGND sg13cmos5l_decap_4
X_10151_ _10151_/Y _10151_/A _10153_/B VPWR VGND sg13cmos5l_nand2_1
X_10082_ _10082_/Y _10082_/A _10082_/B VPWR VGND sg13cmos5l_nand2_1
XFILLER_102_772 VPWR VGND sg13cmos5l_fill_2
X_13910_ _13910_/Q clkload20/A _13910_/D _13910_/RESET_B VPWR VGND sg13cmos5l_dfrbpq_1
XFILLER_47_347 VPWR VGND sg13cmos5l_fill_1
X_13841_ _13841_/Q _14640_/CLK _13841_/D _13841_/RESET_B VPWR VGND sg13cmos5l_dfrbpq_1
XFILLER_90_637 VPWR VGND sg13cmos5l_fill_2
X_10984_ _10984_/Y _14570_/Q _10982_/Y _10980_/Y VPWR VGND sg13cmos5l_o21ai_1
X_13772_ _13772_/Q clkload61/A _13772_/D _13772_/RESET_B VPWR VGND sg13cmos5l_dfrbpq_1
X_12723_ _12732_/B _12742_/A _12724_/B VPWR VGND sg13cmos5l_nand2b_1
XFILLER_71_895 VPWR VGND sg13cmos5l_fill_2
X_12654_ _12715_/A _14231_/Q _12654_/B VPWR VGND sg13cmos5l_nor2_1
XFILLER_12_973 VPWR VGND sg13cmos5l_fill_2
XFILLER_30_247 VPWR VGND sg13cmos5l_fill_1
X_11605_ _11606_/B _11605_/A _11605_/B VPWR VGND sg13cmos5l_nand2_1
X_12585_ _12585_/X _12637_/A _12585_/B VPWR VGND sg13cmos5l_and2_1
X_11536_ _11536_/Y _11536_/A _11536_/B VPWR VGND sg13cmos5l_nor2_1
X_14324_ _14324_/Q clkload66/A _14324_/D _14324_/RESET_B VPWR VGND sg13cmos5l_dfrbpq_1
X_13792__1599 _13792_/RESET_B VPWR VGND sg13cmos5l_tiehi
XFILLER_8_999 VPWR VGND sg13cmos5l_fill_2
X_14255_ _14255_/Q clkload71/A _14255_/D _14255_/RESET_B VPWR VGND sg13cmos5l_dfrbpq_1
XFILLER_7_498 VPWR VGND sg13cmos5l_fill_1
X_11467_ _11467_/Y _11615_/C1 _11465_/Y _12955_/B2 VPWR VGND sg13cmos5l_o21ai_1
X_13206_ _13206_/Q clkload8/A _13206_/D fanout960/X VPWR VGND sg13cmos5l_dfrbpq_1
X_10418_ _10418_/Y _10418_/A _10466_/B VPWR VGND sg13cmos5l_nor2_1
X_11398_ _11456_/A _14176_/Q _11403_/B VPWR VGND sg13cmos5l_xnor2_1
X_14186_ _14186_/Q clkload44/A _14186_/D _14186_/RESET_B VPWR VGND sg13cmos5l_dfrbpq_1
XFILLER_3_682 VPWR VGND sg13cmos5l_fill_2
X_10349_ _10349_/Y _10349_/A _10349_/B VPWR VGND sg13cmos5l_nor2_1
X_13392__2030 _13392_/RESET_B VPWR VGND sg13cmos5l_tiehi
X_13137_ _13138_/B _09342_/B _08047_/B _08055_/B _09342_/Y _13128_/B VPWR VGND sg13cmos5l_a221oi_1
XFILLER_3_693 VPWR VGND sg13cmos5l_fill_2
X_13068_ _14519_/D _13068_/A _13069_/B VPWR VGND sg13cmos5l_nor2b_1
XFILLER_24_4 VPWR VGND sg13cmos5l_fill_2
XFILLER_39_826 VPWR VGND sg13cmos5l_fill_1
XFILLER_78_472 VPWR VGND sg13cmos5l_decap_8
X_12019_ _12106_/A _14359_/Q _13244_/Q VPWR VGND sg13cmos5l_xnor2_1
XFILLER_0_1004 VPWR VGND sg13cmos5l_decap_8
X_07560_ _08155_/A _13208_/Q _07560_/B _07560_/C VPWR VGND sg13cmos5l_nand3_1
XFILLER_0_95 VPWR VGND sg13cmos5l_decap_8
XFILLER_46_380 VPWR VGND sg13cmos5l_fill_1
XFILLER_94_1022 VPWR VGND sg13cmos5l_decap_8
XFILLER_61_350 VPWR VGND sg13cmos5l_fill_1
X_07491_ _07492_/A _13560_/Q _13528_/Q _13496_/Q _13464_/Q _08283_/S _08200_/S1 VPWR
+ VGND sg13cmos5l_mux4_1
X_09230_ _09230_/Y _09230_/A _09230_/B VPWR VGND sg13cmos5l_nor2_1
X_09161_ _09161_/Y _09161_/A _09161_/B VPWR VGND sg13cmos5l_nor2_1
X_08112_ _08112_/Y _08112_/A _08112_/B _08112_/C VPWR VGND sg13cmos5l_nand3_1
X_09092_ _09092_/Y _14420_/Q _11374_/A VPWR VGND sg13cmos5l_nand2_1
X_13622__1769 _13622_/RESET_B VPWR VGND sg13cmos5l_tiehi
X_08043_ _08044_/C _14545_/Q _08043_/B VPWR VGND sg13cmos5l_xnor2_1
X_09994_ _13762_/D _10581_/A1 _10007_/B _09993_/Y VPWR VGND sg13cmos5l_o21ai_1
Xhold3002 _10398_/A _13961_/Q VPWR VGND sg13cmos5l_dlygate4sd3_1
Xhold3013 _10990_/A _14196_/Q VPWR VGND sg13cmos5l_dlygate4sd3_1
Xhold3024 hold3024/X _13473_/Q VPWR VGND sg13cmos5l_dlygate4sd3_1
X_14002__1389 _14002_/RESET_B VPWR VGND sg13cmos5l_tiehi
Xhold2301 _10495_/A _14008_/Q VPWR VGND sg13cmos5l_dlygate4sd3_1
Xhold2312 _12979_/A _14477_/Q VPWR VGND sg13cmos5l_dlygate4sd3_1
Xhold3035 _10414_/A _13969_/Q VPWR VGND sg13cmos5l_dlygate4sd3_1
Xhold3046 hold3046/X _13540_/Q VPWR VGND sg13cmos5l_dlygate4sd3_1
Xhold3057 _13541_/D _09430_/X VPWR VGND sg13cmos5l_dlygate4sd3_1
XFILLER_57_601 VPWR VGND sg13cmos5l_fill_1
XFILLER_76_409 VPWR VGND sg13cmos5l_fill_2
X_08945_ _13257_/D _07296_/Y _13188_/A2 _13192_/B1 _08944_/Y VPWR VGND sg13cmos5l_a22oi_1
Xhold2323 _09965_/A _13748_/Q VPWR VGND sg13cmos5l_dlygate4sd3_1
Xhold2334 _10019_/A _13775_/Q VPWR VGND sg13cmos5l_dlygate4sd3_1
Xhold2345 _10064_/A _13797_/Q VPWR VGND sg13cmos5l_dlygate4sd3_1
Xhold3068 _13453_/D _09337_/X VPWR VGND sg13cmos5l_dlygate4sd3_1
Xhold3079 hold3079/X _13583_/Q VPWR VGND sg13cmos5l_dlygate4sd3_1
X_08876_ _08877_/B hold3078/X _08900_/A2 _08875_/Y VPWR VGND sg13cmos5l_a21oi_1
Xhold2356 _13222_/D _08146_/X VPWR VGND sg13cmos5l_dlygate4sd3_1
Xhold2367 _14145_/D _10755_/Y VPWR VGND sg13cmos5l_dlygate4sd3_1
Xhold2378 _09987_/A _13759_/Q VPWR VGND sg13cmos5l_dlygate4sd3_1
Xhold2389 _10048_/A _13789_/Q VPWR VGND sg13cmos5l_dlygate4sd3_1
XFILLER_28_58 VPWR VGND sg13cmos5l_fill_2
XFILLER_29_369 VPWR VGND sg13cmos5l_fill_2
XFILLER_57_656 VPWR VGND sg13cmos5l_decap_4
X_07827_ _07827_/Y _11121_/A _07829_/B VPWR VGND sg13cmos5l_nor2_1
XFILLER_71_114 VPWR VGND sg13cmos5l_fill_1
X_07758_ _08532_/B _07758_/A _07758_/B _07758_/C VPWR VGND sg13cmos5l_nor3_1
X_14637__2180 _14637_/RESET_B VPWR VGND sg13cmos5l_tiehi
X_07689_ _07689_/Y _14385_/Q _14353_/Q VPWR VGND sg13cmos5l_nor2_1
XFILLER_13_748 VPWR VGND sg13cmos5l_fill_1
XFILLER_52_383 VPWR VGND sg13cmos5l_decap_8
X_09428_ _13539_/D _09288_/A hold3309/X _09434_/S VPWR VGND sg13cmos5l_mux2_1
X_09359_ _13472_/D _07985_/A hold3247/X _09373_/S VPWR VGND sg13cmos5l_mux2_1
X_12370_ _12370_/Y _13935_/Q _12419_/A2 _12377_/B1 _13679_/Q _12427_/B1 VPWR VGND
+ sg13cmos5l_a221oi_1
X_11321_ _11322_/B _11408_/A _11321_/B VPWR VGND sg13cmos5l_nand2_1
XFILLER_4_435 VPWR VGND sg13cmos5l_fill_2
X_11252_ _11253_/B _11252_/A VPWR VGND sg13cmos5l_inv_1
X_14040_ _14040_/Q _14631_/CLK _14040_/D _14040_/RESET_B VPWR VGND sg13cmos5l_dfrbpq_1
X_10203_ _10203_/Y _10203_/A _10217_/B VPWR VGND sg13cmos5l_nor2_1
X_11183_ _14312_/D _11181_/Y _11182_/Y _11173_/Y VPWR VGND sg13cmos5l_o21ai_1
X_13777__1614 _13777_/RESET_B VPWR VGND sg13cmos5l_tiehi
XFILLER_69_98 VPWR VGND sg13cmos5l_fill_1
XFILLER_95_707 VPWR VGND sg13cmos5l_fill_1
X_10134_ _13831_/D _10591_/A1 _10143_/B _10133_/Y VPWR VGND sg13cmos5l_o21ai_1
XFILLER_94_206 VPWR VGND sg13cmos5l_fill_1
X_13465__1957 _13465_/RESET_B VPWR VGND sg13cmos5l_tiehi
X_10065_ _13797_/D _10587_/A1 _10078_/B _10064_/Y VPWR VGND sg13cmos5l_o21ai_1
XFILLER_75_464 VPWR VGND sg13cmos5l_fill_1
Xhold2890 _13088_/B _13087_/Y VPWR VGND sg13cmos5l_dlygate4sd3_1
XFILLER_47_188 VPWR VGND sg13cmos5l_fill_1
XFILLER_75_486 VPWR VGND sg13cmos5l_fill_2
X_13824_ _13824_/Q clkload47/A _13824_/D _13824_/RESET_B VPWR VGND sg13cmos5l_dfrbpq_1
X_10967_ _14224_/D _10943_/A _10880_/B _10966_/Y VPWR VGND sg13cmos5l_o21ai_1
X_13755_ _13755_/Q clkload48/A _13755_/D _13755_/RESET_B VPWR VGND sg13cmos5l_dfrbpq_1
XFILLER_31_523 VPWR VGND sg13cmos5l_fill_2
X_10898_ _10898_/Y _10990_/A _10904_/B VPWR VGND sg13cmos5l_nand2_1
X_13686_ _13686_/Q clkload16/A _13686_/D _13686_/RESET_B VPWR VGND sg13cmos5l_dfrbpq_1
X_12706_ _12706_/X _12715_/A _12706_/B VPWR VGND sg13cmos5l_or2_1
XFILLER_31_567 VPWR VGND sg13cmos5l_fill_1
X_12637_ _12637_/Y _12637_/A _12735_/B _12637_/C VPWR VGND sg13cmos5l_nand3_1
XFILLER_102_1015 VPWR VGND sg13cmos5l_decap_8
X_12568_ _12569_/B _12601_/A _12564_/Y _12567_/Y VPWR VGND sg13cmos5l_a21oi_1
X_11519_ _11523_/B _11519_/A _11519_/B _11519_/C VPWR VGND sg13cmos5l_nand3_1
X_14307_ _14307_/Q clkload39/A _14307_/D _14307_/RESET_B VPWR VGND sg13cmos5l_dfrbpq_1
X_12499_ _12499_/Y _14393_/Q _12503_/B VPWR VGND sg13cmos5l_nand2_1
X_14238_ _14238_/Q _14238_/CLK _14238_/D _14238_/RESET_B VPWR VGND sg13cmos5l_dfrbpq_1
X_14169_ _14169_/Q clkload38/A _14169_/D _14169_/RESET_B VPWR VGND sg13cmos5l_dfrbpq_1
X_13333__2089 _13333_/RESET_B VPWR VGND sg13cmos5l_tiehi
Xfanout709 _11560_/B _11541_/B VPWR VGND sg13cmos5l_buf_1
XFILLER_61_1021 VPWR VGND sg13cmos5l_decap_8
X_08730_ _08730_/Y _13589_/Q _11809_/A2 _08725_/B _13653_/Q _08729_/X VPWR VGND sg13cmos5l_a221oi_1
XFILLER_38_122 VPWR VGND sg13cmos5l_fill_1
X_08661_ _08661_/Y _14034_/Q _12055_/B _08687_/B VPWR VGND sg13cmos5l_a21oi_1
XFILLER_67_998 VPWR VGND sg13cmos5l_decap_4
XFILLER_81_401 VPWR VGND sg13cmos5l_decap_4
X_07612_ _07613_/B _13280_/Q _13281_/Q _13282_/Q VPWR VGND sg13cmos5l_a21o_1
XFILLER_82_979 VPWR VGND sg13cmos5l_fill_1
X_08592_ _14607_/D _08593_/B _08592_/B VPWR VGND sg13cmos5l_xor2_1
X_13510__1912 _13510_/RESET_B VPWR VGND sg13cmos5l_tiehi
XFILLER_81_478 VPWR VGND sg13cmos5l_fill_1
X_07543_ _07546_/B _14545_/Q _13298_/Q VPWR VGND sg13cmos5l_xor2_1
XFILLER_61_180 VPWR VGND sg13cmos5l_fill_2
X_07474_ _07474_/Y _10679_/A1 _08244_/C _08187_/B2 VPWR VGND sg13cmos5l_a21oi_1
X_09213_ _09213_/X _14111_/Q hold3250/X _09235_/S VPWR VGND sg13cmos5l_mux2_1
X_13855__1536 _13855_/RESET_B VPWR VGND sg13cmos5l_tiehi
XFILLER_22_589 VPWR VGND sg13cmos5l_fill_1
X_09144_ _13320_/D _09161_/B _09142_/Y _09143_/Y VPWR VGND sg13cmos5l_a21oi_1
X_13543__1879 _13543_/RESET_B VPWR VGND sg13cmos5l_tiehi
X_09075_ _09075_/Y _11294_/A _09074_/Y _09075_/B1 VPWR VGND sg13cmos5l_a21oi_1
X_08026_ _08043_/B _08995_/A _13278_/Q _10807_/A VPWR VGND sg13cmos5l_mux2_1
X_09977_ _09977_/Y _09977_/A _09977_/B VPWR VGND sg13cmos5l_nand2_1
XFILLER_57_420 VPWR VGND sg13cmos5l_decap_4
XFILLER_76_239 VPWR VGND sg13cmos5l_fill_2
X_08928_ _08928_/Y _14264_/Q _13195_/B1 _08938_/B1 VPWR VGND sg13cmos5l_a21oi_1
XFILLER_29_133 VPWR VGND sg13cmos5l_fill_1
XFILLER_45_604 VPWR VGND sg13cmos5l_decap_4
XFILLER_58_954 VPWR VGND sg13cmos5l_fill_1
XFILLER_73_946 VPWR VGND sg13cmos5l_decap_8
X_08859_ _08863_/A _08582_/B _08867_/B VPWR VGND sg13cmos5l_nand2b_1
X_11870_ _11870_/Y _11870_/A _11869_/Y VPWR VGND sg13cmos5l_nor2b_1
X_10821_ _14169_/D _07264_/Y _10818_/Y _10820_/Y VPWR VGND sg13cmos5l_o21ai_1
XFILLER_25_394 VPWR VGND sg13cmos5l_fill_1
XFILLER_81_990 VPWR VGND sg13cmos5l_fill_1
X_10752_ _10752_/Y _10751_/B _10750_/Y _10751_/Y VPWR VGND sg13cmos5l_o21ai_1
X_13540_ _13540_/Q _14621_/CLK _13540_/D _13540_/RESET_B VPWR VGND sg13cmos5l_dfrbpq_1
X_13471_ _13471_/Q _13568_/CLK _13471_/D _13471_/RESET_B VPWR VGND sg13cmos5l_dfrbpq_1
X_10683_ _14103_/D input12/X _10683_/A1 _10685_/S VPWR VGND sg13cmos5l_mux2_1
X_12422_ _12422_/Y _14033_/Q _12427_/A2 _12428_/B1 _13841_/Q VPWR VGND sg13cmos5l_a22oi_1
X_12353_ _12353_/Y _12353_/A _12353_/B VPWR VGND sg13cmos5l_nand2_1
XFILLER_4_210 VPWR VGND sg13cmos5l_fill_2
X_11304_ _11304_/Y _11312_/B _11301_/X _11303_/Y _11536_/A _08913_/A VPWR VGND sg13cmos5l_a221oi_1
X_12284_ _12286_/B _12284_/A _12329_/A _12284_/C VPWR VGND sg13cmos5l_or3_1
X_14342__1166 _14342_/RESET_B VPWR VGND sg13cmos5l_tiehi
X_11235_ _11256_/C _11235_/A _11235_/B VPWR VGND sg13cmos5l_nand2_1
X_14023_ _14023_/Q clkload76/A _14023_/D _14023_/RESET_B VPWR VGND sg13cmos5l_dfrbpq_1
XFILLER_1_950 VPWR VGND sg13cmos5l_decap_8
XFILLER_68_718 VPWR VGND sg13cmos5l_fill_2
X_11166_ _14310_/D _07185_/Y _11166_/A2 _11165_/Y _10654_/B VPWR VGND sg13cmos5l_a22oi_1
XFILLER_0_460 VPWR VGND sg13cmos5l_fill_1
XFILLER_0_471 VPWR VGND sg13cmos5l_fill_2
XFILLER_49_943 VPWR VGND sg13cmos5l_fill_2
X_10117_ _10117_/Y _10117_/A _10119_/B VPWR VGND sg13cmos5l_nand2_1
X_11097_ _11097_/Y _11097_/A _11121_/B VPWR VGND sg13cmos5l_nor2_1
X_10048_ _10048_/Y _10048_/A _10052_/B VPWR VGND sg13cmos5l_nand2_1
X_13933__1458 _13933_/RESET_B VPWR VGND sg13cmos5l_tiehi
X_13318__2104 _13318_/RESET_B VPWR VGND sg13cmos5l_tiehi
XFILLER_35_103 VPWR VGND sg13cmos5l_fill_2
XFILLER_48_486 VPWR VGND sg13cmos5l_fill_1
XFILLER_64_924 VPWR VGND sg13cmos5l_fill_2
XFILLER_64_957 VPWR VGND sg13cmos5l_decap_4
XFILLER_91_754 VPWR VGND sg13cmos5l_decap_8
XFILLER_91_765 VPWR VGND sg13cmos5l_fill_1
XFILLER_91_798 VPWR VGND sg13cmos5l_fill_1
X_13807_ _13807_/Q _14065_/CLK _13807_/D _13807_/RESET_B VPWR VGND sg13cmos5l_dfrbpq_1
XFILLER_72_990 VPWR VGND sg13cmos5l_decap_8
XFILLER_91_1025 VPWR VGND sg13cmos5l_decap_4
X_11999_ _11999_/Y _07280_/Y _12000_/B _11998_/Y VPWR VGND sg13cmos5l_a21oi_1
X_13738_ _13738_/Q clkload52/A _13738_/D _13738_/RESET_B VPWR VGND sg13cmos5l_dfrbpq_1
XFILLER_91_4 VPWR VGND sg13cmos5l_fill_2
X_13669_ _13669_/Q _14028_/CLK _13669_/D _13669_/RESET_B VPWR VGND sg13cmos5l_dfrbpq_1
X_07190_ _07354_/B _08956_/A VPWR VGND sg13cmos5l_inv_1
XFILLER_8_582 VPWR VGND sg13cmos5l_fill_1
X_14318__1190 _14318_/RESET_B VPWR VGND sg13cmos5l_tiehi
X_09900_ _09900_/Y _09900_/A _09910_/B VPWR VGND sg13cmos5l_nor2_1
Xfanout506 _11749_/B fanout510/X VPWR VGND sg13cmos5l_buf_1
X_09831_ _13682_/D _10419_/A1 _09846_/B _09830_/Y VPWR VGND sg13cmos5l_a21oi_1
Xfanout539 _11157_/A _12735_/C VPWR VGND sg13cmos5l_buf_1
Xfanout528 _08409_/B _08157_/B VPWR VGND sg13cmos5l_buf_1
Xfanout517 _12397_/B _12296_/A2 VPWR VGND sg13cmos5l_buf_1
XFILLER_101_826 VPWR VGND sg13cmos5l_decap_8
X_09762_ _10547_/A _10351_/A _10351_/B VPWR VGND sg13cmos5l_nor2b_1
X_08713_ _08714_/B _14619_/Q _14620_/Q _14621_/Q VPWR VGND sg13cmos5l_o21ai_1
XFILLER_27_604 VPWR VGND sg13cmos5l_fill_1
XFILLER_39_486 VPWR VGND sg13cmos5l_fill_1
X_09693_ _09693_/Y _09693_/A _09693_/B VPWR VGND sg13cmos5l_nor2_1
X_13909__1482 _13909_/RESET_B VPWR VGND sg13cmos5l_tiehi
XFILLER_27_659 VPWR VGND sg13cmos5l_fill_1
XFILLER_66_283 VPWR VGND sg13cmos5l_fill_2
X_08644_ _08644_/Y _08643_/A _08644_/B VPWR VGND sg13cmos5l_nand2b_1
XFILLER_70_905 VPWR VGND sg13cmos5l_decap_8
X_08575_ _08583_/A _08575_/A _08575_/B VPWR VGND sg13cmos5l_nor2_1
X_07526_ _07526_/Y _07526_/A1 _07524_/X _07525_/Y VPWR VGND sg13cmos5l_o21ai_1
X_14420__1088 _14420_/RESET_B VPWR VGND sg13cmos5l_tiehi
X_07457_ _07457_/Y _07457_/A _08168_/A VPWR VGND sg13cmos5l_nand2_1
X_07388_ _07389_/C _08984_/A _13307_/Q _13308_/Q _13309_/Q VPWR VGND sg13cmos5l_nor4_1
X_09127_ _11438_/A _14330_/Q _09163_/B VPWR VGND sg13cmos5l_nand2_1
X_09058_ _09058_/Y _11249_/A _09057_/Y _09076_/A2 VPWR VGND sg13cmos5l_a21oi_1
X_08009_ _13128_/B _12997_/B _12997_/C _08009_/C VPWR VGND sg13cmos5l_or3_1
X_11020_ _11021_/B _11020_/A _11020_/B VPWR VGND sg13cmos5l_nand2_1
X_12971_ _14473_/D _12973_/B _12971_/B VPWR VGND sg13cmos5l_nor2_1
XFILLER_73_754 VPWR VGND sg13cmos5l_fill_1
X_11922_ _11922_/Y _14450_/Q _12380_/B _11920_/Y _11921_/Y VPWR VGND sg13cmos5l_a22oi_1
X_11853_ _11853_/Y _13725_/Q _11914_/A2 _11916_/A2 _13981_/Q _11695_/B VPWR VGND sg13cmos5l_a221oi_1
X_14641_ _14641_/Q clkload77/A _14641_/D _14641_/RESET_B VPWR VGND sg13cmos5l_dfrbpq_1
X_10804_ _10804_/Y _10804_/A _11147_/A VPWR VGND sg13cmos5l_nand2_1
X_11784_ _11784_/Y _13946_/Q _11785_/B _11783_/Y VPWR VGND sg13cmos5l_o21ai_1
X_14572_ _14572_/Q clkload45/A _14572_/D _14572_/RESET_B VPWR VGND sg13cmos5l_dfrbpq_1
XFILLER_13_364 VPWR VGND sg13cmos5l_fill_1
XFILLER_41_695 VPWR VGND sg13cmos5l_fill_1
X_10735_ _10735_/Y _10798_/A _14283_/Q VPWR VGND sg13cmos5l_nand2_1
X_13523_ _13523_/Q _14292_/CLK _13523_/D _13523_/RESET_B VPWR VGND sg13cmos5l_dfrbpq_1
X_10666_ _14090_/D _14271_/D hold3499/X _10675_/S VPWR VGND sg13cmos5l_mux2_1
X_13454_ _13454_/Q clkload33/A _13454_/D _13454_/RESET_B VPWR VGND sg13cmos5l_dfrbpq_1
XFILLER_12_1026 VPWR VGND sg13cmos5l_fill_2
X_13385_ _13385_/Q clkload37/A _13385_/D _13385_/RESET_B VPWR VGND sg13cmos5l_dfrbpq_1
X_12405_ _12405_/Y _14371_/Q _12405_/B VPWR VGND sg13cmos5l_nand2_1
XFILLER_5_541 VPWR VGND sg13cmos5l_fill_2
X_10597_ _14058_/D _10597_/A1 _10596_/B _10596_/Y VPWR VGND sg13cmos5l_o21ai_1
X_14616__2159 _14616_/RESET_B VPWR VGND sg13cmos5l_tiehi
X_12336_ _12361_/B _12359_/A _12360_/A VPWR VGND sg13cmos5l_nor2b_1
X_12267_ _12270_/A _13803_/Q _12260_/B _12297_/C1 VPWR VGND sg13cmos5l_a21oi_1
X_11218_ _11218_/Y _11193_/A _11214_/D _12913_/B2 VPWR VGND sg13cmos5l_o21ai_1
X_12198_ _12198_/Y _12198_/A _12198_/B _12198_/C VPWR VGND sg13cmos5l_nand3_1
X_14006_ _14006_/Q clkload50/A _14006_/D _14006_/RESET_B VPWR VGND sg13cmos5l_dfrbpq_1
XFILLER_95_301 VPWR VGND sg13cmos5l_fill_1
XFILLER_96_824 VPWR VGND sg13cmos5l_fill_1
X_11149_ _11149_/Y _08423_/Y _11149_/B VPWR VGND sg13cmos5l_nand2b_1
X_14201__1276 _14201_/RESET_B VPWR VGND sg13cmos5l_tiehi
XFILLER_36_412 VPWR VGND sg13cmos5l_fill_2
XFILLER_64_721 VPWR VGND sg13cmos5l_fill_2
X_15888_ _15888_/X _15888_/A VPWR VGND sg13cmos5l_buf_1
XFILLER_36_478 VPWR VGND sg13cmos5l_fill_1
XFILLER_17_692 VPWR VGND sg13cmos5l_fill_2
X_08360_ _08360_/Y _08411_/A _08357_/X _08358_/X _08359_/Y _08419_/A1 VPWR VGND sg13cmos5l_a221oi_1
X_07311_ _07311_/Y _13352_/Q VPWR VGND sg13cmos5l_inv_1
XFILLER_32_662 VPWR VGND sg13cmos5l_fill_2
X_08291_ _08291_/Y _11034_/A _11035_/A1 _08284_/Y _08286_/Y _08290_/Y VPWR VGND sg13cmos5l_a221oi_1
XFILLER_82_0 VPWR VGND sg13cmos5l_fill_2
X_07242_ _07709_/B _11711_/A VPWR VGND sg13cmos5l_inv_1
X_07173_ _09575_/C _14449_/Q VPWR VGND sg13cmos5l_inv_1
X_14405__1103 _14405_/RESET_B VPWR VGND sg13cmos5l_tiehi
X_13460__1962 _13460_/RESET_B VPWR VGND sg13cmos5l_tiehi
XFILLER_106_929 VPWR VGND sg13cmos5l_decap_8
XFILLER_87_813 VPWR VGND sg13cmos5l_fill_2
Xfanout314 _09813_/B _09764_/Y VPWR VGND sg13cmos5l_buf_1
Xfanout303 _09846_/B _09859_/A2 VPWR VGND sg13cmos5l_buf_1
XFILLER_86_323 VPWR VGND sg13cmos5l_fill_1
X_09814_ _13674_/D _10532_/A1 _09813_/B _09813_/Y VPWR VGND sg13cmos5l_a21oi_1
Xfanout347 _09642_/B fanout354/X VPWR VGND sg13cmos5l_buf_1
Xfanout336 _10361_/A1 _09510_/Y VPWR VGND sg13cmos5l_buf_1
Xfanout325 _09726_/B _09752_/B VPWR VGND sg13cmos5l_buf_1
X_14446__1061 _14446_/RESET_B VPWR VGND sg13cmos5l_tiehi
Xfanout369 _08165_/A _08310_/B1 VPWR VGND sg13cmos5l_buf_1
Xfanout358 _09060_/B _09077_/B VPWR VGND sg13cmos5l_buf_1
X_09745_ _13641_/D _10399_/A1 _09754_/B _09744_/Y VPWR VGND sg13cmos5l_a21oi_1
XFILLER_55_732 VPWR VGND sg13cmos5l_fill_2
X_09676_ _09685_/B _09676_/A _09676_/B VPWR VGND sg13cmos5l_nor2_1
XFILLER_43_927 VPWR VGND sg13cmos5l_fill_2
X_08627_ _08628_/B _08624_/Y _08625_/Y _08626_/X _08625_/A VPWR VGND sg13cmos5l_a22oi_1
X_08558_ _08558_/Y _08558_/A _08558_/B VPWR VGND sg13cmos5l_nand2_1
X_13243__1020 _13243_/RESET_B VPWR VGND sg13cmos5l_tiehi
XFILLER_51_971 VPWR VGND sg13cmos5l_fill_1
X_07509_ _07509_/Y _08227_/A2 _07507_/Y _07526_/A1 VPWR VGND sg13cmos5l_o21ai_1
X_08489_ _08489_/Y _08489_/A _07746_/Y VPWR VGND sg13cmos5l_nor2b_1
XFILLER_50_481 VPWR VGND sg13cmos5l_decap_8
X_10520_ _14020_/D _10585_/A1 _10519_/B _10519_/Y VPWR VGND sg13cmos5l_o21ai_1
X_10451_ _13986_/D _10581_/A1 _10464_/B _10450_/Y VPWR VGND sg13cmos5l_a21oi_1
X_10382_ _10382_/Y _10382_/A _10384_/B VPWR VGND sg13cmos5l_nor2_1
X_13170_ _13233_/D _13180_/B _13168_/Y _13169_/Y VPWR VGND sg13cmos5l_a21oi_1
XFILLER_2_533 VPWR VGND sg13cmos5l_fill_2
X_12121_ _12121_/Y _12121_/A _12121_/B _12121_/C VPWR VGND sg13cmos5l_nand3_1
X_12052_ _12052_/Y _13828_/Q _12060_/B VPWR VGND sg13cmos5l_nand2_1
X_13635__1756 _13635_/RESET_B VPWR VGND sg13cmos5l_tiehi
XFILLER_105_995 VPWR VGND sg13cmos5l_decap_8
XFILLER_2_588 VPWR VGND sg13cmos5l_fill_1
XFILLER_78_835 VPWR VGND sg13cmos5l_decap_8
X_11003_ _11003_/Y hold3334/X _10983_/B _10996_/Y _14235_/Q VPWR VGND sg13cmos5l_a22oi_1
XFILLER_78_857 VPWR VGND sg13cmos5l_decap_8
XFILLER_89_194 VPWR VGND sg13cmos5l_fill_2
Xfanout870 _08625_/A fanout872/X VPWR VGND sg13cmos5l_buf_1
Xfanout892 _09225_/A _14122_/Q VPWR VGND sg13cmos5l_buf_1
Xfanout881 _11464_/A _11595_/A VPWR VGND sg13cmos5l_buf_1
XFILLER_18_423 VPWR VGND sg13cmos5l_fill_1
X_14015__1376 _14015_/RESET_B VPWR VGND sg13cmos5l_tiehi
X_12954_ _14464_/D _12954_/A VPWR VGND sg13cmos5l_inv_1
XFILLER_34_905 VPWR VGND sg13cmos5l_fill_2
XFILLER_73_551 VPWR VGND sg13cmos5l_fill_1
X_11905_ _11905_/Y _11903_/B _11900_/Y _12136_/A VPWR VGND sg13cmos5l_a21oi_1
X_13850__1541 _13850_/RESET_B VPWR VGND sg13cmos5l_tiehi
XFILLER_73_584 VPWR VGND sg13cmos5l_decap_4
XFILLER_73_595 VPWR VGND sg13cmos5l_fill_1
X_12885_ _12885_/Y _09676_/A _07295_/Y _12869_/Y VPWR VGND sg13cmos5l_a21oi_1
XFILLER_61_768 VPWR VGND sg13cmos5l_fill_1
X_11836_ _11836_/Y _13628_/Q _11944_/A1 _11971_/A2 _13884_/Q _11835_/X VPWR VGND sg13cmos5l_a221oi_1
X_14624_ _14624_/Q clkload43/A _14624_/D _14624_/RESET_B VPWR VGND sg13cmos5l_dfrbpq_1
XFILLER_20_109 VPWR VGND sg13cmos5l_fill_2
X_11767_ _11798_/A _11768_/A _11768_/B _11768_/C VPWR VGND sg13cmos5l_a21o_1
X_14555_ _14555_/Q clkload21/A _14555_/D fanout983/X VPWR VGND sg13cmos5l_dfrbpq_1
XFILLER_41_470 VPWR VGND sg13cmos5l_decap_4
X_10718_ _10718_/Y _10718_/A _10766_/B VPWR VGND sg13cmos5l_nand2_1
X_13506_ _13506_/Q clkload41/A _13506_/D _13506_/RESET_B VPWR VGND sg13cmos5l_dfrbpq_1
X_11698_ _11698_/Y _13911_/Q _11753_/S _08687_/B VPWR VGND sg13cmos5l_a21oi_1
X_14486_ _14486_/Q clkload15/A _14486_/D fanout978/X VPWR VGND sg13cmos5l_dfrbpq_1
X_10649_ _10649_/Y _10649_/A _10649_/B VPWR VGND sg13cmos5l_xnor2_1
X_13437_ _13437_/Q clkload31/A _13437_/D _13437_/RESET_B VPWR VGND sg13cmos5l_dfrbpq_1
X_14219__1258 _14219_/RESET_B VPWR VGND sg13cmos5l_tiehi
X_13368_ _13368_/Q _14105_/CLK _13368_/D _13368_/RESET_B VPWR VGND sg13cmos5l_dfrbpq_1
X_12319_ _12320_/C _13965_/Q _12319_/A2 _12344_/B _13901_/Q VPWR VGND sg13cmos5l_a22oi_1
Xhold3409 hold3409/X _14608_/Q VPWR VGND sg13cmos5l_dlygate4sd3_1
X_13299_ _13299_/Q clkload21/A _13299_/D fanout964/X VPWR VGND sg13cmos5l_dfrbpq_1
Xhold2708 _10976_/A _14228_/Q VPWR VGND sg13cmos5l_dlygate4sd3_1
Xhold2719 _09926_/A _13729_/Q VPWR VGND sg13cmos5l_dlygate4sd3_1
X_07860_ _10987_/C _10848_/A _11014_/B VPWR VGND sg13cmos5l_nand2_1
XFILLER_96_698 VPWR VGND sg13cmos5l_decap_8
X_07791_ _08609_/B _07791_/A _08889_/A VPWR VGND sg13cmos5l_nor2_1
X_09530_ _09530_/Y _09530_/A _09578_/B VPWR VGND sg13cmos5l_nor2_1
XFILLER_92_871 VPWR VGND sg13cmos5l_decap_4
X_09461_ _13571_/D _09288_/A hold3272/X _09467_/S VPWR VGND sg13cmos5l_mux2_1
XFILLER_52_724 VPWR VGND sg13cmos5l_fill_2
X_13478__1944 _13478_/RESET_B VPWR VGND sg13cmos5l_tiehi
X_08412_ _08412_/Y _13361_/Q _08416_/S VPWR VGND sg13cmos5l_nand2b_1
X_09392_ _13504_/D _07985_/A hold3102/X _09409_/S VPWR VGND sg13cmos5l_mux2_1
X_08343_ _14267_/D hold3502/X _12559_/B _11042_/S VPWR VGND sg13cmos5l_mux2_1
X_08274_ _08274_/X _08275_/S _13446_/Q VPWR VGND sg13cmos5l_or2_1
X_13713__1678 _13713_/RESET_B VPWR VGND sg13cmos5l_tiehi
X_07225_ _12039_/A _12093_/A VPWR VGND sg13cmos5l_inv_1
X_13313__2120 _13313_/RESET_B VPWR VGND sg13cmos5l_tiehi
Xfanout122 _09396_/S _09408_/S VPWR VGND sg13cmos5l_buf_1
Xfanout111 _10587_/A1 _09613_/Y VPWR VGND sg13cmos5l_buf_1
Xfanout100 _09230_/B _09234_/S VPWR VGND sg13cmos5l_buf_1
Xfanout155 _10385_/A1 _09592_/Y VPWR VGND sg13cmos5l_buf_1
Xfanout144 _10128_/A1 _09606_/Y VPWR VGND sg13cmos5l_buf_1
Xfanout133 _10960_/B _10829_/S VPWR VGND sg13cmos5l_buf_1
XFILLER_101_475 VPWR VGND sg13cmos5l_fill_2
XFILLER_102_987 VPWR VGND sg13cmos5l_decap_8
Xfanout199 _08409_/C _07423_/Y VPWR VGND sg13cmos5l_buf_1
Xfanout188 _10573_/A1 _09564_/Y VPWR VGND sg13cmos5l_buf_1
Xfanout177 _10514_/A1 _09584_/Y VPWR VGND sg13cmos5l_buf_1
Xfanout166 _10766_/B fanout170/X VPWR VGND sg13cmos5l_buf_1
X_07989_ _07989_/Y _07989_/A _07989_/B _07989_/C VPWR VGND sg13cmos5l_nand3_1
X_09728_ _09728_/Y _09728_/A _09730_/B VPWR VGND sg13cmos5l_nor2_1
X_13346__2076 _13346_/RESET_B VPWR VGND sg13cmos5l_tiehi
XFILLER_83_871 VPWR VGND sg13cmos5l_decap_8
XFILLER_90_819 VPWR VGND sg13cmos5l_decap_8
XFILLER_16_949 VPWR VGND sg13cmos5l_decap_4
XFILLER_42_201 VPWR VGND sg13cmos5l_fill_2
X_09659_ _09659_/Y _09670_/C _09658_/Y VPWR VGND sg13cmos5l_nor2b_1
XFILLER_70_554 VPWR VGND sg13cmos5l_fill_2
X_14615__2158 _14615_/RESET_B VPWR VGND sg13cmos5l_tiehi
X_12670_ _12670_/Y _12658_/Y _12677_/A _12659_/Y VPWR VGND sg13cmos5l_o21ai_1
XFILLER_70_576 VPWR VGND sg13cmos5l_fill_1
X_11621_ _11622_/D _07905_/B _11624_/B _07857_/B VPWR VGND sg13cmos5l_a21oi_1
X_14277__1231 _14277_/RESET_B VPWR VGND sg13cmos5l_tiehi
X_14340_ _14340_/Q _14654_/CLK _14340_/D _14340_/RESET_B VPWR VGND sg13cmos5l_dfrbpq_1
XFILLER_7_625 VPWR VGND sg13cmos5l_fill_1
X_11552_ _11556_/B _11575_/A _11553_/A _11553_/B VPWR VGND sg13cmos5l_a21oi_1
XFILLER_10_175 VPWR VGND sg13cmos5l_fill_2
XFILLER_6_135 VPWR VGND sg13cmos5l_fill_1
X_10503_ _10503_/Y _10503_/A _10511_/B VPWR VGND sg13cmos5l_nand2_1
X_11483_ _11504_/B _11483_/A _11483_/B VPWR VGND sg13cmos5l_nand2_1
X_14271_ _14271_/Q clkload71/A _14271_/D _14271_/RESET_B VPWR VGND sg13cmos5l_dfrbpq_1
XFILLER_12_71 VPWR VGND sg13cmos5l_fill_1
X_10434_ _10434_/Y _10434_/A _10436_/B VPWR VGND sg13cmos5l_nor2_1
X_13222_ _13222_/Q _14576_/CLK _13222_/D fanout978/X VPWR VGND sg13cmos5l_dfrbpq_1
X_10365_ _13944_/D _10561_/A1 _10368_/B _10364_/Y VPWR VGND sg13cmos5l_a21oi_1
X_13868__1523 _13868_/RESET_B VPWR VGND sg13cmos5l_tiehi
X_13153_ _13153_/Y _13153_/A _13162_/B VPWR VGND sg13cmos5l_nand2_1
X_12104_ _12105_/A _14361_/Q _13246_/Q _12047_/C _12102_/X _12103_/Y VPWR VGND sg13cmos5l_a221oi_1
X_10296_ _13910_/D _10361_/A1 _10295_/B _10295_/Y VPWR VGND sg13cmos5l_a21oi_1
X_13556__1866 _13556_/RESET_B VPWR VGND sg13cmos5l_tiehi
X_13084_ _14526_/D _13084_/A _13101_/C VPWR VGND sg13cmos5l_xor2_1
XFILLER_2_396 VPWR VGND sg13cmos5l_fill_2
X_12035_ _12035_/Y _13891_/Q _12030_/B _12345_/B1 _13699_/Q _12346_/B1 VPWR VGND sg13cmos5l_a221oi_1
XFILLER_38_529 VPWR VGND sg13cmos5l_fill_2
XFILLER_66_827 VPWR VGND sg13cmos5l_fill_1
XFILLER_78_698 VPWR VGND sg13cmos5l_fill_1
XFILLER_93_657 VPWR VGND sg13cmos5l_decap_4
X_13986_ _13986_/Q clkload58/A _13986_/D _13986_/RESET_B VPWR VGND sg13cmos5l_dfrbpq_1
XFILLER_18_264 VPWR VGND sg13cmos5l_fill_2
XFILLER_34_735 VPWR VGND sg13cmos5l_fill_2
XFILLER_46_562 VPWR VGND sg13cmos5l_fill_1
XFILLER_46_595 VPWR VGND sg13cmos5l_fill_2
XFILLER_61_510 VPWR VGND sg13cmos5l_decap_8
X_12937_ _12938_/A hold3551/X _11436_/B _11430_/B _12937_/B2 VPWR VGND sg13cmos5l_a22oi_1
X_12868_ _12871_/A _12832_/A _12865_/Y _12866_/Y _12864_/C _12867_/Y VPWR VGND sg13cmos5l_a221oi_1
X_11819_ _11819_/Y _11870_/A _11819_/B VPWR VGND sg13cmos5l_nor2_1
X_14607_ _14607_/Q _14650_/CLK _14607_/D _14607_/RESET_B VPWR VGND sg13cmos5l_dfrbpq_1
XFILLER_105_1002 VPWR VGND sg13cmos5l_decap_8
X_12799_ _12799_/X _12824_/B _12799_/B VPWR VGND sg13cmos5l_xor2_1
X_14538_ _14538_/Q clkload15/A _14538_/D fanout978/X VPWR VGND sg13cmos5l_dfrbpq_1
X_14469_ _15882_/A clkload42/A _14469_/D _14469_/RESET_B VPWR VGND sg13cmos5l_dfrbpq_1
Xhold3206 _13491_/D _09379_/X VPWR VGND sg13cmos5l_dlygate4sd3_1
X_08961_ _08961_/Y _08961_/A _08961_/B VPWR VGND sg13cmos5l_nor2_1
Xhold3217 hold3217/X _13581_/Q VPWR VGND sg13cmos5l_dlygate4sd3_1
Xhold3228 hold3228/X _13332_/Q VPWR VGND sg13cmos5l_dlygate4sd3_1
Xhold3239 hold3239/X _13584_/Q VPWR VGND sg13cmos5l_dlygate4sd3_1
X_07912_ _08734_/B _14619_/Q _14620_/Q _14621_/Q VPWR VGND sg13cmos5l_nor3_1
X_08892_ _14651_/D _08892_/A VPWR VGND sg13cmos5l_inv_1
Xhold2505 _14071_/D _10630_/Y VPWR VGND sg13cmos5l_dlygate4sd3_1
Xhold2516 _14495_/D _13015_/Y VPWR VGND sg13cmos5l_dlygate4sd3_1
Xhold2527 _10721_/A _14134_/Q VPWR VGND sg13cmos5l_dlygate4sd3_1
Xhold2538 _10796_/A _14159_/Q VPWR VGND sg13cmos5l_dlygate4sd3_1
X_07843_ _07844_/C _07843_/A _07843_/B _07843_/C VPWR VGND sg13cmos5l_nand3_1
Xhold2549 _14155_/D _10785_/Y VPWR VGND sg13cmos5l_dlygate4sd3_1
X_14355__1153 _14355_/RESET_B VPWR VGND sg13cmos5l_tiehi
X_07774_ _07775_/A _07838_/C _08539_/B _07773_/Y _08582_/A _07772_/Y VPWR VGND sg13cmos5l_a221oi_1
X_13601__1821 _13601_/RESET_B VPWR VGND sg13cmos5l_tiehi
X_09513_ _09513_/X _14411_/Q _14630_/Q _09532_/S VPWR VGND sg13cmos5l_mux2_1
XFILLER_37_595 VPWR VGND sg13cmos5l_decap_8
X_09444_ _13554_/D _10679_/A1 hold3349/X _09453_/S VPWR VGND sg13cmos5l_mux2_1
X_13946__1445 _13946_/RESET_B VPWR VGND sg13cmos5l_tiehi
X_09375_ _13488_/D _08397_/A hold3220/X _09375_/S VPWR VGND sg13cmos5l_mux2_1
X_08326_ _08326_/X _13578_/Q _13546_/Q _08338_/S VPWR VGND sg13cmos5l_mux2_1
X_08257_ _08257_/Y _08257_/A _08397_/B _08344_/C VPWR VGND sg13cmos5l_nand3_1
X_07208_ _10641_/A _10642_/A VPWR VGND sg13cmos5l_inv_1
X_08188_ _08188_/X _13563_/Q _13531_/Q _13499_/Q _13467_/Q _08283_/S _08200_/S1 VPWR
+ VGND sg13cmos5l_mux4_1
XFILLER_106_523 VPWR VGND sg13cmos5l_decap_4
XFILLER_0_823 VPWR VGND sg13cmos5l_decap_8
X_10150_ _13839_/D fanout62/X _10153_/B _10149_/Y VPWR VGND sg13cmos5l_o21ai_1
X_10081_ _13805_/D fanout75/X _10082_/B _10080_/Y VPWR VGND sg13cmos5l_o21ai_1
XFILLER_0_878 VPWR VGND sg13cmos5l_fill_2
X_13840_ _13840_/Q clkload78/A _13840_/D _13840_/RESET_B VPWR VGND sg13cmos5l_dfrbpq_1
XFILLER_74_77 VPWR VGND sg13cmos5l_fill_1
X_10983_ _10983_/Y _11019_/A _10983_/B VPWR VGND sg13cmos5l_nor2_1
X_13771_ _13771_/Q clkload62/A _13771_/D _13771_/RESET_B VPWR VGND sg13cmos5l_dfrbpq_1
XFILLER_16_746 VPWR VGND sg13cmos5l_fill_2
X_12722_ _12724_/B _12703_/Y _12745_/B _12745_/A VPWR VGND sg13cmos5l_a21oi_1
XFILLER_15_278 VPWR VGND sg13cmos5l_fill_1
XFILLER_71_874 VPWR VGND sg13cmos5l_fill_1
X_14242__1789 _14242_/RESET_B VPWR VGND sg13cmos5l_tiehi
X_12653_ _12653_/X _14231_/Q _14230_/Q VPWR VGND sg13cmos5l_or2_1
X_11604_ _11604_/Y _11604_/A _11604_/B VPWR VGND sg13cmos5l_nand2_1
X_12584_ _12584_/Y _12636_/C _12582_/X _12583_/X _12637_/C VPWR VGND sg13cmos5l_a22oi_1
X_11535_ _11536_/B _11534_/A _11534_/B _11577_/B VPWR VGND sg13cmos5l_a21oi_1
X_14323_ _14323_/Q _14453_/CLK _14323_/D _14323_/RESET_B VPWR VGND sg13cmos5l_dfrbpq_1
X_14433__1075 _14433_/RESET_B VPWR VGND sg13cmos5l_tiehi
X_14254_ _14254_/Q clkload71/A _14254_/D _14254_/RESET_B VPWR VGND sg13cmos5l_dfrbpq_1
X_11466_ _11466_/Y _11466_/A _11476_/C VPWR VGND sg13cmos5l_nor2_1
X_13205_ _13205_/Q clkload8/A _13205_/D fanout960/X VPWR VGND sg13cmos5l_dfrbpq_1
X_10417_ _10417_/Y _10417_/A _10547_/B VPWR VGND sg13cmos5l_nor2b_1
X_11397_ _11413_/A _14176_/Q _11403_/B VPWR VGND sg13cmos5l_nand2_1
X_14185_ _14185_/Q _14217_/CLK _14185_/D _14185_/RESET_B VPWR VGND sg13cmos5l_dfrbpq_1
XFILLER_3_672 VPWR VGND sg13cmos5l_fill_1
X_10348_ _13936_/D fanout57/X _10347_/B _10347_/Y VPWR VGND sg13cmos5l_a21oi_1
X_13136_ _14558_/D hold3544/X _08038_/B _13136_/S VPWR VGND sg13cmos5l_mux2_1
X_10279_ _13902_/D fanout73/X _10278_/B _10278_/Y VPWR VGND sg13cmos5l_a21oi_1
X_13067_ _13069_/B _14518_/Q _14519_/Q _13067_/C VPWR VGND sg13cmos5l_nand3_1
XFILLER_66_602 VPWR VGND sg13cmos5l_fill_1
XFILLER_79_996 VPWR VGND sg13cmos5l_fill_2
X_12018_ _14358_/D _07228_/Y _12154_/A _12014_/Y _12017_/Y VPWR VGND sg13cmos5l_a22oi_1
X_13409__2013 _13409_/RESET_B VPWR VGND sg13cmos5l_tiehi
XFILLER_66_635 VPWR VGND sg13cmos5l_decap_8
XFILLER_94_944 VPWR VGND sg13cmos5l_decap_4
XFILLER_94_977 VPWR VGND sg13cmos5l_fill_1
XFILLER_19_584 VPWR VGND sg13cmos5l_fill_2
XFILLER_47_893 VPWR VGND sg13cmos5l_fill_1
X_13969_ _13969_/Q clkload70/A _13969_/D _13969_/RESET_B VPWR VGND sg13cmos5l_dfrbpq_1
XFILLER_19_595 VPWR VGND sg13cmos5l_fill_1
XFILLER_46_392 VPWR VGND sg13cmos5l_decap_8
X_07490_ _07490_/Y _10685_/A1 _08199_/A1 _08187_/B2 VPWR VGND sg13cmos5l_a21oi_1
XFILLER_55_1007 VPWR VGND sg13cmos5l_fill_1
XFILLER_34_587 VPWR VGND sg13cmos5l_decap_8
XFILLER_61_373 VPWR VGND sg13cmos5l_decap_4
X_09160_ _09160_/Y _14367_/Q _09160_/A2 _09159_/Y VPWR VGND sg13cmos5l_a21oi_1
XFILLER_30_760 VPWR VGND sg13cmos5l_fill_1
X_08111_ _08112_/C _07369_/Y _08111_/B VPWR VGND sg13cmos5l_nand2b_1
X_09091_ _11344_/A _14324_/Q _09193_/B VPWR VGND sg13cmos5l_nand2_1
X_08042_ _08046_/B _14544_/Q _08042_/B VPWR VGND sg13cmos5l_xor2_1
X_13630__1761 _13630_/RESET_B VPWR VGND sg13cmos5l_tiehi
XFILLER_89_716 VPWR VGND sg13cmos5l_decap_4
X_09993_ _09993_/Y _09993_/A _10007_/B VPWR VGND sg13cmos5l_nand2_1
Xhold3003 hold3003/X _13550_/Q VPWR VGND sg13cmos5l_dlygate4sd3_1
Xhold3014 hold3014/X _13350_/Q VPWR VGND sg13cmos5l_dlygate4sd3_1
X_14614__2157 _14614_/RESET_B VPWR VGND sg13cmos5l_tiehi
X_08944_ _08944_/Y hold3524/X _13189_/B1 _13151_/B1 VPWR VGND sg13cmos5l_a21oi_1
Xhold2302 _11481_/A _14333_/Q VPWR VGND sg13cmos5l_dlygate4sd3_1
Xhold3025 _10442_/A _13982_/Q VPWR VGND sg13cmos5l_dlygate4sd3_1
Xhold3036 _09551_/A _13596_/Q VPWR VGND sg13cmos5l_dlygate4sd3_1
Xhold3047 _13540_/D _09429_/X VPWR VGND sg13cmos5l_dlygate4sd3_1
X_14010__1381 _14010_/RESET_B VPWR VGND sg13cmos5l_tiehi
Xhold2313 _10034_/A _13782_/Q VPWR VGND sg13cmos5l_dlygate4sd3_1
Xhold2324 _10099_/A _13814_/Q VPWR VGND sg13cmos5l_dlygate4sd3_1
Xhold2335 hold2335/X _14588_/Q VPWR VGND sg13cmos5l_dlygate4sd3_1
Xhold2346 _12977_/A _14476_/Q VPWR VGND sg13cmos5l_dlygate4sd3_1
Xhold3058 hold3058/X _13398_/Q VPWR VGND sg13cmos5l_dlygate4sd3_1
Xhold3069 hold3069/X _13493_/Q VPWR VGND sg13cmos5l_dlygate4sd3_1
XFILLER_57_635 VPWR VGND sg13cmos5l_decap_8
XFILLER_85_933 VPWR VGND sg13cmos5l_decap_8
XFILLER_85_944 VPWR VGND sg13cmos5l_fill_2
XFILLER_97_793 VPWR VGND sg13cmos5l_fill_1
X_08875_ _08875_/Y _08875_/A _08875_/B VPWR VGND sg13cmos5l_nor2_1
Xhold2357 _10548_/A _14034_/Q VPWR VGND sg13cmos5l_dlygate4sd3_1
Xhold2368 _10021_/A _13776_/Q VPWR VGND sg13cmos5l_dlygate4sd3_1
Xhold2379 _13104_/A _14535_/Q VPWR VGND sg13cmos5l_dlygate4sd3_1
XFILLER_29_359 VPWR VGND sg13cmos5l_fill_1
X_07826_ _15881_/A _13259_/Q _14575_/Q VPWR VGND sg13cmos5l_or2_1
XFILLER_72_627 VPWR VGND sg13cmos5l_fill_1
X_07757_ _07758_/C _07688_/Y _07749_/Y _07756_/Y VPWR VGND sg13cmos5l_o21ai_1
XFILLER_53_863 VPWR VGND sg13cmos5l_fill_1
X_07688_ _07688_/Y _07707_/A VPWR VGND sg13cmos5l_inv_1
XFILLER_52_373 VPWR VGND sg13cmos5l_fill_1
X_09427_ _13538_/D _09286_/A hold3325/X _09438_/S VPWR VGND sg13cmos5l_mux2_1
XFILLER_40_568 VPWR VGND sg13cmos5l_fill_1
X_09358_ _13471_/D _07973_/A hold3318/X _09373_/S VPWR VGND sg13cmos5l_mux2_1
X_14214__1263 _14214_/RESET_B VPWR VGND sg13cmos5l_tiehi
X_08309_ _08309_/X _08309_/A _13385_/Q VPWR VGND sg13cmos5l_or2_1
X_09289_ _13411_/D _07301_/Y _09293_/B _09288_/Y VPWR VGND sg13cmos5l_a21oi_1
X_11320_ _11320_/Y _11320_/A _11358_/B VPWR VGND sg13cmos5l_nand2_1
XFILLER_4_425 VPWR VGND sg13cmos5l_fill_1
X_11251_ _11252_/A _14089_/Q _11256_/D VPWR VGND sg13cmos5l_nor2_1
X_10202_ _13864_/D _10397_/A1 _10209_/B _10201_/Y VPWR VGND sg13cmos5l_a21oi_1
X_11182_ _11182_/Y _11193_/A _11214_/A _12907_/B2 VPWR VGND sg13cmos5l_o21ai_1
X_10133_ _10133_/Y _10133_/A _10143_/B VPWR VGND sg13cmos5l_nand2_1
Xhold3570 hold3570/X _14263_/Q VPWR VGND sg13cmos5l_dlygate4sd3_1
XFILLER_85_43 VPWR VGND sg13cmos5l_fill_2
X_10064_ _10064_/Y _10064_/A _10078_/B VPWR VGND sg13cmos5l_nand2_1
XFILLER_75_443 VPWR VGND sg13cmos5l_decap_8
Xhold2880 _09848_/A _13691_/Q VPWR VGND sg13cmos5l_dlygate4sd3_1
Xhold2891 _10248_/A _13887_/Q VPWR VGND sg13cmos5l_dlygate4sd3_1
XFILLER_47_156 VPWR VGND sg13cmos5l_fill_1
X_13823_ _13823_/Q clkload60/A _13823_/D _13823_/RESET_B VPWR VGND sg13cmos5l_dfrbpq_1
X_13672__1719 _13672_/RESET_B VPWR VGND sg13cmos5l_tiehi
XFILLER_44_852 VPWR VGND sg13cmos5l_fill_1
XFILLER_71_660 VPWR VGND sg13cmos5l_fill_1
X_10966_ _10966_/Y _14195_/Q _13166_/B _10965_/X VPWR VGND sg13cmos5l_a21oi_1
X_13754_ _13754_/Q clkload52/A _13754_/D _13754_/RESET_B VPWR VGND sg13cmos5l_dfrbpq_1
XFILLER_43_384 VPWR VGND sg13cmos5l_decap_8
X_10897_ _10897_/Y _10897_/A _13166_/B VPWR VGND sg13cmos5l_nand2_1
X_13685_ _13685_/Q clkload16/A _13685_/D _13685_/RESET_B VPWR VGND sg13cmos5l_dfrbpq_1
X_12705_ _12706_/B _11150_/X _12595_/Y _12596_/X _11157_/A VPWR VGND sg13cmos5l_a22oi_1
X_14052__1339 _14052_/RESET_B VPWR VGND sg13cmos5l_tiehi
X_13241__1051 _13241_/RESET_B VPWR VGND sg13cmos5l_tiehi
X_12636_ _12636_/Y _12637_/A _12636_/B _12636_/C VPWR VGND sg13cmos5l_nand3_1
XFILLER_8_753 VPWR VGND sg13cmos5l_fill_2
X_14306_ _14306_/Q clkload23/A _14306_/D _14306_/RESET_B VPWR VGND sg13cmos5l_dfrbpq_1
X_13248__1016 _13248_/RESET_B VPWR VGND sg13cmos5l_tiehi
X_12567_ _12567_/Y _12565_/X _12566_/Y _11628_/Y VPWR VGND sg13cmos5l_o21ai_1
X_11518_ _11519_/C _11504_/B _11555_/B _11484_/A VPWR VGND sg13cmos5l_o21ai_1
X_12498_ _14392_/D _12498_/A _12498_/B VPWR VGND sg13cmos5l_nand2_1
X_11449_ _11449_/Y _11449_/A _11560_/B VPWR VGND sg13cmos5l_nand2_1
X_14237_ _14237_/Q clkload38/A _14237_/D _14237_/RESET_B VPWR VGND sg13cmos5l_dfrbpq_1
X_14168_ _14168_/Q clkload43/A _14168_/D _14168_/RESET_B VPWR VGND sg13cmos5l_dfrbpq_1
X_13341__2081 _13341_/RESET_B VPWR VGND sg13cmos5l_tiehi
X_13119_ _13119_/Y _08047_/B _13119_/B VPWR VGND sg13cmos5l_nand2b_1
XFILLER_79_771 VPWR VGND sg13cmos5l_decap_8
X_14099_ _14099_/Q _14102_/CLK _14099_/D fanout996/X VPWR VGND sg13cmos5l_dfrbpq_1
XFILLER_66_443 VPWR VGND sg13cmos5l_decap_8
X_08660_ _08660_/Y _14002_/Q _12058_/B _11725_/B VPWR VGND sg13cmos5l_a21oi_1
XFILLER_54_605 VPWR VGND sg13cmos5l_decap_8
X_07611_ _07629_/B _13303_/Q _07611_/B VPWR VGND sg13cmos5l_xnor2_1
XFILLER_82_958 VPWR VGND sg13cmos5l_fill_1
X_08591_ _08592_/B _08603_/C _08588_/Y _08590_/Y VPWR VGND sg13cmos5l_a21oi_1
X_13648__1743 _13648_/RESET_B VPWR VGND sg13cmos5l_tiehi
X_07542_ _07546_/A _14542_/Q _13295_/Q VPWR VGND sg13cmos5l_xor2_1
XFILLER_62_682 VPWR VGND sg13cmos5l_decap_8
X_07473_ _14244_/D hold3424/X _13032_/B _07533_/S VPWR VGND sg13cmos5l_mux2_1
XFILLER_50_855 VPWR VGND sg13cmos5l_fill_2
X_09212_ _13341_/D _10690_/A1 hold3281/X _09230_/B VPWR VGND sg13cmos5l_mux2_1
X_14028__1363 _14028_/RESET_B VPWR VGND sg13cmos5l_tiehi
X_09143_ _09143_/Y _09143_/A _09161_/B VPWR VGND sg13cmos5l_nor2_1
X_13551__1871 _13551_/RESET_B VPWR VGND sg13cmos5l_tiehi
X_09074_ _09074_/Y _14417_/Q _11293_/A VPWR VGND sg13cmos5l_nand2_1
X_08025_ _08031_/D _14554_/Q _08036_/B VPWR VGND sg13cmos5l_xnor2_1
X_13896__1495 _13896_/RESET_B VPWR VGND sg13cmos5l_tiehi
XFILLER_104_835 VPWR VGND sg13cmos5l_fill_1
XFILLER_1_428 VPWR VGND sg13cmos5l_fill_2
X_09976_ _13753_/D _10563_/A1 _09979_/B _09975_/Y VPWR VGND sg13cmos5l_o21ai_1
X_08927_ _13248_/D _07286_/Y _13196_/A2 _13190_/B1 _08926_/Y VPWR VGND sg13cmos5l_a22oi_1
XFILLER_57_454 VPWR VGND sg13cmos5l_fill_1
X_08858_ _14642_/D hold2267/X _08869_/B _08857_/Y VPWR VGND sg13cmos5l_a21o_1
XFILLER_85_774 VPWR VGND sg13cmos5l_decap_4
X_07809_ _07809_/Y _14402_/Q _12334_/A VPWR VGND sg13cmos5l_nor2_1
X_08789_ _08791_/B _14374_/Q _11164_/B _08831_/B1 VPWR VGND sg13cmos5l_o21ai_1
XFILLER_38_1002 VPWR VGND sg13cmos5l_fill_1
X_10820_ _10820_/Y _14169_/Q _10885_/C _13162_/B _10819_/X VPWR VGND sg13cmos5l_a22oi_1
XFILLER_13_524 VPWR VGND sg13cmos5l_fill_2
X_10751_ _10751_/Y _10751_/A _10751_/B VPWR VGND sg13cmos5l_nand2_1
X_13383__2039 _13383_/RESET_B VPWR VGND sg13cmos5l_tiehi
X_13470_ _13470_/Q clkload32/A _13470_/D _13470_/RESET_B VPWR VGND sg13cmos5l_dfrbpq_1
X_10682_ _14102_/D input11/X hold3435/X _10685_/S VPWR VGND sg13cmos5l_mux2_1
X_12421_ _12421_/Y _13777_/Q _12373_/B _12425_/C1 VPWR VGND sg13cmos5l_a21oi_1
X_12352_ _12356_/C _12352_/A _12352_/B VPWR VGND sg13cmos5l_nor2_1
X_11303_ _11303_/Y _11303_/A _11303_/B VPWR VGND sg13cmos5l_xnor2_1
X_12283_ _12284_/C _12248_/A _07291_/Y _12257_/Y VPWR VGND sg13cmos5l_o21ai_1
X_11234_ _11235_/B _11234_/A _11234_/B VPWR VGND sg13cmos5l_nand2_1
X_14022_ _14022_/Q clkload55/A _14022_/D _14022_/RESET_B VPWR VGND sg13cmos5l_dfrbpq_1
XFILLER_45_1017 VPWR VGND sg13cmos5l_decap_8
X_14657__2200 _14657_/RESET_B VPWR VGND sg13cmos5l_tiehi
X_13726__1665 _13726_/RESET_B VPWR VGND sg13cmos5l_tiehi
XFILLER_1_962 VPWR VGND sg13cmos5l_fill_2
XFILLER_45_1028 VPWR VGND sg13cmos5l_fill_1
X_11165_ _11165_/Y _11161_/Y _12636_/C _11149_/Y VPWR VGND sg13cmos5l_o21ai_1
X_10116_ _13822_/D _10573_/A1 _10137_/B _10115_/Y VPWR VGND sg13cmos5l_o21ai_1
X_11096_ _14291_/D _11147_/B _11094_/Y _11095_/Y VPWR VGND sg13cmos5l_a21oi_1
XFILLER_48_454 VPWR VGND sg13cmos5l_fill_2
XFILLER_49_955 VPWR VGND sg13cmos5l_decap_4
X_10047_ _13788_/D _10569_/A1 _10052_/B _10046_/Y VPWR VGND sg13cmos5l_o21ai_1
XFILLER_48_476 VPWR VGND sg13cmos5l_decap_4
XFILLER_63_402 VPWR VGND sg13cmos5l_decap_8
X_13941__1450 _13941_/RESET_B VPWR VGND sg13cmos5l_tiehi
X_13593__1829 _13593_/RESET_B VPWR VGND sg13cmos5l_tiehi
XFILLER_29_690 VPWR VGND sg13cmos5l_fill_1
X_11998_ _11998_/Y _13762_/Q _12000_/B _11998_/B1 VPWR VGND sg13cmos5l_o21ai_1
X_13806_ _13806_/Q clkload55/A _13806_/D _13806_/RESET_B VPWR VGND sg13cmos5l_dfrbpq_1
XFILLER_32_833 VPWR VGND sg13cmos5l_fill_2
X_10949_ _14217_/D _10818_/Y _10909_/Y _10948_/Y VPWR VGND sg13cmos5l_o21ai_1
X_14613__2156 _14613_/RESET_B VPWR VGND sg13cmos5l_tiehi
X_13737_ _13737_/Q clkload59/A _13737_/D _13737_/RESET_B VPWR VGND sg13cmos5l_dfrbpq_1
Xclkbuf_leaf_70_clk clkload63/A clkload5/A VPWR VGND sg13cmos5l_buf_8
X_13359__2063 _13359_/RESET_B VPWR VGND sg13cmos5l_tiehi
X_13668_ _13668_/Q clkload54/A _13668_/D _13668_/RESET_B VPWR VGND sg13cmos5l_dfrbpq_1
X_13599_ _13599_/Q _14045_/CLK _13599_/D _13599_/RESET_B VPWR VGND sg13cmos5l_dfrbpq_1
X_12619_ _12620_/C _12648_/B _12618_/Y _12594_/A VPWR VGND sg13cmos5l_a21oi_1
XFILLER_6_62 VPWR VGND sg13cmos5l_fill_2
XFILLER_99_800 VPWR VGND sg13cmos5l_fill_2
XFILLER_99_811 VPWR VGND sg13cmos5l_decap_8
XFILLER_59_719 VPWR VGND sg13cmos5l_fill_2
XFILLER_86_505 VPWR VGND sg13cmos5l_fill_1
X_09830_ _09830_/Y _09830_/A _09846_/B VPWR VGND sg13cmos5l_nor2_1
Xfanout529 _08397_/B _08157_/B VPWR VGND sg13cmos5l_buf_1
Xfanout518 _12296_/A2 _12426_/B VPWR VGND sg13cmos5l_buf_1
Xfanout507 _08729_/B fanout510/X VPWR VGND sg13cmos5l_buf_1
X_09761_ _13649_/D fanout55/X _09760_/B _09760_/Y VPWR VGND sg13cmos5l_a21oi_1
X_08712_ _08716_/A _08711_/Y _12449_/A VPWR VGND sg13cmos5l_nand2b_1
XFILLER_39_476 VPWR VGND sg13cmos5l_fill_1
XFILLER_55_925 VPWR VGND sg13cmos5l_decap_8
XFILLER_67_796 VPWR VGND sg13cmos5l_decap_8
XFILLER_82_711 VPWR VGND sg13cmos5l_fill_1
X_09692_ _09692_/Y _09691_/A _11605_/B _09691_/Y VPWR VGND sg13cmos5l_a21oi_1
XFILLER_54_424 VPWR VGND sg13cmos5l_decap_8
XFILLER_55_958 VPWR VGND sg13cmos5l_fill_2
XFILLER_82_755 VPWR VGND sg13cmos5l_decap_8
X_08643_ _08643_/Y _08643_/A _08644_/B VPWR VGND sg13cmos5l_nor2b_1
X_13569__1853 _13569_/RESET_B VPWR VGND sg13cmos5l_tiehi
XFILLER_26_148 VPWR VGND sg13cmos5l_fill_2
XFILLER_42_608 VPWR VGND sg13cmos5l_decap_8
XFILLER_42_619 VPWR VGND sg13cmos5l_fill_2
XFILLER_82_766 VPWR VGND sg13cmos5l_fill_1
X_08574_ _14605_/D _08575_/B _08574_/B VPWR VGND sg13cmos5l_xnor2_1
X_14392__1116 _14392_/RESET_B VPWR VGND sg13cmos5l_tiehi
X_07525_ _07525_/Y _08227_/A2 _07523_/Y _07526_/A1 VPWR VGND sg13cmos5l_o21ai_1
XFILLER_50_630 VPWR VGND sg13cmos5l_fill_2
Xclkbuf_leaf_61_clk clkload70/A clkbuf_4_12_0_clk/X VPWR VGND sg13cmos5l_buf_8
XFILLER_23_899 VPWR VGND sg13cmos5l_fill_1
XFILLER_50_663 VPWR VGND sg13cmos5l_decap_4
X_07456_ _07456_/Y _13032_/A VPWR VGND sg13cmos5l_inv_1
X_13804__1587 _13804_/RESET_B VPWR VGND sg13cmos5l_tiehi
XFILLER_10_549 VPWR VGND sg13cmos5l_fill_2
XFILLER_41_37 VPWR VGND sg13cmos5l_fill_2
XFILLER_50_696 VPWR VGND sg13cmos5l_fill_1
XFILLER_6_509 VPWR VGND sg13cmos5l_fill_2
X_07387_ _07588_/B _08964_/A _14539_/Q VPWR VGND sg13cmos5l_xor2_1
X_09126_ _13317_/D _09125_/B _09124_/Y _09125_/Y VPWR VGND sg13cmos5l_a21oi_1
XFILLER_68_1028 VPWR VGND sg13cmos5l_fill_1
X_09057_ _09057_/Y _14414_/Q _11293_/A VPWR VGND sg13cmos5l_nand2_1
X_13983__1408 _13983_/RESET_B VPWR VGND sg13cmos5l_tiehi
X_08008_ _08009_/C _08050_/A _07629_/A input20/X VPWR VGND sg13cmos5l_o21ai_1
X_09959_ _13745_/D fanout56/X _09958_/B _09958_/Y VPWR VGND sg13cmos5l_a21oi_1
XFILLER_46_914 VPWR VGND sg13cmos5l_fill_2
XFILLER_58_763 VPWR VGND sg13cmos5l_decap_8
XFILLER_58_785 VPWR VGND sg13cmos5l_decap_8
X_12970_ _12971_/B _12968_/A _12969_/C hold2866/X VPWR VGND sg13cmos5l_a21oi_1
X_11921_ _11921_/Y _11926_/A _12164_/C VPWR VGND sg13cmos5l_nand2_1
XFILLER_61_917 VPWR VGND sg13cmos5l_decap_8
X_11852_ _11852_/Y _14045_/Q _11915_/B _11858_/B _13789_/Q VPWR VGND sg13cmos5l_a22oi_1
X_14640_ _14640_/Q _14640_/CLK _14640_/D _14640_/RESET_B VPWR VGND sg13cmos5l_dfrbpq_1
X_10803_ _10803_/Y _10802_/B _10801_/Y _10802_/Y VPWR VGND sg13cmos5l_o21ai_1
X_14571_ _14571_/Q clkload45/A _14571_/D _14571_/RESET_B VPWR VGND sg13cmos5l_dfrbpq_1
X_14368__1140 _14368_/RESET_B VPWR VGND sg13cmos5l_tiehi
X_11783_ _11783_/Y _13914_/Q _11783_/B VPWR VGND sg13cmos5l_nand2b_1
Xclkbuf_leaf_52_clk clkload80/A clkload7/A VPWR VGND sg13cmos5l_buf_8
X_13522_ _13522_/Q _14102_/CLK _13522_/D _13522_/RESET_B VPWR VGND sg13cmos5l_dfrbpq_1
X_10734_ _10734_/Y _10772_/B _10732_/Y _10733_/Y VPWR VGND sg13cmos5l_o21ai_1
X_10665_ _14089_/D _14270_/D hold3482/X _10675_/S VPWR VGND sg13cmos5l_mux2_1
X_13453_ _13453_/Q clkload35/A _13453_/D _13453_/RESET_B VPWR VGND sg13cmos5l_dfrbpq_1
X_13384_ _13384_/Q clkload28/A _13384_/D _13384_/RESET_B VPWR VGND sg13cmos5l_dfrbpq_1
X_12404_ _12542_/B _12430_/A1 _12396_/Y _12400_/Y _12403_/Y VPWR VGND sg13cmos5l_a22oi_1
XFILLER_5_531 VPWR VGND sg13cmos5l_fill_2
X_10596_ _10596_/Y _10596_/A _10596_/B VPWR VGND sg13cmos5l_nand2_1
X_12335_ _12359_/A _14370_/Q _13255_/Q VPWR VGND sg13cmos5l_xnor2_1
X_13959__1432 _13959_/RESET_B VPWR VGND sg13cmos5l_tiehi
X_12266_ _12266_/Y _12264_/Y _12265_/Y _12403_/B1 VPWR VGND sg13cmos5l_a21oi_1
XFILLER_68_505 VPWR VGND sg13cmos5l_fill_1
X_11217_ _11217_/Y _11239_/A _11213_/X _11216_/Y _10982_/Y VPWR VGND sg13cmos5l_a22oi_1
X_12197_ _12198_/C _13929_/Q _12296_/A2 _12087_/B _13673_/Q VPWR VGND sg13cmos5l_a22oi_1
X_14005_ _14005_/Q clkload49/A _14005_/D _14005_/RESET_B VPWR VGND sg13cmos5l_dfrbpq_1
X_11148_ _14306_/D _11147_/B _11146_/Y _11147_/Y VPWR VGND sg13cmos5l_a21oi_1
XFILLER_49_730 VPWR VGND sg13cmos5l_decap_4
XFILLER_37_903 VPWR VGND sg13cmos5l_fill_2
XFILLER_49_763 VPWR VGND sg13cmos5l_fill_2
XFILLER_76_571 VPWR VGND sg13cmos5l_decap_8
X_11079_ _11079_/X _14379_/Q _11083_/B VPWR VGND sg13cmos5l_and2_1
X_14173__1304 _14173_/RESET_B VPWR VGND sg13cmos5l_tiehi
X_15887_ _15887_/X _15887_/A VPWR VGND sg13cmos5l_buf_1
X_07310_ _07310_/Y _07310_/A VPWR VGND sg13cmos5l_inv_1
Xclkbuf_leaf_43_clk clkload71/A clkload6/A VPWR VGND sg13cmos5l_buf_8
XFILLER_20_803 VPWR VGND sg13cmos5l_fill_2
XFILLER_32_674 VPWR VGND sg13cmos5l_fill_1
X_08290_ _08290_/Y _11034_/A _08288_/X _08289_/Y _08287_/X _08317_/A1 VPWR VGND sg13cmos5l_a221oi_1
X_07241_ _11117_/A _14380_/Q VPWR VGND sg13cmos5l_inv_1
XFILLER_9_881 VPWR VGND sg13cmos5l_fill_2
X_07172_ _09575_/B _14450_/Q VPWR VGND sg13cmos5l_inv_1
XFILLER_106_908 VPWR VGND sg13cmos5l_decap_8
XFILLER_11_18 VPWR VGND sg13cmos5l_fill_1
XFILLER_99_663 VPWR VGND sg13cmos5l_fill_2
Xfanout304 _09878_/B _09859_/A2 VPWR VGND sg13cmos5l_buf_1
X_14300__1208 _14300_/RESET_B VPWR VGND sg13cmos5l_tiehi
X_09813_ _09813_/Y _09813_/A _09813_/B VPWR VGND sg13cmos5l_nor2_1
Xfanout348 _09587_/B fanout354/X VPWR VGND sg13cmos5l_buf_1
Xfanout337 _10557_/A1 _09510_/Y VPWR VGND sg13cmos5l_buf_1
Xfanout326 _09754_/B _09730_/B VPWR VGND sg13cmos5l_buf_1
Xfanout315 _09797_/B fanout320/X VPWR VGND sg13cmos5l_buf_1
Xfanout359 _09077_/B _09071_/B VPWR VGND sg13cmos5l_buf_1
XFILLER_74_519 VPWR VGND sg13cmos5l_decap_4
X_09744_ _09744_/Y _09744_/A _09754_/B VPWR VGND sg13cmos5l_nor2_1
X_09675_ _11572_/B _14435_/Q _14654_/Q _09689_/S VPWR VGND sg13cmos5l_mux2_1
XFILLER_70_703 VPWR VGND sg13cmos5l_fill_2
X_08626_ _08626_/X _07812_/Y _08623_/A _07821_/Y VPWR VGND sg13cmos5l_a21o_1
XFILLER_54_265 VPWR VGND sg13cmos5l_fill_1
XFILLER_74_1010 VPWR VGND sg13cmos5l_fill_1
XFILLER_42_438 VPWR VGND sg13cmos5l_decap_8
XFILLER_42_449 VPWR VGND sg13cmos5l_fill_2
XFILLER_70_747 VPWR VGND sg13cmos5l_fill_2
X_08557_ _08557_/Y _08867_/A _07775_/A _07777_/Y VPWR VGND sg13cmos5l_o21ai_1
Xclkbuf_leaf_34_clk clkload43/A clkload3/A VPWR VGND sg13cmos5l_buf_8
XFILLER_50_460 VPWR VGND sg13cmos5l_fill_1
X_07508_ _07508_/X _13428_/Q _13396_/Q _13364_/Q _13332_/Q _07522_/S0 _07522_/S1 VPWR
+ VGND sg13cmos5l_mux4_1
X_08488_ _08489_/A _08491_/A _08819_/A _08488_/C VPWR VGND sg13cmos5l_nor3_1
X_07439_ _07439_/Y _07439_/A _07439_/B VPWR VGND sg13cmos5l_nand2_1
XFILLER_22_195 VPWR VGND sg13cmos5l_fill_1
X_10450_ _10450_/Y _10450_/A _10464_/B VPWR VGND sg13cmos5l_nor2_1
X_09109_ _11396_/A _14327_/Q _09193_/B VPWR VGND sg13cmos5l_nand2_1
X_10381_ _13952_/D _10381_/A1 _10380_/B _10380_/Y VPWR VGND sg13cmos5l_a21oi_1
X_12120_ _12121_/C _13958_/Q _12319_/A2 _12200_/B1 _13638_/Q VPWR VGND sg13cmos5l_a22oi_1
XFILLER_105_974 VPWR VGND sg13cmos5l_decap_8
XFILLER_89_140 VPWR VGND sg13cmos5l_fill_1
X_12051_ _12051_/Y _13764_/Q _12058_/B _12236_/B1 VPWR VGND sg13cmos5l_a21oi_1
X_11002_ _14234_/D _12594_/A _11002_/B VPWR VGND sg13cmos5l_nor2_1
X_14612__2155 _14612_/RESET_B VPWR VGND sg13cmos5l_tiehi
Xfanout860 _09689_/S _14236_/Q VPWR VGND sg13cmos5l_buf_1
Xfanout893 _09295_/A _14121_/Q VPWR VGND sg13cmos5l_buf_1
Xfanout882 _11595_/A _11433_/A1 VPWR VGND sg13cmos5l_buf_1
Xfanout871 _08603_/C fanout872/X VPWR VGND sg13cmos5l_buf_1
XFILLER_18_402 VPWR VGND sg13cmos5l_fill_1
XFILLER_19_958 VPWR VGND sg13cmos5l_fill_1
X_12953_ _12954_/A _12856_/A _11560_/B _11553_/B _12955_/B2 VPWR VGND sg13cmos5l_a22oi_1
X_11904_ _11930_/A _11904_/A _11904_/B VPWR VGND sg13cmos5l_nand2_1
XFILLER_34_939 VPWR VGND sg13cmos5l_fill_2
X_14623_ _14623_/Q clkload39/A _14623_/D _14623_/RESET_B VPWR VGND sg13cmos5l_dfrbpq_1
X_14309__1199 _14309_/RESET_B VPWR VGND sg13cmos5l_tiehi
X_12884_ _12884_/Y _12871_/B _12884_/B VPWR VGND sg13cmos5l_nand2b_1
X_11835_ _11835_/X _13948_/Q _11939_/B VPWR VGND sg13cmos5l_and2_1
Xclkbuf_leaf_25_clk clkload30/A clkbuf_4_4_0_clk/X VPWR VGND sg13cmos5l_buf_8
XFILLER_41_460 VPWR VGND sg13cmos5l_fill_2
XFILLER_42_983 VPWR VGND sg13cmos5l_fill_2
X_11766_ _11799_/A _11768_/A _11768_/B _11768_/C VPWR VGND sg13cmos5l_a21oi_1
X_14554_ _14554_/Q clkload11/A _14554_/D fanout983/X VPWR VGND sg13cmos5l_dfrbpq_1
XFILLER_42_994 VPWR VGND sg13cmos5l_fill_2
X_10717_ _10717_/Y _10759_/A _14277_/Q VPWR VGND sg13cmos5l_nand2_1
X_14485_ _14485_/Q clkload15/A _14485_/D fanout978/X VPWR VGND sg13cmos5l_dfrbpq_1
X_13505_ _13505_/Q clkload30/A _13505_/D _13505_/RESET_B VPWR VGND sg13cmos5l_dfrbpq_1
X_11697_ _11697_/Y _13943_/Q _11697_/B VPWR VGND sg13cmos5l_nand2_1
X_13436_ _13436_/Q _14109_/CLK _13436_/D _13436_/RESET_B VPWR VGND sg13cmos5l_dfrbpq_1
XFILLER_9_199 VPWR VGND sg13cmos5l_fill_1
X_10648_ _10648_/Y _10648_/A _10648_/B VPWR VGND sg13cmos5l_xnor2_1
X_10579_ _14049_/D _10579_/A1 _10582_/B _10578_/Y VPWR VGND sg13cmos5l_o21ai_1
X_13367_ _13367_/Q _14520_/CLK _13367_/D _13367_/RESET_B VPWR VGND sg13cmos5l_dfrbpq_1
X_14227__1250 _14227_/RESET_B VPWR VGND sg13cmos5l_tiehi
X_13298_ _13298_/Q clkload19/A _13298_/D fanout981/X VPWR VGND sg13cmos5l_dfrbpq_1
X_12318_ _12320_/B _13709_/Q _12349_/B1 _12318_/B1 VPWR VGND sg13cmos5l_a21oi_1
X_12249_ _12249_/Y _14461_/Q _12302_/A2 _12247_/Y _12248_/Y VPWR VGND sg13cmos5l_a22oi_1
Xhold2709 _09734_/A _13636_/Q VPWR VGND sg13cmos5l_dlygate4sd3_1
XFILLER_95_132 VPWR VGND sg13cmos5l_fill_1
XFILLER_96_688 VPWR VGND sg13cmos5l_fill_1
X_07790_ _08889_/A _14400_/Q _12282_/A VPWR VGND sg13cmos5l_and2_1
XFILLER_49_593 VPWR VGND sg13cmos5l_decap_8
X_09460_ _13570_/D _09286_/A hold3134/X _09471_/S VPWR VGND sg13cmos5l_mux2_1
XFILLER_92_883 VPWR VGND sg13cmos5l_fill_1
XFILLER_92_894 VPWR VGND sg13cmos5l_decap_8
X_08411_ _08411_/Y _08411_/A _08411_/B VPWR VGND sg13cmos5l_nand2_1
XFILLER_51_224 VPWR VGND sg13cmos5l_fill_2
XFILLER_91_393 VPWR VGND sg13cmos5l_fill_1
X_09391_ _13503_/D _07973_/A hold3107/X _09409_/S VPWR VGND sg13cmos5l_mux2_1
Xclkbuf_leaf_16_clk clkload37/A clkbuf_4_6_0_clk/X VPWR VGND sg13cmos5l_buf_8
X_08342_ _12559_/B _08340_/Y _08341_/X _08332_/Y VPWR VGND sg13cmos5l_o21ai_1
XFILLER_32_471 VPWR VGND sg13cmos5l_fill_1
XFILLER_32_493 VPWR VGND sg13cmos5l_fill_1
X_08273_ _08273_/Y _08277_/A1 _08270_/X _08311_/C1 VPWR VGND sg13cmos5l_a21oi_1
X_13685__1706 _13685_/RESET_B VPWR VGND sg13cmos5l_tiehi
X_07224_ _12071_/A _14361_/Q VPWR VGND sg13cmos5l_inv_1
X_13721__1670 _13721_/RESET_B VPWR VGND sg13cmos5l_tiehi
XFILLER_106_738 VPWR VGND sg13cmos5l_decap_8
X_14065__1326 _14065_/RESET_B VPWR VGND sg13cmos5l_tiehi
Xfanout112 _09453_/S _09467_/S VPWR VGND sg13cmos5l_buf_1
Xfanout101 _09234_/S _09200_/Y VPWR VGND sg13cmos5l_buf_1
Xfanout156 _10793_/B _10790_/B VPWR VGND sg13cmos5l_buf_1
Xfanout145 _10585_/A1 _09606_/Y VPWR VGND sg13cmos5l_buf_1
Xfanout134 _10829_/S _07998_/Y VPWR VGND sg13cmos5l_buf_1
Xfanout123 _09401_/S _09408_/S VPWR VGND sg13cmos5l_buf_1
X_07988_ _07989_/C _13224_/Q _08207_/B1 _08208_/A2 _14519_/Q VPWR VGND sg13cmos5l_a22oi_1
Xfanout189 _10375_/A1 _09557_/Y VPWR VGND sg13cmos5l_buf_1
Xfanout178 _10577_/A1 _09577_/Y VPWR VGND sg13cmos5l_buf_1
Xfanout167 _10816_/A2 fanout170/X VPWR VGND sg13cmos5l_buf_1
X_09727_ _13632_/D _10381_/A1 _09726_/B _09726_/Y VPWR VGND sg13cmos5l_a21oi_1
XFILLER_27_243 VPWR VGND sg13cmos5l_fill_1
XFILLER_28_766 VPWR VGND sg13cmos5l_fill_2
XFILLER_67_390 VPWR VGND sg13cmos5l_fill_1
XFILLER_55_563 VPWR VGND sg13cmos5l_fill_1
X_09658_ _09658_/Y _09657_/A _09657_/B _09671_/A VPWR VGND sg13cmos5l_a21oi_1
XFILLER_70_544 VPWR VGND sg13cmos5l_decap_4
X_08609_ _08610_/C _08893_/A _08609_/B _08609_/C VPWR VGND sg13cmos5l_nand3_1
X_09589_ _09625_/C _09589_/A _09589_/B _09589_/C VPWR VGND sg13cmos5l_nor3_1
X_11620_ _12165_/A _12162_/B _12136_/A VPWR VGND sg13cmos5l_nand2_1
XFILLER_11_633 VPWR VGND sg13cmos5l_fill_2
XFILLER_23_471 VPWR VGND sg13cmos5l_fill_1
X_11551_ _11557_/B _11556_/A _11551_/B _11564_/B VPWR VGND sg13cmos5l_and3_1
XFILLER_7_604 VPWR VGND sg13cmos5l_fill_1
X_10502_ _14011_/D _10567_/A1 _10501_/B _10501_/Y VPWR VGND sg13cmos5l_o21ai_1
X_11482_ _11483_/B _11482_/A _11482_/B VPWR VGND sg13cmos5l_nand2_1
X_14270_ _14270_/Q clkload72/A _14270_/D _14270_/RESET_B VPWR VGND sg13cmos5l_dfrbpq_1
X_10433_ _13977_/D _10563_/A1 _10432_/B _10432_/Y VPWR VGND sg13cmos5l_a21oi_1
X_13221_ _13221_/Q clkload10/A _13221_/D fanout974/X VPWR VGND sg13cmos5l_dfrbpq_1
X_10364_ _10364_/Y _10364_/A _10380_/B VPWR VGND sg13cmos5l_nor2_1
X_13152_ _13227_/D _07297_/Y _13188_/A2 _13192_/B1 _13151_/Y VPWR VGND sg13cmos5l_a22oi_1
X_12103_ _12103_/Y _12071_/A _07284_/Y _12077_/A VPWR VGND sg13cmos5l_a21oi_1
X_10295_ _10295_/Y _10295_/A _10295_/B VPWR VGND sg13cmos5l_nor2_1
X_13083_ _13086_/C _13084_/A _13101_/C VPWR VGND sg13cmos5l_and2_1
XFILLER_2_386 VPWR VGND sg13cmos5l_fill_1
X_12034_ _12034_/Y _13955_/Q _12348_/A2 _12346_/A2 _13635_/Q VPWR VGND sg13cmos5l_a22oi_1
XFILLER_78_677 VPWR VGND sg13cmos5l_fill_2
XFILLER_93_625 VPWR VGND sg13cmos5l_fill_1
Xfanout690 _09076_/A2 _09075_/B1 VPWR VGND sg13cmos5l_buf_1
X_13763__1628 _13763_/RESET_B VPWR VGND sg13cmos5l_tiehi
XFILLER_46_552 VPWR VGND sg13cmos5l_fill_2
X_13985_ _13985_/Q clkload58/A _13985_/D _13985_/RESET_B VPWR VGND sg13cmos5l_dfrbpq_1
X_12936_ _14455_/D _12936_/A VPWR VGND sg13cmos5l_inv_1
X_12867_ _12867_/Y _12857_/A _12855_/Y _12854_/Y VPWR VGND sg13cmos5l_o21ai_1
X_11818_ _11819_/B _12408_/A1 _11814_/Y _11817_/Y VPWR VGND sg13cmos5l_o21ai_1
X_14606_ _14606_/Q clkload81/A _14606_/D _14606_/RESET_B VPWR VGND sg13cmos5l_dfrbpq_1
X_14537_ _14537_/Q clkload15/A _14537_/D fanout978/X VPWR VGND sg13cmos5l_dfrbpq_1
X_12798_ _12799_/B _09616_/A _12100_/B _12806_/A VPWR VGND sg13cmos5l_o21ai_1
X_11749_ _11749_/X _13945_/Q _11749_/B VPWR VGND sg13cmos5l_and2_1
X_14468_ _14468_/Q clkload73/A _14468_/D _14468_/RESET_B VPWR VGND sg13cmos5l_dfrbpq_1
X_14399_ _14399_/Q clkload80/A _14399_/D _14399_/RESET_B VPWR VGND sg13cmos5l_dfrbpq_1
X_13419_ _13419_/Q _14238_/CLK _13419_/D _13419_/RESET_B VPWR VGND sg13cmos5l_dfrbpq_1
X_13396__2026 _13396_/RESET_B VPWR VGND sg13cmos5l_tiehi
XFILLER_5_180 VPWR VGND sg13cmos5l_decap_8
X_08960_ _08960_/Y _13291_/Q _08960_/B VPWR VGND sg13cmos5l_nand2_1
Xhold3207 hold3207/X _13487_/Q VPWR VGND sg13cmos5l_dlygate4sd3_1
Xhold3218 hold3218/X _13271_/Q VPWR VGND sg13cmos5l_dlygate4sd3_1
Xhold3229 hold3229/X _13521_/Q VPWR VGND sg13cmos5l_dlygate4sd3_1
Xclkbuf_leaf_5_clk clkload14/A clkload0/A VPWR VGND sg13cmos5l_buf_8
XFILLER_38_0 VPWR VGND sg13cmos5l_fill_2
XFILLER_69_644 VPWR VGND sg13cmos5l_fill_2
X_07911_ _14572_/D _07911_/A _07911_/B VPWR VGND sg13cmos5l_nor2_1
X_08891_ _08892_/A _08609_/B _08867_/B _08900_/A2 hold3409/X _08890_/Y VPWR VGND sg13cmos5l_a221oi_1
Xhold2506 _10105_/A _13817_/Q VPWR VGND sg13cmos5l_dlygate4sd3_1
Xhold2517 _10111_/A _13820_/Q VPWR VGND sg13cmos5l_dlygate4sd3_1
Xhold2528 _14134_/D _10722_/Y VPWR VGND sg13cmos5l_dlygate4sd3_1
X_07842_ _07843_/C _07842_/A _08450_/A _07842_/C _07842_/D VPWR VGND sg13cmos5l_nor4_1
Xhold2539 _14159_/D _10797_/Y VPWR VGND sg13cmos5l_dlygate4sd3_1
XFILLER_84_658 VPWR VGND sg13cmos5l_fill_1
XFILLER_84_669 VPWR VGND sg13cmos5l_decap_4
X_07773_ _07773_/Y _08861_/A _12039_/A VPWR VGND sg13cmos5l_nor2_1
X_09512_ _13590_/D _09511_/B _10361_/A1 _09511_/Y VPWR VGND sg13cmos5l_a21oi_1
X_13739__1652 _13739_/RESET_B VPWR VGND sg13cmos5l_tiehi
XFILLER_52_500 VPWR VGND sg13cmos5l_fill_1
X_13427__1995 _13427_/RESET_B VPWR VGND sg13cmos5l_tiehi
XFILLER_13_909 VPWR VGND sg13cmos5l_fill_2
X_09443_ _09443_/Y _09443_/A _09443_/B VPWR VGND sg13cmos5l_nand2_1
X_09374_ _09374_/X _14128_/Q hold3207/X _09375_/S VPWR VGND sg13cmos5l_mux2_1
XFILLER_52_588 VPWR VGND sg13cmos5l_decap_4
X_08325_ _08325_/X _08338_/S _13450_/Q VPWR VGND sg13cmos5l_or2_1
X_14611__2154 _14611_/RESET_B VPWR VGND sg13cmos5l_tiehi
X_08256_ _14260_/D hold3423/X _12573_/B _08368_/S VPWR VGND sg13cmos5l_mux2_1
X_07207_ _13014_/A _13015_/A VPWR VGND sg13cmos5l_inv_1
X_08187_ _08187_/Y _08199_/A1 _08182_/X _08186_/Y _08187_/B2 VPWR VGND sg13cmos5l_a22oi_1
XFILLER_106_546 VPWR VGND sg13cmos5l_fill_2
X_10080_ _10080_/Y _10080_/A _10082_/B VPWR VGND sg13cmos5l_nand2_1
XFILLER_48_817 VPWR VGND sg13cmos5l_fill_2
XFILLER_90_639 VPWR VGND sg13cmos5l_fill_1
X_10982_ _10982_/Y _11338_/A _10982_/B VPWR VGND sg13cmos5l_nand2_1
X_13770_ _13770_/Q clkload52/A _13770_/D _13770_/RESET_B VPWR VGND sg13cmos5l_dfrbpq_1
XFILLER_15_213 VPWR VGND sg13cmos5l_fill_1
XFILLER_55_371 VPWR VGND sg13cmos5l_fill_2
X_12721_ _12745_/B _14449_/Q _13239_/Q _13240_/Q _14450_/Q VPWR VGND sg13cmos5l_a22oi_1
X_14569__2115 _14569_/RESET_B VPWR VGND sg13cmos5l_tiehi
X_12652_ _12654_/B _14231_/Q _14230_/Q VPWR VGND sg13cmos5l_nor2_1
X_11603_ _14340_/D _11593_/Y _11602_/Y _11590_/Y VPWR VGND sg13cmos5l_o21ai_1
X_12583_ _12583_/X _12583_/A _12583_/B VPWR VGND sg13cmos5l_and2_1
XFILLER_8_935 VPWR VGND sg13cmos5l_decap_8
X_11534_ _11534_/Y _11534_/A _11534_/B _11577_/B VPWR VGND sg13cmos5l_nand3_1
X_14322_ _14322_/Q clkload65/A _14322_/D _14322_/RESET_B VPWR VGND sg13cmos5l_dfrbpq_1
X_11465_ _11465_/Y _11460_/Y _11461_/X _11464_/X VPWR VGND sg13cmos5l_o21ai_1
X_14253_ _14253_/Q _14622_/CLK _14253_/D _14253_/RESET_B VPWR VGND sg13cmos5l_dfrbpq_1
X_10416_ _10547_/B _10416_/A _10416_/B _10416_/C _10416_/D VPWR VGND sg13cmos5l_nor4_1
X_13204_ _13204_/Q clkload8/A _13204_/D fanout960/X VPWR VGND sg13cmos5l_dfrbpq_1
X_11396_ _11403_/B _11396_/A _11396_/B VPWR VGND sg13cmos5l_nand2_1
X_14184_ _14184_/Q _14217_/CLK _14184_/D _14184_/RESET_B VPWR VGND sg13cmos5l_dfrbpq_1
X_13817__1574 _13817_/RESET_B VPWR VGND sg13cmos5l_tiehi
X_10347_ _10347_/Y _10347_/A _10347_/B VPWR VGND sg13cmos5l_nor2_1
X_13135_ _14557_/D hold3547/X _08043_/B _13136_/S VPWR VGND sg13cmos5l_mux2_1
X_10278_ _10278_/Y _10278_/A _10278_/B VPWR VGND sg13cmos5l_nor2_1
X_13066_ _13068_/A _13065_/A _13067_/C hold2957/X VPWR VGND sg13cmos5l_a21oi_1
X_12017_ _12017_/Y _12154_/A _12017_/B _12017_/C VPWR VGND sg13cmos5l_nor3_1
XFILLER_38_316 VPWR VGND sg13cmos5l_fill_2
XFILLER_94_923 VPWR VGND sg13cmos5l_decap_8
XFILLER_94_956 VPWR VGND sg13cmos5l_fill_1
XFILLER_0_31 VPWR VGND sg13cmos5l_decap_8
X_13968_ _13968_/Q clkload78/A _13968_/D _13968_/RESET_B VPWR VGND sg13cmos5l_dfrbpq_1
X_12919_ _12920_/A _14447_/Q _11262_/B _11302_/C _12923_/B2 VPWR VGND sg13cmos5l_a22oi_1
XFILLER_34_577 VPWR VGND sg13cmos5l_fill_1
X_13899_ _13899_/Q clkload62/A _13899_/D _13899_/RESET_B VPWR VGND sg13cmos5l_dfrbpq_1
XFILLER_34_599 VPWR VGND sg13cmos5l_fill_1
X_08110_ _08112_/B _08095_/B _09344_/A _08102_/C VPWR VGND sg13cmos5l_o21ai_1
X_09090_ _13311_/D _09095_/B _09088_/Y _09089_/Y VPWR VGND sg13cmos5l_a21oi_1
X_08041_ _08046_/A _14540_/Q _08041_/B VPWR VGND sg13cmos5l_xor2_1
XFILLER_89_706 VPWR VGND sg13cmos5l_fill_1
X_09992_ _13761_/D _10579_/A1 _10007_/B _09991_/Y VPWR VGND sg13cmos5l_o21ai_1
Xhold3004 _10183_/A _13855_/Q VPWR VGND sg13cmos5l_dlygate4sd3_1
Xhold3015 _10368_/A _13946_/Q VPWR VGND sg13cmos5l_dlygate4sd3_1
X_08943_ _13256_/D _07295_/Y _08943_/A2 _13196_/B1 _08942_/Y VPWR VGND sg13cmos5l_a22oi_1
Xhold2303 _10066_/A _13798_/Q VPWR VGND sg13cmos5l_dlygate4sd3_1
Xhold3026 hold3026/X _13413_/Q VPWR VGND sg13cmos5l_dlygate4sd3_1
Xhold3037 _09950_/A _13741_/Q VPWR VGND sg13cmos5l_dlygate4sd3_1
Xhold3048 hold3048/X _13377_/Q VPWR VGND sg13cmos5l_dlygate4sd3_1
Xhold2314 _10676_/A _14098_/Q VPWR VGND sg13cmos5l_dlygate4sd3_1
Xhold2325 _10545_/A _14033_/Q VPWR VGND sg13cmos5l_dlygate4sd3_1
Xhold2336 _11436_/A _14330_/Q VPWR VGND sg13cmos5l_dlygate4sd3_1
Xhold3059 hold3059/X _13574_/Q VPWR VGND sg13cmos5l_dlygate4sd3_1
Xclkbuf_4_15_0_clk clkload7/A clkbuf_0_clk/X VPWR VGND sg13cmos5l_buf_8
X_08874_ _08877_/A _07652_/Y _08867_/B _08894_/B _08579_/A VPWR VGND sg13cmos5l_a22oi_1
Xhold2347 _14476_/D _12977_/X VPWR VGND sg13cmos5l_dlygate4sd3_1
Xhold2358 _10539_/A _14030_/Q VPWR VGND sg13cmos5l_dlygate4sd3_1
Xhold2369 hold2369/X _14586_/Q VPWR VGND sg13cmos5l_dlygate4sd3_1
X_13514__1908 _13514_/RESET_B VPWR VGND sg13cmos5l_tiehi
X_07825_ _14616_/D _08628_/A _07822_/Y _07823_/Y VPWR VGND sg13cmos5l_a21oi_1
X_07756_ _07756_/Y _08847_/A _07756_/B VPWR VGND sg13cmos5l_nand2b_1
XFILLER_13_717 VPWR VGND sg13cmos5l_fill_1
X_07687_ _07707_/A _08838_/A _08517_/B _08847_/A _08529_/B VPWR VGND sg13cmos5l_nor4_1
X_09426_ _09426_/X _14114_/Q hold3114/X _09438_/S VPWR VGND sg13cmos5l_mux2_1
XFILLER_25_599 VPWR VGND sg13cmos5l_fill_2
XFILLER_40_525 VPWR VGND sg13cmos5l_fill_1
X_09357_ _09357_/X _14111_/Q hold3304/X _09373_/S VPWR VGND sg13cmos5l_mux2_1
XFILLER_60_36 VPWR VGND sg13cmos5l_fill_1
X_08308_ _08308_/X _13513_/Q _13481_/Q _08309_/A VPWR VGND sg13cmos5l_mux2_1
X_09288_ _09288_/Y _09288_/A _09293_/B VPWR VGND sg13cmos5l_nor2_1
X_08239_ _08239_/Y _08238_/S _07301_/Y _08310_/B1 VPWR VGND sg13cmos5l_a21oi_1
X_11250_ _11253_/A _14089_/Q _11256_/D VPWR VGND sg13cmos5l_nand2_1
X_10201_ _10201_/Y _10201_/A _10209_/B VPWR VGND sg13cmos5l_nor2_1
X_11181_ _11181_/Y _11189_/B _11180_/Y _11176_/A VPWR VGND sg13cmos5l_a21oi_1
X_10132_ _13830_/D fanout79/X _10147_/B _10131_/Y VPWR VGND sg13cmos5l_o21ai_1
Xhold3560 hold3560/X _14556_/Q VPWR VGND sg13cmos5l_dlygate4sd3_1
X_10063_ _13796_/D _10128_/A1 _10074_/B _10062_/Y VPWR VGND sg13cmos5l_o21ai_1
Xhold3571 _13055_/B _15892_/A VPWR VGND sg13cmos5l_dlygate4sd3_1
XFILLER_102_593 VPWR VGND sg13cmos5l_fill_2
Xhold2870 _10295_/A _13910_/Q VPWR VGND sg13cmos5l_dlygate4sd3_1
Xhold2881 _09836_/A _13685_/Q VPWR VGND sg13cmos5l_dlygate4sd3_1
Xhold2892 _10444_/A _13983_/Q VPWR VGND sg13cmos5l_dlygate4sd3_1
XFILLER_29_872 VPWR VGND sg13cmos5l_fill_1
X_13822_ _13822_/Q clkload63/A _13822_/D _13822_/RESET_B VPWR VGND sg13cmos5l_dfrbpq_1
X_13680__1711 _13680_/RESET_B VPWR VGND sg13cmos5l_tiehi
X_13753_ _13753_/Q clkload17/A _13753_/D _13753_/RESET_B VPWR VGND sg13cmos5l_dfrbpq_1
XFILLER_43_341 VPWR VGND sg13cmos5l_fill_1
X_10965_ _10965_/X _14224_/Q _10976_/B VPWR VGND sg13cmos5l_and2_1
X_12704_ _12704_/X _12704_/A _12743_/A VPWR VGND sg13cmos5l_xor2_1
X_10896_ _14195_/D _10861_/B _10895_/Y _10893_/Y VPWR VGND sg13cmos5l_o21ai_1
X_13684_ _13684_/Q clkload17/A _13684_/D _13684_/RESET_B VPWR VGND sg13cmos5l_dfrbpq_1
X_14060__1331 _14060_/RESET_B VPWR VGND sg13cmos5l_tiehi
X_12635_ _12635_/Y _12735_/A _12636_/B VPWR VGND sg13cmos5l_nand2_1
X_12566_ _12566_/Y _14438_/Q _13228_/Q _12648_/B VPWR VGND sg13cmos5l_o21ai_1
XFILLER_11_293 VPWR VGND sg13cmos5l_fill_2
X_11517_ _11519_/B _11517_/A _11517_/B VPWR VGND sg13cmos5l_nand2_1
X_14305_ _14305_/Q clkload25/A _14305_/D _14305_/RESET_B VPWR VGND sg13cmos5l_dfrbpq_1
X_12497_ _12498_/B _12504_/A _13245_/Q _12496_/Y VPWR VGND sg13cmos5l_o21ai_1
X_11448_ _14330_/D _11446_/Y _11447_/Y _11436_/Y VPWR VGND sg13cmos5l_o21ai_1
X_14236_ _14236_/Q clkload43/A _14236_/D _14236_/RESET_B VPWR VGND sg13cmos5l_dfrbpq_1
X_11379_ _11379_/Y _11387_/B _11379_/B VPWR VGND sg13cmos5l_xnor2_1
X_14167_ _14167_/Q clkload23/A _14167_/D fanout993/X VPWR VGND sg13cmos5l_dfrbpq_1
X_13118_ _14546_/D hold3555/X _08038_/B _13118_/S VPWR VGND sg13cmos5l_mux2_1
X_14098_ _14098_/Q clkload25/A _14098_/D fanout990/X VPWR VGND sg13cmos5l_dfrbpq_1
XFILLER_94_720 VPWR VGND sg13cmos5l_fill_1
X_14610__2153 _14610_/RESET_B VPWR VGND sg13cmos5l_tiehi
X_13049_ _13052_/B _15889_/A _15888_/A _13049_/C VPWR VGND sg13cmos5l_nand3_1
X_14262__1809 _14262_/RESET_B VPWR VGND sg13cmos5l_tiehi
XFILLER_67_989 VPWR VGND sg13cmos5l_fill_2
XFILLER_82_915 VPWR VGND sg13cmos5l_decap_8
XFILLER_82_926 VPWR VGND sg13cmos5l_decap_8
XFILLER_82_937 VPWR VGND sg13cmos5l_fill_1
XFILLER_93_241 VPWR VGND sg13cmos5l_fill_2
XFILLER_94_786 VPWR VGND sg13cmos5l_fill_1
X_07610_ _07611_/B _13283_/Q _07613_/A VPWR VGND sg13cmos5l_xnor2_1
X_08590_ _08590_/Y _08603_/C _08881_/A _08590_/C VPWR VGND sg13cmos5l_nor3_1
X_07541_ _07547_/B _14547_/Q _14549_/Q _14548_/Q _14550_/Q _13291_/Q _13290_/Q VPWR
+ VGND sg13cmos5l_mux4_1
X_07472_ _13032_/B _07472_/A _07472_/B VPWR VGND sg13cmos5l_and2_1
XFILLER_50_845 VPWR VGND sg13cmos5l_decap_4
XFILLER_61_182 VPWR VGND sg13cmos5l_fill_1
XFILLER_61_193 VPWR VGND sg13cmos5l_fill_2
X_09211_ _09211_/X _14109_/Q hold3151/X _09225_/B VPWR VGND sg13cmos5l_mux2_1
X_09142_ _09142_/Y _14364_/Q _09160_/A2 _09141_/Y VPWR VGND sg13cmos5l_a21oi_1
X_09073_ _11294_/A _14321_/Q _09073_/B VPWR VGND sg13cmos5l_nand2_1
X_08024_ _08036_/B _08979_/A _13275_/Q _10807_/A VPWR VGND sg13cmos5l_mux2_1
X_09975_ _09975_/Y _09975_/A _09979_/B VPWR VGND sg13cmos5l_nand2_1
X_14568__2114 _14568_/RESET_B VPWR VGND sg13cmos5l_tiehi
X_08926_ _08926_/Y hold3570/X _13195_/B1 _08938_/B1 VPWR VGND sg13cmos5l_a21oi_1
XFILLER_58_967 VPWR VGND sg13cmos5l_decap_8
X_08857_ _08857_/Y _08538_/A _08879_/A2 _08856_/Y VPWR VGND sg13cmos5l_o21ai_1
XFILLER_29_179 VPWR VGND sg13cmos5l_fill_1
XFILLER_73_926 VPWR VGND sg13cmos5l_decap_4
XFILLER_85_786 VPWR VGND sg13cmos5l_fill_1
XFILLER_85_797 VPWR VGND sg13cmos5l_decap_8
X_07808_ _07808_/Y _08606_/B VPWR VGND sg13cmos5l_inv_1
XFILLER_72_414 VPWR VGND sg13cmos5l_fill_2
X_08788_ _08791_/A _14374_/Q _11636_/A _08808_/B VPWR VGND sg13cmos5l_nand3_1
XFILLER_72_458 VPWR VGND sg13cmos5l_decap_8
X_07739_ _07740_/B _11121_/A _11740_/A _11117_/A _11711_/A VPWR VGND sg13cmos5l_a22oi_1
X_10750_ _10750_/Y _10798_/A _14288_/Q VPWR VGND sg13cmos5l_nand2_1
XFILLER_41_856 VPWR VGND sg13cmos5l_fill_1
X_09409_ _13521_/D _09307_/A hold3229/X _09409_/S VPWR VGND sg13cmos5l_mux2_1
X_10681_ _14101_/D input10/X _10681_/A1 _10685_/S VPWR VGND sg13cmos5l_mux2_1
X_13391__2031 _13391_/RESET_B VPWR VGND sg13cmos5l_tiehi
X_12420_ _12420_/Y _13745_/Q _12373_/B _12366_/B _14001_/Q _12427_/B1 VPWR VGND sg13cmos5l_a221oi_1
X_12351_ _12352_/B _12351_/A1 _12343_/Y _12347_/Y _12350_/Y VPWR VGND sg13cmos5l_a22oi_1
X_11302_ _11352_/A _11302_/A _11302_/B _11302_/C _11303_/B VPWR VGND sg13cmos5l_nand4_1
X_12282_ _12329_/A _12282_/A _13253_/Q VPWR VGND sg13cmos5l_xor2_1
XFILLER_105_0 VPWR VGND sg13cmos5l_fill_2
XFILLER_5_779 VPWR VGND sg13cmos5l_fill_1
XFILLER_84_1001 VPWR VGND sg13cmos5l_fill_1
X_11233_ _11233_/Y _11233_/A _11262_/B VPWR VGND sg13cmos5l_nand2_1
X_14021_ _14021_/Q clkload64/A _14021_/D _14021_/RESET_B VPWR VGND sg13cmos5l_dfrbpq_1
XFILLER_49_901 VPWR VGND sg13cmos5l_fill_2
X_11164_ _11164_/X _11628_/A _11164_/B VPWR VGND sg13cmos5l_and2_1
XFILLER_0_473 VPWR VGND sg13cmos5l_fill_1
XFILLER_48_411 VPWR VGND sg13cmos5l_decap_8
X_10115_ _10115_/Y _10115_/A _10137_/B VPWR VGND sg13cmos5l_nand2_1
X_11095_ _11095_/Y _11095_/A _11147_/B VPWR VGND sg13cmos5l_nor2_1
XFILLER_48_422 VPWR VGND sg13cmos5l_fill_2
XFILLER_48_433 VPWR VGND sg13cmos5l_fill_1
X_10046_ _10046_/Y _10046_/A _10052_/B VPWR VGND sg13cmos5l_nand2_1
Xhold3390 hold3390/X _13437_/Q VPWR VGND sg13cmos5l_dlygate4sd3_1
XFILLER_35_138 VPWR VGND sg13cmos5l_fill_1
XFILLER_16_341 VPWR VGND sg13cmos5l_fill_1
X_11997_ _11997_/Y _13986_/Q _12010_/C1 _12203_/B1 VPWR VGND sg13cmos5l_o21ai_1
X_13805_ _13805_/Q clkload55/A _13805_/D _13805_/RESET_B VPWR VGND sg13cmos5l_dfrbpq_1
X_10948_ _10948_/Y _10948_/A _10976_/B VPWR VGND sg13cmos5l_nand2_1
X_13736_ _13736_/Q _14640_/CLK _13736_/D _13736_/RESET_B VPWR VGND sg13cmos5l_dfrbpq_1
XFILLER_91_6 VPWR VGND sg13cmos5l_fill_1
X_10879_ _14191_/D _10865_/Y _10877_/Y _10878_/Y VPWR VGND sg13cmos5l_o21ai_1
X_13667_ _13667_/Q clkload59/A _13667_/D _13667_/RESET_B VPWR VGND sg13cmos5l_dfrbpq_1
X_13598_ _13598_/Q clkload60/A _13598_/D _13598_/RESET_B VPWR VGND sg13cmos5l_dfrbpq_1
X_12618_ _12618_/Y _12618_/A _12618_/B VPWR VGND sg13cmos5l_xnor2_1
X_12549_ _12549_/X _12583_/A _12549_/B VPWR VGND sg13cmos5l_and2_1
XANTENNA_1 _14396_/Q VPWR VGND sg13cmos5l_antennanp
XFILLER_6_41 VPWR VGND sg13cmos5l_fill_2
X_14219_ _14219_/Q _14614_/CLK _14219_/D _14219_/RESET_B VPWR VGND sg13cmos5l_dfrbpq_1
Xfanout519 _12426_/B _08648_/Y VPWR VGND sg13cmos5l_buf_1
Xfanout508 _11939_/B fanout510/X VPWR VGND sg13cmos5l_buf_1
X_09760_ _09760_/Y _09760_/A _09760_/B VPWR VGND sg13cmos5l_nor2_1
X_08711_ _08711_/Y _11788_/C1 _08704_/Y _08710_/Y VPWR VGND sg13cmos5l_a21oi_1
X_09691_ _09691_/Y _09691_/A _09691_/B VPWR VGND sg13cmos5l_nor2_1
XFILLER_94_561 VPWR VGND sg13cmos5l_fill_1
X_08642_ _08644_/B _14177_/Q _12480_/A VPWR VGND sg13cmos5l_nand2b_1
XFILLER_66_285 VPWR VGND sg13cmos5l_fill_1
XFILLER_70_918 VPWR VGND sg13cmos5l_fill_1
XFILLER_82_778 VPWR VGND sg13cmos5l_fill_2
X_08573_ _08574_/B _08572_/A _08570_/Y _08571_/X _08572_/Y VPWR VGND sg13cmos5l_a22oi_1
X_07524_ _07524_/X _13429_/Q _13397_/Q _13365_/Q _13333_/Q _07524_/S0 _08200_/S1 VPWR
+ VGND sg13cmos5l_mux4_1
XFILLER_50_642 VPWR VGND sg13cmos5l_decap_8
X_07455_ _13032_/A _07532_/A _07455_/B _07455_/C VPWR VGND sg13cmos5l_nand3_1
X_13776__1615 _13776_/RESET_B VPWR VGND sg13cmos5l_tiehi
XFILLER_50_675 VPWR VGND sg13cmos5l_decap_8
X_13464__1958 _13464_/RESET_B VPWR VGND sg13cmos5l_tiehi
X_07386_ _07409_/B _08979_/A _14542_/Q VPWR VGND sg13cmos5l_xor2_1
X_09125_ _09125_/Y _09125_/A _09125_/B VPWR VGND sg13cmos5l_nor2_1
X_09056_ _11249_/A _14318_/Q _09073_/B VPWR VGND sg13cmos5l_nand2_1
X_13991__1400 _13991_/RESET_B VPWR VGND sg13cmos5l_tiehi
X_08007_ _12997_/C _14242_/Q _08050_/A _14577_/Q VPWR VGND sg13cmos5l_o21ai_1
XFILLER_2_716 VPWR VGND sg13cmos5l_fill_2
XFILLER_106_20 VPWR VGND sg13cmos5l_fill_1
XFILLER_1_237 VPWR VGND sg13cmos5l_fill_1
XFILLER_49_208 VPWR VGND sg13cmos5l_fill_1
XFILLER_77_528 VPWR VGND sg13cmos5l_decap_4
X_09958_ _09958_/Y _09958_/A _09958_/B VPWR VGND sg13cmos5l_nor2_1
XFILLER_106_64 VPWR VGND sg13cmos5l_fill_2
X_08909_ _08912_/B _14405_/Q _14373_/Q _08840_/B VPWR VGND sg13cmos5l_o21ai_1
XFILLER_45_403 VPWR VGND sg13cmos5l_decap_8
XFILLER_46_904 VPWR VGND sg13cmos5l_fill_1
XFILLER_92_509 VPWR VGND sg13cmos5l_fill_1
X_09889_ _13711_/D fanout61/X _09892_/B _09888_/Y VPWR VGND sg13cmos5l_a21oi_1
XFILLER_45_414 VPWR VGND sg13cmos5l_fill_1
XFILLER_57_296 VPWR VGND sg13cmos5l_decap_4
X_11920_ _11920_/Y _11901_/A _12124_/A2 _12162_/B VPWR VGND sg13cmos5l_a21oi_1
X_11851_ _11851_/Y _11851_/A _11851_/B _11851_/C VPWR VGND sg13cmos5l_nand3_1
XFILLER_60_406 VPWR VGND sg13cmos5l_decap_8
X_10802_ _10802_/Y _10802_/A _10802_/B VPWR VGND sg13cmos5l_nand2_1
X_11782_ _11782_/Y _11778_/Y _11779_/Y _11780_/Y _11781_/Y VPWR VGND sg13cmos5l_a22oi_1
X_14570_ _14570_/Q clkload43/A _14570_/D _14570_/RESET_B VPWR VGND sg13cmos5l_dfrbpq_1
XFILLER_82_67 VPWR VGND sg13cmos5l_fill_1
X_10733_ _10733_/Y _14138_/Q _10772_/B VPWR VGND sg13cmos5l_nand2_1
X_13521_ _13521_/Q clkload32/A _13521_/D _13521_/RESET_B VPWR VGND sg13cmos5l_dfrbpq_1
X_10664_ _14088_/D _14269_/D hold3504/X _10894_/D VPWR VGND sg13cmos5l_mux2_1
X_13452_ _13452_/Q _14238_/CLK _13452_/D _13452_/RESET_B VPWR VGND sg13cmos5l_dfrbpq_1
XFILLER_40_196 VPWR VGND sg13cmos5l_fill_2
X_10595_ _14057_/D _10595_/A1 _10594_/B _10594_/Y VPWR VGND sg13cmos5l_o21ai_1
X_14261__1808 _14261_/RESET_B VPWR VGND sg13cmos5l_tiehi
X_13383_ _13383_/Q clkload28/A _13383_/D _13383_/RESET_B VPWR VGND sg13cmos5l_dfrbpq_1
X_12403_ _12403_/Y _12401_/Y _12402_/Y _12403_/B1 VPWR VGND sg13cmos5l_a21oi_1
XFILLER_12_1028 VPWR VGND sg13cmos5l_fill_1
XFILLER_5_521 VPWR VGND sg13cmos5l_fill_1
X_12334_ _12362_/A _12334_/A _12334_/B VPWR VGND sg13cmos5l_nor2_1
XFILLER_5_554 VPWR VGND sg13cmos5l_fill_1
X_12265_ _12265_/Y _13931_/Q _12296_/A2 _12290_/A2 _13867_/Q _12297_/C1 VPWR VGND
+ sg13cmos5l_a221oi_1
X_14004_ _14004_/Q clkload17/A _14004_/D _14004_/RESET_B VPWR VGND sg13cmos5l_dfrbpq_1
X_11216_ _11216_/Y _11256_/A _11215_/Y _11193_/A VPWR VGND sg13cmos5l_o21ai_1
X_12196_ _12198_/B _13609_/Q _12200_/B1 _12203_/A2 VPWR VGND sg13cmos5l_a21oi_1
XFILLER_96_815 VPWR VGND sg13cmos5l_decap_8
X_11147_ _11147_/Y _11147_/A _11147_/B VPWR VGND sg13cmos5l_nor2_1
X_13854__1537 _13854_/RESET_B VPWR VGND sg13cmos5l_tiehi
XFILLER_0_292 VPWR VGND sg13cmos5l_decap_8
XFILLER_37_926 VPWR VGND sg13cmos5l_fill_1
XFILLER_49_753 VPWR VGND sg13cmos5l_fill_2
XFILLER_64_701 VPWR VGND sg13cmos5l_fill_2
X_11078_ _14287_/D _11144_/B _11076_/Y _11077_/Y VPWR VGND sg13cmos5l_a21oi_1
XFILLER_37_959 VPWR VGND sg13cmos5l_fill_2
XFILLER_64_723 VPWR VGND sg13cmos5l_fill_1
X_10029_ _13779_/D _10551_/A1 _10044_/B _10028_/Y VPWR VGND sg13cmos5l_o21ai_1
X_15886_ _15886_/X _15886_/A VPWR VGND sg13cmos5l_buf_1
XFILLER_91_531 VPWR VGND sg13cmos5l_decap_4
XFILLER_51_417 VPWR VGND sg13cmos5l_decap_4
XFILLER_17_694 VPWR VGND sg13cmos5l_fill_1
XFILLER_32_664 VPWR VGND sg13cmos5l_fill_1
X_14567__2113 _14567_/RESET_B VPWR VGND sg13cmos5l_tiehi
X_13719_ _13719_/Q _14299_/CLK _13719_/D _13719_/RESET_B VPWR VGND sg13cmos5l_dfrbpq_1
X_07240_ _07829_/B _11740_/A VPWR VGND sg13cmos5l_inv_1
X_07171_ _09575_/A _14451_/Q VPWR VGND sg13cmos5l_inv_1
Xfanout305 _09859_/A2 _09829_/Y VPWR VGND sg13cmos5l_buf_1
XFILLER_59_517 VPWR VGND sg13cmos5l_decap_8
X_09812_ _13673_/D _10399_/A1 _09825_/B _09811_/Y VPWR VGND sg13cmos5l_a21oi_1
Xfanout338 _10357_/A1 _09497_/Y VPWR VGND sg13cmos5l_buf_1
Xfanout327 _09730_/B _09752_/B VPWR VGND sg13cmos5l_buf_1
Xfanout316 _09827_/B fanout320/X VPWR VGND sg13cmos5l_buf_1
Xfanout349 _09693_/B fanout354/X VPWR VGND sg13cmos5l_buf_1
X_09743_ _13640_/D _10397_/A1 _09748_/B _09742_/Y VPWR VGND sg13cmos5l_a21oi_1
XFILLER_55_712 VPWR VGND sg13cmos5l_fill_1
XFILLER_55_734 VPWR VGND sg13cmos5l_fill_1
XFILLER_67_594 VPWR VGND sg13cmos5l_decap_8
X_09674_ _13614_/D _09673_/B fanout73/X _09673_/Y VPWR VGND sg13cmos5l_a21oi_1
XFILLER_27_469 VPWR VGND sg13cmos5l_fill_1
X_08625_ _08625_/Y _08625_/A _08625_/B VPWR VGND sg13cmos5l_nor2_1
X_14341__1167 _14341_/RESET_B VPWR VGND sg13cmos5l_tiehi
XFILLER_43_929 VPWR VGND sg13cmos5l_fill_1
XFILLER_82_575 VPWR VGND sg13cmos5l_fill_2
X_08556_ _14602_/D _08867_/A _08556_/B VPWR VGND sg13cmos5l_xnor2_1
X_07507_ _07507_/Y _07507_/A VPWR VGND sg13cmos5l_inv_1
XFILLER_35_1028 VPWR VGND sg13cmos5l_fill_1
X_08487_ _14591_/D _08491_/A _08487_/B VPWR VGND sg13cmos5l_xor2_1
X_07438_ _07439_/B _13215_/Q _07530_/A2 _07527_/B1 _15889_/A VPWR VGND sg13cmos5l_a22oi_1
X_07369_ _07369_/Y _07369_/A _07369_/B VPWR VGND sg13cmos5l_nand2_1
X_09108_ _13314_/D _09125_/B _09106_/Y _09107_/Y VPWR VGND sg13cmos5l_a21oi_1
X_13932__1459 _13932_/RESET_B VPWR VGND sg13cmos5l_tiehi
X_13317__2105 _13317_/RESET_B VPWR VGND sg13cmos5l_tiehi
X_10380_ _10380_/Y _10380_/A _10380_/B VPWR VGND sg13cmos5l_nor2_1
X_09039_ _13302_/D _09060_/B _09037_/Y _09038_/Y VPWR VGND sg13cmos5l_a21oi_1
XFILLER_105_953 VPWR VGND sg13cmos5l_decap_8
X_12050_ _12050_/Y _13732_/Q _12055_/B VPWR VGND sg13cmos5l_nand2_1
XFILLER_81_1026 VPWR VGND sg13cmos5l_fill_2
X_11001_ _11002_/B hold3400/X _10983_/B _10996_/Y _14234_/Q VPWR VGND sg13cmos5l_a22oi_1
Xfanout861 _10351_/A _14233_/Q VPWR VGND sg13cmos5l_buf_1
Xfanout850 _11636_/A _11164_/B VPWR VGND sg13cmos5l_buf_1
Xfanout894 _09293_/A _14120_/Q VPWR VGND sg13cmos5l_buf_1
Xfanout883 _11433_/A1 _14194_/Q VPWR VGND sg13cmos5l_buf_1
Xfanout872 fanout872/X _14216_/Q VPWR VGND sg13cmos5l_buf_1
XFILLER_58_583 VPWR VGND sg13cmos5l_decap_8
X_12952_ _14463_/D _12952_/A VPWR VGND sg13cmos5l_inv_1
XFILLER_34_907 VPWR VGND sg13cmos5l_fill_1
X_11903_ _11984_/A _11903_/A _11903_/B VPWR VGND sg13cmos5l_or2_1
X_14622_ _14622_/Q _14622_/CLK _14622_/D _14622_/RESET_B VPWR VGND sg13cmos5l_dfrbpq_1
X_14317__1191 _14317_/RESET_B VPWR VGND sg13cmos5l_tiehi
X_12883_ _12888_/A _14467_/Q _13257_/Q VPWR VGND sg13cmos5l_xor2_1
XFILLER_61_759 VPWR VGND sg13cmos5l_decap_8
X_11834_ _11834_/Y _13692_/Q _11966_/B _12000_/B VPWR VGND sg13cmos5l_a21oi_1
XFILLER_41_450 VPWR VGND sg13cmos5l_fill_1
X_11765_ _11768_/C _11765_/A _13235_/Q VPWR VGND sg13cmos5l_xnor2_1
X_14553_ _14553_/Q clkload21/A _14553_/D fanout966/X VPWR VGND sg13cmos5l_dfrbpq_1
XFILLER_9_134 VPWR VGND sg13cmos5l_decap_8
X_10716_ _10716_/Y _10808_/S _10714_/Y _10715_/Y VPWR VGND sg13cmos5l_o21ai_1
X_11696_ _11696_/Y _13655_/Q _11702_/B _11727_/B VPWR VGND sg13cmos5l_a21oi_1
X_14484_ _14484_/Q clkload15/A _14484_/D fanout979/X VPWR VGND sg13cmos5l_dfrbpq_1
X_13504_ _13504_/Q _13568_/CLK _13504_/D _13504_/RESET_B VPWR VGND sg13cmos5l_dfrbpq_1
XFILLER_9_145 VPWR VGND sg13cmos5l_fill_1
X_10647_ _10649_/B _14078_/Q _14079_/Q _14080_/Q _10647_/D VPWR VGND sg13cmos5l_nand4_1
X_13435_ _13435_/Q _14109_/CLK _13435_/D _13435_/RESET_B VPWR VGND sg13cmos5l_dfrbpq_1
XFILLER_9_178 VPWR VGND sg13cmos5l_decap_4
X_10578_ _10578_/Y _10578_/A _10582_/B VPWR VGND sg13cmos5l_nand2_1
X_13908__1483 _13908_/RESET_B VPWR VGND sg13cmos5l_tiehi
X_13366_ _13366_/Q clkload27/A _13366_/D _13366_/RESET_B VPWR VGND sg13cmos5l_dfrbpq_1
X_13297_ _13297_/Q clkload19/A _13297_/D fanout981/X VPWR VGND sg13cmos5l_dfrbpq_1
X_12317_ _12320_/A _13645_/Q _12317_/B VPWR VGND sg13cmos5l_nand2_1
X_12248_ _12248_/Y _12248_/A _12301_/B VPWR VGND sg13cmos5l_nand2_1
XFILLER_3_31 VPWR VGND sg13cmos5l_fill_2
XFILLER_96_601 VPWR VGND sg13cmos5l_decap_8
XFILLER_69_859 VPWR VGND sg13cmos5l_fill_1
X_12179_ _12179_/Y _12177_/Y _12178_/Y _12378_/B1 VPWR VGND sg13cmos5l_a21oi_1
XFILLER_58_1028 VPWR VGND sg13cmos5l_fill_1
X_08410_ _08411_/B _13521_/Q _13489_/Q _08416_/S VPWR VGND sg13cmos5l_mux2_1
X_09390_ _13502_/D _07961_/A hold3200/X _09409_/S VPWR VGND sg13cmos5l_mux2_1
X_08341_ _08341_/X _08335_/Y _08336_/Y _08406_/B1 VPWR VGND sg13cmos5l_a21o_1
X_08272_ _08272_/Y _08275_/S _13382_/Q _08271_/Y VPWR VGND sg13cmos5l_o21ai_1
X_07223_ _12100_/A _14362_/Q VPWR VGND sg13cmos5l_inv_1
XFILLER_106_717 VPWR VGND sg13cmos5l_decap_8
XFILLER_105_238 VPWR VGND sg13cmos5l_fill_1
X_14359__1149 _14359_/RESET_B VPWR VGND sg13cmos5l_tiehi
XFILLER_102_923 VPWR VGND sg13cmos5l_decap_4
Xfanout113 _09467_/S _09474_/S VPWR VGND sg13cmos5l_buf_1
Xfanout102 _08977_/B _07640_/B1 VPWR VGND sg13cmos5l_buf_1
Xfanout146 _13119_/B _08102_/C VPWR VGND sg13cmos5l_buf_1
Xfanout135 _10826_/S _10894_/D VPWR VGND sg13cmos5l_buf_1
Xfanout124 _09409_/S _09405_/S VPWR VGND sg13cmos5l_buf_1
XFILLER_47_509 VPWR VGND sg13cmos5l_decap_8
XFILLER_75_807 VPWR VGND sg13cmos5l_fill_1
X_07987_ _07989_/B _14080_/Q _08207_/A2 _07433_/Y _14537_/Q VPWR VGND sg13cmos5l_a22oi_1
Xfanout179 _10381_/A1 _09577_/Y VPWR VGND sg13cmos5l_buf_1
Xfanout168 _10802_/B fanout170/X VPWR VGND sg13cmos5l_buf_1
Xfanout157 _10790_/B _10778_/B VPWR VGND sg13cmos5l_buf_1
X_09726_ _09726_/Y _09726_/A _09726_/B VPWR VGND sg13cmos5l_nor2_1
X_14260__1807 _14260_/RESET_B VPWR VGND sg13cmos5l_tiehi
XFILLER_55_542 VPWR VGND sg13cmos5l_decap_8
XFILLER_103_54 VPWR VGND sg13cmos5l_fill_1
X_09657_ _09670_/C _09657_/A _09657_/B VPWR VGND sg13cmos5l_nor2_1
X_08608_ _08610_/B _08895_/A _08889_/A VPWR VGND sg13cmos5l_nand2b_1
X_09588_ _11374_/B _14422_/Q _14641_/Q _09615_/S VPWR VGND sg13cmos5l_mux2_1
X_08539_ _08539_/Y _08559_/A _08539_/B VPWR VGND sg13cmos5l_nand2_1
X_11550_ _11564_/B _11580_/A _11549_/C _11577_/C VPWR VGND sg13cmos5l_a21o_1
XFILLER_23_494 VPWR VGND sg13cmos5l_fill_1
X_10501_ _10501_/Y _10501_/A _10501_/B VPWR VGND sg13cmos5l_nand2_1
X_11481_ _11481_/Y _11481_/A _11560_/B VPWR VGND sg13cmos5l_nand2_1
X_13220_ _13220_/Q _14532_/CLK _13220_/D fanout974/X VPWR VGND sg13cmos5l_dfrbpq_1
X_10432_ _10432_/Y _10432_/A _10432_/B VPWR VGND sg13cmos5l_nor2_1
X_14200__1277 _14200_/RESET_B VPWR VGND sg13cmos5l_tiehi
X_10363_ _13943_/D _10559_/A1 _10380_/B _10362_/Y VPWR VGND sg13cmos5l_a21oi_1
X_13151_ _13151_/Y _14273_/Q _07891_/C _13151_/B1 VPWR VGND sg13cmos5l_a21oi_1
XFILLER_2_332 VPWR VGND sg13cmos5l_fill_2
XFILLER_3_833 VPWR VGND sg13cmos5l_decap_4
X_12102_ _12102_/X _12102_/A _12102_/B VPWR VGND sg13cmos5l_and2_1
X_13082_ _14525_/D _13101_/C _13082_/B VPWR VGND sg13cmos5l_nor2_1
XFILLER_3_877 VPWR VGND sg13cmos5l_fill_2
X_10294_ _13909_/D _10425_/A1 _10295_/B _10293_/Y VPWR VGND sg13cmos5l_a21oi_1
X_12033_ _12033_/Y _12033_/A _12033_/B _12033_/C VPWR VGND sg13cmos5l_nand3_1
XFILLER_66_818 VPWR VGND sg13cmos5l_fill_1
X_14566__2112 _14566_/RESET_B VPWR VGND sg13cmos5l_tiehi
XFILLER_19_701 VPWR VGND sg13cmos5l_fill_2
XFILLER_59_892 VPWR VGND sg13cmos5l_fill_2
XFILLER_92_103 VPWR VGND sg13cmos5l_fill_2
XFILLER_93_615 VPWR VGND sg13cmos5l_decap_4
Xfanout691 _09075_/B1 _11029_/B VPWR VGND sg13cmos5l_buf_1
Xfanout680 _11293_/A _11308_/A VPWR VGND sg13cmos5l_buf_1
X_13771__1620 _13771_/RESET_B VPWR VGND sg13cmos5l_tiehi
XFILLER_46_531 VPWR VGND sg13cmos5l_fill_2
X_14404__1104 _14404_/RESET_B VPWR VGND sg13cmos5l_tiehi
X_13984_ _13984_/Q _14048_/CLK _13984_/D _13984_/RESET_B VPWR VGND sg13cmos5l_dfrbpq_1
XFILLER_34_726 VPWR VGND sg13cmos5l_fill_1
XFILLER_80_309 VPWR VGND sg13cmos5l_fill_2
X_12935_ _12936_/A _14455_/Q _11436_/B _11416_/B _12937_/B2 VPWR VGND sg13cmos5l_a22oi_1
XFILLER_18_288 VPWR VGND sg13cmos5l_fill_1
XFILLER_46_597 VPWR VGND sg13cmos5l_fill_1
X_12866_ _12866_/Y _12866_/A _12866_/B VPWR VGND sg13cmos5l_nor2_1
XFILLER_61_567 VPWR VGND sg13cmos5l_fill_1
X_11817_ _11817_/Y _14446_/Q _12353_/B _11816_/Y VPWR VGND sg13cmos5l_a21oi_1
X_14605_ _14605_/Q clkload81/A _14605_/D _14605_/RESET_B VPWR VGND sg13cmos5l_dfrbpq_1
XFILLER_61_589 VPWR VGND sg13cmos5l_decap_8
X_14536_ _14536_/Q clkload14/A _14536_/D _09199_/A VPWR VGND sg13cmos5l_dfrbpq_1
X_12797_ _12824_/B _14458_/Q _13248_/Q VPWR VGND sg13cmos5l_xor2_1
X_11748_ _11748_/Y _13625_/Q _11805_/A2 _11752_/S VPWR VGND sg13cmos5l_a21oi_1
X_11679_ _11679_/X _14347_/Q _13232_/Q VPWR VGND sg13cmos5l_xor2_1
X_14467_ _14467_/Q _14654_/CLK _14467_/D _14467_/RESET_B VPWR VGND sg13cmos5l_dfrbpq_1
X_14398_ _14398_/Q clkload80/A _14398_/D _14398_/RESET_B VPWR VGND sg13cmos5l_dfrbpq_1
X_13418_ _13418_/Q clkload42/A _13418_/D _13418_/RESET_B VPWR VGND sg13cmos5l_dfrbpq_1
X_13349_ _13349_/Q clkload35/A _13349_/D _13349_/RESET_B VPWR VGND sg13cmos5l_dfrbpq_1
XFILLER_97_921 VPWR VGND sg13cmos5l_fill_2
Xhold3208 _13487_/D _09374_/X VPWR VGND sg13cmos5l_dlygate4sd3_1
Xhold3219 hold3219/X _13400_/Q VPWR VGND sg13cmos5l_dlygate4sd3_1
X_07910_ _07911_/B _11025_/A _14226_/Q _07908_/D hold3510/X VPWR VGND sg13cmos5l_a22oi_1
X_08890_ _08890_/Y _07791_/A _08895_/B _08889_/Y VPWR VGND sg13cmos5l_o21ai_1
Xhold2507 _10533_/A _14027_/Q VPWR VGND sg13cmos5l_dlygate4sd3_1
Xhold2518 _10054_/A _13792_/Q VPWR VGND sg13cmos5l_dlygate4sd3_1
Xhold2529 _09985_/A _13758_/Q VPWR VGND sg13cmos5l_dlygate4sd3_1
X_07841_ _07842_/D _08815_/A _08460_/A _08469_/A _14582_/D VPWR VGND sg13cmos5l_or4_1
XFILLER_96_497 VPWR VGND sg13cmos5l_fill_1
X_07772_ _07772_/Y _14393_/Q _12071_/A VPWR VGND sg13cmos5l_nor2_1
XFILLER_84_648 VPWR VGND sg13cmos5l_fill_2
X_09511_ _09511_/Y _09511_/A _09511_/B VPWR VGND sg13cmos5l_nor2_1
XFILLER_24_203 VPWR VGND sg13cmos5l_fill_1
XFILLER_37_586 VPWR VGND sg13cmos5l_fill_1
X_09442_ _13553_/D _09307_/A hold3291/X _09442_/S VPWR VGND sg13cmos5l_mux2_1
XFILLER_40_718 VPWR VGND sg13cmos5l_fill_1
XFILLER_52_567 VPWR VGND sg13cmos5l_decap_4
X_09373_ _09373_/X _14127_/Q hold3195/X _09373_/S VPWR VGND sg13cmos5l_mux2_1
X_08324_ _08324_/Y _08405_/A1 _08321_/X _08419_/A1 VPWR VGND sg13cmos5l_a21oi_1
X_13634__1757 _13634_/RESET_B VPWR VGND sg13cmos5l_tiehi
X_08255_ _12573_/B _08248_/Y _08254_/Y _08244_/Y VPWR VGND sg13cmos5l_o21ai_1
X_07206_ _13063_/A _13064_/A VPWR VGND sg13cmos5l_inv_1
X_08186_ _08186_/Y _08186_/A _08186_/B _08186_/C VPWR VGND sg13cmos5l_nand3_1
X_14014__1377 _14014_/RESET_B VPWR VGND sg13cmos5l_tiehi
XFILLER_106_558 VPWR VGND sg13cmos5l_fill_1
XFILLER_88_954 VPWR VGND sg13cmos5l_decap_8
XFILLER_58_58 VPWR VGND sg13cmos5l_fill_1
XFILLER_88_987 VPWR VGND sg13cmos5l_decap_8
XFILLER_88_998 VPWR VGND sg13cmos5l_fill_2
XFILLER_101_285 VPWR VGND sg13cmos5l_fill_2
XFILLER_47_339 VPWR VGND sg13cmos5l_fill_2
XFILLER_28_575 VPWR VGND sg13cmos5l_fill_2
XFILLER_55_350 VPWR VGND sg13cmos5l_fill_2
XFILLER_56_862 VPWR VGND sg13cmos5l_decap_4
X_09709_ _13623_/D _10298_/A1 _09714_/B _09708_/Y VPWR VGND sg13cmos5l_a21oi_1
X_10981_ _10983_/B _10981_/A _14570_/Q VPWR VGND sg13cmos5l_nor2_1
XFILLER_43_523 VPWR VGND sg13cmos5l_fill_1
XFILLER_43_534 VPWR VGND sg13cmos5l_fill_2
XFILLER_71_843 VPWR VGND sg13cmos5l_decap_4
X_14218__1259 _14218_/RESET_B VPWR VGND sg13cmos5l_tiehi
X_12720_ _12742_/A _14451_/Q _13241_/Q VPWR VGND sg13cmos5l_xnor2_1
XFILLER_31_707 VPWR VGND sg13cmos5l_fill_2
XFILLER_43_567 VPWR VGND sg13cmos5l_fill_2
XFILLER_71_865 VPWR VGND sg13cmos5l_decap_8
X_12651_ _12651_/Y _14230_/Q _12651_/B VPWR VGND sg13cmos5l_nand2_1
XFILLER_30_206 VPWR VGND sg13cmos5l_fill_1
X_11602_ _11602_/Y _11595_/Y _11607_/A _11599_/Y _11601_/Y _11615_/C1 VPWR VGND sg13cmos5l_a221oi_1
X_12582_ _12582_/X _12735_/A _12582_/B VPWR VGND sg13cmos5l_and2_1
X_11533_ _11577_/B _11563_/A _11553_/A VPWR VGND sg13cmos5l_xnor2_1
X_14321_ _14321_/Q clkload65/A _14321_/D _14321_/RESET_B VPWR VGND sg13cmos5l_dfrbpq_1
XFILLER_11_497 VPWR VGND sg13cmos5l_fill_2
X_11464_ _11464_/X _11464_/A _11464_/B _11493_/A VPWR VGND sg13cmos5l_or3_1
X_14252_ _14252_/Q _14622_/CLK _14252_/D _14252_/RESET_B VPWR VGND sg13cmos5l_dfrbpq_1
X_10415_ _13969_/D fanout55/X _10414_/B _10414_/Y VPWR VGND sg13cmos5l_a21oi_1
X_13789__1602 _13789_/RESET_B VPWR VGND sg13cmos5l_tiehi
X_13203_ _13203_/Q clkload8/A _13203_/D fanout959/X VPWR VGND sg13cmos5l_dfrbpq_1
X_11395_ _11396_/B _11408_/A _11395_/B VPWR VGND sg13cmos5l_nand2_1
X_14183_ _14183_/Q _14217_/CLK _14183_/D _14183_/RESET_B VPWR VGND sg13cmos5l_dfrbpq_1
X_13477__1945 _13477_/RESET_B VPWR VGND sg13cmos5l_tiehi
X_10346_ _13935_/D fanout61/X _10345_/B _10345_/Y VPWR VGND sg13cmos5l_a21oi_1
X_13134_ _14556_/D hold3560/X _08042_/B _13136_/S VPWR VGND sg13cmos5l_mux2_1
XFILLER_79_921 VPWR VGND sg13cmos5l_decap_8
XFILLER_79_943 VPWR VGND sg13cmos5l_decap_8
X_10277_ _13901_/D fanout76/X _10276_/B _10276_/Y VPWR VGND sg13cmos5l_a21oi_1
X_13065_ _14518_/D _13065_/A _13067_/C VPWR VGND sg13cmos5l_xor2_1
XFILLER_78_453 VPWR VGND sg13cmos5l_fill_1
XFILLER_79_987 VPWR VGND sg13cmos5l_fill_1
X_12016_ _12017_/C _12097_/A1 _12012_/Y _12015_/Y VPWR VGND sg13cmos5l_o21ai_1
XFILLER_78_486 VPWR VGND sg13cmos5l_decap_8
XFILLER_78_497 VPWR VGND sg13cmos5l_fill_1
XFILLER_79_998 VPWR VGND sg13cmos5l_fill_1
XFILLER_93_412 VPWR VGND sg13cmos5l_fill_2
X_13712__1679 _13712_/RESET_B VPWR VGND sg13cmos5l_tiehi
XFILLER_94_968 VPWR VGND sg13cmos5l_fill_1
XFILLER_0_1018 VPWR VGND sg13cmos5l_decap_8
XFILLER_65_169 VPWR VGND sg13cmos5l_fill_1
XFILLER_81_618 VPWR VGND sg13cmos5l_fill_1
X_13967_ _13967_/Q _14020_/CLK _13967_/D _13967_/RESET_B VPWR VGND sg13cmos5l_dfrbpq_1
XFILLER_19_586 VPWR VGND sg13cmos5l_fill_1
X_12918_ _14446_/D _12918_/A VPWR VGND sg13cmos5l_inv_1
XFILLER_22_707 VPWR VGND sg13cmos5l_fill_2
XFILLER_62_865 VPWR VGND sg13cmos5l_fill_2
X_13898_ _13898_/Q clkload51/A _13898_/D _13898_/RESET_B VPWR VGND sg13cmos5l_dfrbpq_1
X_13312__2121 _13312_/RESET_B VPWR VGND sg13cmos5l_tiehi
X_12849_ _12857_/B _12866_/A _12863_/A _12849_/C VPWR VGND sg13cmos5l_or3_1
XFILLER_61_397 VPWR VGND sg13cmos5l_decap_8
XFILLER_30_773 VPWR VGND sg13cmos5l_fill_1
XFILLER_9_85 VPWR VGND sg13cmos5l_fill_2
X_14519_ _14519_/Q _14520_/CLK _14519_/D fanout972/X VPWR VGND sg13cmos5l_dfrbpq_1
X_08040_ _08044_/B _14541_/Q _08040_/B VPWR VGND sg13cmos5l_xnor2_1
X_13345__2077 _13345_/RESET_B VPWR VGND sg13cmos5l_tiehi
XFILLER_50_0 VPWR VGND sg13cmos5l_fill_1
X_09991_ _09991_/Y _09991_/A _10007_/B VPWR VGND sg13cmos5l_nand2_1
Xhold3005 hold3005/X _13347_/Q VPWR VGND sg13cmos5l_dlygate4sd3_1
X_08942_ _08942_/Y _14271_/Q _13189_/B1 _13151_/B1 VPWR VGND sg13cmos5l_a21oi_1
Xhold3016 _11173_/A _14312_/Q VPWR VGND sg13cmos5l_dlygate4sd3_1
Xhold3027 _09736_/A _13637_/Q VPWR VGND sg13cmos5l_dlygate4sd3_1
Xhold3038 _10185_/A _13856_/Q VPWR VGND sg13cmos5l_dlygate4sd3_1
X_14276__1232 _14276_/RESET_B VPWR VGND sg13cmos5l_tiehi
Xhold2304 _10925_/A _14208_/Q VPWR VGND sg13cmos5l_dlygate4sd3_1
Xhold2315 _09999_/A _13765_/Q VPWR VGND sg13cmos5l_dlygate4sd3_1
Xhold2326 _10072_/A _13801_/Q VPWR VGND sg13cmos5l_dlygate4sd3_1
Xhold2337 _10527_/A _14024_/Q VPWR VGND sg13cmos5l_dlygate4sd3_1
Xhold3049 _08104_/A _13200_/Q VPWR VGND sg13cmos5l_dlygate4sd3_1
XFILLER_85_913 VPWR VGND sg13cmos5l_decap_8
X_08873_ _14646_/D _08873_/A _08873_/B VPWR VGND sg13cmos5l_nand2_1
Xhold2348 _10509_/A _14015_/Q VPWR VGND sg13cmos5l_dlygate4sd3_1
Xhold2359 _08958_/A _13270_/Q VPWR VGND sg13cmos5l_dlygate4sd3_1
X_07824_ _14615_/D _07823_/A _12415_/A _07822_/Y VPWR VGND sg13cmos5l_o21ai_1
X_13522__1900 _13522_/RESET_B VPWR VGND sg13cmos5l_tiehi
XFILLER_72_618 VPWR VGND sg13cmos5l_decap_4
X_07755_ _07756_/B _08529_/B _07753_/Y _07754_/Y VPWR VGND sg13cmos5l_o21ai_1
X_07686_ _08529_/B _07686_/A _07685_/Y VPWR VGND sg13cmos5l_nor2b_1
X_09425_ _09425_/X _14113_/Q hold3197/X _09438_/S VPWR VGND sg13cmos5l_mux2_1
X_13867__1524 _13867_/RESET_B VPWR VGND sg13cmos5l_tiehi
X_13555__1867 _13555_/RESET_B VPWR VGND sg13cmos5l_tiehi
X_09356_ _13469_/D _10690_/A1 hold3086/X _09373_/S VPWR VGND sg13cmos5l_mux2_1
X_08307_ _08307_/Y _09225_/A _08307_/B _08344_/C VPWR VGND sg13cmos5l_nand3_1
X_09287_ _13410_/D _07299_/Y _09306_/S _09286_/Y VPWR VGND sg13cmos5l_a21oi_1
X_14565__2111 _14565_/RESET_B VPWR VGND sg13cmos5l_tiehi
XFILLER_5_906 VPWR VGND sg13cmos5l_fill_2
X_08238_ _08238_/X _13571_/Q _13539_/Q _08238_/S VPWR VGND sg13cmos5l_mux2_1
X_08169_ _14250_/D _07264_/Y _08168_/A _08168_/Y VPWR VGND sg13cmos5l_a21oi_1
X_10200_ _13863_/D _10395_/A1 _10209_/B _10199_/Y VPWR VGND sg13cmos5l_a21oi_1
X_11180_ _11180_/Y _11179_/A _11179_/B _11536_/A VPWR VGND sg13cmos5l_a21oi_1
X_10131_ _10131_/Y _10131_/A _10147_/B VPWR VGND sg13cmos5l_nand2_1
X_10062_ _10062_/Y _10062_/A _10074_/B VPWR VGND sg13cmos5l_nand2_1
Xhold3550 hold3550/X _14555_/Q VPWR VGND sg13cmos5l_dlygate4sd3_1
Xhold3561 hold3561/X _14539_/Q VPWR VGND sg13cmos5l_dlygate4sd3_1
XFILLER_76_913 VPWR VGND sg13cmos5l_decap_4
XFILLER_85_23 VPWR VGND sg13cmos5l_fill_1
Xhold3572 _10897_/A _14225_/Q VPWR VGND sg13cmos5l_dlygate4sd3_1
Xhold2860 _09862_/A _13698_/Q VPWR VGND sg13cmos5l_dlygate4sd3_1
Xhold2871 _10412_/A _13968_/Q VPWR VGND sg13cmos5l_dlygate4sd3_1
Xhold2882 _10327_/A _13926_/Q VPWR VGND sg13cmos5l_dlygate4sd3_1
Xhold2893 _10284_/A _13905_/Q VPWR VGND sg13cmos5l_dlygate4sd3_1
XFILLER_28_350 VPWR VGND sg13cmos5l_fill_1
X_13821_ _13821_/Q _14045_/CLK _13821_/D _13821_/RESET_B VPWR VGND sg13cmos5l_dfrbpq_1
XFILLER_29_895 VPWR VGND sg13cmos5l_fill_2
XFILLER_90_415 VPWR VGND sg13cmos5l_fill_1
X_13752_ _13752_/Q _14631_/CLK _13752_/D _13752_/RESET_B VPWR VGND sg13cmos5l_dfrbpq_1
X_10964_ _14223_/D _07893_/A _10963_/Y _10834_/Y VPWR VGND sg13cmos5l_a21oi_1
X_12703_ _12703_/Y _12704_/A _12743_/A VPWR VGND sg13cmos5l_nand2_1
X_10895_ _10895_/Y _10961_/B _10895_/B VPWR VGND sg13cmos5l_nand2_1
X_13683_ _13683_/Q clkload18/A _13683_/D _13683_/RESET_B VPWR VGND sg13cmos5l_dfrbpq_1
XFILLER_43_397 VPWR VGND sg13cmos5l_fill_1
X_12634_ _14412_/D _12686_/A _12634_/B _12634_/C _12634_/D VPWR VGND sg13cmos5l_nand4_1
X_14354__1154 _14354_/RESET_B VPWR VGND sg13cmos5l_tiehi
X_12565_ _12565_/X _14438_/Q _13228_/Q VPWR VGND sg13cmos5l_and2_1
X_11516_ _11523_/A _11393_/B _11392_/B _11393_/X _11334_/A _11515_/Y VPWR VGND sg13cmos5l_a221oi_1
X_14304_ _14304_/Q clkload26/A _14304_/D _14304_/RESET_B VPWR VGND sg13cmos5l_dfrbpq_1
XFILLER_8_799 VPWR VGND sg13cmos5l_fill_1
X_12496_ _12496_/Y _12504_/A _12069_/Y _12503_/B VPWR VGND sg13cmos5l_a21oi_1
X_11447_ _11447_/Y _11447_/A1 _11463_/B _12937_/B2 VPWR VGND sg13cmos5l_o21ai_1
X_14235_ _14235_/Q _14622_/CLK _14235_/D _14235_/RESET_B VPWR VGND sg13cmos5l_dfrbpq_1
X_13600__1822 _13600_/RESET_B VPWR VGND sg13cmos5l_tiehi
XFILLER_98_515 VPWR VGND sg13cmos5l_decap_8
X_11378_ _11379_/B _11389_/A _11378_/B VPWR VGND sg13cmos5l_nand2_1
X_14166_ _14166_/Q clkload22/A _14166_/D fanout991/X VPWR VGND sg13cmos5l_dfrbpq_1
X_10329_ _10329_/Y _10329_/A _10339_/B VPWR VGND sg13cmos5l_nor2_1
X_13117_ _14545_/D hold3535/X _08043_/B _13118_/S VPWR VGND sg13cmos5l_mux2_1
X_14097_ _14097_/Q clkload66/A _14097_/D _14097_/RESET_B VPWR VGND sg13cmos5l_dfrbpq_1
X_13945__1446 _13945_/RESET_B VPWR VGND sg13cmos5l_tiehi
X_13048_ _13048_/Y _15888_/A _13049_/C hold3327/X VPWR VGND sg13cmos5l_a21oi_1
XFILLER_67_968 VPWR VGND sg13cmos5l_fill_1
XFILLER_94_732 VPWR VGND sg13cmos5l_fill_1
XFILLER_54_629 VPWR VGND sg13cmos5l_decap_8
X_07540_ _07547_/A _07540_/A _07540_/B _07540_/C _07540_/D VPWR VGND sg13cmos5l_nor4_1
XFILLER_22_515 VPWR VGND sg13cmos5l_decap_8
XFILLER_62_662 VPWR VGND sg13cmos5l_fill_2
X_07471_ _07472_/B _07459_/Y _07464_/Y _07470_/X _11040_/A VPWR VGND sg13cmos5l_a22oi_1
XFILLER_50_857 VPWR VGND sg13cmos5l_fill_1
XFILLER_98_0 VPWR VGND sg13cmos5l_fill_2
X_09210_ _13339_/D _08182_/A hold3172/X _09225_/B VPWR VGND sg13cmos5l_mux2_1
X_09141_ _09141_/Y _11471_/A _09140_/Y _09160_/A2 VPWR VGND sg13cmos5l_a21oi_1
X_09072_ _13308_/D _09071_/B _09070_/Y _09071_/Y VPWR VGND sg13cmos5l_a21oi_1
X_08023_ _08031_/C _14556_/Q _08042_/B VPWR VGND sg13cmos5l_xnor2_1
XFILLER_104_804 VPWR VGND sg13cmos5l_fill_2
XFILLER_104_815 VPWR VGND sg13cmos5l_fill_2
XFILLER_104_826 VPWR VGND sg13cmos5l_fill_2
X_09974_ _13752_/D _10561_/A1 _09977_/B _09973_/Y VPWR VGND sg13cmos5l_o21ai_1
X_08925_ _13247_/D _12100_/B _13196_/A2 _13190_/B1 _08924_/Y VPWR VGND sg13cmos5l_a22oi_1
X_08856_ _08856_/Y _07764_/Y _08861_/C _08848_/B _07767_/A VPWR VGND sg13cmos5l_a22oi_1
X_07807_ _08606_/B _07784_/A _07800_/A _07806_/Y _07788_/Y _07801_/Y VPWR VGND sg13cmos5l_a221oi_1
X_08787_ _08787_/Y _14223_/Q _08908_/B _08910_/C _08840_/B VPWR VGND sg13cmos5l_nor4_1
X_14432__1076 _14432_/RESET_B VPWR VGND sg13cmos5l_tiehi
X_07738_ _08476_/C _11117_/A _11711_/A VPWR VGND sg13cmos5l_nand2_1
XFILLER_53_673 VPWR VGND sg13cmos5l_decap_8
XFILLER_53_684 VPWR VGND sg13cmos5l_fill_1
X_07669_ _08582_/B _08861_/A _12093_/A VPWR VGND sg13cmos5l_xnor2_1
XFILLER_80_492 VPWR VGND sg13cmos5l_fill_2
X_09408_ _13520_/D _08397_/A hold3293/X _09408_/S VPWR VGND sg13cmos5l_mux2_1
X_10680_ _14100_/D input9/X hold3452/X _10685_/S VPWR VGND sg13cmos5l_mux2_1
X_09339_ _13455_/D _09304_/A hold3157/X _09340_/S VPWR VGND sg13cmos5l_mux2_1
X_13408__2014 _13408_/RESET_B VPWR VGND sg13cmos5l_tiehi
X_12350_ _12350_/Y _12348_/Y _12349_/Y _12351_/A1 VPWR VGND sg13cmos5l_a21oi_1
X_11301_ _11301_/X _11316_/A _11301_/B VPWR VGND sg13cmos5l_and2_1
X_12281_ _12307_/A _12282_/A _13253_/Q VPWR VGND sg13cmos5l_nand2_1
X_11232_ _14316_/D _11230_/Y _11231_/Y _11220_/Y VPWR VGND sg13cmos5l_o21ai_1
X_14020_ _14020_/Q _14020_/CLK _14020_/D _14020_/RESET_B VPWR VGND sg13cmos5l_dfrbpq_1
X_11163_ _14309_/D _07186_/Y _11166_/A2 _11162_/Y _10654_/B VPWR VGND sg13cmos5l_a22oi_1
XFILLER_106_196 VPWR VGND sg13cmos5l_fill_1
X_10114_ _13821_/D _10571_/A1 _10119_/B _10113_/Y VPWR VGND sg13cmos5l_o21ai_1
XFILLER_1_964 VPWR VGND sg13cmos5l_fill_1
XFILLER_49_913 VPWR VGND sg13cmos5l_fill_2
X_11094_ _11094_/Y _14390_/Q _11093_/B _11093_/Y VPWR VGND sg13cmos5l_a21oi_1
X_10045_ _13787_/D _10567_/A1 _10044_/B _10044_/Y VPWR VGND sg13cmos5l_o21ai_1
Xhold3391 hold3391/X _14257_/Q VPWR VGND sg13cmos5l_dlygate4sd3_1
Xhold3380 hold3380/X _13424_/Q VPWR VGND sg13cmos5l_dlygate4sd3_1
XFILLER_48_456 VPWR VGND sg13cmos5l_fill_1
XFILLER_91_713 VPWR VGND sg13cmos5l_fill_2
Xhold2690 _10333_/A _13929_/Q VPWR VGND sg13cmos5l_dlygate4sd3_1
X_13804_ _13804_/Q _14028_/CLK _13804_/D _13804_/RESET_B VPWR VGND sg13cmos5l_dfrbpq_1
X_11996_ _11996_/Y _14018_/Q _12000_/B VPWR VGND sg13cmos5l_nor2_1
XFILLER_32_802 VPWR VGND sg13cmos5l_fill_2
XFILLER_50_109 VPWR VGND sg13cmos5l_fill_2
X_10947_ _14216_/D _08502_/A _10834_/Y _10946_/X VPWR VGND sg13cmos5l_o21ai_1
X_13735_ _13735_/Q _14064_/CLK _13735_/D _13735_/RESET_B VPWR VGND sg13cmos5l_dfrbpq_1
XFILLER_32_835 VPWR VGND sg13cmos5l_fill_1
X_13666_ _13666_/Q clkload60/A _13666_/D _13666_/RESET_B VPWR VGND sg13cmos5l_dfrbpq_1
X_10878_ _10878_/Y _10878_/A _10932_/B VPWR VGND sg13cmos5l_nand2_1
X_12617_ _12618_/B _14442_/Q _13232_/Q VPWR VGND sg13cmos5l_xor2_1
Xclkbuf_4_14_0_clk clkbuf_4_14_0_clk/X clkbuf_0_clk/X VPWR VGND sg13cmos5l_buf_8
X_13597_ _13597_/Q clkload46/A _13597_/D _13597_/RESET_B VPWR VGND sg13cmos5l_dfrbpq_1
XFILLER_8_541 VPWR VGND sg13cmos5l_fill_1
X_12548_ _12548_/Y _14343_/Q _11164_/B _11091_/B VPWR VGND sg13cmos5l_o21ai_1
XANTENNA_2 _14401_/Q VPWR VGND sg13cmos5l_antennanp
X_12479_ _12479_/Y _12479_/A _12485_/B VPWR VGND sg13cmos5l_nand2_1
XFILLER_6_64 VPWR VGND sg13cmos5l_fill_1
XFILLER_99_802 VPWR VGND sg13cmos5l_fill_1
X_14218_ _14218_/Q _14614_/CLK _14218_/D _14218_/RESET_B VPWR VGND sg13cmos5l_dfrbpq_1
Xfanout509 _11915_/B fanout510/X VPWR VGND sg13cmos5l_buf_1
X_14149_ _14149_/Q clkload23/A _14149_/D fanout991/X VPWR VGND sg13cmos5l_dfrbpq_1
XFILLER_67_710 VPWR VGND sg13cmos5l_decap_4
XFILLER_98_378 VPWR VGND sg13cmos5l_fill_2
X_14213__1264 _14213_/RESET_B VPWR VGND sg13cmos5l_tiehi
X_08710_ _08710_/Y _08706_/Y _08709_/Y _11788_/C1 VPWR VGND sg13cmos5l_a21oi_1
X_09690_ _09691_/B _14468_/Q _09690_/B VPWR VGND sg13cmos5l_xor2_1
X_14564__2110 _14564_/RESET_B VPWR VGND sg13cmos5l_tiehi
XFILLER_27_618 VPWR VGND sg13cmos5l_fill_2
X_08641_ _08643_/A _12545_/A _14174_/Q VPWR VGND sg13cmos5l_nor2_1
XFILLER_27_629 VPWR VGND sg13cmos5l_fill_2
X_08572_ _08572_/Y _08572_/A _08579_/A VPWR VGND sg13cmos5l_nor2_1
XFILLER_22_301 VPWR VGND sg13cmos5l_fill_1
XFILLER_23_813 VPWR VGND sg13cmos5l_fill_1
X_07523_ _07523_/Y _07523_/A VPWR VGND sg13cmos5l_inv_1
XFILLER_35_695 VPWR VGND sg13cmos5l_fill_2
XFILLER_50_632 VPWR VGND sg13cmos5l_fill_1
X_07454_ _07455_/C _12964_/B _07454_/B _07454_/C _07454_/D VPWR VGND sg13cmos5l_nand4_1
XFILLER_22_356 VPWR VGND sg13cmos5l_fill_1
XFILLER_41_39 VPWR VGND sg13cmos5l_fill_1
X_07385_ _07414_/B _14547_/Q _07467_/C VPWR VGND sg13cmos5l_nor2_1
X_13472__1950 _13472_/RESET_B VPWR VGND sg13cmos5l_tiehi
X_09124_ _09124_/Y _14361_/Q _09135_/B1 _09123_/Y VPWR VGND sg13cmos5l_a21oi_1
X_09055_ _13305_/D _09060_/B _09053_/Y _09054_/Y VPWR VGND sg13cmos5l_a21oi_1
XFILLER_2_706 VPWR VGND sg13cmos5l_fill_1
X_08006_ _08006_/Y _14242_/Q _10807_/A VPWR VGND sg13cmos5l_nor2_1
XFILLER_89_356 VPWR VGND sg13cmos5l_fill_2
XFILLER_58_710 VPWR VGND sg13cmos5l_fill_1
X_09957_ _13744_/D fanout58/X _09958_/B _09956_/Y VPWR VGND sg13cmos5l_a21oi_1
X_08908_ _08912_/A _08908_/A _08908_/B VPWR VGND sg13cmos5l_nand2_1
XFILLER_100_851 VPWR VGND sg13cmos5l_fill_1
XFILLER_100_862 VPWR VGND sg13cmos5l_fill_1
XFILLER_46_916 VPWR VGND sg13cmos5l_fill_1
XFILLER_57_231 VPWR VGND sg13cmos5l_fill_1
XFILLER_73_702 VPWR VGND sg13cmos5l_decap_8
X_09888_ _09888_/Y _09888_/A _09892_/B VPWR VGND sg13cmos5l_nor2_1
XFILLER_100_895 VPWR VGND sg13cmos5l_fill_1
X_08839_ _08842_/B _07675_/B _08839_/B VPWR VGND sg13cmos5l_nand2b_1
X_13247__1017 _13247_/RESET_B VPWR VGND sg13cmos5l_tiehi
X_11850_ _11851_/C _11873_/A _11849_/B _11982_/B VPWR VGND sg13cmos5l_a21o_1
X_10801_ _10801_/Y _10801_/A _14305_/Q VPWR VGND sg13cmos5l_nand2_1
X_11781_ _11781_/Y _13658_/Q _11785_/B _11727_/B VPWR VGND sg13cmos5l_a21oi_1
XFILLER_15_40 VPWR VGND sg13cmos5l_fill_1
X_10732_ _10732_/Y _10780_/A _11056_/A VPWR VGND sg13cmos5l_nand2_1
X_13520_ _13520_/Q clkload34/A _13520_/D _13520_/RESET_B VPWR VGND sg13cmos5l_dfrbpq_1
X_13340__2082 _13340_/RESET_B VPWR VGND sg13cmos5l_tiehi
XFILLER_15_51 VPWR VGND sg13cmos5l_fill_1
X_10663_ _14087_/D _07263_/Y _10894_/D _10662_/Y VPWR VGND sg13cmos5l_a21oi_1
X_13451_ _13451_/Q _14238_/CLK _13451_/D _13451_/RESET_B VPWR VGND sg13cmos5l_dfrbpq_1
X_10594_ _10594_/Y _10594_/A _10594_/B VPWR VGND sg13cmos5l_nand2_1
X_13382_ _13382_/Q clkload35/A _13382_/D _13382_/RESET_B VPWR VGND sg13cmos5l_dfrbpq_1
X_12402_ _12402_/Y _13648_/Q _12402_/A2 _12144_/B _13904_/Q _12402_/C1 VPWR VGND sg13cmos5l_a221oi_1
X_12333_ _12360_/A _12256_/A _12330_/Y _12332_/Y VPWR VGND sg13cmos5l_o21ai_1
X_13647__1744 _13647_/RESET_B VPWR VGND sg13cmos5l_tiehi
XFILLER_5_588 VPWR VGND sg13cmos5l_fill_1
X_12264_ _12264_/Y _13611_/Q _12292_/B _12260_/B _13675_/Q VPWR VGND sg13cmos5l_a22oi_1
X_14003_ _14003_/Q clkload50/A _14003_/D _14003_/RESET_B VPWR VGND sg13cmos5l_dfrbpq_1
X_11215_ _11215_/Y _11203_/A _11214_/C _11214_/D VPWR VGND sg13cmos5l_a21oi_1
X_12195_ _12198_/A _13865_/Q _12195_/B VPWR VGND sg13cmos5l_nand2_1
Xoutput50 uo_out[5] _08766_/Y VPWR VGND sg13cmos5l_buf_1
X_11146_ _11146_/Y _14389_/Q _11151_/B _11146_/B1 _14405_/Q _11087_/X VPWR VGND sg13cmos5l_a221oi_1
X_11077_ _11077_/Y _11077_/A _11144_/B VPWR VGND sg13cmos5l_nor2_1
X_14027__1364 _14027_/RESET_B VPWR VGND sg13cmos5l_tiehi
X_10028_ _10028_/Y _10028_/A _10044_/B VPWR VGND sg13cmos5l_nand2_1
XFILLER_91_510 VPWR VGND sg13cmos5l_decap_8
X_15885_ _15885_/X _15885_/A VPWR VGND sg13cmos5l_buf_1
X_13550__1872 _13550_/RESET_B VPWR VGND sg13cmos5l_tiehi
XFILLER_56_80 VPWR VGND sg13cmos5l_fill_2
XFILLER_17_651 VPWR VGND sg13cmos5l_fill_2
XFILLER_17_662 VPWR VGND sg13cmos5l_fill_2
XFILLER_60_930 VPWR VGND sg13cmos5l_fill_1
X_11979_ _11979_/Y _11979_/A _11979_/B VPWR VGND sg13cmos5l_nor2_1
X_13895__1496 _13895_/RESET_B VPWR VGND sg13cmos5l_tiehi
X_13718_ _13718_/Q clkload50/A _13718_/D _13718_/RESET_B VPWR VGND sg13cmos5l_dfrbpq_1
XFILLER_20_805 VPWR VGND sg13cmos5l_fill_1
XFILLER_60_974 VPWR VGND sg13cmos5l_decap_4
X_13649_ _13649_/Q _14020_/CLK _13649_/D _13649_/RESET_B VPWR VGND sg13cmos5l_dfrbpq_1
X_07170_ _09589_/B _14452_/Q VPWR VGND sg13cmos5l_inv_1
XFILLER_87_838 VPWR VGND sg13cmos5l_decap_4
X_09811_ _09811_/Y _09811_/A _09825_/B VPWR VGND sg13cmos5l_nor2_1
Xfanout339 _10553_/A1 _09497_/Y VPWR VGND sg13cmos5l_buf_1
Xfanout328 _09748_/B _09760_/B VPWR VGND sg13cmos5l_buf_1
Xfanout317 _09817_/B _09825_/B VPWR VGND sg13cmos5l_buf_1
Xfanout306 _09886_/B _09862_/B VPWR VGND sg13cmos5l_buf_1
X_09742_ _09742_/Y _09742_/A _09748_/B VPWR VGND sg13cmos5l_nor2_1
X_09673_ _09673_/Y _09673_/A _09673_/B VPWR VGND sg13cmos5l_nor2_1
XFILLER_27_448 VPWR VGND sg13cmos5l_fill_1
X_08624_ _08624_/Y _08621_/B _08621_/C _07816_/X VPWR VGND sg13cmos5l_o21ai_1
XFILLER_42_407 VPWR VGND sg13cmos5l_decap_4
XFILLER_70_705 VPWR VGND sg13cmos5l_fill_1
X_08555_ _08556_/B _08559_/A _08558_/B _08554_/Y VPWR VGND sg13cmos5l_o21ai_1
XFILLER_51_941 VPWR VGND sg13cmos5l_fill_1
X_07506_ _07507_/A _13556_/Q _13524_/Q _13492_/Q _13460_/Q _07522_/S0 _07522_/S1 VPWR
+ VGND sg13cmos5l_mux4_1
X_13725__1666 _13725_/RESET_B VPWR VGND sg13cmos5l_tiehi
XFILLER_23_665 VPWR VGND sg13cmos5l_decap_8
X_08486_ _08487_/B _08498_/A _08483_/Y _08484_/Y _08485_/Y VPWR VGND sg13cmos5l_a22oi_1
X_07437_ _07439_/A _14071_/Q _07465_/B _07512_/B _14528_/Q VPWR VGND sg13cmos5l_a22oi_1
X_07368_ _07414_/A input20/X _14242_/Q _12963_/B VPWR VGND sg13cmos5l_nand3_1
X_09107_ _09107_/Y _09107_/A _09125_/B VPWR VGND sg13cmos5l_nor2_1
X_13940__1451 _13940_/RESET_B VPWR VGND sg13cmos5l_tiehi
X_07299_ _07299_/Y _07299_/A VPWR VGND sg13cmos5l_inv_1
X_09038_ _09038_/Y _09038_/A _09060_/B VPWR VGND sg13cmos5l_nor2_1
XFILLER_104_431 VPWR VGND sg13cmos5l_fill_2
XFILLER_105_932 VPWR VGND sg13cmos5l_decap_8
X_11000_ _14233_/D _11000_/A _11000_/B VPWR VGND sg13cmos5l_nand2_1
XFILLER_77_337 VPWR VGND sg13cmos5l_fill_2
Xfanout851 _11164_/B _14342_/Q VPWR VGND sg13cmos5l_buf_1
Xfanout840 _12130_/A _14363_/Q VPWR VGND sg13cmos5l_buf_1
X_13358__2064 _13358_/RESET_B VPWR VGND sg13cmos5l_tiehi
Xfanout884 _09307_/A _14130_/Q VPWR VGND sg13cmos5l_buf_1
Xfanout873 _11192_/A _11202_/A VPWR VGND sg13cmos5l_buf_1
Xfanout862 _10351_/B _14232_/Q VPWR VGND sg13cmos5l_buf_1
Xfanout895 _08269_/A _14119_/Q VPWR VGND sg13cmos5l_buf_1
X_12951_ _12952_/A _14463_/Q _11560_/B _11553_/A _12955_/B2 VPWR VGND sg13cmos5l_a22oi_1
X_11902_ _11904_/B _11903_/A _11903_/B VPWR VGND sg13cmos5l_nor2_1
X_12882_ _12895_/A _14467_/Q _13257_/Q VPWR VGND sg13cmos5l_and2_1
XFILLER_27_971 VPWR VGND sg13cmos5l_fill_1
XFILLER_61_716 VPWR VGND sg13cmos5l_decap_8
X_11833_ _11833_/Y _13596_/Q _11998_/B1 _11971_/A2 _13852_/Q _12010_/C1 VPWR VGND
+ sg13cmos5l_a221oi_1
X_14621_ _14621_/Q _14621_/CLK _14621_/D _14621_/RESET_B VPWR VGND sg13cmos5l_dfrbpq_1
X_11764_ _14349_/D _11763_/Y _11740_/A _11870_/A VPWR VGND sg13cmos5l_mux2_1
X_14552_ _14552_/Q clkload11/A _14552_/D fanout963/X VPWR VGND sg13cmos5l_dfrbpq_1
X_10715_ _10715_/Y _10715_/A _10808_/S VPWR VGND sg13cmos5l_nand2_1
X_11695_ _11695_/Y _13687_/Q _11695_/B VPWR VGND sg13cmos5l_nand2_1
X_14483_ _14483_/Q _14576_/CLK _14483_/D fanout979/X VPWR VGND sg13cmos5l_dfrbpq_1
X_13503_ _13503_/Q _13568_/CLK _13503_/D _13503_/RESET_B VPWR VGND sg13cmos5l_dfrbpq_1
X_10646_ _14079_/D _10648_/B _10646_/B VPWR VGND sg13cmos5l_and2_1
X_13434_ _13434_/Q clkload27/A _13434_/D _13434_/RESET_B VPWR VGND sg13cmos5l_dfrbpq_1
XFILLER_6_853 VPWR VGND sg13cmos5l_fill_1
X_10577_ _14048_/D _10577_/A1 _10577_/A2 _10576_/Y VPWR VGND sg13cmos5l_o21ai_1
Xclkbuf_leaf_102_clk clkload12/A clkbuf_4_0_0_clk/X VPWR VGND sg13cmos5l_buf_8
X_13365_ _13365_/Q _14292_/CLK _13365_/D _13365_/RESET_B VPWR VGND sg13cmos5l_dfrbpq_1
X_13568__1854 _13568_/RESET_B VPWR VGND sg13cmos5l_tiehi
X_13296_ _13296_/Q clkload19/A _13296_/D fanout982/X VPWR VGND sg13cmos5l_dfrbpq_1
X_12316_ _12316_/Y _13869_/Q _12344_/B _12087_/B _13677_/Q _12349_/C1 VPWR VGND sg13cmos5l_a221oi_1
X_12247_ _12247_/Y _07656_/B _12383_/A2 _12417_/B VPWR VGND sg13cmos5l_a21oi_1
X_14391__1117 _14391_/RESET_B VPWR VGND sg13cmos5l_tiehi
XFILLER_96_613 VPWR VGND sg13cmos5l_fill_2
X_12178_ _12178_/Y _13768_/Q _12399_/A2 _12174_/B _14024_/Q VPWR VGND sg13cmos5l_a22oi_1
X_13803__1588 _13803_/RESET_B VPWR VGND sg13cmos5l_tiehi
XFILLER_49_551 VPWR VGND sg13cmos5l_fill_2
X_11129_ _11129_/Y _11129_/A _11132_/B VPWR VGND sg13cmos5l_nor2_1
XFILLER_49_573 VPWR VGND sg13cmos5l_decap_8
XFILLER_95_178 VPWR VGND sg13cmos5l_fill_2
XFILLER_64_521 VPWR VGND sg13cmos5l_decap_8
XFILLER_92_852 VPWR VGND sg13cmos5l_decap_8
X_13982__1409 _13982_/RESET_B VPWR VGND sg13cmos5l_tiehi
XFILLER_52_749 VPWR VGND sg13cmos5l_fill_2
X_14449__1057 _14449_/RESET_B VPWR VGND sg13cmos5l_tiehi
X_08340_ _08340_/Y _08388_/A _08338_/X _08339_/Y _08337_/X _08391_/B1 VPWR VGND sg13cmos5l_a221oi_1
X_08271_ _08271_/Y _08275_/S _07307_/Y _08339_/B1 VPWR VGND sg13cmos5l_a21oi_1
X_07222_ _12162_/A _12130_/A VPWR VGND sg13cmos5l_inv_1
X_13231__1038 _13231_/RESET_B VPWR VGND sg13cmos5l_tiehi
Xfanout103 _08963_/S _07640_/B1 VPWR VGND sg13cmos5l_buf_1
X_14367__1141 _14367_/RESET_B VPWR VGND sg13cmos5l_tiehi
XFILLER_86_101 VPWR VGND sg13cmos5l_fill_1
Xfanout147 _09024_/B _09030_/B VPWR VGND sg13cmos5l_buf_1
Xfanout136 _10894_/D _10675_/S VPWR VGND sg13cmos5l_buf_1
Xfanout125 _09405_/S _09408_/S VPWR VGND sg13cmos5l_buf_1
Xfanout114 _09471_/S _09475_/S VPWR VGND sg13cmos5l_buf_1
X_07986_ _07989_/A _14485_/Q _08209_/B1 _11039_/B1 _14501_/Q VPWR VGND sg13cmos5l_a22oi_1
Xfanout169 _10805_/B fanout170/X VPWR VGND sg13cmos5l_buf_1
Xfanout158 _10778_/B _10799_/B VPWR VGND sg13cmos5l_buf_1
X_09725_ _13631_/D _10379_/A1 _09726_/B _09724_/Y VPWR VGND sg13cmos5l_a21oi_1
XFILLER_83_852 VPWR VGND sg13cmos5l_fill_1
X_09656_ _11530_/B _14432_/Q _14651_/Q _09662_/S VPWR VGND sg13cmos5l_mux2_1
XFILLER_70_502 VPWR VGND sg13cmos5l_fill_1
X_08607_ _08607_/X _08893_/A _08609_/B _08607_/C VPWR VGND sg13cmos5l_and3_1
X_13958__1433 _13958_/RESET_B VPWR VGND sg13cmos5l_tiehi
XFILLER_36_790 VPWR VGND sg13cmos5l_fill_1
X_09587_ _09587_/Y _09587_/A _09587_/B VPWR VGND sg13cmos5l_nor2_1
X_08538_ _14599_/D _08538_/A _08538_/B VPWR VGND sg13cmos5l_xnor2_1
X_08469_ _14587_/D _08469_/A _08469_/B VPWR VGND sg13cmos5l_xnor2_1
X_10500_ _14010_/D _10565_/A1 _10501_/B _10499_/Y VPWR VGND sg13cmos5l_o21ai_1
X_11480_ _14332_/D _11478_/Y _11479_/Y _11469_/Y VPWR VGND sg13cmos5l_o21ai_1
X_10431_ _13976_/D _10496_/A1 _10466_/B _10430_/Y VPWR VGND sg13cmos5l_a21oi_1
X_14172__1305 _14172_/RESET_B VPWR VGND sg13cmos5l_tiehi
XFILLER_3_801 VPWR VGND sg13cmos5l_fill_1
X_10362_ _10362_/Y _10362_/A _10380_/B VPWR VGND sg13cmos5l_nor2_1
X_13150_ _13226_/D hold3382/X _07997_/D _07925_/Y VPWR VGND sg13cmos5l_a21o_1
X_10293_ _10293_/Y _10293_/A _10295_/B VPWR VGND sg13cmos5l_nor2_1
X_12101_ _12110_/A _14362_/Q _13247_/Q VPWR VGND sg13cmos5l_xnor2_1
X_13081_ _13081_/Y _14524_/Q _13080_/C hold2438/X VPWR VGND sg13cmos5l_a21oi_1
XFILLER_105_751 VPWR VGND sg13cmos5l_fill_2
X_12032_ _12033_/C _13603_/Q _12200_/B1 _12087_/B _13667_/Q VPWR VGND sg13cmos5l_a22oi_1
XFILLER_2_377 VPWR VGND sg13cmos5l_fill_1
XFILLER_78_646 VPWR VGND sg13cmos5l_fill_2
XFILLER_78_668 VPWR VGND sg13cmos5l_decap_4
XFILLER_59_860 VPWR VGND sg13cmos5l_fill_1
Xfanout692 _09106_/A2 _09112_/A2 VPWR VGND sg13cmos5l_buf_1
Xfanout681 _11308_/A _11542_/A VPWR VGND sg13cmos5l_buf_1
Xfanout670 _13194_/A2 _08943_/A2 VPWR VGND sg13cmos5l_buf_1
X_13983_ _13983_/Q clkload46/A _13983_/D _13983_/RESET_B VPWR VGND sg13cmos5l_dfrbpq_1
X_12934_ _14454_/D _12934_/A VPWR VGND sg13cmos5l_inv_1
XFILLER_46_576 VPWR VGND sg13cmos5l_fill_1
XFILLER_74_874 VPWR VGND sg13cmos5l_fill_1
X_12865_ _12865_/Y _12865_/A VPWR VGND sg13cmos5l_inv_1
XFILLER_33_237 VPWR VGND sg13cmos5l_fill_1
X_11816_ _11816_/Y _07235_/Y _11868_/A2 _11816_/B1 _12663_/B VPWR VGND sg13cmos5l_a22oi_1
X_14604_ _14604_/Q clkload75/A _14604_/D _14604_/RESET_B VPWR VGND sg13cmos5l_dfrbpq_1
X_12796_ _12823_/A _14458_/Q _13248_/Q VPWR VGND sg13cmos5l_nor2_1
X_11747_ _11747_/Y _11747_/A _11747_/B _11747_/C VPWR VGND sg13cmos5l_nand3_1
X_14535_ _14535_/Q clkload14/A _14535_/D _09199_/A VPWR VGND sg13cmos5l_dfrbpq_1
XFILLER_105_1016 VPWR VGND sg13cmos5l_decap_8
XFILLER_105_1027 VPWR VGND sg13cmos5l_fill_2
X_14445__1063 _14445_/RESET_B VPWR VGND sg13cmos5l_tiehi
X_11678_ _11678_/Y _14347_/Q _13232_/Q VPWR VGND sg13cmos5l_nand2_1
X_14466_ _14466_/Q _14654_/CLK _14466_/D _14466_/RESET_B VPWR VGND sg13cmos5l_dfrbpq_1
X_10629_ _10635_/D _10629_/A _10630_/B VPWR VGND sg13cmos5l_nor2_1
X_14397_ _14397_/Q clkload75/A _14397_/D _14397_/RESET_B VPWR VGND sg13cmos5l_dfrbpq_1
X_13417_ _13417_/Q clkload37/A _13417_/D _13417_/RESET_B VPWR VGND sg13cmos5l_dfrbpq_1
X_13348_ _13348_/Q clkload37/A _13348_/D _13348_/RESET_B VPWR VGND sg13cmos5l_dfrbpq_1
Xhold3209 hold3209/X _13496_/Q VPWR VGND sg13cmos5l_dlygate4sd3_1
X_13279_ _13279_/Q clkload21/A _13279_/D fanout964/X VPWR VGND sg13cmos5l_dfrbpq_1
Xhold2508 _10724_/A _14135_/Q VPWR VGND sg13cmos5l_dlygate4sd3_1
Xhold2519 _10521_/A _14021_/Q VPWR VGND sg13cmos5l_dlygate4sd3_1
XFILLER_69_679 VPWR VGND sg13cmos5l_fill_2
X_07840_ _07842_/C _08473_/A _08465_/A _08455_/A VPWR VGND sg13cmos5l_nand3_1
XFILLER_56_307 VPWR VGND sg13cmos5l_fill_2
XFILLER_56_318 VPWR VGND sg13cmos5l_decap_8
XFILLER_56_329 VPWR VGND sg13cmos5l_decap_8
XFILLER_83_115 VPWR VGND sg13cmos5l_fill_2
X_07771_ _08539_/B _08532_/B _07839_/A _07769_/Y VPWR VGND sg13cmos5l_o21ai_1
X_09510_ _09510_/Y _09509_/A _09506_/X _09508_/Y _09509_/Y VPWR VGND sg13cmos5l_a22oi_1
XFILLER_65_863 VPWR VGND sg13cmos5l_decap_4
XFILLER_80_800 VPWR VGND sg13cmos5l_fill_2
XFILLER_80_811 VPWR VGND sg13cmos5l_decap_4
XFILLER_25_749 VPWR VGND sg13cmos5l_fill_2
X_09441_ _09441_/X _14129_/Q hold3356/X _09441_/S VPWR VGND sg13cmos5l_mux2_1
X_09372_ _13485_/D _09230_/A hold3168/X _09373_/S VPWR VGND sg13cmos5l_mux2_1
XFILLER_21_911 VPWR VGND sg13cmos5l_fill_2
X_08323_ _08323_/Y _08263_/S _13386_/Q _08322_/Y VPWR VGND sg13cmos5l_o21ai_1
X_08254_ _08254_/Y _08254_/A1 _08253_/Y _13040_/C VPWR VGND sg13cmos5l_o21ai_1
X_07205_ _13057_/A _07205_/A VPWR VGND sg13cmos5l_inv_1
X_08185_ _08186_/C _13219_/Q _08207_/B1 _11039_/A2 _14532_/Q VPWR VGND sg13cmos5l_a22oi_1
XFILLER_106_548 VPWR VGND sg13cmos5l_fill_1
XFILLER_0_837 VPWR VGND sg13cmos5l_decap_4
XFILLER_88_933 VPWR VGND sg13cmos5l_fill_2
XFILLER_101_264 VPWR VGND sg13cmos5l_fill_2
XFILLER_87_487 VPWR VGND sg13cmos5l_fill_1
X_07969_ _07969_/Y _08214_/A _07968_/X VPWR VGND sg13cmos5l_nor2b_1
X_09708_ _09708_/Y _09708_/A _09714_/B VPWR VGND sg13cmos5l_nor2_1
XFILLER_90_619 VPWR VGND sg13cmos5l_fill_2
X_10980_ _10980_/Y _10979_/Y _10980_/B VPWR VGND sg13cmos5l_nand2b_1
XFILLER_55_384 VPWR VGND sg13cmos5l_fill_2
X_09639_ _09639_/Y _09639_/A _09639_/B _09650_/C VPWR VGND sg13cmos5l_nor3_1
X_14226__1251 _14226_/RESET_B VPWR VGND sg13cmos5l_tiehi
X_12650_ _12650_/X _14230_/Q _12651_/B VPWR VGND sg13cmos5l_and2_1
XFILLER_71_888 VPWR VGND sg13cmos5l_decap_8
X_11601_ _11601_/Y _11601_/A _11601_/B VPWR VGND sg13cmos5l_nor2_1
X_14320_ _14320_/Q clkload65/A _14320_/D _14320_/RESET_B VPWR VGND sg13cmos5l_dfrbpq_1
X_12581_ _14408_/D _12594_/A _12581_/B VPWR VGND sg13cmos5l_nor2_1
XFILLER_8_915 VPWR VGND sg13cmos5l_fill_1
X_11532_ _11532_/Y _11575_/A _11553_/A VPWR VGND sg13cmos5l_xnor2_1
X_11463_ _11493_/A _11476_/A _11463_/B _11476_/C VPWR VGND sg13cmos5l_and3_1
X_14251_ _14251_/Q _14622_/CLK _14251_/D _14251_/RESET_B VPWR VGND sg13cmos5l_dfrbpq_1
X_10414_ _10414_/Y _10414_/A _10414_/B VPWR VGND sg13cmos5l_nor2_1
X_14182_ _14182_/Q _14217_/CLK _14182_/D _14182_/RESET_B VPWR VGND sg13cmos5l_dfrbpq_1
X_13202_ _13202_/Q clkload12/A _13202_/D fanout957/X VPWR VGND sg13cmos5l_dfrbpq_1
X_11394_ _11399_/A _11334_/A _11393_/X _11392_/X VPWR VGND sg13cmos5l_a21o_1
X_13133_ _14555_/D hold3550/X _08037_/B _13136_/S VPWR VGND sg13cmos5l_mux2_1
X_10345_ _10345_/Y _10345_/A _10345_/B VPWR VGND sg13cmos5l_nor2_1
X_10276_ _10276_/Y _10276_/A _10276_/B VPWR VGND sg13cmos5l_nor2_1
X_13064_ _14517_/D _13064_/A _13064_/B VPWR VGND sg13cmos5l_xnor2_1
X_12015_ _12015_/Y _14453_/Q _12380_/B VPWR VGND sg13cmos5l_nand2_1
XFILLER_78_465 VPWR VGND sg13cmos5l_decap_8
X_13684__1707 _13684_/RESET_B VPWR VGND sg13cmos5l_tiehi
XFILLER_48_81 VPWR VGND sg13cmos5l_fill_1
XFILLER_59_690 VPWR VGND sg13cmos5l_fill_1
XFILLER_66_649 VPWR VGND sg13cmos5l_decap_4
X_13720__1671 _13720_/RESET_B VPWR VGND sg13cmos5l_tiehi
X_13966_ _13966_/Q clkload56/A _13966_/D _13966_/RESET_B VPWR VGND sg13cmos5l_dfrbpq_1
XFILLER_46_362 VPWR VGND sg13cmos5l_decap_8
XFILLER_62_833 VPWR VGND sg13cmos5l_fill_1
XFILLER_80_107 VPWR VGND sg13cmos5l_fill_1
X_13897_ _13897_/Q clkload63/A _13897_/D _13897_/RESET_B VPWR VGND sg13cmos5l_dfrbpq_1
X_12917_ _12918_/A _14446_/Q _11262_/B _11302_/B _12923_/B2 VPWR VGND sg13cmos5l_a22oi_1
XFILLER_61_343 VPWR VGND sg13cmos5l_fill_2
X_14064__1327 _14064_/RESET_B VPWR VGND sg13cmos5l_tiehi
X_12848_ _12850_/A _12866_/A _12849_/C _12863_/A VPWR VGND sg13cmos5l_o21ai_1
X_12779_ _12779_/X _12891_/A1 _12585_/X _12739_/A VPWR VGND sg13cmos5l_a21o_1
X_14518_ _14518_/Q _14520_/CLK _14518_/D fanout972/X VPWR VGND sg13cmos5l_dfrbpq_1
X_14449_ _14449_/Q clkload65/A _14449_/D _14449_/RESET_B VPWR VGND sg13cmos5l_dfrbpq_1
X_09990_ _13760_/D _10577_/A1 _09989_/B _09989_/Y VPWR VGND sg13cmos5l_o21ai_1
Xhold3006 _10171_/A _13849_/Q VPWR VGND sg13cmos5l_dlygate4sd3_1
XFILLER_88_229 VPWR VGND sg13cmos5l_fill_1
X_08941_ _13255_/D _12334_/B _13188_/A2 _13196_/B1 _08940_/Y VPWR VGND sg13cmos5l_a22oi_1
Xhold3017 hold3017/X _13505_/Q VPWR VGND sg13cmos5l_dlygate4sd3_1
Xhold3028 hold3028/X _13510_/Q VPWR VGND sg13cmos5l_dlygate4sd3_1
Xhold3039 _10993_/B _14198_/Q VPWR VGND sg13cmos5l_dlygate4sd3_1
XFILLER_69_454 VPWR VGND sg13cmos5l_fill_2
X_08872_ _08873_/B _07661_/X _08848_/B _08869_/B hold2948/X VPWR VGND sg13cmos5l_a22oi_1
Xhold2305 _10074_/A _13802_/Q VPWR VGND sg13cmos5l_dlygate4sd3_1
Xhold2316 _09997_/A _13764_/Q VPWR VGND sg13cmos5l_dlygate4sd3_1
Xhold2327 _10515_/A _14018_/Q VPWR VGND sg13cmos5l_dlygate4sd3_1
XFILLER_69_476 VPWR VGND sg13cmos5l_fill_1
XFILLER_69_487 VPWR VGND sg13cmos5l_decap_8
X_07823_ _07823_/Y _07823_/A _12415_/A VPWR VGND sg13cmos5l_nor2_1
Xhold2338 _11529_/A _14336_/Q VPWR VGND sg13cmos5l_dlygate4sd3_1
Xhold2349 _10715_/A _14132_/Q VPWR VGND sg13cmos5l_dlygate4sd3_1
XFILLER_57_649 VPWR VGND sg13cmos5l_decap_8
XFILLER_84_468 VPWR VGND sg13cmos5l_fill_1
X_07754_ _07754_/Y _14388_/Q _14356_/Q VPWR VGND sg13cmos5l_nand2b_1
XFILLER_37_384 VPWR VGND sg13cmos5l_fill_1
X_07685_ _07685_/Y _14388_/Q _14356_/Q VPWR VGND sg13cmos5l_nand2_1
XFILLER_37_395 VPWR VGND sg13cmos5l_fill_1
X_09424_ _09424_/X _14112_/Q hold3306/X _09438_/S VPWR VGND sg13cmos5l_mux2_1
Xclkbuf_leaf_91_clk clkload25/A clkload1/A VPWR VGND sg13cmos5l_buf_8
X_09355_ _09355_/X _14109_/Q hold3393/X _09368_/S VPWR VGND sg13cmos5l_mux2_1
X_08306_ _14264_/D _08430_/B _12624_/A _08294_/Y VPWR VGND sg13cmos5l_o21ai_1
X_09286_ _09286_/Y _09286_/A _09306_/S VPWR VGND sg13cmos5l_nor2_1
X_08237_ _08237_/X _08238_/S _13443_/Q VPWR VGND sg13cmos5l_or2_1
XFILLER_5_918 VPWR VGND sg13cmos5l_fill_2
X_13762__1629 _13762_/RESET_B VPWR VGND sg13cmos5l_tiehi
X_08168_ _08168_/Y _08168_/A _12639_/B VPWR VGND sg13cmos5l_nor2_1
X_08099_ _08100_/C _09443_/A _08095_/Y _08111_/B _08068_/A VPWR VGND sg13cmos5l_a22oi_1
X_10130_ _13829_/D _10587_/A1 _10143_/B _10129_/Y VPWR VGND sg13cmos5l_o21ai_1
XFILLER_0_656 VPWR VGND sg13cmos5l_fill_2
XFILLER_76_903 VPWR VGND sg13cmos5l_decap_8
X_10061_ _13795_/D _10583_/A1 _10072_/B _10060_/Y VPWR VGND sg13cmos5l_o21ai_1
Xhold3540 hold3540/X _14542_/Q VPWR VGND sg13cmos5l_dlygate4sd3_1
Xhold3551 hold3551/X _14456_/Q VPWR VGND sg13cmos5l_dlygate4sd3_1
XFILLER_75_402 VPWR VGND sg13cmos5l_fill_2
Xhold2850 _10276_/A _13901_/Q VPWR VGND sg13cmos5l_dlygate4sd3_1
Xhold3562 hold3562/X _13207_/Q VPWR VGND sg13cmos5l_dlygate4sd3_1
XFILLER_102_595 VPWR VGND sg13cmos5l_fill_1
XFILLER_29_830 VPWR VGND sg13cmos5l_fill_1
Xhold2861 _10305_/A _13915_/Q VPWR VGND sg13cmos5l_dlygate4sd3_1
Xhold2872 _10402_/A _13963_/Q VPWR VGND sg13cmos5l_dlygate4sd3_1
Xhold2883 _13084_/A _14526_/Q VPWR VGND sg13cmos5l_dlygate4sd3_1
XFILLER_47_148 VPWR VGND sg13cmos5l_fill_1
XFILLER_75_457 VPWR VGND sg13cmos5l_decap_8
Xhold2894 _11129_/A _14300_/Q VPWR VGND sg13cmos5l_dlygate4sd3_1
X_13820_ _13820_/Q clkload46/A _13820_/D _13820_/RESET_B VPWR VGND sg13cmos5l_dfrbpq_1
XFILLER_16_513 VPWR VGND sg13cmos5l_fill_1
XFILLER_44_822 VPWR VGND sg13cmos5l_fill_1
XFILLER_84_980 VPWR VGND sg13cmos5l_fill_2
X_10963_ _10963_/Y _14222_/Q _10963_/B _10963_/C VPWR VGND sg13cmos5l_nor3_1
X_13751_ _13751_/Q _14299_/CLK _13751_/D _13751_/RESET_B VPWR VGND sg13cmos5l_dfrbpq_1
X_13395__2027 _13395_/RESET_B VPWR VGND sg13cmos5l_tiehi
XFILLER_16_557 VPWR VGND sg13cmos5l_fill_1
XFILLER_71_652 VPWR VGND sg13cmos5l_decap_4
Xclkbuf_leaf_82_clk clkload48/A clkbuf_4_8_0_clk/X VPWR VGND sg13cmos5l_buf_8
X_12702_ _12743_/A _14449_/Q _13239_/Q VPWR VGND sg13cmos5l_xor2_1
XFILLER_31_516 VPWR VGND sg13cmos5l_decap_8
X_10894_ _10895_/B _14254_/D _14255_/D _14256_/D _10894_/D VPWR VGND sg13cmos5l_nor4_1
X_13682_ _13682_/Q _14631_/CLK _13682_/D _13682_/RESET_B VPWR VGND sg13cmos5l_dfrbpq_1
X_12633_ _12634_/D _12648_/B _12646_/B _12633_/C VPWR VGND sg13cmos5l_nand3_1
X_12564_ _12564_/Y _12548_/Y _12561_/Y _12563_/Y VPWR VGND sg13cmos5l_o21ai_1
XFILLER_102_1008 VPWR VGND sg13cmos5l_decap_8
X_11515_ _11515_/Y _11515_/A _11517_/B VPWR VGND sg13cmos5l_nand2_1
X_14303_ _14303_/Q clkload25/A _14303_/D _14303_/RESET_B VPWR VGND sg13cmos5l_dfrbpq_1
XFILLER_11_295 VPWR VGND sg13cmos5l_fill_1
XFILLER_7_233 VPWR VGND sg13cmos5l_fill_1
X_14234_ _14234_/Q _14622_/CLK _14234_/D _14234_/RESET_B VPWR VGND sg13cmos5l_dfrbpq_1
X_13738__1653 _13738_/RESET_B VPWR VGND sg13cmos5l_tiehi
X_12495_ _12498_/A _12495_/A _12503_/B VPWR VGND sg13cmos5l_nand2_1
X_11446_ _11446_/Y _11442_/Y _11444_/Y _11445_/X _11444_/A _11615_/C1 VPWR VGND sg13cmos5l_a221oi_1
X_11377_ _11387_/B _14175_/Q _11401_/C VPWR VGND sg13cmos5l_xnor2_1
X_14165_ _14165_/Q clkload22/A _14165_/D fanout991/X VPWR VGND sg13cmos5l_dfrbpq_1
X_13426__1996 _13426_/RESET_B VPWR VGND sg13cmos5l_tiehi
X_10328_ _13926_/D fanout80/X _10343_/B _10327_/Y VPWR VGND sg13cmos5l_a21oi_1
X_14096_ _14096_/Q clkload66/A _14096_/D _14096_/RESET_B VPWR VGND sg13cmos5l_dfrbpq_1
X_13116_ _14544_/D hold3536/X _08042_/B _13118_/S VPWR VGND sg13cmos5l_mux2_1
X_13047_ _14509_/D _13047_/A _13049_/C VPWR VGND sg13cmos5l_xor2_1
XFILLER_66_402 VPWR VGND sg13cmos5l_decap_8
XFILLER_67_914 VPWR VGND sg13cmos5l_fill_1
XFILLER_67_936 VPWR VGND sg13cmos5l_decap_4
X_10259_ _13892_/D _10585_/A1 _10280_/B _10258_/Y VPWR VGND sg13cmos5l_a21oi_1
XFILLER_38_104 VPWR VGND sg13cmos5l_fill_2
XFILLER_94_755 VPWR VGND sg13cmos5l_decap_8
XFILLER_81_405 VPWR VGND sg13cmos5l_fill_2
XFILLER_82_906 VPWR VGND sg13cmos5l_decap_4
XFILLER_62_641 VPWR VGND sg13cmos5l_decap_4
XFILLER_90_950 VPWR VGND sg13cmos5l_fill_1
Xclkbuf_leaf_73_clk clkload55/A clkbuf_4_10_0_clk/X VPWR VGND sg13cmos5l_buf_8
X_13949_ _13949_/Q _14042_/CLK _13949_/D _13949_/RESET_B VPWR VGND sg13cmos5l_dfrbpq_1
X_07470_ _07470_/X _07470_/A _07470_/B _07470_/C _07470_/D VPWR VGND sg13cmos5l_and4_1
X_09140_ _09140_/Y _14428_/Q _11450_/A VPWR VGND sg13cmos5l_nand2_1
X_09071_ _09071_/Y _09071_/A _09071_/B VPWR VGND sg13cmos5l_nor2_1
X_08022_ _08042_/B _08989_/A _10807_/A _08021_/Y VPWR VGND sg13cmos5l_o21ai_1
X_09973_ _09973_/Y _09973_/A _09977_/B VPWR VGND sg13cmos5l_nand2_1
X_08924_ _08924_/Y _14262_/Q _13195_/B1 _08938_/B1 VPWR VGND sg13cmos5l_a21oi_1
XFILLER_57_424 VPWR VGND sg13cmos5l_fill_2
X_08855_ _14641_/D _08855_/A VPWR VGND sg13cmos5l_inv_1
XFILLER_45_608 VPWR VGND sg13cmos5l_fill_1
XFILLER_84_254 VPWR VGND sg13cmos5l_fill_1
X_07806_ _07806_/Y _08609_/B _07804_/Y _08602_/B VPWR VGND sg13cmos5l_o21ai_1
X_08786_ _08786_/Y _13149_/A1 _07342_/Y _08785_/Y VPWR VGND sg13cmos5l_o21ai_1
X_07737_ _08476_/B _07736_/A _07736_/B _08473_/A VPWR VGND sg13cmos5l_o21ai_1
XFILLER_81_961 VPWR VGND sg13cmos5l_fill_1
Xclkbuf_leaf_64_clk _14640_/CLK clkbuf_4_14_0_clk/X VPWR VGND sg13cmos5l_buf_8
X_13816__1575 _13816_/RESET_B VPWR VGND sg13cmos5l_tiehi
XFILLER_80_471 VPWR VGND sg13cmos5l_fill_1
XFILLER_81_972 VPWR VGND sg13cmos5l_decap_4
X_07668_ _08582_/A _07666_/X _08551_/C VPWR VGND sg13cmos5l_nand2b_1
X_07599_ _07606_/B _07599_/A _07613_/A VPWR VGND sg13cmos5l_nor2_1
X_09407_ _09407_/X _14128_/Q hold3288/X _09408_/S VPWR VGND sg13cmos5l_mux2_1
XFILLER_40_357 VPWR VGND sg13cmos5l_fill_2
XFILLER_40_368 VPWR VGND sg13cmos5l_fill_2
X_09338_ _13454_/D _09302_/A hold3144/X _09338_/S VPWR VGND sg13cmos5l_mux2_1
X_09269_ _09269_/Y _09410_/A _09309_/B VPWR VGND sg13cmos5l_nand2_1
X_11300_ _11312_/B _11331_/A _11327_/A _11300_/C VPWR VGND sg13cmos5l_or3_1
X_12280_ _14367_/D _12248_/A _12385_/A _12279_/Y VPWR VGND sg13cmos5l_a21oi_1
XFILLER_105_2 VPWR VGND sg13cmos5l_fill_1
XFILLER_106_131 VPWR VGND sg13cmos5l_fill_1
XFILLER_20_41 VPWR VGND sg13cmos5l_fill_2
X_11231_ _11231_/Y _08914_/B _11228_/B _12913_/B2 VPWR VGND sg13cmos5l_o21ai_1
X_11162_ _11162_/Y _11160_/Y _11161_/Y _11149_/Y VPWR VGND sg13cmos5l_o21ai_1
XFILLER_1_943 VPWR VGND sg13cmos5l_decap_8
X_10113_ _10113_/Y _10113_/A _10119_/B VPWR VGND sg13cmos5l_nand2_1
XFILLER_96_56 VPWR VGND sg13cmos5l_fill_2
X_11093_ _11093_/Y _11093_/A _11093_/B VPWR VGND sg13cmos5l_nor2_1
Xhold3370 hold3370/X _13566_/Q VPWR VGND sg13cmos5l_dlygate4sd3_1
XFILLER_0_497 VPWR VGND sg13cmos5l_fill_2
X_10044_ _10044_/Y _10044_/A _10044_/B VPWR VGND sg13cmos5l_nand2_1
Xhold3392 _12323_/A _14368_/Q VPWR VGND sg13cmos5l_dlygate4sd3_1
Xhold3381 _10881_/A _14192_/Q VPWR VGND sg13cmos5l_dlygate4sd3_1
XFILLER_36_619 VPWR VGND sg13cmos5l_fill_2
Xhold2680 _09750_/A _13644_/Q VPWR VGND sg13cmos5l_dlygate4sd3_1
Xhold2691 _09594_/A _13603_/Q VPWR VGND sg13cmos5l_dlygate4sd3_1
XFILLER_29_671 VPWR VGND sg13cmos5l_fill_1
XFILLER_63_416 VPWR VGND sg13cmos5l_fill_2
X_13803_ _13803_/Q clkload62/A _13803_/D _13803_/RESET_B VPWR VGND sg13cmos5l_dfrbpq_1
XFILLER_16_310 VPWR VGND sg13cmos5l_fill_1
XFILLER_28_170 VPWR VGND sg13cmos5l_fill_1
XFILLER_72_950 VPWR VGND sg13cmos5l_fill_2
XFILLER_91_747 VPWR VGND sg13cmos5l_decap_8
X_11995_ _12017_/B _11995_/A _12021_/B VPWR VGND sg13cmos5l_nor2b_1
Xclkbuf_leaf_55_clk clkload76/A clkbuf_4_14_0_clk/X VPWR VGND sg13cmos5l_buf_8
XFILLER_90_268 VPWR VGND sg13cmos5l_fill_2
XFILLER_91_1018 VPWR VGND sg13cmos5l_decap_8
X_10946_ _10946_/X _10946_/A _10946_/B _10946_/C VPWR VGND sg13cmos5l_or3_1
X_13734_ _13734_/Q clkload57/A _13734_/D _13734_/RESET_B VPWR VGND sg13cmos5l_dfrbpq_1
X_10877_ _10877_/Y _10877_/A _10909_/B VPWR VGND sg13cmos5l_nand2_1
X_13665_ _13665_/Q clkload58/A _13665_/D _13665_/RESET_B VPWR VGND sg13cmos5l_dfrbpq_1
X_12616_ _12631_/A _14442_/Q _13232_/Q VPWR VGND sg13cmos5l_nor2_1
XFILLER_40_880 VPWR VGND sg13cmos5l_fill_1
X_13596_ _13596_/Q clkload46/A _13596_/D _13596_/RESET_B VPWR VGND sg13cmos5l_dfrbpq_1
XFILLER_8_564 VPWR VGND sg13cmos5l_fill_2
X_13513__1909 _13513_/RESET_B VPWR VGND sg13cmos5l_tiehi
X_12547_ _14405_/D _07823_/A _12541_/B _12545_/Y _12546_/Y VPWR VGND sg13cmos5l_a22oi_1
XANTENNA_3 ui_in[11] VPWR VGND sg13cmos5l_antennanp
X_12478_ _14387_/D _12485_/B _12477_/Y _12475_/Y VPWR VGND sg13cmos5l_o21ai_1
X_11429_ _11429_/Y _11402_/Y _11416_/B _11430_/B VPWR VGND sg13cmos5l_a21oi_1
X_14217_ _14217_/Q _14217_/CLK _14217_/D _14217_/RESET_B VPWR VGND sg13cmos5l_dfrbpq_1
X_14148_ _14148_/Q _14576_/CLK _14148_/D fanout991/X VPWR VGND sg13cmos5l_dfrbpq_1
X_14079_ _14079_/Q _14520_/CLK _14079_/D fanout972/X VPWR VGND sg13cmos5l_dfrbpq_1
XFILLER_94_541 VPWR VGND sg13cmos5l_fill_2
X_08640_ _08640_/X _12468_/A _14176_/Q _08638_/X VPWR VGND sg13cmos5l_a21o_1
X_08571_ _08571_/X _08875_/A _08571_/B VPWR VGND sg13cmos5l_or2_1
Xclkbuf_leaf_46_clk _14614_/CLK clkload6/A VPWR VGND sg13cmos5l_buf_8
XFILLER_63_961 VPWR VGND sg13cmos5l_fill_1
X_07522_ _07523_/A _13557_/Q _13525_/Q _13493_/Q _13461_/Q _07522_/S0 _07522_/S1 VPWR
+ VGND sg13cmos5l_mux4_1
X_14579__2122 _14579_/RESET_B VPWR VGND sg13cmos5l_tiehi
XFILLER_62_482 VPWR VGND sg13cmos5l_fill_2
X_07453_ _07454_/D _14070_/Q _07465_/B _07530_/A2 _13214_/Q VPWR VGND sg13cmos5l_a22oi_1
X_07384_ _07594_/A _08995_/A _14545_/Q VPWR VGND sg13cmos5l_xnor2_1
X_09123_ _09123_/Y _11422_/A _09122_/Y _09135_/B1 VPWR VGND sg13cmos5l_a21oi_1
X_09054_ _09054_/Y _09054_/A _09060_/B VPWR VGND sg13cmos5l_nor2_1
X_08005_ _08005_/Y _13140_/A _08005_/B _08092_/B VPWR VGND sg13cmos5l_nor3_1
XFILLER_2_718 VPWR VGND sg13cmos5l_fill_1
XFILLER_103_123 VPWR VGND sg13cmos5l_fill_1
X_09956_ _09956_/Y _09956_/A _09956_/B VPWR VGND sg13cmos5l_nor2_1
X_08907_ _14655_/D _08907_/A _08907_/B _08907_/C VPWR VGND sg13cmos5l_nand3_1
X_09887_ _13710_/D fanout73/X _09886_/B _09886_/Y VPWR VGND sg13cmos5l_a21oi_1
X_08838_ _08842_/A _08838_/A _08908_/B VPWR VGND sg13cmos5l_nand2_1
XFILLER_100_885 VPWR VGND sg13cmos5l_decap_4
XFILLER_46_939 VPWR VGND sg13cmos5l_fill_2
XFILLER_58_799 VPWR VGND sg13cmos5l_decap_4
XFILLER_73_747 VPWR VGND sg13cmos5l_decap_8
X_08769_ _08769_/Y _08781_/A1 _14154_/Q _13263_/Q _08781_/B2 VPWR VGND sg13cmos5l_a22oi_1
Xclkbuf_leaf_37_clk clkload38/A clkbuf_4_6_0_clk/X VPWR VGND sg13cmos5l_buf_8
X_10800_ _10800_/Y _10772_/B _10798_/Y _10799_/Y VPWR VGND sg13cmos5l_o21ai_1
X_11780_ _11780_/Y _13690_/Q _11780_/B VPWR VGND sg13cmos5l_nand2_1
X_10731_ _10731_/Y _10751_/B _10729_/Y _10730_/Y VPWR VGND sg13cmos5l_o21ai_1
XFILLER_15_74 VPWR VGND sg13cmos5l_fill_2
X_13450_ _13450_/Q clkload42/A _13450_/D _13450_/RESET_B VPWR VGND sg13cmos5l_dfrbpq_1
X_10662_ _10662_/Y _10894_/D _14268_/D VPWR VGND sg13cmos5l_nor2_1
X_12401_ _12401_/Y _13968_/Q _12397_/B _12401_/B1 _13712_/Q VPWR VGND sg13cmos5l_a22oi_1
X_10593_ _14056_/D _10593_/A1 _10610_/B _10592_/Y VPWR VGND sg13cmos5l_o21ai_1
X_13381_ _13381_/Q clkload35/A _13381_/D _13381_/RESET_B VPWR VGND sg13cmos5l_dfrbpq_1
X_12332_ _12332_/Y _14369_/Q _13254_/Q _12284_/C _12330_/C _12331_/Y VPWR VGND sg13cmos5l_a221oi_1
X_12263_ _12263_/Y _12263_/A _12263_/B _12263_/C VPWR VGND sg13cmos5l_nand3_1
X_11214_ _11256_/A _11214_/A _11214_/B _11214_/C _11214_/D VPWR VGND sg13cmos5l_and4_1
X_14002_ _14002_/Q clkload53/A _14002_/D _14002_/RESET_B VPWR VGND sg13cmos5l_dfrbpq_1
X_12194_ _12194_/Y _12286_/A _12189_/Y _12192_/Y _12193_/Y _12191_/Y VPWR VGND sg13cmos5l_a221oi_1
Xoutput40 uo_out[10] _08776_/Y VPWR VGND sg13cmos5l_buf_1
Xoutput51 uo_out[6] _08768_/Y VPWR VGND sg13cmos5l_buf_1
X_11145_ _14305_/D _11145_/A1 _11143_/Y _11144_/Y VPWR VGND sg13cmos5l_a21oi_1
X_11076_ _11076_/Y _14386_/Q _11088_/A2 _11075_/X VPWR VGND sg13cmos5l_a21oi_1
XFILLER_76_541 VPWR VGND sg13cmos5l_fill_1
XFILLER_76_552 VPWR VGND sg13cmos5l_fill_1
X_10027_ _13778_/D _10549_/A1 _10042_/B _10026_/Y VPWR VGND sg13cmos5l_o21ai_1
X_15884_ _15884_/X _15884_/A VPWR VGND sg13cmos5l_buf_1
XFILLER_52_909 VPWR VGND sg13cmos5l_decap_4
Xclkbuf_leaf_28_clk _13568_/CLK clkload2/A VPWR VGND sg13cmos5l_buf_8
X_11978_ _11979_/B _12097_/A1 _11974_/Y _11977_/Y VPWR VGND sg13cmos5l_o21ai_1
X_10929_ _10929_/Y _14256_/Q _14255_/Q _14254_/Q VPWR VGND sg13cmos5l_nand3b_1
X_13717_ _13717_/Q clkload16/A _13717_/D _13717_/RESET_B VPWR VGND sg13cmos5l_dfrbpq_1
X_13648_ _13648_/Q _14064_/CLK _13648_/D _13648_/RESET_B VPWR VGND sg13cmos5l_dfrbpq_1
X_13579_ _13579_/Q _14238_/CLK _13579_/D _13579_/RESET_B VPWR VGND sg13cmos5l_dfrbpq_1
XFILLER_8_372 VPWR VGND sg13cmos5l_fill_1
XFILLER_87_806 VPWR VGND sg13cmos5l_decap_8
XFILLER_87_828 VPWR VGND sg13cmos5l_decap_4
X_09810_ _13672_/D _10397_/A1 _09825_/B _09809_/Y VPWR VGND sg13cmos5l_a21oi_1
Xfanout329 _09758_/B _09760_/B VPWR VGND sg13cmos5l_buf_1
Xfanout318 _09825_/B fanout320/X VPWR VGND sg13cmos5l_buf_1
Xfanout307 _09862_/B _09890_/B VPWR VGND sg13cmos5l_buf_1
XFILLER_98_176 VPWR VGND sg13cmos5l_fill_1
X_09741_ _13639_/D _10395_/A1 _09748_/B _09740_/Y VPWR VGND sg13cmos5l_a21oi_1
X_13390__2032 _13390_/RESET_B VPWR VGND sg13cmos5l_tiehi
XFILLER_28_928 VPWR VGND sg13cmos5l_fill_2
XFILLER_55_725 VPWR VGND sg13cmos5l_decap_8
X_09672_ _09672_/Y _09691_/A _11561_/B _09676_/B _09671_/Y VPWR VGND sg13cmos5l_a22oi_1
XFILLER_55_747 VPWR VGND sg13cmos5l_fill_2
XFILLER_94_382 VPWR VGND sg13cmos5l_fill_2
X_08623_ _14612_/D _08623_/A _08623_/B VPWR VGND sg13cmos5l_xnor2_1
Xclkbuf_leaf_19_clk clkload27/A clkbuf_4_4_0_clk/X VPWR VGND sg13cmos5l_buf_8
X_08554_ _08554_/Y _08559_/A _08554_/B VPWR VGND sg13cmos5l_nand2_1
XFILLER_23_611 VPWR VGND sg13cmos5l_fill_2
XFILLER_35_471 VPWR VGND sg13cmos5l_fill_2
X_07505_ _07505_/Y _10681_/A1 _08199_/A1 _11040_/A VPWR VGND sg13cmos5l_a21oi_1
XFILLER_11_806 VPWR VGND sg13cmos5l_fill_2
X_08485_ _08485_/Y _14382_/Q _11765_/A _08498_/A VPWR VGND sg13cmos5l_a21oi_1
X_07436_ _07436_/Y _08964_/A _12963_/A _07436_/C VPWR VGND sg13cmos5l_nor3_1
X_07367_ _12963_/B _14308_/Q _14307_/Q _14310_/Q _14309_/Q VPWR VGND sg13cmos5l_nor4_1
XFILLER_6_309 VPWR VGND sg13cmos5l_fill_1
X_09106_ _09106_/Y _14358_/Q _09106_/A2 _09105_/Y VPWR VGND sg13cmos5l_a21oi_1
X_07298_ _07298_/Y _14625_/Q VPWR VGND sg13cmos5l_inv_1
X_09037_ _09037_/Y _11668_/A _09065_/A2 _09036_/Y VPWR VGND sg13cmos5l_a21oi_1
XFILLER_105_911 VPWR VGND sg13cmos5l_decap_8
XFILLER_105_988 VPWR VGND sg13cmos5l_decap_8
XFILLER_77_305 VPWR VGND sg13cmos5l_fill_2
XFILLER_81_1028 VPWR VGND sg13cmos5l_fill_1
Xfanout852 _10877_/A _14256_/Q VPWR VGND sg13cmos5l_buf_1
Xfanout841 _12093_/A _14360_/Q VPWR VGND sg13cmos5l_buf_1
Xfanout830 _11151_/B _14565_/Q VPWR VGND sg13cmos5l_buf_1
XFILLER_77_349 VPWR VGND sg13cmos5l_fill_1
X_09939_ _13735_/D _10591_/A1 _09948_/B _09938_/Y VPWR VGND sg13cmos5l_a21oi_1
Xfanout885 _08397_/A _14129_/Q VPWR VGND sg13cmos5l_buf_1
Xfanout874 _11258_/A _11275_/A VPWR VGND sg13cmos5l_buf_1
Xfanout863 _10978_/B _14222_/Q VPWR VGND sg13cmos5l_buf_1
Xclkbuf_4_13_0_clk clkload6/A clkbuf_0_clk/X VPWR VGND sg13cmos5l_buf_8
XFILLER_73_511 VPWR VGND sg13cmos5l_decap_8
XFILLER_85_371 VPWR VGND sg13cmos5l_fill_2
XFILLER_86_872 VPWR VGND sg13cmos5l_decap_8
Xfanout896 _08257_/A _14118_/Q VPWR VGND sg13cmos5l_buf_1
X_12950_ _14462_/D _12950_/A VPWR VGND sg13cmos5l_inv_1
X_11901_ _11901_/Y _11901_/A _11901_/B _11903_/B VPWR VGND sg13cmos5l_nor3_1
X_12881_ _14435_/D _12878_/X _12880_/Y _12893_/B1 VPWR VGND sg13cmos5l_a21oi_1
X_11832_ _11832_/Y _13916_/Q _11939_/B _11862_/B _13660_/Q VPWR VGND sg13cmos5l_a22oi_1
X_14620_ _14620_/Q _14622_/CLK _14620_/D _14620_/RESET_B VPWR VGND sg13cmos5l_dfrbpq_1
XFILLER_42_931 VPWR VGND sg13cmos5l_fill_1
XFILLER_73_588 VPWR VGND sg13cmos5l_fill_1
X_14551_ _14551_/Q clkload12/A _14551_/D fanout963/X VPWR VGND sg13cmos5l_dfrbpq_1
X_11763_ _11763_/Y _11762_/Y _11763_/B VPWR VGND sg13cmos5l_nand2b_1
XFILLER_14_677 VPWR VGND sg13cmos5l_fill_2
XFILLER_41_474 VPWR VGND sg13cmos5l_fill_1
X_10714_ _10714_/Y _10774_/A _14276_/Q VPWR VGND sg13cmos5l_nand2_1
X_11694_ _11694_/Y _13783_/Q _11702_/B _11727_/B VPWR VGND sg13cmos5l_a21oi_1
X_14482_ _14482_/Q _14576_/CLK _14482_/D fanout978/X VPWR VGND sg13cmos5l_dfrbpq_1
X_13502_ _13502_/Q clkload32/A _13502_/D _13502_/RESET_B VPWR VGND sg13cmos5l_dfrbpq_1
X_10645_ _10646_/B _14078_/Q _10647_/D _14079_/Q VPWR VGND sg13cmos5l_a21o_1
X_13433_ _13433_/Q _14102_/CLK _13433_/D _13433_/RESET_B VPWR VGND sg13cmos5l_dfrbpq_1
X_13364_ _13364_/Q clkload27/A _13364_/D _13364_/RESET_B VPWR VGND sg13cmos5l_dfrbpq_1
X_10576_ _10576_/Y _10576_/A _10576_/B VPWR VGND sg13cmos5l_nand2_1
X_12315_ _12315_/Y _13933_/Q _12319_/A2 _12317_/B _13613_/Q VPWR VGND sg13cmos5l_a22oi_1
XFILLER_5_342 VPWR VGND sg13cmos5l_fill_1
X_13295_ _13295_/Q clkload19/A _13295_/D fanout981/X VPWR VGND sg13cmos5l_dfrbpq_1
X_12246_ _12519_/B _12239_/Y _12244_/Y _12245_/Y _12231_/Y VPWR VGND sg13cmos5l_a22oi_1
X_12177_ _12177_/Y _13832_/Q _12401_/B1 _12402_/C1 VPWR VGND sg13cmos5l_a21oi_1
XFILLER_3_33 VPWR VGND sg13cmos5l_fill_1
X_11128_ _11128_/Y _14383_/Q _11143_/A2 _11093_/B _14399_/Q _11063_/X VPWR VGND sg13cmos5l_a221oi_1
X_13775__1616 _13775_/RESET_B VPWR VGND sg13cmos5l_tiehi
X_13811__1580 _13811_/RESET_B VPWR VGND sg13cmos5l_tiehi
X_13463__1959 _13463_/RESET_B VPWR VGND sg13cmos5l_tiehi
XFILLER_36_202 VPWR VGND sg13cmos5l_fill_1
X_11059_ _11152_/A _11143_/A2 _11083_/B VPWR VGND sg13cmos5l_nand2b_1
XFILLER_76_382 VPWR VGND sg13cmos5l_decap_8
XFILLER_37_769 VPWR VGND sg13cmos5l_fill_2
XFILLER_92_864 VPWR VGND sg13cmos5l_decap_8
X_13990__1401 _13990_/RESET_B VPWR VGND sg13cmos5l_tiehi
XFILLER_33_920 VPWR VGND sg13cmos5l_fill_1
X_08270_ _08270_/X _13510_/Q _13478_/Q _08275_/S VPWR VGND sg13cmos5l_mux2_1
X_07221_ _12192_/A _14364_/Q VPWR VGND sg13cmos5l_inv_1
XFILLER_73_0 VPWR VGND sg13cmos5l_fill_2
Xclkbuf_leaf_8_clk _14292_/CLK clkload0/A VPWR VGND sg13cmos5l_buf_8
Xfanout104 _08994_/B _07640_/B1 VPWR VGND sg13cmos5l_buf_1
Xfanout137 _10675_/S _07998_/Y VPWR VGND sg13cmos5l_buf_1
Xfanout126 _09408_/S _09377_/Y VPWR VGND sg13cmos5l_buf_1
Xfanout115 _09475_/S _09474_/S VPWR VGND sg13cmos5l_buf_1
XFILLER_59_338 VPWR VGND sg13cmos5l_decap_8
X_07985_ _07985_/X _07985_/A _08409_/B VPWR VGND sg13cmos5l_and2_1
Xfanout159 _10781_/B fanout163/X VPWR VGND sg13cmos5l_buf_1
Xfanout148 _09033_/S _09030_/B VPWR VGND sg13cmos5l_buf_1
X_09724_ _09724_/Y _09724_/A _09724_/B VPWR VGND sg13cmos5l_nor2_1
X_13439__1983 _13439_/RESET_B VPWR VGND sg13cmos5l_tiehi
X_09655_ _09655_/Y _09655_/A _09655_/B VPWR VGND sg13cmos5l_nor2_1
X_08606_ _08606_/Y _08625_/A _08606_/B VPWR VGND sg13cmos5l_nand2_1
XFILLER_24_920 VPWR VGND sg13cmos5l_fill_1
X_09586_ _13601_/D _09587_/B _10514_/A1 _09585_/Y VPWR VGND sg13cmos5l_a21oi_1
XFILLER_70_569 VPWR VGND sg13cmos5l_decap_8
X_08537_ _08538_/B _08536_/A _07762_/Y _08536_/Y VPWR VGND sg13cmos5l_a21oi_1
XFILLER_11_614 VPWR VGND sg13cmos5l_decap_4
X_08468_ _08469_/B _08471_/A _07734_/X _08467_/Y VPWR VGND sg13cmos5l_a21oi_1
X_07419_ _07420_/C _14577_/Q _10780_/A VPWR VGND sg13cmos5l_nand2_1
X_08399_ _08399_/Y _08398_/S _07323_/Y _08404_/B1 VPWR VGND sg13cmos5l_a21oi_1
X_10430_ _10430_/Y _10430_/A _10466_/B VPWR VGND sg13cmos5l_nor2_1
X_13999__1392 _13999_/RESET_B VPWR VGND sg13cmos5l_tiehi
X_13853__1538 _13853_/RESET_B VPWR VGND sg13cmos5l_tiehi
X_10361_ _13942_/D _10361_/A1 _10374_/B _10360_/Y VPWR VGND sg13cmos5l_a21oi_1
X_10292_ _13908_/D _10357_/A1 _10295_/B _10291_/Y VPWR VGND sg13cmos5l_a21oi_1
X_12100_ _12134_/A _12100_/A _12100_/B VPWR VGND sg13cmos5l_nor2_1
X_13080_ _13101_/C _14524_/Q _14525_/Q _13080_/C VPWR VGND sg13cmos5l_and3_1
XFILLER_2_334 VPWR VGND sg13cmos5l_fill_1
XFILLER_3_879 VPWR VGND sg13cmos5l_fill_1
X_12031_ _12033_/B _13923_/Q _12348_/A2 _12349_/C1 VPWR VGND sg13cmos5l_a21oi_1
Xfanout660 _10692_/S _10694_/S VPWR VGND sg13cmos5l_buf_1
Xfanout693 _09112_/A2 _09135_/B1 VPWR VGND sg13cmos5l_buf_1
Xfanout682 _11374_/A _11408_/A VPWR VGND sg13cmos5l_buf_1
Xfanout671 _13188_/A2 _08943_/A2 VPWR VGND sg13cmos5l_buf_1
X_13982_ _13982_/Q clkload63/A _13982_/D _13982_/RESET_B VPWR VGND sg13cmos5l_dfrbpq_1
XFILLER_59_894 VPWR VGND sg13cmos5l_fill_1
XFILLER_86_691 VPWR VGND sg13cmos5l_fill_1
X_12933_ _12934_/A _14454_/Q _11358_/B _11403_/B _12933_/B2 VPWR VGND sg13cmos5l_a22oi_1
XFILLER_37_94 VPWR VGND sg13cmos5l_fill_2
XFILLER_61_536 VPWR VGND sg13cmos5l_decap_8
X_12864_ _12865_/A _12832_/B _12864_/B _12864_/C VPWR VGND sg13cmos5l_nand3b_1
X_11815_ _12663_/B _14350_/Q _11867_/B VPWR VGND sg13cmos5l_nand2_1
X_14603_ _14603_/Q clkload75/A _14603_/D _14603_/RESET_B VPWR VGND sg13cmos5l_dfrbpq_1
X_12795_ _14426_/D _12150_/Y _12794_/Y _12755_/A VPWR VGND sg13cmos5l_a21oi_1
XFILLER_53_60 VPWR VGND sg13cmos5l_fill_1
X_11746_ _11747_/C _13849_/Q _11754_/B2 _08725_/B _13657_/Q VPWR VGND sg13cmos5l_a22oi_1
X_14534_ _14534_/Q clkload14/A _14534_/D fanout973/X VPWR VGND sg13cmos5l_dfrbpq_1
X_11677_ _14346_/D _11676_/Y hold3032/X _11708_/A VPWR VGND sg13cmos5l_mux2_1
X_14465_ _14465_/Q _14654_/CLK _14465_/D _14465_/RESET_B VPWR VGND sg13cmos5l_dfrbpq_1
X_10628_ _14070_/D _10630_/B _10628_/B VPWR VGND sg13cmos5l_and2_1
X_14396_ _14396_/Q clkload75/A _14396_/D _14396_/RESET_B VPWR VGND sg13cmos5l_dfrbpq_1
X_13829__1562 _13829_/RESET_B VPWR VGND sg13cmos5l_tiehi
X_13416_ _13416_/Q clkload28/A _13416_/D _13416_/RESET_B VPWR VGND sg13cmos5l_dfrbpq_1
X_10559_ _14039_/D _10559_/A1 _10564_/B _10558_/Y VPWR VGND sg13cmos5l_o21ai_1
X_13347_ _13347_/Q clkload37/A _13347_/D _13347_/RESET_B VPWR VGND sg13cmos5l_dfrbpq_1
X_14340__1168 _14340_/RESET_B VPWR VGND sg13cmos5l_tiehi
X_13278_ _13278_/Q clkload18/A _13278_/D fanout981/X VPWR VGND sg13cmos5l_dfrbpq_1
XFILLER_5_194 VPWR VGND sg13cmos5l_decap_4
X_12229_ _12229_/Y _13770_/Q _12237_/B VPWR VGND sg13cmos5l_nand2_1
XFILLER_69_614 VPWR VGND sg13cmos5l_fill_2
Xhold2509 _14135_/D _10725_/Y VPWR VGND sg13cmos5l_dlygate4sd3_1
X_07770_ _07839_/A _08540_/A _08538_/A VPWR VGND sg13cmos5l_nand2b_1
XFILLER_76_190 VPWR VGND sg13cmos5l_fill_2
X_09440_ _13551_/D _09304_/A hold3246/X _09441_/S VPWR VGND sg13cmos5l_mux2_1
X_13316__2106 _13316_/RESET_B VPWR VGND sg13cmos5l_tiehi
XFILLER_64_374 VPWR VGND sg13cmos5l_decap_4
XFILLER_65_886 VPWR VGND sg13cmos5l_fill_2
X_09371_ _13484_/D _08344_/A hold3336/X _09376_/S VPWR VGND sg13cmos5l_mux2_1
X_08322_ _08322_/Y _08338_/S _07314_/Y _08339_/B1 VPWR VGND sg13cmos5l_a21oi_1
X_08253_ _08253_/Y _08252_/A _08250_/Y _08252_/Y VPWR VGND sg13cmos5l_o21ai_1
X_07204_ _12988_/A _14482_/Q VPWR VGND sg13cmos5l_inv_1
X_08184_ _08186_/B _14480_/Q _08209_/B1 _08208_/A2 _15893_/A VPWR VGND sg13cmos5l_a22oi_1
X_14316__1192 _14316_/RESET_B VPWR VGND sg13cmos5l_tiehi
XFILLER_58_16 VPWR VGND sg13cmos5l_fill_2
XFILLER_75_606 VPWR VGND sg13cmos5l_decap_4
X_07968_ _07968_/X _13438_/Q _13406_/Q _13374_/Q _13342_/Q _08378_/A1 _07194_/A VPWR
+ VGND sg13cmos5l_mux4_1
X_14649__2192 _14649_/RESET_B VPWR VGND sg13cmos5l_tiehi
XFILLER_28_533 VPWR VGND sg13cmos5l_fill_1
X_09707_ _13622_/D _10361_/A1 _09706_/B _09706_/Y VPWR VGND sg13cmos5l_a21oi_1
XFILLER_55_352 VPWR VGND sg13cmos5l_fill_1
X_07899_ _11153_/A _11628_/A _11164_/B VPWR VGND sg13cmos5l_nor2_1
XFILLER_28_577 VPWR VGND sg13cmos5l_fill_1
X_09638_ _09650_/C _14460_/Q _14459_/Q _09638_/C VPWR VGND sg13cmos5l_and3_1
X_13907__1484 _13907_/RESET_B VPWR VGND sg13cmos5l_tiehi
XFILLER_31_709 VPWR VGND sg13cmos5l_fill_1
X_09569_ _09569_/Y _14450_/Q _09570_/B VPWR VGND sg13cmos5l_nand2_1
X_11600_ _11601_/B _11610_/A _11599_/B _11608_/B VPWR VGND sg13cmos5l_a21oi_1
X_12580_ _12581_/B hold3531/X _11657_/B _12575_/Y _12601_/A _12579_/Y VPWR VGND sg13cmos5l_a221oi_1
XFILLER_12_945 VPWR VGND sg13cmos5l_fill_1
X_11531_ _11553_/A _11531_/A _11531_/B VPWR VGND sg13cmos5l_nand2_1
XFILLER_12_989 VPWR VGND sg13cmos5l_fill_2
XFILLER_7_448 VPWR VGND sg13cmos5l_fill_2
X_11462_ _11464_/B _11476_/A _11463_/B _11476_/C VPWR VGND sg13cmos5l_a21oi_1
X_14250_ _14250_/Q clkload38/A _14250_/D _14250_/RESET_B VPWR VGND sg13cmos5l_dfrbpq_1
X_10413_ _13968_/D fanout57/X _10412_/B _10412_/Y VPWR VGND sg13cmos5l_a21oi_1
X_11393_ _11393_/X _11393_/A _11393_/B VPWR VGND sg13cmos5l_and2_1
X_14181_ _14181_/Q clkload43/A _14181_/D _14181_/RESET_B VPWR VGND sg13cmos5l_dfrbpq_1
X_13201_ _13201_/Q clkload12/A _13201_/D fanout957/X VPWR VGND sg13cmos5l_dfrbpq_1
XFILLER_3_621 VPWR VGND sg13cmos5l_fill_1
X_10344_ _13934_/D fanout73/X _10343_/B _10343_/Y VPWR VGND sg13cmos5l_a21oi_1
X_13132_ _14554_/D hold3525/X _08036_/B _13136_/S VPWR VGND sg13cmos5l_mux2_1
XFILLER_78_411 VPWR VGND sg13cmos5l_decap_4
X_10275_ _13900_/D fanout78/X _10284_/B _10274_/Y VPWR VGND sg13cmos5l_a21oi_1
X_13063_ _13067_/C _13063_/A _13063_/B VPWR VGND sg13cmos5l_nor2_1
X_12014_ _12014_/Y _14359_/Q _12124_/A2 _12013_/Y VPWR VGND sg13cmos5l_o21ai_1
Xfanout490 _11811_/B1 _11730_/B1 VPWR VGND sg13cmos5l_buf_1
X_13965_ _13965_/Q _14053_/CLK _13965_/D _13965_/RESET_B VPWR VGND sg13cmos5l_dfrbpq_1
XFILLER_0_45 VPWR VGND sg13cmos5l_decap_4
XFILLER_74_694 VPWR VGND sg13cmos5l_decap_4
X_13896_ _13896_/Q clkload78/A _13896_/D _13896_/RESET_B VPWR VGND sg13cmos5l_dfrbpq_1
X_12916_ _14445_/D _12916_/A VPWR VGND sg13cmos5l_inv_1
XFILLER_22_709 VPWR VGND sg13cmos5l_fill_1
X_12847_ _12849_/C _12847_/A _12866_/B VPWR VGND sg13cmos5l_and2_1
XFILLER_61_366 VPWR VGND sg13cmos5l_decap_8
X_12778_ _12778_/Y _12859_/A _12778_/B VPWR VGND sg13cmos5l_nand2_1
XFILLER_9_87 VPWR VGND sg13cmos5l_fill_1
X_11729_ _11729_/Y _13688_/Q _11727_/B _11697_/B VPWR VGND sg13cmos5l_o21ai_1
X_14517_ _14517_/Q _14520_/CLK _14517_/D fanout972/X VPWR VGND sg13cmos5l_dfrbpq_1
X_14448_ _14448_/Q clkload68/A _14448_/D _14448_/RESET_B VPWR VGND sg13cmos5l_dfrbpq_1
X_14379_ _14379_/Q _14631_/CLK _14379_/D _14379_/RESET_B VPWR VGND sg13cmos5l_dfrbpq_1
XFILLER_103_519 VPWR VGND sg13cmos5l_fill_2
X_08940_ _08940_/Y hold3566/X _13191_/B1 _13151_/B1 VPWR VGND sg13cmos5l_a21oi_1
Xhold3007 _10256_/A _13891_/Q VPWR VGND sg13cmos5l_dlygate4sd3_1
Xhold3018 hold3018/X _14207_/Q VPWR VGND sg13cmos5l_dlygate4sd3_1
Xhold3029 _10165_/A _13846_/Q VPWR VGND sg13cmos5l_dlygate4sd3_1
XFILLER_36_0 VPWR VGND sg13cmos5l_fill_2
XFILLER_97_731 VPWR VGND sg13cmos5l_fill_2
X_08871_ _08873_/A _08562_/B _08867_/B _08861_/C _07662_/X VPWR VGND sg13cmos5l_a22oi_1
Xhold2306 _10068_/A _13799_/Q VPWR VGND sg13cmos5l_dlygate4sd3_1
Xhold2317 _11571_/A _14339_/Q VPWR VGND sg13cmos5l_dlygate4sd3_1
Xhold2328 _10123_/A _13826_/Q VPWR VGND sg13cmos5l_dlygate4sd3_1
XFILLER_57_628 VPWR VGND sg13cmos5l_decap_8
XFILLER_85_926 VPWR VGND sg13cmos5l_decap_8
XFILLER_97_764 VPWR VGND sg13cmos5l_fill_2
X_07822_ _07822_/Y _07821_/Y _07822_/B VPWR VGND sg13cmos5l_nand2b_1
Xhold2339 _11262_/A _14319_/Q VPWR VGND sg13cmos5l_dlygate4sd3_1
X_07753_ _07753_/Y _07675_/Y _07752_/Y _07751_/Y VPWR VGND sg13cmos5l_a21oi_1
XFILLER_37_374 VPWR VGND sg13cmos5l_fill_1
XFILLER_65_694 VPWR VGND sg13cmos5l_fill_1
XFILLER_93_970 VPWR VGND sg13cmos5l_decap_4
X_07684_ _07686_/A _14388_/Q _14356_/Q VPWR VGND sg13cmos5l_nor2_1
XFILLER_25_536 VPWR VGND sg13cmos5l_fill_1
X_09423_ _13534_/D _07961_/A hold3340/X _09438_/S VPWR VGND sg13cmos5l_mux2_1
X_09354_ _13467_/D _08182_/A hold3371/X _09368_/S VPWR VGND sg13cmos5l_mux2_1
X_08305_ _12624_/A _08356_/C _08295_/X _08304_/Y VPWR VGND sg13cmos5l_a21oi_1
XFILLER_21_753 VPWR VGND sg13cmos5l_fill_2
X_09285_ _13409_/D _08206_/A hold3082/X _09295_/B VPWR VGND sg13cmos5l_mux2_1
X_08236_ _08236_/Y _08238_/S _13379_/Q _08235_/Y VPWR VGND sg13cmos5l_o21ai_1
XFILLER_5_908 VPWR VGND sg13cmos5l_fill_1
X_08167_ _12639_/B _07420_/B _08166_/Y _08162_/Y VPWR VGND sg13cmos5l_o21ai_1
X_14403__1105 _14403_/RESET_B VPWR VGND sg13cmos5l_tiehi
X_13770__1621 _13770_/RESET_B VPWR VGND sg13cmos5l_tiehi
X_08098_ _08111_/B _08098_/A _08098_/B VPWR VGND sg13cmos5l_nor2_1
XFILLER_79_208 VPWR VGND sg13cmos5l_fill_2
XFILLER_88_731 VPWR VGND sg13cmos5l_fill_2
X_10060_ _10060_/Y _10060_/A _10072_/B VPWR VGND sg13cmos5l_nand2_1
Xhold3541 hold3541/X _14268_/Q VPWR VGND sg13cmos5l_dlygate4sd3_1
Xhold3552 _12485_/A _14389_/Q VPWR VGND sg13cmos5l_dlygate4sd3_1
Xhold3530 _12987_/B _12986_/X VPWR VGND sg13cmos5l_dlygate4sd3_1
XFILLER_0_679 VPWR VGND sg13cmos5l_fill_1
XFILLER_102_563 VPWR VGND sg13cmos5l_fill_2
XFILLER_88_786 VPWR VGND sg13cmos5l_decap_4
Xhold2840 _10323_/A _13924_/Q VPWR VGND sg13cmos5l_dlygate4sd3_1
Xhold3563 _07929_/A _14225_/Q VPWR VGND sg13cmos5l_dlygate4sd3_1
XFILLER_48_639 VPWR VGND sg13cmos5l_fill_2
XFILLER_75_436 VPWR VGND sg13cmos5l_decap_8
Xhold2851 _09113_/A _13315_/Q VPWR VGND sg13cmos5l_dlygate4sd3_1
Xhold2862 _09756_/A _13647_/Q VPWR VGND sg13cmos5l_dlygate4sd3_1
Xhold2873 _09149_/A _13321_/Q VPWR VGND sg13cmos5l_dlygate4sd3_1
Xhold2884 _09771_/A _13653_/Q VPWR VGND sg13cmos5l_dlygate4sd3_1
XFILLER_75_469 VPWR VGND sg13cmos5l_fill_1
Xhold2895 _09791_/A _13663_/Q VPWR VGND sg13cmos5l_dlygate4sd3_1
XFILLER_29_897 VPWR VGND sg13cmos5l_fill_1
XFILLER_56_661 VPWR VGND sg13cmos5l_fill_1
XFILLER_62_108 VPWR VGND sg13cmos5l_fill_2
X_10962_ _14222_/D _10960_/Y _10961_/Y _10998_/A VPWR VGND sg13cmos5l_a21oi_1
X_13750_ _13750_/Q clkload49/A _13750_/D _13750_/RESET_B VPWR VGND sg13cmos5l_dfrbpq_1
X_12701_ _12704_/A _12680_/B _12699_/Y _12700_/Y _12698_/A VPWR VGND sg13cmos5l_a22oi_1
XFILLER_43_377 VPWR VGND sg13cmos5l_decap_8
XFILLER_70_163 VPWR VGND sg13cmos5l_fill_1
XFILLER_71_675 VPWR VGND sg13cmos5l_fill_2
X_10893_ _10893_/Y _10893_/A _10960_/B VPWR VGND sg13cmos5l_nand2_1
X_13681_ _13681_/Q _14065_/CLK _13681_/D _13681_/RESET_B VPWR VGND sg13cmos5l_dfrbpq_1
XFILLER_24_580 VPWR VGND sg13cmos5l_fill_1
X_12632_ _12633_/C _12631_/A _12631_/C _12631_/B VPWR VGND sg13cmos5l_o21ai_1
X_12563_ _12563_/Y _13032_/B _12639_/C _12641_/A _12562_/Y VPWR VGND sg13cmos5l_a22oi_1
X_11514_ _11517_/B _11514_/A _11514_/B _11514_/C VPWR VGND sg13cmos5l_nor3_1
X_14302_ _14302_/Q clkload26/A _14302_/D _14302_/RESET_B VPWR VGND sg13cmos5l_dfrbpq_1
X_12494_ _14391_/D _12503_/B _12493_/Y _12491_/Y VPWR VGND sg13cmos5l_o21ai_1
X_11445_ _11445_/X _11476_/A _11463_/B VPWR VGND sg13cmos5l_xor2_1
X_14233_ _14233_/Q _14622_/CLK _14233_/D _14233_/RESET_B VPWR VGND sg13cmos5l_dfrbpq_1
XFILLER_50_72 VPWR VGND sg13cmos5l_fill_2
X_11376_ _11389_/B _14175_/Q _11401_/C VPWR VGND sg13cmos5l_nor2_1
X_14164_ _14164_/Q clkload22/A _14164_/D fanout990/X VPWR VGND sg13cmos5l_dfrbpq_1
XFILLER_106_880 VPWR VGND sg13cmos5l_decap_8
X_10327_ _10327_/Y _10327_/A _10343_/B VPWR VGND sg13cmos5l_nor2_1
X_14095_ _14095_/Q clkload65/A _14095_/D _14095_/RESET_B VPWR VGND sg13cmos5l_dfrbpq_1
X_13115_ _14543_/D hold3520/X _08037_/B _13118_/S VPWR VGND sg13cmos5l_mux2_1
XFILLER_3_473 VPWR VGND sg13cmos5l_fill_2
X_10258_ _10258_/Y _10258_/A _10280_/B VPWR VGND sg13cmos5l_nor2_1
X_13046_ _14508_/D _13046_/A _13049_/C VPWR VGND sg13cmos5l_nor2_1
X_13633__1758 _13633_/RESET_B VPWR VGND sg13cmos5l_tiehi
XFILLER_66_436 VPWR VGND sg13cmos5l_decap_8
X_10189_ _10189_/Y _10189_/A _10189_/B VPWR VGND sg13cmos5l_nor2_1
XFILLER_75_992 VPWR VGND sg13cmos5l_fill_2
XFILLER_93_288 VPWR VGND sg13cmos5l_fill_2
X_13948_ _13948_/Q clkload47/A _13948_/D _13948_/RESET_B VPWR VGND sg13cmos5l_dfrbpq_1
X_14013__1378 _14013_/RESET_B VPWR VGND sg13cmos5l_tiehi
XFILLER_62_664 VPWR VGND sg13cmos5l_fill_1
XFILLER_62_675 VPWR VGND sg13cmos5l_decap_8
X_13879_ _13879_/Q clkload53/A _13879_/D _13879_/RESET_B VPWR VGND sg13cmos5l_dfrbpq_1
XFILLER_62_697 VPWR VGND sg13cmos5l_fill_1
XFILLER_98_2 VPWR VGND sg13cmos5l_fill_1
XFILLER_30_583 VPWR VGND sg13cmos5l_fill_1
X_09070_ _09070_/Y _11821_/A _09076_/A2 _09069_/Y VPWR VGND sg13cmos5l_a21oi_1
X_08021_ _08021_/Y _08062_/S _13277_/Q VPWR VGND sg13cmos5l_nand2_1
X_14648__2191 _14648_/RESET_B VPWR VGND sg13cmos5l_tiehi
XFILLER_104_806 VPWR VGND sg13cmos5l_fill_1
X_09972_ _13751_/D _10298_/A1 _09977_/B _09971_/Y VPWR VGND sg13cmos5l_o21ai_1
X_08923_ _08923_/X _08923_/A _11611_/A VPWR VGND sg13cmos5l_and2_1
XFILLER_58_904 VPWR VGND sg13cmos5l_fill_2
X_08854_ _08855_/A _08540_/A _08867_/B _08869_/B hold3412/X _08853_/Y VPWR VGND sg13cmos5l_a221oi_1
X_13609__1782 _13609_/RESET_B VPWR VGND sg13cmos5l_tiehi
X_07805_ _08602_/B _14400_/Q _12282_/A VPWR VGND sg13cmos5l_nand2b_1
X_08785_ _08785_/Y _14578_/Q _14163_/Q _14162_/Q _08785_/B2 VPWR VGND sg13cmos5l_a22oi_1
XFILLER_38_661 VPWR VGND sg13cmos5l_fill_2
XFILLER_66_992 VPWR VGND sg13cmos5l_fill_2
X_07736_ _07736_/X _07736_/A _07736_/B VPWR VGND sg13cmos5l_or2_1
XFILLER_65_480 VPWR VGND sg13cmos5l_fill_2
X_13788__1603 _13788_/RESET_B VPWR VGND sg13cmos5l_tiehi
XFILLER_13_506 VPWR VGND sg13cmos5l_fill_1
XFILLER_26_889 VPWR VGND sg13cmos5l_fill_1
XFILLER_52_130 VPWR VGND sg13cmos5l_fill_1
X_07667_ _08551_/C _14393_/Q _14361_/Q VPWR VGND sg13cmos5l_or2_1
X_13476__1946 _13476_/RESET_B VPWR VGND sg13cmos5l_tiehi
XFILLER_80_494 VPWR VGND sg13cmos5l_fill_1
X_07598_ _07613_/A _13282_/Q _13280_/Q _13281_/Q VPWR VGND sg13cmos5l_nand3_1
X_09406_ _09406_/X _14127_/Q hold3316/X _09409_/S VPWR VGND sg13cmos5l_mux2_1
X_09337_ _09337_/X hold3067/X _13453_/Q _09338_/S VPWR VGND sg13cmos5l_mux2_1
X_09268_ _13393_/D _09307_/A hold3101/X _09268_/S VPWR VGND sg13cmos5l_mux2_1
X_08219_ _08219_/X _13506_/Q _13474_/Q _08258_/S VPWR VGND sg13cmos5l_mux2_1
XFILLER_101_1020 VPWR VGND sg13cmos5l_decap_8
X_09199_ _09309_/B _09199_/A _09199_/B _09343_/D VPWR VGND sg13cmos5l_and3_1
X_11230_ _11230_/Y _11258_/A _11226_/Y _11229_/Y _10982_/Y VPWR VGND sg13cmos5l_a22oi_1
XFILLER_1_911 VPWR VGND sg13cmos5l_fill_1
X_11161_ _11161_/Y _08435_/B _11161_/B _11161_/C VPWR VGND sg13cmos5l_nand3b_1
XFILLER_1_922 VPWR VGND sg13cmos5l_decap_8
X_10112_ _13820_/D _10569_/A1 _10119_/B _10111_/Y VPWR VGND sg13cmos5l_o21ai_1
XFILLER_49_915 VPWR VGND sg13cmos5l_fill_1
X_11092_ _11161_/B _11092_/A VPWR VGND sg13cmos5l_inv_1
Xhold3360 hold3360/X _13448_/Q VPWR VGND sg13cmos5l_dlygate4sd3_1
XFILLER_48_403 VPWR VGND sg13cmos5l_fill_2
XFILLER_88_572 VPWR VGND sg13cmos5l_fill_2
X_10043_ _13786_/D _10369_/A1 _10042_/B _10042_/Y VPWR VGND sg13cmos5l_o21ai_1
Xhold3393 hold3393/X _13468_/Q VPWR VGND sg13cmos5l_dlygate4sd3_1
Xhold3382 hold3382/X _14168_/Q VPWR VGND sg13cmos5l_dlygate4sd3_1
Xhold3371 hold3371/X _13467_/Q VPWR VGND sg13cmos5l_dlygate4sd3_1
Xhold2670 _09740_/A _13639_/Q VPWR VGND sg13cmos5l_dlygate4sd3_1
Xhold2681 _10382_/A _13953_/Q VPWR VGND sg13cmos5l_dlygate4sd3_1
Xhold2692 _13092_/A _14530_/Q VPWR VGND sg13cmos5l_dlygate4sd3_1
XFILLER_17_801 VPWR VGND sg13cmos5l_fill_1
XFILLER_57_981 VPWR VGND sg13cmos5l_fill_1
XFILLER_91_715 VPWR VGND sg13cmos5l_fill_1
X_13802_ _13802_/Q clkload52/A _13802_/D _13802_/RESET_B VPWR VGND sg13cmos5l_dfrbpq_1
X_11994_ _11995_/A _11993_/A _12107_/A _12286_/A VPWR VGND sg13cmos5l_o21ai_1
X_13344__2078 _13344_/RESET_B VPWR VGND sg13cmos5l_tiehi
XFILLER_32_804 VPWR VGND sg13cmos5l_fill_1
XFILLER_45_61 VPWR VGND sg13cmos5l_fill_2
X_10945_ _14215_/D _10945_/A VPWR VGND sg13cmos5l_inv_1
X_13733_ _13733_/Q _14053_/CLK _13733_/D _13733_/RESET_B VPWR VGND sg13cmos5l_dfrbpq_1
X_10876_ _10909_/B _14254_/Q _14255_/Q VPWR VGND sg13cmos5l_nor2b_1
X_13664_ _13664_/Q _14048_/CLK _13664_/D _13664_/RESET_B VPWR VGND sg13cmos5l_dfrbpq_1
XFILLER_31_336 VPWR VGND sg13cmos5l_fill_2
X_14275__1233 _14275_/RESET_B VPWR VGND sg13cmos5l_tiehi
X_12615_ _12618_/A _12603_/X _12604_/Y _12602_/X VPWR VGND sg13cmos5l_a21oi_1
X_13595_ _13595_/Q _14042_/CLK _13595_/D _13595_/RESET_B VPWR VGND sg13cmos5l_dfrbpq_1
XFILLER_12_583 VPWR VGND sg13cmos5l_fill_2
X_12546_ _12546_/Y _12546_/A1 _07297_/A _12541_/B VPWR VGND sg13cmos5l_a21oi_1
X_13521__1901 _13521_/RESET_B VPWR VGND sg13cmos5l_tiehi
X_12477_ _12477_/Y _12480_/A _13240_/Q _12476_/Y VPWR VGND sg13cmos5l_o21ai_1
XANTENNA_4 ui_in[8] VPWR VGND sg13cmos5l_antennanp
X_11428_ _11428_/Y _11456_/C _11428_/B VPWR VGND sg13cmos5l_xnor2_1
X_14216_ _14216_/Q _14217_/CLK _14216_/D _14216_/RESET_B VPWR VGND sg13cmos5l_dfrbpq_1
X_11359_ _11360_/B _11374_/A _11359_/B VPWR VGND sg13cmos5l_nand2_1
X_14147_ _14147_/Q clkload22/A _14147_/D fanout990/X VPWR VGND sg13cmos5l_dfrbpq_1
X_13866__1525 _13866_/RESET_B VPWR VGND sg13cmos5l_tiehi
X_14078_ _14078_/Q _14520_/CLK _14078_/D fanout972/X VPWR VGND sg13cmos5l_dfrbpq_1
X_13554__1868 _13554_/RESET_B VPWR VGND sg13cmos5l_tiehi
XFILLER_94_520 VPWR VGND sg13cmos5l_fill_2
X_13029_ _13070_/B _13030_/A _13030_/B VPWR VGND sg13cmos5l_nor2_1
XFILLER_39_469 VPWR VGND sg13cmos5l_fill_2
XFILLER_54_417 VPWR VGND sg13cmos5l_decap_8
X_08570_ _08570_/Y _07652_/Y _08567_/B _07780_/Y VPWR VGND sg13cmos5l_o21ai_1
X_07521_ _07521_/Y _09414_/A0 _08199_/A1 _11040_/A VPWR VGND sg13cmos5l_a21oi_1
XFILLER_35_697 VPWR VGND sg13cmos5l_fill_1
X_07452_ _07454_/C _14527_/Q _07512_/B _07527_/B1 _15888_/A VPWR VGND sg13cmos5l_a22oi_1
XFILLER_50_656 VPWR VGND sg13cmos5l_decap_8
X_07383_ _07408_/B _14549_/Q _07436_/C VPWR VGND sg13cmos5l_nor2_1
XFILLER_50_689 VPWR VGND sg13cmos5l_decap_8
X_09122_ _09122_/Y _14425_/Q _11450_/A VPWR VGND sg13cmos5l_nand2_1
X_09053_ _09053_/Y _11740_/A _09076_/A2 _09052_/Y VPWR VGND sg13cmos5l_a21oi_1
X_08004_ _08092_/B _12964_/A _08098_/A _13040_/C VPWR VGND sg13cmos5l_and3_1
XFILLER_58_701 VPWR VGND sg13cmos5l_fill_1
XFILLER_89_358 VPWR VGND sg13cmos5l_fill_1
XFILLER_98_870 VPWR VGND sg13cmos5l_decap_4
X_09955_ _13743_/D fanout62/X _09958_/B _09954_/Y VPWR VGND sg13cmos5l_a21oi_1
X_08906_ _08907_/C _08906_/A _08911_/B VPWR VGND sg13cmos5l_nand2_1
X_09886_ _09886_/Y _09886_/A _09886_/B VPWR VGND sg13cmos5l_nor2_1
XFILLER_100_831 VPWR VGND sg13cmos5l_fill_2
XFILLER_66_38 VPWR VGND sg13cmos5l_fill_2
X_08837_ _14637_/D _08837_/A VPWR VGND sg13cmos5l_inv_1
X_14353__1155 _14353_/RESET_B VPWR VGND sg13cmos5l_tiehi
XFILLER_73_759 VPWR VGND sg13cmos5l_fill_1
X_08768_ _08768_/Y _08782_/A1 _07333_/Y _08767_/Y VPWR VGND sg13cmos5l_o21ai_1
X_07719_ _07719_/Y _14376_/Q _07720_/B VPWR VGND sg13cmos5l_nor2_1
X_08699_ _08699_/X _13908_/Q _11749_/B VPWR VGND sg13cmos5l_and2_1
XFILLER_53_461 VPWR VGND sg13cmos5l_fill_1
XFILLER_53_494 VPWR VGND sg13cmos5l_fill_1
XFILLER_54_995 VPWR VGND sg13cmos5l_fill_2
XFILLER_81_792 VPWR VGND sg13cmos5l_decap_8
X_10730_ _10730_/Y _10730_/A _10751_/B VPWR VGND sg13cmos5l_nand2_1
X_10661_ _14086_/D _14267_/D hold3549/X _10829_/S VPWR VGND sg13cmos5l_mux2_1
XFILLER_41_689 VPWR VGND sg13cmos5l_fill_1
X_13944__1447 _13944_/RESET_B VPWR VGND sg13cmos5l_tiehi
X_12400_ _12400_/Y _12400_/A _12400_/B _12400_/C VPWR VGND sg13cmos5l_nand3_1
X_10592_ _10592_/Y _10592_/A _10610_/B VPWR VGND sg13cmos5l_nand2_1
X_13380_ _13380_/Q _14117_/CLK _13380_/D _13380_/RESET_B VPWR VGND sg13cmos5l_dfrbpq_1
X_12331_ _12331_/Y _12301_/A _07293_/Y _12307_/A VPWR VGND sg13cmos5l_a21oi_1
X_12262_ _12263_/C _13643_/Q _12373_/B _12290_/A2 _13899_/Q VPWR VGND sg13cmos5l_a22oi_1
XFILLER_103_0 VPWR VGND sg13cmos5l_fill_2
X_11213_ _11213_/X _11258_/A _11213_/B VPWR VGND sg13cmos5l_and2_1
X_14001_ _14001_/Q _14640_/CLK _14001_/D _14001_/RESET_B VPWR VGND sg13cmos5l_dfrbpq_1
X_12193_ _12193_/Y _12193_/A _12301_/B VPWR VGND sg13cmos5l_nand2_1
Xoutput30 uio_out[1] _15881_/X VPWR VGND sg13cmos5l_buf_1
Xoutput41 uo_out[11] _08778_/Y VPWR VGND sg13cmos5l_buf_1
Xoutput52 uo_out[7] _08770_/Y VPWR VGND sg13cmos5l_buf_1
X_11144_ _11144_/Y _11144_/A _11144_/B VPWR VGND sg13cmos5l_nor2_1
XFILLER_49_734 VPWR VGND sg13cmos5l_fill_1
XFILLER_89_881 VPWR VGND sg13cmos5l_decap_8
XFILLER_95_339 VPWR VGND sg13cmos5l_fill_2
X_11075_ _11075_/X _14378_/Q _11083_/B VPWR VGND sg13cmos5l_and2_1
X_10026_ _10026_/Y _10026_/A _10042_/B VPWR VGND sg13cmos5l_nand2_1
Xhold3190 hold3190/X _13529_/Q VPWR VGND sg13cmos5l_dlygate4sd3_1
XFILLER_76_564 VPWR VGND sg13cmos5l_decap_8
X_15883_ _15883_/X input20/X VPWR VGND sg13cmos5l_buf_1
X_14647__2190 _14647_/RESET_B VPWR VGND sg13cmos5l_tiehi
XFILLER_48_299 VPWR VGND sg13cmos5l_fill_2
XFILLER_64_737 VPWR VGND sg13cmos5l_decap_4
XFILLER_16_130 VPWR VGND sg13cmos5l_fill_1
XFILLER_17_664 VPWR VGND sg13cmos5l_fill_1
XFILLER_44_450 VPWR VGND sg13cmos5l_fill_1
X_11977_ _11977_/Y _14452_/Q _12380_/B _11976_/Y VPWR VGND sg13cmos5l_a21oi_1
XFILLER_17_686 VPWR VGND sg13cmos5l_fill_1
XFILLER_44_483 VPWR VGND sg13cmos5l_fill_2
X_10928_ _14209_/D _10848_/Y _10909_/Y _10927_/Y VPWR VGND sg13cmos5l_o21ai_1
X_13716_ _13716_/Q clkload17/A _13716_/D _13716_/RESET_B VPWR VGND sg13cmos5l_dfrbpq_1
XFILLER_32_689 VPWR VGND sg13cmos5l_fill_2
X_10859_ _10891_/C _10954_/C _14245_/D VPWR VGND sg13cmos5l_nor2b_1
X_13647_ _13647_/Q _14020_/CLK _13647_/D _13647_/RESET_B VPWR VGND sg13cmos5l_dfrbpq_1
X_13578_ _13578_/Q clkload42/A _13578_/D _13578_/RESET_B VPWR VGND sg13cmos5l_dfrbpq_1
XFILLER_75_4 VPWR VGND sg13cmos5l_fill_2
X_12529_ _14400_/D _12529_/A _12529_/B VPWR VGND sg13cmos5l_nand2_1
X_14431__1077 _14431_/RESET_B VPWR VGND sg13cmos5l_tiehi
Xfanout319 _09821_/B fanout320/X VPWR VGND sg13cmos5l_buf_1
Xfanout308 _09882_/B _09890_/B VPWR VGND sg13cmos5l_buf_1
X_09740_ _09740_/Y _09740_/A _09748_/B VPWR VGND sg13cmos5l_nor2_1
.ends
